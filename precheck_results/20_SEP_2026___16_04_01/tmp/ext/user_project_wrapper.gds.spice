* NGSPICE file created from user_project_wrapper.ext - technology: sky130A

.subckt SS_sky130_ef_sc_hd__decap_40_12 VNB VPB VGND VPWR
X0 VPWR VGND VPWR VPB sky130_fd_pr__pfet_01v8_hvt ad=0.7482 pd=3.46 as=0 ps=0 w=0.87 l=1.65
X1 VGND VPWR VGND VNB sky130_fd_pr__nfet_01v8 ad=1.496 pd=6.54 as=0 ps=0 w=0.55 l=1.6
.ends

* Black-box entry subcircuit for SS_sky130_fd_sc_hd__fill_2 abstract view
.subckt SS_sky130_fd_sc_hd__fill_2 VGND VPWR VPB VNB
.ends

* Black-box entry subcircuit for SS_sky130_fd_sc_hd__tapvpwrvgnd_1 abstract view
.subckt SS_sky130_fd_sc_hd__tapvpwrvgnd_1 VPWR VGND
.ends

* Black-box entry subcircuit for SS_sky130_fd_sc_hd__fill_4 abstract view
.subckt SS_sky130_fd_sc_hd__fill_4 VGND VPWR VPB VNB
.ends

* Black-box entry subcircuit for SS_sky130_fd_sc_hd__fill_1 abstract view
.subckt SS_sky130_fd_sc_hd__fill_1 VPWR VGND VPB VNB
.ends

.subckt SS_sky130_fd_sc_hd__decap_3 VPWR VGND VPB VNB
X0 VPWR VGND VPWR VPB sky130_fd_pr__pfet_01v8_hvt ad=0.2262 pd=2.26 as=0 ps=0 w=0.87 l=0.59
X1 VGND VPWR VGND VNB sky130_fd_pr__nfet_01v8 ad=0.143 pd=1.62 as=0 ps=0 w=0.55 l=0.59
.ends

* Black-box entry subcircuit for SS_sky130_fd_sc_hd__fill_8 abstract view
.subckt SS_sky130_fd_sc_hd__fill_8 VGND VPWR VPB VNB
.ends

.subckt SS_sky130_fd_sc_hd__or2_2 VPWR VGND VPB VNB X A B
X0 a_121_297# B a_39_297# VPB sky130_fd_pr__pfet_01v8_hvt ad=0.0441 pd=0.63 as=0.1092 ps=1.36 w=0.42 l=0.15
X1 X a_39_297# VGND VNB sky130_fd_pr__nfet_01v8 ad=0.08775 pd=0.92 as=0.10675 ps=1.005 w=0.65 l=0.15 M=2
X2 VPWR a_39_297# X VPB sky130_fd_pr__pfet_01v8_hvt ad=0.26 pd=2.52 as=0.135 ps=1.27 w=1 l=0.15 M=2
X3 VPWR A a_121_297# VPB sky130_fd_pr__pfet_01v8_hvt ad=0.15575 pd=1.355 as=0.0441 ps=0.63 w=0.42 l=0.15
X4 VGND A a_39_297# VNB sky130_fd_pr__nfet_01v8 ad=0.10675 pd=1.005 as=0.0567 ps=0.69 w=0.42 l=0.15
X5 a_39_297# B VGND VNB sky130_fd_pr__nfet_01v8 ad=0.0567 pd=0.69 as=0.1092 ps=1.36 w=0.42 l=0.15
.ends

.subckt SS_sky130_fd_sc_hd__o211a_2 VNB VPB VPWR VGND A2 A1 X C1 B1
X0 a_27_47# B1 VPWR VPB sky130_fd_pr__pfet_01v8_hvt ad=0.3675 pd=1.735 as=0.14 ps=1.28 w=1 l=0.15
X1 VGND a_27_47# X VNB sky130_fd_pr__nfet_01v8 ad=0.23075 pd=2.01 as=0.091 ps=0.93 w=0.65 l=0.15 M=2
X2 VPWR C1 a_27_47# VPB sky130_fd_pr__pfet_01v8_hvt ad=0.14 pd=1.28 as=0.265 ps=2.53 w=1 l=0.15
X3 VPWR A1 a_373_297# VPB sky130_fd_pr__pfet_01v8_hvt ad=0.195 pd=1.39 as=0.105 ps=1.21 w=1 l=0.15
X4 a_182_47# A2 VGND VNB sky130_fd_pr__nfet_01v8 ad=0.091 pd=0.93 as=0.16535 ps=1.82 w=0.65 l=0.15
X5 X a_27_47# VPWR VPB sky130_fd_pr__pfet_01v8_hvt ad=0.14 pd=1.28 as=0.195 ps=1.39 w=1 l=0.15 M=2
X6 a_182_47# B1 a_110_47# VNB sky130_fd_pr__nfet_01v8 ad=0.16535 pd=1.82 as=0.06825 ps=0.86 w=0.65 l=0.15
X7 a_373_297# A2 a_27_47# VPB sky130_fd_pr__pfet_01v8_hvt ad=0.105 pd=1.21 as=0.3675 ps=1.735 w=1 l=0.15
X8 a_110_47# C1 a_27_47# VNB sky130_fd_pr__nfet_01v8 ad=0.06825 pd=0.86 as=0.17225 ps=1.83 w=0.65 l=0.15
X9 VGND A1 a_182_47# VNB sky130_fd_pr__nfet_01v8 ad=0.104 pd=0.97 as=0.091 ps=0.93 w=0.65 l=0.15
.ends

.subckt SS_sky130_fd_sc_hd__dfxtp_2 Q CLK D VPB VNB VPWR VGND
X0 Q a_1059_315# VGND VNB sky130_fd_pr__nfet_01v8 ad=0.08775 pd=0.92 as=0.08775 ps=0.92 w=0.65 l=0.15 M=2
X1 VPWR a_1059_315# Q VPB sky130_fd_pr__pfet_01v8_hvt ad=0.26 pd=2.52 as=0.135 ps=1.27 w=1 l=0.15 M=2
X2 a_891_413# a_193_47# a_634_159# VNB sky130_fd_pr__special_nfet_01v8 ad=0.0684 pd=0.74 as=0.0989 ps=0.995 w=0.36 l=0.15
X3 a_561_413# a_27_47# a_466_413# VPB sky130_fd_pr__pfet_01v8_hvt ad=0.07665 pd=0.785 as=0.06825 ps=0.745 w=0.42 l=0.15
X4 VPWR CLK a_27_47# VPB sky130_fd_pr__pfet_01v8_hvt ad=0.0864 pd=0.91 as=0.1664 ps=1.8 w=0.64 l=0.15
X5 a_381_47# D VPWR VPB sky130_fd_pr__pfet_01v8_hvt ad=0.05775 pd=0.695 as=0.1092 ps=1.36 w=0.42 l=0.15
X6 VGND a_634_159# a_592_47# VNB sky130_fd_pr__nfet_01v8 ad=0.12095 pd=1.085 as=0.0696 ps=0.765 w=0.42 l=0.15
X7 VPWR a_891_413# a_1059_315# VPB sky130_fd_pr__pfet_01v8_hvt ad=0.135 pd=1.27 as=0.27 ps=2.54 w=1 l=0.15
X8 a_466_413# a_193_47# a_381_47# VPB sky130_fd_pr__pfet_01v8_hvt ad=0.06825 pd=0.745 as=0.05775 ps=0.695 w=0.42 l=0.15
X9 VPWR a_634_159# a_561_413# VPB sky130_fd_pr__pfet_01v8_hvt ad=0.178875 pd=1.26 as=0.07665 ps=0.785 w=0.42 l=0.15
X10 a_634_159# a_466_413# VGND VNB sky130_fd_pr__nfet_01v8 ad=0.0989 pd=0.995 as=0.12095 ps=1.085 w=0.64 l=0.15
X11 a_634_159# a_466_413# VPWR VPB sky130_fd_pr__pfet_01v8_hvt ad=0.1095 pd=1.075 as=0.178875 ps=1.26 w=0.75 l=0.15
X12 a_975_413# a_193_47# a_891_413# VPB sky130_fd_pr__pfet_01v8_hvt ad=0.0882 pd=0.84 as=0.0567 ps=0.69 w=0.42 l=0.15
X13 VGND a_1059_315# a_1017_47# VNB sky130_fd_pr__nfet_01v8 ad=0.1092 pd=1.36 as=0.066 ps=0.745 w=0.42 l=0.15
X14 a_193_47# a_27_47# VGND VNB sky130_fd_pr__nfet_01v8 ad=0.1092 pd=1.36 as=0.0567 ps=0.69 w=0.42 l=0.15
X15 a_891_413# a_27_47# a_634_159# VPB sky130_fd_pr__pfet_01v8_hvt ad=0.0567 pd=0.69 as=0.1095 ps=1.075 w=0.42 l=0.15
X16 a_592_47# a_193_47# a_466_413# VNB sky130_fd_pr__special_nfet_01v8 ad=0.0696 pd=0.765 as=0.0621 ps=0.705 w=0.36 l=0.15
X17 VPWR a_1059_315# a_975_413# VPB sky130_fd_pr__pfet_01v8_hvt ad=0.1113 pd=1.37 as=0.0882 ps=0.84 w=0.42 l=0.15
X18 a_1017_47# a_27_47# a_891_413# VNB sky130_fd_pr__special_nfet_01v8 ad=0.066 pd=0.745 as=0.0684 ps=0.74 w=0.36 l=0.15
X19 a_193_47# a_27_47# VPWR VPB sky130_fd_pr__pfet_01v8_hvt ad=0.1664 pd=1.8 as=0.0864 ps=0.91 w=0.64 l=0.15
X20 a_466_413# a_27_47# a_381_47# VNB sky130_fd_pr__special_nfet_01v8 ad=0.0621 pd=0.705 as=0.0813 ps=0.83 w=0.36 l=0.15
X21 VGND a_891_413# a_1059_315# VNB sky130_fd_pr__nfet_01v8 ad=0.08775 pd=0.92 as=0.169 ps=1.82 w=0.65 l=0.15
X22 a_381_47# D VGND VNB sky130_fd_pr__nfet_01v8 ad=0.0813 pd=0.83 as=0.1092 ps=1.36 w=0.42 l=0.15
X23 VGND CLK a_27_47# VNB sky130_fd_pr__nfet_01v8 ad=0.0567 pd=0.69 as=0.1092 ps=1.36 w=0.42 l=0.15
.ends

.subckt SS_sky130_fd_sc_hd__conb_1 LO HI VPB VNB VGND VPWR
X0 VPWR HI sky130_fd_pr__res_generic_po w=0.48 l=0.045
X1 LO VGND sky130_fd_pr__res_generic_po w=0.48 l=0.045
.ends

.subckt SS_sky130_fd_sc_hd__o221a_2 VPB VNB VGND VPWR B1 B2 A2 A1 X C1
X0 VPWR a_38_47# X VPB sky130_fd_pr__pfet_01v8_hvt ad=0.26 pd=2.52 as=0.135 ps=1.27 w=1 l=0.15 M=2
X1 VPWR A1 a_497_297# VPB sky130_fd_pr__pfet_01v8_hvt ad=0.165 pd=1.33 as=0.105 ps=1.21 w=1 l=0.15
X2 a_141_47# B2 a_225_47# VNB sky130_fd_pr__nfet_01v8 ad=0.169 pd=1.82 as=0.08775 ps=0.92 w=0.65 l=0.15
X3 a_497_297# A2 a_38_47# VPB sky130_fd_pr__pfet_01v8_hvt ad=0.105 pd=1.21 as=0.3875 ps=1.775 w=1 l=0.15
X4 VGND A1 a_225_47# VNB sky130_fd_pr__nfet_01v8 ad=0.08775 pd=0.92 as=0.08775 ps=0.92 w=0.65 l=0.15
X5 VPWR C1 a_38_47# VPB sky130_fd_pr__pfet_01v8_hvt ad=0.165 pd=1.33 as=0.325 ps=2.65 w=1 l=0.15
X6 a_237_297# B1 VPWR VPB sky130_fd_pr__pfet_01v8_hvt ad=0.1125 pd=1.225 as=0.165 ps=1.33 w=1 l=0.15
X7 a_38_47# B2 a_237_297# VPB sky130_fd_pr__pfet_01v8_hvt ad=0.3875 pd=1.775 as=0.1125 ps=1.225 w=1 l=0.15
X8 a_225_47# A2 VGND VNB sky130_fd_pr__nfet_01v8 ad=0.08775 pd=0.92 as=0.169 ps=1.82 w=0.65 l=0.15
X9 X a_38_47# VGND VNB sky130_fd_pr__nfet_01v8 ad=0.08775 pd=0.92 as=0.08775 ps=0.92 w=0.65 l=0.15 M=2
X10 a_141_47# C1 a_38_47# VNB sky130_fd_pr__nfet_01v8 ad=0.08775 pd=0.92 as=0.23725 ps=2.03 w=0.65 l=0.15
X11 a_225_47# B1 a_141_47# VNB sky130_fd_pr__nfet_01v8 ad=0.08775 pd=0.92 as=0.08775 ps=0.92 w=0.65 l=0.15
.ends

.subckt SS_sky130_fd_sc_hd__a22o_2 VPWR VGND VPB VNB B2 B1 A1 A2 X
X0 VPWR a_27_297# X VPB sky130_fd_pr__pfet_01v8_hvt ad=0.27 pd=2.54 as=0.135 ps=1.27 w=1 l=0.15 M=2
X1 VGND A2 a_381_47# VNB sky130_fd_pr__nfet_01v8 ad=0.102375 pd=0.965 as=0.10725 ps=0.98 w=0.65 l=0.15
X2 X a_27_297# VGND VNB sky130_fd_pr__nfet_01v8 ad=0.08775 pd=0.92 as=0.102375 ps=0.965 w=0.65 l=0.15 M=2
X3 a_27_297# B1 a_109_47# VNB sky130_fd_pr__nfet_01v8 ad=0.169 pd=1.82 as=0.07475 ps=0.88 w=0.65 l=0.15
X4 a_27_297# B1 a_109_297# VPB sky130_fd_pr__pfet_01v8_hvt ad=0.26 pd=2.52 as=0.135 ps=1.27 w=1 l=0.15
X5 a_109_297# A1 VPWR VPB sky130_fd_pr__pfet_01v8_hvt ad=0.165 pd=1.33 as=0.26 ps=2.52 w=1 l=0.15
X6 VPWR A2 a_109_297# VPB sky130_fd_pr__pfet_01v8_hvt ad=0.1575 pd=1.315 as=0.165 ps=1.33 w=1 l=0.15
X7 a_381_47# A1 a_27_297# VNB sky130_fd_pr__nfet_01v8 ad=0.10725 pd=0.98 as=0.169 ps=1.82 w=0.65 l=0.15
X8 a_109_297# B2 a_27_297# VPB sky130_fd_pr__pfet_01v8_hvt ad=0.135 pd=1.27 as=0.26 ps=2.52 w=1 l=0.15
X9 a_109_47# B2 VGND VNB sky130_fd_pr__nfet_01v8 ad=0.07475 pd=0.88 as=0.169 ps=1.82 w=0.65 l=0.15
.ends

.subckt SS_sky130_fd_sc_hd__buf_12 VPB VNB VGND VPWR A X
X0 VGND a_109_47# X VNB sky130_fd_pr__nfet_01v8 ad=0.08775 pd=0.92 as=0.08775 ps=0.92 w=0.65 l=0.15 M=12
X1 X a_109_47# VPWR VPB sky130_fd_pr__pfet_01v8_hvt ad=0.135 pd=1.27 as=0.135 ps=1.27 w=1 l=0.15 M=12
X2 VPWR A a_109_47# VPB sky130_fd_pr__pfet_01v8_hvt ad=0.135 pd=1.27 as=0.135 ps=1.27 w=1 l=0.15 M=4
X3 VGND A a_109_47# VNB sky130_fd_pr__nfet_01v8 ad=0.08775 pd=0.92 as=0.08775 ps=0.92 w=0.65 l=0.15 M=4
.ends

.subckt SS_sky130_fd_sc_hd__buf_4 VPWR VGND X A VPB VNB
X0 VPWR a_27_47# X VPB sky130_fd_pr__pfet_01v8_hvt ad=0.26 pd=2.52 as=0.135 ps=1.27 w=1 l=0.15 M=4
X1 X a_27_47# VGND VNB sky130_fd_pr__nfet_01v8 ad=0.08775 pd=0.92 as=0.08775 ps=0.92 w=0.65 l=0.15 M=4
X2 VPWR A a_27_47# VPB sky130_fd_pr__pfet_01v8_hvt ad=0.135 pd=1.27 as=0.26 ps=2.52 w=1 l=0.15
X3 VGND A a_27_47# VNB sky130_fd_pr__nfet_01v8 ad=0.08775 pd=0.92 as=0.169 ps=1.82 w=0.65 l=0.15
.ends

.subckt SS_sky130_fd_sc_hd__clkdlybuf4s25_1 VNB VPB VPWR VGND A X
X0 a_244_47# a_27_47# VPWR VPB sky130_fd_pr__pfet_01v8_hvt ad=0.2173 pd=2.17 as=0.19265 ps=1.415 w=0.82 l=0.25
X1 VPWR a_244_47# a_355_47# VPB sky130_fd_pr__pfet_01v8_hvt ad=0.2726 pd=1.61 as=0.2173 ps=2.17 w=0.82 l=0.25
X2 X a_355_47# VPWR VPB sky130_fd_pr__pfet_01v8_hvt ad=0.495 pd=2.99 as=0.2726 ps=1.61 w=1 l=0.15
X3 VPWR A a_27_47# VPB sky130_fd_pr__pfet_01v8_hvt ad=0.19265 pd=1.415 as=0.27 ps=2.54 w=1 l=0.15
X4 VGND A a_27_47# VNB sky130_fd_pr__nfet_01v8 ad=0.1228 pd=1.065 as=0.1134 ps=1.38 w=0.42 l=0.15
X5 VGND a_244_47# a_355_47# VNB sky130_fd_pr__nfet_01v8 ad=0.1856 pd=1.26 as=0.17225 ps=1.83 w=0.65 l=0.25
X6 X a_355_47# VGND VNB sky130_fd_pr__nfet_01v8 ad=0.2079 pd=1.83 as=0.1856 ps=1.26 w=0.42 l=0.15
X7 a_244_47# a_27_47# VGND VNB sky130_fd_pr__nfet_01v8 ad=0.17225 pd=1.83 as=0.1228 ps=1.065 w=0.65 l=0.25
.ends

.subckt SS_sky130_fd_sc_hd__buf_2 VPWR VGND X A VPB VNB
X0 VPWR a_27_47# X VPB sky130_fd_pr__pfet_01v8_hvt ad=0.265 pd=2.53 as=0.135 ps=1.27 w=1 l=0.15 M=2
X1 VPWR A a_27_47# VPB sky130_fd_pr__pfet_01v8_hvt ad=0.149 pd=1.325 as=0.1664 ps=1.8 w=0.64 l=0.15
X2 X a_27_47# VGND VNB sky130_fd_pr__nfet_01v8 ad=0.08775 pd=0.92 as=0.097 ps=0.975 w=0.65 l=0.15 M=2
X3 VGND A a_27_47# VNB sky130_fd_pr__nfet_01v8 ad=0.097 pd=0.975 as=0.1092 ps=1.36 w=0.42 l=0.15
.ends

.subckt SS_sky130_fd_sc_hd__nand2_2 VPB VNB VGND VPWR Y A B
X0 VPWR A Y VPB sky130_fd_pr__pfet_01v8_hvt ad=0.26 pd=2.52 as=0.135 ps=1.27 w=1 l=0.15 M=2
X1 VPWR B Y VPB sky130_fd_pr__pfet_01v8_hvt ad=0.135 pd=1.27 as=0.135 ps=1.27 w=1 l=0.15 M=2
X2 a_27_47# B VGND VNB sky130_fd_pr__nfet_01v8 ad=0.08775 pd=0.92 as=0.08775 ps=0.92 w=0.65 l=0.15 M=2
X3 a_27_47# A Y VNB sky130_fd_pr__nfet_01v8 ad=0.169 pd=1.82 as=0.08775 ps=0.92 w=0.65 l=0.15 M=2
.ends

.subckt SS_sky130_fd_sc_hd__a2111o_2 VNB VPB VGND VPWR A2 A1 B1 C1 X D1
X0 VPWR a_86_235# X VPB sky130_fd_pr__pfet_01v8_hvt ad=0.265 pd=2.53 as=0.14 ps=1.28 w=1 l=0.15 M=2
X1 VGND C1 a_86_235# VNB sky130_fd_pr__nfet_01v8 ad=0.121875 pd=1.025 as=0.091 ps=0.93 w=0.65 l=0.15
X2 a_86_235# D1 VGND VNB sky130_fd_pr__nfet_01v8 ad=0.091 pd=0.93 as=0.290875 ps=1.545 w=0.65 l=0.15
X3 X a_86_235# VGND VNB sky130_fd_pr__nfet_01v8 ad=0.091 pd=0.93 as=0.18525 ps=1.87 w=0.65 l=0.15 M=2
X4 a_715_47# A1 a_86_235# VNB sky130_fd_pr__nfet_01v8 ad=0.12675 pd=1.04 as=0.108875 ps=0.985 w=0.65 l=0.15
X5 VGND A2 a_715_47# VNB sky130_fd_pr__nfet_01v8 ad=0.221 pd=1.98 as=0.12675 ps=1.04 w=0.65 l=0.15
X6 a_499_297# C1 a_427_297# VPB sky130_fd_pr__pfet_01v8_hvt ad=0.195 pd=1.39 as=0.105 ps=1.21 w=1 l=0.15
X7 a_86_235# B1 VGND VNB sky130_fd_pr__nfet_01v8 ad=0.108875 pd=0.985 as=0.121875 ps=1.025 w=0.65 l=0.15
X8 a_607_297# B1 a_499_297# VPB sky130_fd_pr__pfet_01v8_hvt ad=0.195 pd=1.39 as=0.195 ps=1.39 w=1 l=0.15
X9 a_427_297# D1 a_86_235# VPB sky130_fd_pr__pfet_01v8_hvt ad=0.105 pd=1.21 as=0.41 ps=2.82 w=1 l=0.15
X10 VPWR A1 a_607_297# VPB sky130_fd_pr__pfet_01v8_hvt ad=0.195 pd=1.39 as=0.195 ps=1.39 w=1 l=0.15
X11 a_607_297# A2 VPWR VPB sky130_fd_pr__pfet_01v8_hvt ad=0.265 pd=2.53 as=0.195 ps=1.39 w=1 l=0.15
.ends

.subckt SS_sky130_fd_sc_hd__dlygate4sd3_1 X A VPB VNB VGND VPWR
X0 VPWR A a_49_47# VPB sky130_fd_pr__pfet_01v8_hvt ad=0.0567 pd=0.69 as=0.1092 ps=1.36 w=0.42 l=0.15
X1 VGND a_285_47# a_391_47# VNB sky130_fd_pr__nfet_01v8 ad=0.097 pd=0.975 as=0.1092 ps=1.36 w=0.42 l=0.5
X2 X a_391_47# VPWR VPB sky130_fd_pr__pfet_01v8_hvt ad=0.26 pd=2.52 as=0.14075 ps=1.325 w=1 l=0.15
X3 VGND A a_49_47# VNB sky130_fd_pr__nfet_01v8 ad=0.0567 pd=0.69 as=0.1092 ps=1.36 w=0.42 l=0.15
X4 VPWR a_285_47# a_391_47# VPB sky130_fd_pr__pfet_01v8_hvt ad=0.14075 pd=1.325 as=0.1092 ps=1.36 w=0.42 l=0.5
X5 a_285_47# a_49_47# VGND VNB sky130_fd_pr__nfet_01v8 ad=0.1092 pd=1.36 as=0.0567 ps=0.69 w=0.42 l=0.5
X6 a_285_47# a_49_47# VPWR VPB sky130_fd_pr__pfet_01v8_hvt ad=0.1092 pd=1.36 as=0.0567 ps=0.69 w=0.42 l=0.5
X7 X a_391_47# VGND VNB sky130_fd_pr__nfet_01v8 ad=0.169 pd=1.82 as=0.097 ps=0.975 w=0.65 l=0.15
.ends

.subckt SS_sky130_fd_sc_hd__clkbuf_8 X A VPB VNB VGND VPWR
X0 VPWR A a_110_47# VPB sky130_fd_pr__pfet_01v8_hvt ad=0.14 pd=1.28 as=0.14 ps=1.28 w=1 l=0.15 M=2
X1 VPWR a_110_47# X VPB sky130_fd_pr__pfet_01v8_hvt ad=0.14 pd=1.28 as=0.14 ps=1.28 w=1 l=0.15 M=8
X2 X a_110_47# VGND VNB sky130_fd_pr__nfet_01v8 ad=0.0588 pd=0.7 as=0.0588 ps=0.7 w=0.42 l=0.15 M=8
X3 VGND A a_110_47# VNB sky130_fd_pr__nfet_01v8 ad=0.0588 pd=0.7 as=0.0588 ps=0.7 w=0.42 l=0.15 M=2
.ends

.subckt SS_sky130_fd_sc_hd__diode_2 DIODE VGND VPWR VPB VNB
X0 VNB DIODE sky130_fd_pr__diode_pw2nd_05v5 perim=2.64e+06 area=4.347e+11
.ends

.subckt SS_sky130_fd_sc_hd__a221o_2 VPWR VGND VPB VNB C1 B2 B1 A1 A2 X
X0 VPWR a_27_47# X VPB sky130_fd_pr__pfet_01v8_hvt ad=0.285 pd=2.57 as=0.135 ps=1.27 w=1 l=0.15 M=2
X1 a_465_47# A1 a_27_47# VNB sky130_fd_pr__nfet_01v8 ad=0.10725 pd=0.98 as=0.169 ps=1.82 w=0.65 l=0.15
X2 a_109_297# B1 a_193_297# VPB sky130_fd_pr__pfet_01v8_hvt ad=0.26 pd=2.52 as=0.135 ps=1.27 w=1 l=0.15
X3 a_193_297# B2 a_109_297# VPB sky130_fd_pr__pfet_01v8_hvt ad=0.135 pd=1.27 as=0.135 ps=1.27 w=1 l=0.15
X4 X a_27_47# VGND VNB sky130_fd_pr__nfet_01v8 ad=0.08775 pd=0.92 as=0.102375 ps=0.965 w=0.65 l=0.15 M=2
X5 a_205_47# B2 VGND VNB sky130_fd_pr__nfet_01v8 ad=0.06825 pd=0.86 as=0.10725 ps=0.98 w=0.65 l=0.15
X6 VPWR A2 a_193_297# VPB sky130_fd_pr__pfet_01v8_hvt ad=0.1575 pd=1.315 as=0.165 ps=1.33 w=1 l=0.15
X7 a_193_297# A1 VPWR VPB sky130_fd_pr__pfet_01v8_hvt ad=0.165 pd=1.33 as=0.26 ps=2.52 w=1 l=0.15
X8 a_27_47# B1 a_205_47# VNB sky130_fd_pr__nfet_01v8 ad=0.169 pd=1.82 as=0.06825 ps=0.86 w=0.65 l=0.15
X9 a_109_297# C1 a_27_47# VPB sky130_fd_pr__pfet_01v8_hvt ad=0.135 pd=1.27 as=0.26 ps=2.52 w=1 l=0.15
X10 VGND C1 a_27_47# VNB sky130_fd_pr__nfet_01v8 ad=0.10725 pd=0.98 as=0.169 ps=1.82 w=0.65 l=0.15
X11 VGND A2 a_465_47# VNB sky130_fd_pr__nfet_01v8 ad=0.102375 pd=0.965 as=0.10725 ps=0.98 w=0.65 l=0.15
.ends

.subckt SS_sky130_fd_sc_hd__or4_2 VPWR VGND VPB VNB B D C A X
X0 a_27_297# B VGND VNB sky130_fd_pr__nfet_01v8 ad=0.0567 pd=0.69 as=0.0567 ps=0.69 w=0.42 l=0.15
X1 a_27_297# D VGND VNB sky130_fd_pr__nfet_01v8 ad=0.0693 pd=0.75 as=0.1092 ps=1.36 w=0.42 l=0.15
X2 a_277_297# B a_205_297# VPB sky130_fd_pr__pfet_01v8_hvt ad=0.0693 pd=0.75 as=0.0441 ps=0.63 w=0.42 l=0.15
X3 VPWR A a_277_297# VPB sky130_fd_pr__pfet_01v8_hvt ad=0.14825 pd=1.34 as=0.0693 ps=0.75 w=0.42 l=0.15
X4 X a_27_297# VGND VNB sky130_fd_pr__nfet_01v8 ad=0.08775 pd=0.92 as=0.101875 ps=0.99 w=0.65 l=0.15 M=2
X5 a_205_297# C a_109_297# VPB sky130_fd_pr__pfet_01v8_hvt ad=0.0441 pd=0.63 as=0.0693 ps=0.75 w=0.42 l=0.15
X6 VPWR a_27_297# X VPB sky130_fd_pr__pfet_01v8_hvt ad=0.305 pd=2.61 as=0.135 ps=1.27 w=1 l=0.15 M=2
X7 VGND C a_27_297# VNB sky130_fd_pr__nfet_01v8 ad=0.0567 pd=0.69 as=0.0693 ps=0.75 w=0.42 l=0.15
X8 a_109_297# D a_27_297# VPB sky130_fd_pr__pfet_01v8_hvt ad=0.0693 pd=0.75 as=0.1092 ps=1.36 w=0.42 l=0.15
X9 VGND A a_27_297# VNB sky130_fd_pr__nfet_01v8 ad=0.101875 pd=0.99 as=0.0567 ps=0.69 w=0.42 l=0.15
.ends

.subckt SS_sky130_fd_sc_hd__or4bb_2 VPWR VGND VPB VNB B A C_N D_N X
X0 a_398_413# a_206_93# a_316_413# VPB sky130_fd_pr__pfet_01v8_hvt ad=0.1215 pd=1.33 as=0.1092 ps=1.36 w=0.42 l=0.15
X1 VPWR a_316_413# X VPB sky130_fd_pr__pfet_01v8_hvt ad=0.285 pd=2.57 as=0.135 ps=1.27 w=1 l=0.15 M=2
X2 X a_316_413# VGND VNB sky130_fd_pr__nfet_01v8 ad=0.08775 pd=0.92 as=0.101875 ps=0.99 w=0.65 l=0.15 M=2
X3 VGND C_N a_27_410# VNB sky130_fd_pr__nfet_01v8 ad=0.06195 pd=0.715 as=0.1092 ps=1.36 w=0.42 l=0.15
X4 VPWR C_N a_27_410# VPB sky130_fd_pr__pfet_01v8_hvt ad=0.1226 pd=1.32 as=0.1092 ps=1.36 w=0.42 l=0.15
X5 VGND a_27_410# a_316_413# VNB sky130_fd_pr__nfet_01v8 ad=0.0567 pd=0.69 as=0.06405 ps=0.725 w=0.42 l=0.15
X6 VGND A a_316_413# VNB sky130_fd_pr__nfet_01v8 ad=0.101875 pd=0.99 as=0.0567 ps=0.69 w=0.42 l=0.15
X7 a_566_297# B a_494_297# VPB sky130_fd_pr__pfet_01v8_hvt ad=0.05985 pd=0.705 as=0.0441 ps=0.63 w=0.42 l=0.15
X8 a_206_93# D_N VGND VNB sky130_fd_pr__nfet_01v8 ad=0.1092 pd=1.36 as=0.06195 ps=0.715 w=0.42 l=0.15
X9 a_316_413# B VGND VNB sky130_fd_pr__nfet_01v8 ad=0.0567 pd=0.69 as=0.0567 ps=0.69 w=0.42 l=0.15
X10 a_206_93# D_N VPWR VPB sky130_fd_pr__pfet_01v8_hvt ad=0.1176 pd=1.4 as=0.1226 ps=1.32 w=0.42 l=0.15
X11 a_494_297# a_27_410# a_398_413# VPB sky130_fd_pr__pfet_01v8_hvt ad=0.0441 pd=0.63 as=0.1215 ps=1.33 w=0.42 l=0.15
X12 a_316_413# a_206_93# VGND VNB sky130_fd_pr__nfet_01v8 ad=0.06405 pd=0.725 as=0.1092 ps=1.36 w=0.42 l=0.15
X13 VPWR A a_566_297# VPB sky130_fd_pr__pfet_01v8_hvt ad=0.14825 pd=1.34 as=0.05985 ps=0.705 w=0.42 l=0.15
.ends

.subckt SS_sky130_fd_sc_hd__buf_6 VPWR VGND X A VPB VNB
X0 VPWR a_161_47# X VPB sky130_fd_pr__pfet_01v8_hvt ad=0.26 pd=2.52 as=0.135 ps=1.27 w=1 l=0.15 M=6
X1 a_161_47# A VGND VNB sky130_fd_pr__nfet_01v8 ad=0.08775 pd=0.92 as=0.169 ps=1.82 w=0.65 l=0.15 M=2
X2 VGND a_161_47# X VNB sky130_fd_pr__nfet_01v8 ad=0.08775 pd=0.92 as=0.08775 ps=0.92 w=0.65 l=0.15 M=6
X3 VPWR A a_161_47# VPB sky130_fd_pr__pfet_01v8_hvt ad=0.135 pd=1.27 as=0.135 ps=1.27 w=1 l=0.15 M=2
.ends

.subckt SS_sky130_fd_sc_hd__and4bb_2 VNB VPB VGND VPWR A_N X C D B_N
X0 a_174_21# C VPWR VPB sky130_fd_pr__pfet_01v8_hvt ad=0.0567 pd=0.69 as=0.0588 ps=0.7 w=0.42 l=0.15
X1 a_174_21# a_27_47# VPWR VPB sky130_fd_pr__pfet_01v8_hvt ad=0.0672 pd=0.74 as=0.33075 ps=1.705 w=0.42 l=0.15
X2 a_476_47# a_27_47# a_174_21# VNB sky130_fd_pr__nfet_01v8 ad=0.0441 pd=0.63 as=0.1092 ps=1.36 w=0.42 l=0.15
X3 VPWR a_174_21# X VPB sky130_fd_pr__pfet_01v8_hvt ad=0.33075 pd=1.705 as=0.135 ps=1.27 w=1 l=0.15 M=2
X4 a_548_47# a_505_280# a_476_47# VNB sky130_fd_pr__nfet_01v8 ad=0.06405 pd=0.725 as=0.0441 ps=0.63 w=0.42 l=0.15
X5 VPWR A_N a_27_47# VPB sky130_fd_pr__pfet_01v8_hvt ad=0.14075 pd=1.325 as=0.1092 ps=1.36 w=0.42 l=0.15
X6 X a_174_21# VGND VNB sky130_fd_pr__nfet_01v8 ad=0.08775 pd=0.92 as=0.097 ps=0.975 w=0.65 l=0.15 M=2
X7 VPWR D a_174_21# VPB sky130_fd_pr__pfet_01v8_hvt ad=0.0924 pd=0.86 as=0.0567 ps=0.69 w=0.42 l=0.15
X8 VGND D a_639_47# VNB sky130_fd_pr__nfet_01v8 ad=0.0924 pd=0.86 as=0.0567 ps=0.69 w=0.42 l=0.15
X9 VPWR a_505_280# a_174_21# VPB sky130_fd_pr__pfet_01v8_hvt ad=0.0588 pd=0.7 as=0.0672 ps=0.74 w=0.42 l=0.15
X10 a_505_280# B_N VPWR VPB sky130_fd_pr__pfet_01v8_hvt ad=0.1092 pd=1.36 as=0.0924 ps=0.86 w=0.42 l=0.15
X11 a_505_280# B_N VGND VNB sky130_fd_pr__nfet_01v8 ad=0.1092 pd=1.36 as=0.0924 ps=0.86 w=0.42 l=0.15
X12 a_639_47# C a_548_47# VNB sky130_fd_pr__nfet_01v8 ad=0.0567 pd=0.69 as=0.06405 ps=0.725 w=0.42 l=0.15
X13 VGND A_N a_27_47# VNB sky130_fd_pr__nfet_01v8 ad=0.097 pd=0.975 as=0.1092 ps=1.36 w=0.42 l=0.15
.ends

.subckt SS_sky130_fd_sc_hd__and2_2 VPWR VGND A X B VPB VNB
X0 X a_61_75# VPWR VPB sky130_fd_pr__pfet_01v8_hvt ad=0.195 pd=1.39 as=0.16655 ps=1.39 w=1 l=0.15 M=2
X1 VPWR B a_61_75# VPB sky130_fd_pr__pfet_01v8_hvt ad=0.16655 pd=1.39 as=0.0567 ps=0.69 w=0.42 l=0.15
X2 VGND B a_147_75# VNB sky130_fd_pr__nfet_01v8 ad=0.1118 pd=1.04 as=0.0567 ps=0.69 w=0.42 l=0.15
X3 X a_61_75# VGND VNB sky130_fd_pr__nfet_01v8 ad=0.12675 pd=1.04 as=0.1118 ps=1.04 w=0.65 l=0.15 M=2
X4 a_61_75# A VPWR VPB sky130_fd_pr__pfet_01v8_hvt ad=0.0567 pd=0.69 as=0.1176 ps=1.4 w=0.42 l=0.15
X5 a_147_75# A a_61_75# VNB sky130_fd_pr__nfet_01v8 ad=0.0567 pd=0.69 as=0.1176 ps=1.4 w=0.42 l=0.15
.ends

.subckt SS_sky130_fd_sc_hd__or3_2 VGND VPWR VPB VNB B C A X
X0 VPWR a_30_53# X VPB sky130_fd_pr__pfet_01v8_hvt ad=0.315 pd=2.63 as=0.135 ps=1.27 w=1 l=0.15 M=2
X1 VGND a_30_53# X VNB sky130_fd_pr__nfet_01v8 ad=0.18525 pd=1.87 as=0.08775 ps=0.92 w=0.65 l=0.15 M=2
X2 a_112_297# C a_30_53# VPB sky130_fd_pr__pfet_01v8_hvt ad=0.0441 pd=0.63 as=0.1092 ps=1.36 w=0.42 l=0.15
X3 VGND A a_30_53# VNB sky130_fd_pr__nfet_01v8 ad=0.101875 pd=0.99 as=0.0567 ps=0.69 w=0.42 l=0.15
X4 a_30_53# B VGND VNB sky130_fd_pr__nfet_01v8 ad=0.0567 pd=0.69 as=0.0567 ps=0.69 w=0.42 l=0.15
X5 VGND C a_30_53# VNB sky130_fd_pr__nfet_01v8 ad=0.0567 pd=0.69 as=0.1092 ps=1.36 w=0.42 l=0.15
X6 a_184_297# B a_112_297# VPB sky130_fd_pr__pfet_01v8_hvt ad=0.0693 pd=0.75 as=0.0441 ps=0.63 w=0.42 l=0.15
X7 VPWR A a_184_297# VPB sky130_fd_pr__pfet_01v8_hvt ad=0.14825 pd=1.34 as=0.0693 ps=0.75 w=0.42 l=0.15
.ends

.subckt SS_sky130_fd_sc_hd__inv_6 VPB VNB VPWR VGND Y A
X0 VPWR A Y VPB sky130_fd_pr__pfet_01v8_hvt ad=0.27 pd=2.54 as=0.135 ps=1.27 w=1 l=0.15 M=6
X1 Y A VGND VNB sky130_fd_pr__nfet_01v8 ad=0.08775 pd=0.92 as=0.08775 ps=0.92 w=0.65 l=0.15 M=6
.ends

.subckt SS_sky130_fd_sc_hd__and4b_2 VPWR VGND VNB VPB A_N B C D X
X0 VPWR a_193_413# X VPB sky130_fd_pr__pfet_01v8_hvt ad=0.26 pd=2.52 as=0.1525 ps=1.305 w=1 l=0.15 M=2
X1 a_297_47# a_27_413# a_193_413# VNB sky130_fd_pr__nfet_01v8 ad=0.0441 pd=0.63 as=0.1092 ps=1.36 w=0.42 l=0.15
X2 a_369_47# B a_297_47# VNB sky130_fd_pr__nfet_01v8 ad=0.0735 pd=0.77 as=0.0441 ps=0.63 w=0.42 l=0.15
X3 X a_193_413# VGND VNB sky130_fd_pr__nfet_01v8 ad=0.099125 pd=0.955 as=0.103975 ps=1 w=0.65 l=0.15 M=2
X4 VPWR D a_193_413# VPB sky130_fd_pr__pfet_01v8_hvt ad=0.14325 pd=1.33 as=0.06615 ps=0.735 w=0.42 l=0.15
X5 VPWR A_N a_27_413# VPB sky130_fd_pr__pfet_01v8_hvt ad=0.0567 pd=0.69 as=0.1092 ps=1.36 w=0.42 l=0.15
X6 VGND D a_469_47# VNB sky130_fd_pr__nfet_01v8 ad=0.103975 pd=1 as=0.06195 ps=0.715 w=0.42 l=0.15
X7 VPWR B a_193_413# VPB sky130_fd_pr__pfet_01v8_hvt ad=0.1281 pd=1.03 as=0.0987 ps=0.89 w=0.42 l=0.15
X8 a_193_413# C VPWR VPB sky130_fd_pr__pfet_01v8_hvt ad=0.06615 pd=0.735 as=0.1281 ps=1.03 w=0.42 l=0.15
X9 a_193_413# a_27_413# VPWR VPB sky130_fd_pr__pfet_01v8_hvt ad=0.0987 pd=0.89 as=0.0567 ps=0.69 w=0.42 l=0.15
X10 a_469_47# C a_369_47# VNB sky130_fd_pr__nfet_01v8 ad=0.06195 pd=0.715 as=0.0735 ps=0.77 w=0.42 l=0.15
X11 a_27_413# A_N VGND VNB sky130_fd_pr__nfet_01v8 ad=0.1092 pd=1.36 as=0.1092 ps=1.36 w=0.42 l=0.15
.ends

.subckt SS_sky130_fd_sc_hd__clkbuf_4 VGND VPWR A X VPB VNB
X0 VPWR A a_27_47# VPB sky130_fd_pr__pfet_01v8_hvt ad=0.165 pd=1.33 as=0.265 ps=2.53 w=1 l=0.15
X1 VGND a_27_47# X VNB sky130_fd_pr__nfet_01v8 ad=0.1218 pd=1.42 as=0.0588 ps=0.7 w=0.42 l=0.15 M=4
X2 X a_27_47# VPWR VPB sky130_fd_pr__pfet_01v8_hvt ad=0.14 pd=1.28 as=0.14 ps=1.28 w=1 l=0.15 M=4
X3 VGND A a_27_47# VNB sky130_fd_pr__nfet_01v8 ad=0.07035 pd=0.755 as=0.1113 ps=1.37 w=0.42 l=0.15
.ends

.subckt SS_sky130_fd_sc_hd__a21o_2 VNB VPB VGND VPWR A2 A1 B1 X
X0 VPWR a_80_199# X VPB sky130_fd_pr__pfet_01v8_hvt ad=0.265 pd=2.53 as=0.14 ps=1.28 w=1 l=0.15 M=2
X1 VGND a_80_199# X VNB sky130_fd_pr__nfet_01v8 ad=0.1105 pd=0.99 as=0.091 ps=0.93 w=0.65 l=0.15 M=2
X2 a_386_297# A2 VPWR VPB sky130_fd_pr__pfet_01v8_hvt ad=0.26 pd=2.52 as=0.1575 ps=1.315 w=1 l=0.15
X3 a_80_199# B1 VGND VNB sky130_fd_pr__nfet_01v8 ad=0.1625 pd=1.15 as=0.1105 ps=0.99 w=0.65 l=0.15
X4 a_386_297# B1 a_80_199# VPB sky130_fd_pr__pfet_01v8_hvt ad=0.14 pd=1.28 as=0.265 ps=2.53 w=1 l=0.15
X5 a_458_47# A1 a_80_199# VNB sky130_fd_pr__nfet_01v8 ad=0.1235 pd=1.03 as=0.1625 ps=1.15 w=0.65 l=0.15
X6 VPWR A1 a_386_297# VPB sky130_fd_pr__pfet_01v8_hvt ad=0.1575 pd=1.315 as=0.14 ps=1.28 w=1 l=0.15
X7 VGND A2 a_458_47# VNB sky130_fd_pr__nfet_01v8 ad=0.17225 pd=1.83 as=0.1235 ps=1.03 w=0.65 l=0.15
.ends

.subckt SS_sky130_fd_sc_hd__clkinv_2 VNB VPB VPWR VGND A Y
X0 Y A VGND VNB sky130_fd_pr__nfet_01v8 ad=0.0588 pd=0.7 as=0.1113 ps=1.37 w=0.42 l=0.15 M=2
X1 Y A VPWR VPB sky130_fd_pr__pfet_01v8_hvt ad=0.14 pd=1.28 as=0.14 ps=1.28 w=1 l=0.15 M=3
.ends

.subckt SS_sky130_fd_sc_hd__clkbuf_2 VGND VPWR A X VPB VNB
X0 VPWR A a_27_47# VPB sky130_fd_pr__pfet_01v8_hvt ad=0.1625 pd=1.325 as=0.265 ps=2.53 w=1 l=0.15
X1 VPWR a_27_47# X VPB sky130_fd_pr__pfet_01v8_hvt ad=0.26 pd=2.52 as=0.135 ps=1.27 w=1 l=0.15 M=2
X2 VGND A a_27_47# VNB sky130_fd_pr__nfet_01v8 ad=0.06825 pd=0.745 as=0.1113 ps=1.37 w=0.42 l=0.15
X3 X a_27_47# VGND VNB sky130_fd_pr__nfet_01v8 ad=0.0567 pd=0.69 as=0.06825 ps=0.745 w=0.42 l=0.15 M=2
.ends

.subckt SS_sky130_fd_sc_hd__buf_1 VGND VPWR X A VPB VNB
X0 VPWR A a_27_47# VPB sky130_fd_pr__pfet_01v8_hvt ad=0.11455 pd=1.08 as=0.2054 ps=2.1 w=0.79 l=0.15
X1 X a_27_47# VGND VNB sky130_fd_pr__nfet_01v8 ad=0.1352 pd=1.56 as=0.0754 ps=0.81 w=0.52 l=0.15
X2 X a_27_47# VPWR VPB sky130_fd_pr__pfet_01v8_hvt ad=0.2054 pd=2.1 as=0.11455 ps=1.08 w=0.79 l=0.15
X3 VGND A a_27_47# VNB sky130_fd_pr__nfet_01v8 ad=0.0754 pd=0.81 as=0.1352 ps=1.56 w=0.52 l=0.15
.ends

.subckt SS_sky130_fd_sc_hd__a211o_2 VNB VPB VGND VPWR X A2 A1 B1 C1
X0 a_79_21# A1 a_348_47# VNB sky130_fd_pr__nfet_01v8 ad=0.115375 pd=1.005 as=0.13325 ps=1.06 w=0.65 l=0.15
X1 a_79_21# C1 VGND VNB sky130_fd_pr__nfet_01v8 ad=0.169 pd=1.82 as=0.10725 ps=0.98 w=0.65 l=0.15
X2 VGND a_79_21# X VNB sky130_fd_pr__nfet_01v8 ad=0.199875 pd=1.265 as=0.091 ps=0.93 w=0.65 l=0.15 M=2
X3 VPWR a_79_21# X VPB sky130_fd_pr__pfet_01v8_hvt ad=0.26 pd=2.52 as=0.135 ps=1.27 w=1 l=0.15 M=2
X4 a_79_21# C1 a_585_297# VPB sky130_fd_pr__pfet_01v8_hvt ad=0.26 pd=2.52 as=0.105 ps=1.21 w=1 l=0.15
X5 VPWR A2 a_299_297# VPB sky130_fd_pr__pfet_01v8_hvt ad=0.195 pd=1.39 as=0.26 ps=2.52 w=1 l=0.15
X6 a_299_297# A1 VPWR VPB sky130_fd_pr__pfet_01v8_hvt ad=0.165 pd=1.33 as=0.195 ps=1.39 w=1 l=0.15
X7 a_585_297# B1 a_299_297# VPB sky130_fd_pr__pfet_01v8_hvt ad=0.105 pd=1.21 as=0.165 ps=1.33 w=1 l=0.15
X8 a_348_47# A2 VGND VNB sky130_fd_pr__nfet_01v8 ad=0.13325 pd=1.06 as=0.199875 ps=1.265 w=0.65 l=0.15
X9 VGND B1 a_79_21# VNB sky130_fd_pr__nfet_01v8 ad=0.10725 pd=0.98 as=0.115375 ps=1.005 w=0.65 l=0.15
.ends

.subckt SS_sky130_fd_sc_hd__nor4b_4 VPB VNB VGND VPWR B D_N A C Y
X0 VGND B Y VNB sky130_fd_pr__nfet_01v8 ad=0.08775 pd=0.92 as=0.08775 ps=0.92 w=0.65 l=0.15 M=4
X1 VGND D_N a_1191_21# VNB sky130_fd_pr__nfet_01v8 ad=0.182 pd=1.86 as=0.169 ps=1.82 w=0.65 l=0.15
X2 a_803_297# a_1191_21# Y VPB sky130_fd_pr__pfet_01v8_hvt ad=0.26 pd=2.52 as=0.135 ps=1.27 w=1 l=0.15 M=4
X3 a_445_297# B a_27_297# VPB sky130_fd_pr__pfet_01v8_hvt ad=0.135 pd=1.27 as=0.135 ps=1.27 w=1 l=0.15 M=4
X4 a_27_297# A VPWR VPB sky130_fd_pr__pfet_01v8_hvt ad=0.135 pd=1.27 as=0.135 ps=1.27 w=1 l=0.15 M=4
X5 Y C VGND VNB sky130_fd_pr__nfet_01v8 ad=0.08775 pd=0.92 as=0.08775 ps=0.92 w=0.65 l=0.15 M=4
X6 Y a_1191_21# VGND VNB sky130_fd_pr__nfet_01v8 ad=0.08775 pd=0.92 as=0.08775 ps=0.92 w=0.65 l=0.15 M=4
X7 VPWR D_N a_1191_21# VPB sky130_fd_pr__pfet_01v8_hvt ad=0.28 pd=2.56 as=0.26 ps=2.52 w=1 l=0.15
X8 VGND A Y VNB sky130_fd_pr__nfet_01v8 ad=0.08775 pd=0.92 as=0.08775 ps=0.92 w=0.65 l=0.15 M=4
X9 a_803_297# C a_445_297# VPB sky130_fd_pr__pfet_01v8_hvt ad=0.135 pd=1.27 as=0.135 ps=1.27 w=1 l=0.15 M=4
.ends

.subckt SS_sky130_fd_sc_hd__clkbuf_16 VNB VPB VGND VPWR A X
X0 VPWR A a_110_47# VPB sky130_fd_pr__pfet_01v8_hvt ad=0.14 pd=1.28 as=0.14 ps=1.28 w=1 l=0.15 M=4
X1 VPWR a_110_47# X VPB sky130_fd_pr__pfet_01v8_hvt ad=0.14 pd=1.28 as=0.14 ps=1.28 w=1 l=0.15 M=16
X2 a_110_47# A VGND VNB sky130_fd_pr__nfet_01v8 ad=0.0588 pd=0.7 as=0.0588 ps=0.7 w=0.42 l=0.15 M=4
X3 VGND a_110_47# X VNB sky130_fd_pr__nfet_01v8 ad=0.0588 pd=0.7 as=0.0588 ps=0.7 w=0.42 l=0.15 M=16
.ends

.subckt SS_sky130_fd_sc_hd__nor4b_2 VNB VPB VGND VPWR A B C Y D_N
X0 VPWR D_N a_694_21# VPB sky130_fd_pr__pfet_01v8_hvt ad=0.1092 pd=1.36 as=0.1092 ps=1.36 w=0.42 l=0.15
X1 a_27_297# B a_277_297# VPB sky130_fd_pr__pfet_01v8_hvt ad=0.26 pd=2.52 as=0.135 ps=1.27 w=1 l=0.15 M=2
X2 a_474_297# a_694_21# Y VPB sky130_fd_pr__pfet_01v8_hvt ad=0.26 pd=2.52 as=0.135 ps=1.27 w=1 l=0.15 M=2
X3 VGND C Y VNB sky130_fd_pr__nfet_01v8 ad=0.08775 pd=0.92 as=0.08775 ps=0.92 w=0.65 l=0.15 M=2
X4 VGND D_N a_694_21# VNB sky130_fd_pr__nfet_01v8 ad=0.1092 pd=1.36 as=0.1092 ps=1.36 w=0.42 l=0.15
X5 a_27_297# A VPWR VPB sky130_fd_pr__pfet_01v8_hvt ad=0.135 pd=1.27 as=0.135 ps=1.27 w=1 l=0.15 M=2
X6 VGND A Y VNB sky130_fd_pr__nfet_01v8 ad=0.08775 pd=0.92 as=0.08775 ps=0.92 w=0.65 l=0.15 M=2
X7 VGND B Y VNB sky130_fd_pr__nfet_01v8 ad=0.169 pd=1.82 as=0.08775 ps=0.92 w=0.65 l=0.15 M=2
X8 a_474_297# C a_277_297# VPB sky130_fd_pr__pfet_01v8_hvt ad=0.135 pd=1.27 as=0.135 ps=1.27 w=1 l=0.15 M=2
X9 Y a_694_21# VGND VNB sky130_fd_pr__nfet_01v8 ad=0.08775 pd=0.92 as=0.08775 ps=0.92 w=0.65 l=0.15 M=2
.ends

.subckt SS_sky130_fd_sc_hd__inv_2 VPB VNB VPWR VGND Y A
X0 Y A VPWR VPB sky130_fd_pr__pfet_01v8_hvt ad=0.135 pd=1.27 as=0.26 ps=2.52 w=1 l=0.15 M=2
X1 VGND A Y VNB sky130_fd_pr__nfet_01v8 ad=0.169 pd=1.82 as=0.08775 ps=0.92 w=0.65 l=0.15 M=2
.ends

.subckt afe_wb adc_data[0] adc_data[10] adc_data[11] adc_data[1] adc_data[2] adc_data[3]
+ adc_data[4] adc_data[5] adc_data[6] adc_data[7] adc_data[8] adc_data[9] adc_eof
+ analog_ctrl[0] analog_ctrl[100] analog_ctrl[101] analog_ctrl[102] analog_ctrl[103]
+ analog_ctrl[104] analog_ctrl[105] analog_ctrl[106] analog_ctrl[107] analog_ctrl[108]
+ analog_ctrl[109] analog_ctrl[10] analog_ctrl[110] analog_ctrl[111] analog_ctrl[112]
+ analog_ctrl[113] analog_ctrl[114] analog_ctrl[115] analog_ctrl[116] analog_ctrl[117]
+ analog_ctrl[118] analog_ctrl[119] analog_ctrl[11] analog_ctrl[120] analog_ctrl[121]
+ analog_ctrl[122] analog_ctrl[12] analog_ctrl[13] analog_ctrl[14] analog_ctrl[15]
+ analog_ctrl[16] analog_ctrl[17] analog_ctrl[18] analog_ctrl[19] analog_ctrl[1] analog_ctrl[20]
+ analog_ctrl[21] analog_ctrl[22] analog_ctrl[23] analog_ctrl[24] analog_ctrl[25]
+ analog_ctrl[26] analog_ctrl[27] analog_ctrl[28] analog_ctrl[29] analog_ctrl[2] analog_ctrl[30]
+ analog_ctrl[31] analog_ctrl[32] analog_ctrl[33] analog_ctrl[34] analog_ctrl[35]
+ analog_ctrl[36] analog_ctrl[37] analog_ctrl[38] analog_ctrl[39] analog_ctrl[3] analog_ctrl[40]
+ analog_ctrl[41] analog_ctrl[42] analog_ctrl[43] analog_ctrl[44] analog_ctrl[45]
+ analog_ctrl[46] analog_ctrl[47] analog_ctrl[48] analog_ctrl[49] analog_ctrl[4] analog_ctrl[50]
+ analog_ctrl[51] analog_ctrl[52] analog_ctrl[53] analog_ctrl[54] analog_ctrl[55]
+ analog_ctrl[56] analog_ctrl[57] analog_ctrl[58] analog_ctrl[59] analog_ctrl[5] analog_ctrl[60]
+ analog_ctrl[61] analog_ctrl[62] analog_ctrl[63] analog_ctrl[64] analog_ctrl[65]
+ analog_ctrl[66] analog_ctrl[67] analog_ctrl[68] analog_ctrl[69] analog_ctrl[6] analog_ctrl[70]
+ analog_ctrl[71] analog_ctrl[72] analog_ctrl[73] analog_ctrl[74] analog_ctrl[75]
+ analog_ctrl[76] analog_ctrl[77] analog_ctrl[78] analog_ctrl[79] analog_ctrl[7] analog_ctrl[80]
+ analog_ctrl[81] analog_ctrl[82] analog_ctrl[83] analog_ctrl[84] analog_ctrl[85]
+ analog_ctrl[86] analog_ctrl[87] analog_ctrl[88] analog_ctrl[89] analog_ctrl[8] analog_ctrl[90]
+ analog_ctrl[91] analog_ctrl[92] analog_ctrl[93] analog_ctrl[94] analog_ctrl[95]
+ analog_ctrl[96] analog_ctrl[97] analog_ctrl[98] analog_ctrl[99] analog_ctrl[9] analog_io_oeb[0]
+ analog_io_oeb[10] analog_io_oeb[11] analog_io_oeb[12] analog_io_oeb[13] analog_io_oeb[14]
+ analog_io_oeb[15] analog_io_oeb[16] analog_io_oeb[17] analog_io_oeb[18] analog_io_oeb[19]
+ analog_io_oeb[1] analog_io_oeb[20] analog_io_oeb[21] analog_io_oeb[22] analog_io_oeb[23]
+ analog_io_oeb[24] analog_io_oeb[25] analog_io_oeb[26] analog_io_oeb[27] analog_io_oeb[2]
+ analog_io_oeb[3] analog_io_oeb[4] analog_io_oeb[5] analog_io_oeb[6] analog_io_oeb[7]
+ analog_io_oeb[8] analog_io_oeb[9] analog_io_out[0] analog_io_out[10] analog_io_out[11]
+ analog_io_out[12] analog_io_out[13] analog_io_out[14] analog_io_out[15] analog_io_out[16]
+ analog_io_out[17] analog_io_out[18] analog_io_out[19] analog_io_out[1] analog_io_out[20]
+ analog_io_out[21] analog_io_out[22] analog_io_out[23] analog_io_out[24] analog_io_out[25]
+ analog_io_out[26] analog_io_out[27] analog_io_out[2] analog_io_out[3] analog_io_out[4]
+ analog_io_out[5] analog_io_out[6] analog_io_out[7] analog_io_out[8] analog_io_out[9]
+ wb_clk_i wb_rst_i wbs_ack_o wbs_adr_i[0] wbs_adr_i[10] wbs_adr_i[11] wbs_adr_i[12]
+ wbs_adr_i[13] wbs_adr_i[14] wbs_adr_i[15] wbs_adr_i[16] wbs_adr_i[17] wbs_adr_i[18]
+ wbs_adr_i[19] wbs_adr_i[1] wbs_adr_i[20] wbs_adr_i[21] wbs_adr_i[22] wbs_adr_i[23]
+ wbs_adr_i[24] wbs_adr_i[25] wbs_adr_i[26] wbs_adr_i[27] wbs_adr_i[28] wbs_adr_i[29]
+ wbs_adr_i[2] wbs_adr_i[30] wbs_adr_i[31] wbs_adr_i[3] wbs_adr_i[4] wbs_adr_i[5]
+ wbs_adr_i[6] wbs_adr_i[7] wbs_adr_i[8] wbs_adr_i[9] wbs_cyc_i wbs_dat_i[0] wbs_dat_i[10]
+ wbs_dat_i[11] wbs_dat_i[12] wbs_dat_i[13] wbs_dat_i[14] wbs_dat_i[15] wbs_dat_i[16]
+ wbs_dat_i[17] wbs_dat_i[18] wbs_dat_i[19] wbs_dat_i[1] wbs_dat_i[20] wbs_dat_i[21]
+ wbs_dat_i[22] wbs_dat_i[23] wbs_dat_i[24] wbs_dat_i[25] wbs_dat_i[26] wbs_dat_i[27]
+ wbs_dat_i[28] wbs_dat_i[29] wbs_dat_i[2] wbs_dat_i[30] wbs_dat_i[31] wbs_dat_i[3]
+ wbs_dat_i[4] wbs_dat_i[5] wbs_dat_i[6] wbs_dat_i[7] wbs_dat_i[8] wbs_dat_i[9] wbs_dat_o[0]
+ wbs_dat_o[10] wbs_dat_o[11] wbs_dat_o[12] wbs_dat_o[13] wbs_dat_o[14] wbs_dat_o[15]
+ wbs_dat_o[16] wbs_dat_o[17] wbs_dat_o[18] wbs_dat_o[19] wbs_dat_o[1] wbs_dat_o[20]
+ wbs_dat_o[21] wbs_dat_o[22] wbs_dat_o[23] wbs_dat_o[24] wbs_dat_o[25] wbs_dat_o[26]
+ wbs_dat_o[27] wbs_dat_o[28] wbs_dat_o[29] wbs_dat_o[2] wbs_dat_o[30] wbs_dat_o[31]
+ wbs_dat_o[3] wbs_dat_o[4] wbs_dat_o[5] wbs_dat_o[6] wbs_dat_o[7] wbs_dat_o[8] wbs_dat_o[9]
+ wbs_sel_i[0] wbs_sel_i[1] wbs_sel_i[2] wbs_sel_i[3] wbs_stb_i wbs_we_i vccd1 vssd1
XFILLER_27_417 vssd1 vccd1 vssd1 vccd1 SS_sky130_ef_sc_hd__decap_40_12
XFILLER_39_277 vssd1 vccd1 vccd1 vssd1 SS_sky130_fd_sc_hd__fill_2
XFILLER_55_726 vssd1 vccd1 vccd1 vssd1 SS_sky130_fd_sc_hd__fill_2
XTAP_TAPCELL_ROW_87_1605 vccd1 vssd1 SS_sky130_fd_sc_hd__tapvpwrvgnd_1
XFILLER_94_361 vssd1 vccd1 vccd1 vssd1 SS_sky130_fd_sc_hd__fill_2
XFILLER_67_597 vssd1 vccd1 vssd1 vccd1 SS_sky130_ef_sc_hd__decap_40_12
XFILLER_82_545 vssd1 vccd1 vssd1 vccd1 SS_sky130_ef_sc_hd__decap_40_12
XFILLER_35_461 vssd1 vccd1 vssd1 vccd1 SS_sky130_ef_sc_hd__decap_40_12
XFILLER_82_589 vssd1 vccd1 vssd1 vccd1 SS_sky130_ef_sc_hd__decap_40_12
XFILLER_22_133 vssd1 vccd1 vccd1 vssd1 SS_sky130_fd_sc_hd__fill_4
XTAP_TAPCELL_ROW_46_990 vccd1 vssd1 SS_sky130_fd_sc_hd__tapvpwrvgnd_1
XFILLER_52_29 vssd1 vccd1 vssd1 vccd1 SS_sky130_ef_sc_hd__decap_40_12
XFILLER_50_475 vccd1 vssd1 vccd1 vssd1 SS_sky130_fd_sc_hd__fill_1
XFILLER_22_177 vssd1 vccd1 vssd1 vccd1 SS_sky130_ef_sc_hd__decap_40_12
XFILLER_109_706 vssd1 vccd1 vssd1 vccd1 SS_sky130_ef_sc_hd__decap_40_12
XFILLER_136_525 vssd1 vccd1 vccd1 vssd1 SS_sky130_fd_sc_hd__fill_4
XFILLER_108_249 vssd1 vccd1 vccd1 vssd1 SS_sky130_fd_sc_hd__fill_2
XTAP_TAPCELL_ROW_98_1767 vccd1 vssd1 SS_sky130_fd_sc_hd__tapvpwrvgnd_1
XFILLER_124_709 vssd1 vccd1 vccd1 vssd1 SS_sky130_fd_sc_hd__fill_4
XPHY_EDGE_ROW_107_Left_246 vccd1 vssd1 vccd1 vssd1 SS_sky130_fd_sc_hd__decap_3
XFILLER_89_111 vccd1 vssd1 vccd1 vssd1 SS_sky130_fd_sc_hd__fill_1
XFILLER_104_400 vssd1 vccd1 vssd1 vccd1 SS_sky130_ef_sc_hd__decap_40_12
XFILLER_77_15 vssd1 vccd1 vssd1 vccd1 SS_sky130_ef_sc_hd__decap_40_12
XFILLER_117_55 vccd1 vssd1 vccd1 vssd1 SS_sky130_fd_sc_hd__fill_1
XFILLER_104_433 vssd1 vccd1 vssd1 vccd1 SS_sky130_ef_sc_hd__decap_40_12
XTAP_TAPCELL_ROW_129_2233 vccd1 vssd1 SS_sky130_fd_sc_hd__tapvpwrvgnd_1
XFILLER_104_477 vssd1 vccd1 vssd1 vccd1 SS_sky130_ef_sc_hd__decap_40_12
XFILLER_58_531 vccd1 vssd1 vccd1 vssd1 SS_sky130_fd_sc_hd__fill_1
XFILLER_58_542 vssd1 vccd1 vssd1 vccd1 SS_sky130_ef_sc_hd__decap_40_12
XTAP_TAPCELL_ROW_5_376 vccd1 vssd1 SS_sky130_fd_sc_hd__tapvpwrvgnd_1
XFILLER_18_417 vssd1 vccd1 vccd1 vssd1 SS_sky130_fd_sc_hd__fill_2
XTAP_TAPCELL_ROW_51_1063 vccd1 vssd1 SS_sky130_fd_sc_hd__tapvpwrvgnd_1
XFILLER_58_586 vssd1 vccd1 vccd1 vssd1 SS_sky130_fd_sc_hd__fill_2
XFILLER_85_361 vssd1 vccd1 vccd1 vssd1 SS_sky130_fd_sc_hd__fill_8
XFILLER_133_54 vssd1 vccd1 vccd1 vssd1 SS_sky130_fd_sc_hd__fill_2
XFILLER_100_661 vssd1 vccd1 vccd1 vssd1 SS_sky130_fd_sc_hd__fill_2
XFILLER_92_309 vssd1 vccd1 vssd1 vccd1 SS_sky130_ef_sc_hd__decap_40_12
XFILLER_45_225 vssd1 vccd1 vssd1 vccd1 SS_sky130_ef_sc_hd__decap_40_12
XPHY_EDGE_ROW_116_Left_255 vccd1 vssd1 vccd1 vssd1 SS_sky130_fd_sc_hd__decap_3
XFILLER_26_41 vssd1 vccd1 vssd1 vccd1 SS_sky130_ef_sc_hd__decap_40_12
XFILLER_93_69 vssd1 vccd1 vssd1 vccd1 SS_sky130_ef_sc_hd__decap_40_12
XFILLER_14_601 vssd1 vccd1 vssd1 vccd1 SS_sky130_ef_sc_hd__decap_40_12
XFILLER_54_781 vssd1 vccd1 vssd1 vccd1 SS_sky130_ef_sc_hd__decap_40_12
XFILLER_61_729 vssd1 vccd1 vssd1 vccd1 SS_sky130_ef_sc_hd__decap_40_12
XFILLER_13_111 vccd1 vssd1 vccd1 vssd1 SS_sky130_fd_sc_hd__fill_1
XFILLER_14_645 vssd1 vccd1 vssd1 vccd1 SS_sky130_ef_sc_hd__decap_40_12
XFILLER_26_85 vssd1 vccd1 vssd1 vccd1 SS_sky130_ef_sc_hd__decap_40_12
XTAP_TAPCELL_ROW_24_662 vccd1 vssd1 SS_sky130_fd_sc_hd__tapvpwrvgnd_1
XFILLER_9_137 vssd1 vccd1 vssd1 vccd1 SS_sky130_ef_sc_hd__decap_40_12
XFILLER_6_811 vccd1 vssd1 vccd1 vssd1 SS_sky130_fd_sc_hd__fill_1
XFILLER_127_503 vccd1 vssd1 vccd1 vssd1 SS_sky130_fd_sc_hd__fill_1
XFILLER_127_558 vssd1 vccd1 vccd1 vssd1 SS_sky130_fd_sc_hd__fill_2
XPHY_EDGE_ROW_125_Left_264 vccd1 vssd1 vccd1 vssd1 SS_sky130_fd_sc_hd__decap_3
XFILLER_123_753 vssd1 vccd1 vssd1 vccd1 SS_sky130_ef_sc_hd__decap_40_12
XFILLER_107_293 vssd1 vccd1 vssd1 vccd1 SS_sky130_ef_sc_hd__decap_40_12
XFILLER_123_797 vssd1 vccd1 vccd1 vssd1 SS_sky130_fd_sc_hd__fill_4
XFILLER_110_403 vssd1 vccd1 vccd1 vssd1 SS_sky130_fd_sc_hd__fill_8
XFILLER_96_637 vssd1 vccd1 vccd1 vssd1 SS_sky130_fd_sc_hd__fill_4
XFILLER_96_626 vssd1 vccd1 vccd1 vssd1 SS_sky130_fd_sc_hd__fill_4
X_1270_ vccd1 vssd1 vccd1 vssd1 _1270_/X _1664_/Q _1272_/B SS_sky130_fd_sc_hd__or2_2
XFILLER_95_125 vssd1 vccd1 vssd1 vccd1 SS_sky130_ef_sc_hd__decap_40_12
XFILLER_49_553 vssd1 vccd1 vccd1 vssd1 SS_sky130_fd_sc_hd__fill_2
XFILLER_67_81 vssd1 vccd1 vssd1 vccd1 SS_sky130_ef_sc_hd__decap_40_12
XFILLER_76_361 vssd1 vccd1 vccd1 vssd1 SS_sky130_fd_sc_hd__fill_2
XPHY_EDGE_ROW_134_Left_273 vccd1 vssd1 vccd1 vssd1 SS_sky130_fd_sc_hd__decap_3
XFILLER_95_169 vssd1 vccd1 vssd1 vccd1 SS_sky130_ef_sc_hd__decap_40_12
XFILLER_49_597 vssd1 vccd1 vssd1 vccd1 SS_sky130_ef_sc_hd__decap_40_12
XFILLER_64_512 vssd1 vccd1 vssd1 vccd1 SS_sky130_ef_sc_hd__decap_40_12
XTAP_TAPCELL_ROW_69_1335 vccd1 vssd1 SS_sky130_fd_sc_hd__tapvpwrvgnd_1
XFILLER_64_545 vssd1 vccd1 vccd1 vssd1 SS_sky130_fd_sc_hd__fill_8
XFILLER_17_461 vssd1 vccd1 vssd1 vccd1 SS_sky130_ef_sc_hd__decap_40_12
XFILLER_45_781 vssd1 vccd1 vccd1 vssd1 SS_sky130_fd_sc_hd__fill_2
XFILLER_51_217 vssd1 vccd1 vccd1 vssd1 SS_sky130_fd_sc_hd__fill_4
XTAP_TAPCELL_ROW_82_1524 vccd1 vssd1 SS_sky130_fd_sc_hd__tapvpwrvgnd_1
XTAP_TAPCELL_ROW_82_1535 vccd1 vssd1 SS_sky130_fd_sc_hd__tapvpwrvgnd_1
XFILLER_32_475 vccd1 vssd1 vccd1 vssd1 SS_sky130_fd_sc_hd__fill_1
XFILLER_20_637 vssd1 vccd1 vccd1 vssd1 SS_sky130_fd_sc_hd__fill_4
XFILLER_9_671 vccd1 vssd1 vccd1 vssd1 SS_sky130_fd_sc_hd__fill_1
X_0985_ vssd1 vccd1 vccd1 vssd1 _0985_/A2 input29/X _1525_/D _1447_/C1 _0984_/X SS_sky130_fd_sc_hd__o211a_2
XTAP_TAPCELL_ROW_113_2001 vccd1 vssd1 SS_sky130_fd_sc_hd__tapvpwrvgnd_1
XFILLER_133_517 vssd1 vccd1 vccd1 vssd1 SS_sky130_fd_sc_hd__fill_8
XFILLER_118_569 vssd1 vccd1 vssd1 vccd1 SS_sky130_ef_sc_hd__decap_40_12
X_1606_ _1849_/A _1608_/CLK _1606_/D vccd1 vssd1 vccd1 vssd1 SS_sky130_fd_sc_hd__dfxtp_2
XFILLER_59_317 vssd1 vccd1 vssd1 vccd1 SS_sky130_ef_sc_hd__decap_40_12
X_1537_ _1537_/Q _1634_/CLK _1537_/D vccd1 vssd1 vccd1 vssd1 SS_sky130_fd_sc_hd__dfxtp_2
XFILLER_99_486 vssd1 vccd1 vccd1 vssd1 SS_sky130_fd_sc_hd__fill_2
XTAP_TAPCELL_ROW_93_1697 vccd1 vssd1 SS_sky130_fd_sc_hd__tapvpwrvgnd_1
X_1468_ vccd1 vssd1 vccd1 vssd1 _1468_/X _1760_/Q _1468_/B SS_sky130_fd_sc_hd__or2_2
XFILLER_101_447 vccd1 vssd1 vccd1 vssd1 SS_sky130_fd_sc_hd__fill_1
XFILLER_74_309 vssd1 vccd1 vssd1 vccd1 SS_sky130_ef_sc_hd__decap_40_12
X_1399_ vssd1 vccd1 vccd1 vssd1 _1405_/A2 input39/X _1726_/D _1403_/C1 _1398_/X SS_sky130_fd_sc_hd__o211a_2
XTAP_TAPCELL_ROW_2_324 vccd1 vssd1 SS_sky130_fd_sc_hd__tapvpwrvgnd_1
XTAP_TAPCELL_ROW_2_335 vccd1 vssd1 SS_sky130_fd_sc_hd__tapvpwrvgnd_1
XFILLER_27_225 vssd1 vccd1 vssd1 vccd1 SS_sky130_ef_sc_hd__decap_40_12
XTAP_TAPCELL_ROW_124_2163 vccd1 vssd1 SS_sky130_fd_sc_hd__tapvpwrvgnd_1
XFILLER_103_57 vssd1 vccd1 vssd1 vccd1 SS_sky130_ef_sc_hd__decap_40_12
XFILLER_36_781 vssd1 vccd1 vssd1 vccd1 SS_sky130_ef_sc_hd__decap_40_12
XFILLER_43_729 vssd1 vccd1 vssd1 vccd1 SS_sky130_ef_sc_hd__decap_40_12
XFILLER_11_615 vccd1 vssd1 vccd1 vssd1 SS_sky130_fd_sc_hd__fill_1
XTAP_TAPCELL_ROW_41_908 vccd1 vssd1 SS_sky130_fd_sc_hd__tapvpwrvgnd_1
XTAP_TAPCELL_ROW_41_919 vccd1 vssd1 SS_sky130_fd_sc_hd__tapvpwrvgnd_1
XTAP_TAPCELL_ROW_21_610 vccd1 vssd1 SS_sky130_fd_sc_hd__tapvpwrvgnd_1
XTAP_TAPCELL_ROW_21_621 vccd1 vssd1 SS_sky130_fd_sc_hd__tapvpwrvgnd_1
XFILLER_23_497 vssd1 vccd1 vccd1 vssd1 SS_sky130_fd_sc_hd__fill_4
XFILLER_137_823 vccd1 vssd1 vccd1 vssd1 SS_sky130_fd_sc_hd__fill_1
XFILLER_137_801 vssd1 vccd1 vccd1 vssd1 SS_sky130_fd_sc_hd__fill_2
XFILLER_109_503 vccd1 vssd1 vccd1 vssd1 SS_sky130_fd_sc_hd__fill_1
XFILLER_12_65 vssd1 vccd1 vssd1 vccd1 SS_sky130_ef_sc_hd__decap_40_12
XFILLER_136_344 vccd1 vssd1 vccd1 vssd1 SS_sky130_fd_sc_hd__fill_1
XFILLER_128_65 vssd1 vccd1 vssd1 vccd1 SS_sky130_ef_sc_hd__decap_40_12
XFILLER_2_357 vssd1 vccd1 vccd1 vssd1 SS_sky130_fd_sc_hd__fill_4
XFILLER_78_637 vssd1 vccd1 vccd1 vssd1 SS_sky130_fd_sc_hd__fill_4
XFILLER_132_572 vssd1 vccd1 vccd1 vssd1 SS_sky130_fd_sc_hd__fill_2
XFILLER_120_701 vssd1 vccd1 vssd1 vccd1 SS_sky130_ef_sc_hd__decap_40_12
XFILLER_105_797 vssd1 vccd1 vssd1 vccd1 SS_sky130_ef_sc_hd__decap_40_12
XFILLER_77_125 vssd1 vccd1 vssd1 vccd1 SS_sky130_ef_sc_hd__decap_40_12
XFILLER_77_169 vssd1 vccd1 vssd1 vccd1 SS_sky130_ef_sc_hd__decap_40_12
XFILLER_37_51 vssd1 vccd1 vccd1 vssd1 SS_sky130_fd_sc_hd__fill_4
XFILLER_58_361 vssd1 vccd1 vccd1 vssd1 SS_sky130_fd_sc_hd__fill_2
XFILLER_58_383 vssd1 vccd1 vssd1 vccd1 SS_sky130_ef_sc_hd__decap_40_12
XFILLER_86_681 vssd1 vccd1 vssd1 vccd1 SS_sky130_ef_sc_hd__decap_40_12
XTAP_TAPCELL_ROW_109_1936 vccd1 vssd1 SS_sky130_fd_sc_hd__tapvpwrvgnd_1
XFILLER_92_139 vccd1 vssd1 vccd1 vssd1 SS_sky130_fd_sc_hd__fill_1
XTAP_TAPCELL_ROW_29_732 vccd1 vssd1 SS_sky130_fd_sc_hd__tapvpwrvgnd_1
Xafe_wb_550 afe_wb_550/LO analog_io_oeb[14] vccd1 vssd1 vssd1 vccd1 SS_sky130_fd_sc_hd__conb_1
XFILLER_46_545 vssd1 vccd1 vssd1 vccd1 SS_sky130_ef_sc_hd__decap_40_12
XFILLER_46_567 vssd1 vccd1 vssd1 vccd1 SS_sky130_ef_sc_hd__decap_40_12
Xafe_wb_561 afe_wb_561/LO analog_io_oeb[25] vccd1 vssd1 vssd1 vccd1 SS_sky130_fd_sc_hd__conb_1
XFILLER_33_217 vssd1 vccd1 vccd1 vssd1 SS_sky130_fd_sc_hd__fill_4
XFILLER_46_589 vssd1 vccd1 vccd1 vssd1 SS_sky130_fd_sc_hd__fill_4
XFILLER_61_559 vccd1 vssd1 vccd1 vssd1 SS_sky130_fd_sc_hd__fill_1
XTAP_TAPCELL_ROW_64_1254 vccd1 vssd1 SS_sky130_fd_sc_hd__tapvpwrvgnd_1
XTAP_TAPCELL_ROW_64_1265 vccd1 vssd1 SS_sky130_fd_sc_hd__tapvpwrvgnd_1
XFILLER_14_475 vccd1 vssd1 vccd1 vssd1 SS_sky130_fd_sc_hd__fill_1
XFILLER_41_261 vssd1 vccd1 vssd1 vccd1 SS_sky130_ef_sc_hd__decap_40_12
XFILLER_10_681 vssd1 vccd1 vssd1 vccd1 SS_sky130_ef_sc_hd__decap_40_12
X_0770_ vccd1 vssd1 vssd1 vccd1 _0766_/X _0769_/X _0860_/A2 _1477_/Q _1477_/D _1417_/C1
+ SS_sky130_fd_sc_hd__o221a_2
XFILLER_6_641 vssd1 vccd1 vccd1 vssd1 SS_sky130_fd_sc_hd__fill_2
XFILLER_69_615 vccd1 vssd1 vccd1 vssd1 SS_sky130_fd_sc_hd__fill_1
XFILLER_123_561 vssd1 vccd1 vccd1 vssd1 SS_sky130_fd_sc_hd__fill_8
X_1322_ vccd1 vssd1 vccd1 vssd1 _1322_/X _1689_/Q _1330_/B SS_sky130_fd_sc_hd__or2_2
XFILLER_110_233 vssd1 vccd1 vssd1 vccd1 SS_sky130_ef_sc_hd__decap_40_12
XFILLER_56_309 vssd1 vccd1 vssd1 vccd1 SS_sky130_ef_sc_hd__decap_40_12
X_1253_ vssd1 vccd1 vccd1 vssd1 _1265_/A2 input32/X _1655_/D _1451_/C1 _1252_/X SS_sky130_fd_sc_hd__o211a_2
XFILLER_96_489 vssd1 vccd1 vccd1 vssd1 SS_sky130_fd_sc_hd__fill_4
XFILLER_37_501 vssd1 vccd1 vccd1 vssd1 SS_sky130_fd_sc_hd__fill_2
XFILLER_37_523 vccd1 vssd1 vccd1 vssd1 SS_sky130_fd_sc_hd__fill_1
XFILLER_49_361 vssd1 vccd1 vssd1 vccd1 SS_sky130_ef_sc_hd__decap_40_12
XFILLER_77_670 vssd1 vccd1 vccd1 vssd1 SS_sky130_fd_sc_hd__fill_2
XFILLER_110_277 vssd1 vccd1 vssd1 vccd1 SS_sky130_ef_sc_hd__decap_40_12
X_1184_ vccd1 vssd1 vccd1 vssd1 _1184_/X _1184_/A _1208_/B SS_sky130_fd_sc_hd__or2_2
XFILLER_25_729 vssd1 vccd1 vccd1 vssd1 SS_sky130_fd_sc_hd__fill_2
XFILLER_80_813 vccd1 vssd1 vccd1 vssd1 SS_sky130_fd_sc_hd__fill_1
XFILLER_91_161 vssd1 vccd1 vccd1 vssd1 SS_sky130_fd_sc_hd__fill_4
XFILLER_92_673 vccd1 vssd1 vccd1 vssd1 SS_sky130_fd_sc_hd__fill_1
XFILLER_52_537 vssd1 vccd1 vccd1 vssd1 SS_sky130_fd_sc_hd__fill_2
XFILLER_20_401 vssd1 vccd1 vssd1 vccd1 SS_sky130_ef_sc_hd__decap_40_12
XFILLER_20_445 vssd1 vccd1 vssd1 vccd1 SS_sky130_ef_sc_hd__decap_40_12
XFILLER_20_489 vssd1 vccd1 vssd1 vccd1 SS_sky130_ef_sc_hd__decap_40_12
X_0968_ vccd1 vssd1 vccd1 vssd1 _0968_/X _0968_/A _0984_/B SS_sky130_fd_sc_hd__or2_2
XFILLER_118_322 vssd1 vccd1 vssd1 vccd1 SS_sky130_ef_sc_hd__decap_40_12
XTAP_TAPCELL_ROW_95_1726 vccd1 vssd1 SS_sky130_fd_sc_hd__tapvpwrvgnd_1
X_0899_ vccd1 vssd1 vccd1 vssd1 _1691_/Q _1277_/A _1723_/Q wire452/X _0901_/B SS_sky130_fd_sc_hd__a22o_2
XFILLER_118_377 vssd1 vccd1 vccd1 vssd1 SS_sky130_fd_sc_hd__fill_4
XTAP_TAPCELL_ROW_7_405 vccd1 vssd1 SS_sky130_fd_sc_hd__tapvpwrvgnd_1
XFILLER_0_817 vssd1 vccd1 vccd1 vssd1 SS_sky130_fd_sc_hd__fill_2
XFILLER_102_701 vssd1 vccd1 vccd1 vssd1 SS_sky130_fd_sc_hd__fill_4
XFILLER_99_261 vssd1 vccd1 vssd1 vccd1 SS_sky130_ef_sc_hd__decap_40_12
XFILLER_0_839 vccd1 vssd1 vccd1 vssd1 SS_sky130_fd_sc_hd__fill_1
XFILLER_59_125 vssd1 vccd1 vssd1 vccd1 SS_sky130_ef_sc_hd__decap_40_12
XFILLER_87_423 vccd1 vssd1 vccd1 vssd1 SS_sky130_fd_sc_hd__fill_1
XFILLER_59_169 vssd1 vccd1 vssd1 vccd1 SS_sky130_ef_sc_hd__decap_40_12
XFILLER_75_629 vssd1 vccd1 vssd1 vccd1 SS_sky130_ef_sc_hd__decap_40_12
XFILLER_28_501 vssd1 vccd1 vssd1 vccd1 SS_sky130_ef_sc_hd__decap_40_12
XFILLER_56_810 vssd1 vccd1 vccd1 vssd1 SS_sky130_fd_sc_hd__fill_2
XFILLER_68_681 vssd1 vccd1 vccd1 vssd1 SS_sky130_fd_sc_hd__fill_8
XFILLER_74_139 vccd1 vssd1 vccd1 vssd1 SS_sky130_fd_sc_hd__fill_1
XFILLER_87_489 vssd1 vccd1 vccd1 vssd1 SS_sky130_fd_sc_hd__fill_2
XFILLER_101_277 vssd1 vccd1 vccd1 vssd1 SS_sky130_fd_sc_hd__fill_2
XFILLER_28_545 vssd1 vccd1 vssd1 vccd1 SS_sky130_ef_sc_hd__decap_40_12
XFILLER_74_27 vccd1 vssd1 vccd1 vssd1 SS_sky130_fd_sc_hd__fill_1
XFILLER_15_217 vssd1 vccd1 vccd1 vssd1 SS_sky130_fd_sc_hd__fill_4
XFILLER_28_589 vssd1 vccd1 vssd1 vccd1 SS_sky130_ef_sc_hd__decap_40_12
XFILLER_43_526 vssd1 vccd1 vssd1 vccd1 SS_sky130_ef_sc_hd__decap_40_12
XFILLER_70_301 vssd1 vccd1 vccd1 vssd1 SS_sky130_fd_sc_hd__fill_4
XFILLER_71_835 vssd1 vccd1 vccd1 vssd1 SS_sky130_fd_sc_hd__fill_4
XFILLER_83_673 vssd1 vccd1 vssd1 vccd1 SS_sky130_ef_sc_hd__decap_40_12
XFILLER_30_209 vssd1 vccd1 vssd1 vccd1 SS_sky130_ef_sc_hd__decap_40_12
XFILLER_90_15 vssd1 vccd1 vssd1 vccd1 SS_sky130_ef_sc_hd__decap_40_12
XFILLER_130_77 vssd1 vccd1 vccd1 vssd1 SS_sky130_fd_sc_hd__fill_4
XTAP_TAPCELL_ROW_104_1866 vccd1 vssd1 SS_sky130_fd_sc_hd__tapvpwrvgnd_1
XTAP_TAPCELL_ROW_104_1855 vccd1 vssd1 SS_sky130_fd_sc_hd__tapvpwrvgnd_1
XFILLER_23_261 vssd1 vccd1 vssd1 vccd1 SS_sky130_ef_sc_hd__decap_40_12
XFILLER_51_581 vssd1 vccd1 vssd1 vccd1 SS_sky130_ef_sc_hd__decap_40_12
XFILLER_70_389 vssd1 vccd1 vccd1 vssd1 SS_sky130_fd_sc_hd__fill_4
XFILLER_7_405 vssd1 vccd1 vssd1 vccd1 SS_sky130_ef_sc_hd__decap_40_12
XFILLER_11_445 vssd1 vccd1 vccd1 vssd1 SS_sky130_fd_sc_hd__fill_2
XFILLER_23_42 vssd1 vccd1 vssd1 vccd1 SS_sky130_ef_sc_hd__decap_40_12
Xwire314 vccd1 vssd1 vssd1 vccd1 wire314/A analog_ctrl[61] SS_sky130_fd_sc_hd__buf_12
XFILLER_135_3 vssd1 vccd1 vssd1 vccd1 SS_sky130_ef_sc_hd__decap_40_12
Xwire303 vccd1 vssd1 vssd1 vccd1 wire303/A analog_ctrl[106] SS_sky130_fd_sc_hd__buf_12
XFILLER_7_449 vssd1 vccd1 vssd1 vccd1 SS_sky130_ef_sc_hd__decap_40_12
Xwire336 vccd1 vssd1 vssd1 vccd1 wire336/A analog_ctrl[41] SS_sky130_fd_sc_hd__buf_12
Xwire325 vccd1 vssd1 vssd1 vccd1 wire325/A analog_ctrl[51] SS_sky130_fd_sc_hd__buf_12
Xwire347 vccd1 vssd1 wire347/X wire347/A vccd1 vssd1 SS_sky130_fd_sc_hd__buf_4
XPHY_EDGE_ROW_137_Right_137 vccd1 vssd1 vccd1 vssd1 SS_sky130_fd_sc_hd__decap_3
XTAP_TAPCELL_ROW_137_2354 vccd1 vssd1 SS_sky130_fd_sc_hd__tapvpwrvgnd_1
XFILLER_136_141 vssd1 vccd1 vssd1 vccd1 SS_sky130_ef_sc_hd__decap_40_12
Xwire369 vccd1 vssd1 vssd1 vccd1 wire369/A wbs_dat_o[23] SS_sky130_fd_sc_hd__buf_12
Xwire358 vccd1 vssd1 vssd1 vccd1 wire358/A wbs_dat_o[4] SS_sky130_fd_sc_hd__buf_12
XFILLER_109_333 vssd1 vccd1 vccd1 vssd1 SS_sky130_fd_sc_hd__fill_2
XFILLER_99_57 vssd1 vccd1 vssd1 vccd1 SS_sky130_ef_sc_hd__decap_40_12
XFILLER_2_121 vssd1 vccd1 vssd1 vccd1 SS_sky130_ef_sc_hd__decap_40_12
XFILLER_2_165 vssd1 vccd1 vssd1 vccd1 SS_sky130_ef_sc_hd__decap_40_12
XFILLER_78_401 vssd1 vccd1 vssd1 vccd1 SS_sky130_ef_sc_hd__decap_40_12
XFILLER_105_561 vssd1 vccd1 vccd1 vssd1 SS_sky130_fd_sc_hd__fill_4
XFILLER_120_531 vccd1 vssd1 vccd1 vssd1 SS_sky130_fd_sc_hd__fill_1
XFILLER_38_309 vssd1 vccd1 vssd1 vccd1 SS_sky130_ef_sc_hd__decap_40_12
XFILLER_78_456 vssd1 vccd1 vccd1 vssd1 SS_sky130_fd_sc_hd__fill_2
XFILLER_19_501 vssd1 vccd1 vccd1 vssd1 SS_sky130_fd_sc_hd__fill_2
XFILLER_48_83 vccd1 vssd1 vccd1 vssd1 SS_sky130_fd_sc_hd__fill_1
XFILLER_78_489 vssd1 vccd1 vssd1 vccd1 SS_sky130_ef_sc_hd__decap_40_12
Xfanout480 vssd1 vccd1 vccd1 vssd1 wire493/A _1329_/C1 SS_sky130_fd_sc_hd__clkdlybuf4s25_1
Xfanout491 vssd1 vccd1 vccd1 vssd1 wire493/A _1471_/C1 SS_sky130_fd_sc_hd__clkdlybuf4s25_1
XFILLER_0_57 vssd1 vccd1 vssd1 vccd1 SS_sky130_ef_sc_hd__decap_40_12
XFILLER_62_813 vccd1 vssd1 vccd1 vssd1 SS_sky130_fd_sc_hd__fill_1
XFILLER_73_161 vssd1 vccd1 vccd1 vssd1 SS_sky130_fd_sc_hd__fill_4
XFILLER_80_109 vssd1 vccd1 vssd1 vccd1 SS_sky130_ef_sc_hd__decap_40_12
XFILLER_34_537 vccd1 vssd1 vccd1 vssd1 SS_sky130_fd_sc_hd__fill_1
XFILLER_61_334 vssd1 vccd1 vccd1 vssd1 SS_sky130_fd_sc_hd__fill_2
XFILLER_61_345 vssd1 vccd1 vssd1 vccd1 SS_sky130_ef_sc_hd__decap_40_12
XFILLER_9_55 vccd1 vssd1 vccd1 vssd1 SS_sky130_fd_sc_hd__fill_1
X_1871_ vccd1 vssd1 _1871_/X _1871_/A vccd1 vssd1 SS_sky130_fd_sc_hd__buf_2
X_0822_ vccd1 vssd1 vccd1 vssd1 _1646_/Q wire430/X _1678_/Q _0891_/B1 _0822_/X SS_sky130_fd_sc_hd__a22o_2
XFILLER_80_81 vssd1 vccd1 vccd1 vssd1 SS_sky130_fd_sc_hd__fill_2
XPHY_EDGE_ROW_104_Right_104 vccd1 vssd1 vccd1 vssd1 SS_sky130_fd_sc_hd__decap_3
XTAP_TAPCELL_ROW_12_473 vccd1 vssd1 SS_sky130_fd_sc_hd__tapvpwrvgnd_1
XTAP_TAPCELL_ROW_12_484 vccd1 vssd1 SS_sky130_fd_sc_hd__tapvpwrvgnd_1
XTAP_TAPCELL_ROW_77_1456 vccd1 vssd1 SS_sky130_fd_sc_hd__tapvpwrvgnd_1
XFILLER_128_697 vssd1 vccd1 vccd1 vssd1 SS_sky130_fd_sc_hd__fill_2
X_0753_ vccd1 vssd1 vssd1 vccd1 _0943_/A _0753_/A _0753_/B SS_sky130_fd_sc_hd__nand2_2
XFILLER_50_3 vssd1 vccd1 vssd1 vccd1 SS_sky130_ef_sc_hd__decap_40_12
XFILLER_88_209 vssd1 vccd1 vssd1 vccd1 SS_sky130_ef_sc_hd__decap_40_12
XFILLER_69_445 vssd1 vccd1 vccd1 vssd1 SS_sky130_fd_sc_hd__fill_2
XTAP_TAPCELL_ROW_90_1645 vccd1 vssd1 SS_sky130_fd_sc_hd__tapvpwrvgnd_1
XTAP_TAPCELL_ROW_90_1656 vccd1 vssd1 SS_sky130_fd_sc_hd__tapvpwrvgnd_1
XFILLER_123_391 vccd1 vssd1 vccd1 vssd1 SS_sky130_fd_sc_hd__fill_1
X_1305_ vssd1 vccd1 vccd1 vssd1 _1319_/A2 input24/X _1680_/D _1437_/C1 _1304_/X SS_sky130_fd_sc_hd__o211a_2
XFILLER_111_553 vssd1 vccd1 vccd1 vssd1 SS_sky130_fd_sc_hd__fill_4
XFILLER_97_765 vssd1 vccd1 vssd1 vccd1 SS_sky130_ef_sc_hd__decap_40_12
XFILLER_96_253 vssd1 vccd1 vssd1 vccd1 SS_sky130_ef_sc_hd__decap_40_12
XFILLER_38_810 vssd1 vccd1 vccd1 vssd1 SS_sky130_fd_sc_hd__fill_2
XFILLER_57_629 vssd1 vccd1 vssd1 vccd1 SS_sky130_ef_sc_hd__decap_40_12
XFILLER_56_139 vccd1 vssd1 vccd1 vssd1 SS_sky130_fd_sc_hd__fill_1
X_1236_ vccd1 vssd1 vccd1 vssd1 _1236_/X _1647_/Q _1272_/B SS_sky130_fd_sc_hd__or2_2
XFILLER_52_301 vssd1 vccd1 vccd1 vssd1 SS_sky130_fd_sc_hd__fill_4
XFILLER_53_813 vccd1 vssd1 vccd1 vssd1 SS_sky130_fd_sc_hd__fill_1
X_1167_ vssd1 vccd1 vccd1 vssd1 wire233/X wire501/X _1613_/D _1423_/C1 _1166_/X SS_sky130_fd_sc_hd__o211a_2
XFILLER_71_109 vssd1 vccd1 vccd1 vssd1 SS_sky130_fd_sc_hd__fill_2
XTAP_TAPCELL_ROW_121_2111 vccd1 vssd1 SS_sky130_fd_sc_hd__tapvpwrvgnd_1
XFILLER_25_559 vccd1 vssd1 vccd1 vssd1 SS_sky130_fd_sc_hd__fill_1
XFILLER_80_643 vccd1 vssd1 vccd1 vssd1 SS_sky130_fd_sc_hd__fill_1
XTAP_TAPCELL_ROW_121_2122 vccd1 vssd1 SS_sky130_fd_sc_hd__tapvpwrvgnd_1
XFILLER_12_209 vssd1 vccd1 vssd1 vccd1 SS_sky130_ef_sc_hd__decap_40_12
X_1098_ vccd1 vssd1 vccd1 vssd1 _1098_/X _1854_/A _1116_/B SS_sky130_fd_sc_hd__or2_2
XFILLER_52_345 vssd1 vccd1 vssd1 vccd1 SS_sky130_ef_sc_hd__decap_40_12
XFILLER_40_529 vssd1 vccd1 vccd1 vssd1 SS_sky130_fd_sc_hd__fill_2
XFILLER_52_389 vssd1 vccd1 vssd1 vccd1 SS_sky130_ef_sc_hd__decap_40_12
XFILLER_21_765 vssd1 vccd1 vssd1 vccd1 SS_sky130_ef_sc_hd__decap_40_12
XFILLER_138_417 vssd1 vccd1 vccd1 vssd1 SS_sky130_fd_sc_hd__fill_2
XFILLER_20_253 vssd1 vccd1 vssd1 vccd1 SS_sky130_ef_sc_hd__decap_40_12
XTAP_TAPCELL_ROW_31_760 vccd1 vssd1 SS_sky130_fd_sc_hd__tapvpwrvgnd_1
XTAP_TAPCELL_ROW_31_771 vccd1 vssd1 SS_sky130_fd_sc_hd__tapvpwrvgnd_1
XFILLER_60_29 vssd1 vccd1 vssd1 vccd1 SS_sky130_ef_sc_hd__decap_40_12
XFILLER_119_653 vssd1 vccd1 vssd1 vccd1 SS_sky130_ef_sc_hd__decap_40_12
XTAP_TAPCELL_ROW_119_2084 vccd1 vssd1 SS_sky130_fd_sc_hd__tapvpwrvgnd_1
XFILLER_118_141 vssd1 vccd1 vssd1 vccd1 SS_sky130_ef_sc_hd__decap_40_12
XFILLER_4_419 vccd1 vssd1 vccd1 vssd1 SS_sky130_fd_sc_hd__fill_1
XFILLER_134_612 vssd1 vccd1 vccd1 vssd1 SS_sky130_fd_sc_hd__fill_4
XFILLER_119_697 vssd1 vccd1 vssd1 vccd1 SS_sky130_ef_sc_hd__decap_40_12
XFILLER_69_27 vssd1 vccd1 vssd1 vccd1 SS_sky130_ef_sc_hd__decap_40_12
XTAP_TAPCELL_ROW_132_2273 vccd1 vssd1 SS_sky130_fd_sc_hd__tapvpwrvgnd_1
XFILLER_133_111 vccd1 vssd1 vccd1 vssd1 SS_sky130_fd_sc_hd__fill_1
XFILLER_134_645 vssd1 vccd1 vccd1 vssd1 SS_sky130_fd_sc_hd__fill_8
XFILLER_106_336 vccd1 vssd1 vccd1 vssd1 SS_sky130_fd_sc_hd__fill_1
XTAP_TAPCELL_ROW_132_2284 vccd1 vssd1 SS_sky130_fd_sc_hd__tapvpwrvgnd_1
XFILLER_134_678 vssd1 vccd1 vssd1 vccd1 SS_sky130_ef_sc_hd__decap_40_12
XFILLER_121_339 vccd1 vssd1 vccd1 vssd1 SS_sky130_fd_sc_hd__fill_1
XFILLER_0_669 vssd1 vccd1 vccd1 vssd1 SS_sky130_fd_sc_hd__fill_2
XFILLER_85_15 vssd1 vccd1 vssd1 vccd1 SS_sky130_ef_sc_hd__decap_40_12
XFILLER_125_55 vccd1 vssd1 vccd1 vssd1 SS_sky130_fd_sc_hd__fill_1
XFILLER_75_437 vssd1 vccd1 vccd1 vssd1 SS_sky130_fd_sc_hd__fill_8
XFILLER_18_53 vssd1 vccd1 vssd1 vccd1 SS_sky130_ef_sc_hd__decap_40_12
XTAP_TAPCELL_ROW_48_1013 vccd1 vssd1 SS_sky130_fd_sc_hd__tapvpwrvgnd_1
XFILLER_55_161 vssd1 vccd1 vccd1 vssd1 SS_sky130_fd_sc_hd__fill_4
XFILLER_62_109 vssd1 vccd1 vssd1 vccd1 SS_sky130_ef_sc_hd__decap_40_12
XFILLER_18_97 vssd1 vccd1 vssd1 vccd1 SS_sky130_ef_sc_hd__decap_40_12
XTAP_TAPCELL_ROW_39_882 vccd1 vssd1 SS_sky130_fd_sc_hd__tapvpwrvgnd_1
XTAP_TAPCELL_ROW_48_1024 vccd1 vssd1 SS_sky130_fd_sc_hd__tapvpwrvgnd_1
XFILLER_70_153 vssd1 vccd1 vssd1 vccd1 SS_sky130_ef_sc_hd__decap_40_12
XFILLER_71_654 vssd1 vccd1 vccd1 vssd1 SS_sky130_fd_sc_hd__fill_4
XFILLER_24_581 vssd1 vccd1 vccd1 vssd1 SS_sky130_fd_sc_hd__fill_4
XFILLER_31_529 vssd1 vccd1 vssd1 vccd1 SS_sky130_ef_sc_hd__decap_40_12
XFILLER_34_41 vssd1 vccd1 vssd1 vccd1 SS_sky130_ef_sc_hd__decap_40_12
XFILLER_43_389 vssd1 vccd1 vccd1 vssd1 SS_sky130_fd_sc_hd__fill_2
XTAP_TAPCELL_ROW_61_1213 vccd1 vssd1 SS_sky130_fd_sc_hd__tapvpwrvgnd_1
XFILLER_71_687 vccd1 vssd1 vccd1 vssd1 SS_sky130_fd_sc_hd__fill_1
XFILLER_34_85 vssd1 vccd1 vssd1 vccd1 SS_sky130_ef_sc_hd__decap_40_12
XFILLER_70_197 vssd1 vccd1 vssd1 vccd1 SS_sky130_ef_sc_hd__decap_40_12
XFILLER_129_406 vssd1 vccd1 vssd1 vccd1 SS_sky130_ef_sc_hd__decap_40_12
XFILLER_8_725 vssd1 vccd1 vssd1 vccd1 SS_sky130_ef_sc_hd__decap_40_12
XFILLER_8_769 vssd1 vccd1 vssd1 vccd1 SS_sky130_ef_sc_hd__decap_40_12
XFILLER_7_279 vccd1 vssd1 vccd1 vssd1 SS_sky130_fd_sc_hd__fill_1
XFILLER_124_133 vssd1 vccd1 vccd1 vssd1 SS_sky130_fd_sc_hd__fill_4
XFILLER_3_441 vssd1 vccd1 vccd1 vssd1 SS_sky130_fd_sc_hd__fill_4
XTAP_TAPCELL_ROW_59_1186 vccd1 vssd1 SS_sky130_fd_sc_hd__tapvpwrvgnd_1
XFILLER_112_306 vssd1 vccd1 vccd1 vssd1 SS_sky130_fd_sc_hd__fill_2
XFILLER_98_507 vssd1 vccd1 vssd1 vccd1 SS_sky130_ef_sc_hd__decap_40_12
XFILLER_3_485 vssd1 vccd1 vssd1 vccd1 SS_sky130_ef_sc_hd__decap_40_12
XFILLER_79_721 vssd1 vccd1 vccd1 vssd1 SS_sky130_fd_sc_hd__fill_4
XFILLER_124_177 vssd1 vccd1 vssd1 vccd1 SS_sky130_ef_sc_hd__decap_40_12
XFILLER_59_93 vssd1 vccd1 vssd1 vccd1 SS_sky130_ef_sc_hd__decap_40_12
XTAP_TAPCELL_ROW_72_1375 vccd1 vssd1 SS_sky130_fd_sc_hd__tapvpwrvgnd_1
XTAP_TAPCELL_ROW_72_1386 vccd1 vssd1 SS_sky130_fd_sc_hd__tapvpwrvgnd_1
XFILLER_78_253 vssd1 vccd1 vssd1 vccd1 SS_sky130_ef_sc_hd__decap_40_12
XFILLER_79_765 vssd1 vccd1 vssd1 vccd1 SS_sky130_ef_sc_hd__decap_40_12
XFILLER_94_713 vssd1 vccd1 vssd1 vccd1 SS_sky130_ef_sc_hd__decap_40_12
XFILLER_38_139 vccd1 vssd1 vccd1 vssd1 SS_sky130_fd_sc_hd__fill_1
XFILLER_93_223 vccd1 vssd1 vccd1 vssd1 SS_sky130_fd_sc_hd__fill_1
X_1021_ vssd1 vccd1 vccd1 vssd1 _1033_/A2 input45/X _1542_/D _1149_/C1 _1020_/X SS_sky130_fd_sc_hd__o211a_2
XFILLER_47_673 vssd1 vccd1 vssd1 vccd1 SS_sky130_ef_sc_hd__decap_40_12
XFILLER_53_109 vssd1 vccd1 vccd1 vssd1 SS_sky130_fd_sc_hd__fill_2
XFILLER_75_81 vssd1 vccd1 vssd1 vccd1 SS_sky130_ef_sc_hd__decap_40_12
XFILLER_81_429 vssd1 vccd1 vssd1 vccd1 SS_sky130_ef_sc_hd__decap_40_12
XFILLER_34_301 vssd1 vccd1 vccd1 vssd1 SS_sky130_fd_sc_hd__fill_4
XFILLER_62_643 vccd1 vssd1 vccd1 vssd1 SS_sky130_fd_sc_hd__fill_1
XFILLER_74_481 vssd1 vccd1 vccd1 vssd1 SS_sky130_fd_sc_hd__fill_2
XTAP_TAPCELL_ROW_17_554 vccd1 vssd1 SS_sky130_fd_sc_hd__tapvpwrvgnd_1
XFILLER_34_345 vssd1 vccd1 vssd1 vccd1 SS_sky130_ef_sc_hd__decap_40_12
XFILLER_50_805 vssd1 vccd1 vccd1 vssd1 SS_sky130_fd_sc_hd__fill_4
XFILLER_62_665 vssd1 vccd1 vssd1 vccd1 SS_sky130_ef_sc_hd__decap_40_12
XFILLER_22_529 vssd1 vccd1 vccd1 vssd1 SS_sky130_fd_sc_hd__fill_2
XFILLER_34_389 vssd1 vccd1 vssd1 vccd1 SS_sky130_ef_sc_hd__decap_40_12
X_1854_ vccd1 vssd1 _1854_/X _1854_/A vccd1 vssd1 SS_sky130_fd_sc_hd__buf_2
XFILLER_135_409 vssd1 vccd1 vccd1 vssd1 SS_sky130_fd_sc_hd__fill_2
X_0805_ vssd1 vccd1 vssd1 vccd1 _0874_/A2 _1903_/A wire347/X _0801_/X _0805_/X _0804_/X
+ SS_sky130_fd_sc_hd__a2111o_2
XFILLER_128_483 vccd1 vssd1 vccd1 vssd1 SS_sky130_fd_sc_hd__fill_1
Xhold703 _1064_/A _1564_/Q vccd1 vssd1 vssd1 vccd1 SS_sky130_fd_sc_hd__dlygate4sd3_1
XFILLER_116_601 vssd1 vccd1 vssd1 vccd1 SS_sky130_ef_sc_hd__decap_40_12
Xmax_cap422 vccd1 vssd1 _0941_/B1 _0755_/Y vccd1 vssd1 SS_sky130_fd_sc_hd__buf_2
Xhold736 _1689_/D _1323_/X vccd1 vssd1 vssd1 vccd1 SS_sky130_fd_sc_hd__dlygate4sd3_1
XFILLER_116_645 vssd1 vccd1 vssd1 vccd1 SS_sky130_ef_sc_hd__decap_40_12
XFILLER_116_634 vssd1 vccd1 vccd1 vssd1 SS_sky130_fd_sc_hd__fill_8
XFILLER_115_111 vccd1 vssd1 vccd1 vssd1 SS_sky130_fd_sc_hd__fill_1
Xhold714 _1204_/A _1632_/Q vccd1 vssd1 vssd1 vccd1 SS_sky130_fd_sc_hd__dlygate4sd3_1
Xhold725 _1310_/A _1683_/Q vccd1 vssd1 vssd1 vccd1 SS_sky130_fd_sc_hd__dlygate4sd3_1
Xhold747 _1044_/A _1554_/Q vccd1 vssd1 vssd1 vccd1 SS_sky130_fd_sc_hd__dlygate4sd3_1
Xhold769 _1456_/A _1754_/Q vccd1 vssd1 vssd1 vccd1 SS_sky130_fd_sc_hd__dlygate4sd3_1
Xhold758 input24/A wbs_dat_i[13] vccd1 vssd1 vssd1 vccd1 SS_sky130_fd_sc_hd__dlygate4sd3_1
XFILLER_111_361 vssd1 vccd1 vccd1 vssd1 SS_sky130_fd_sc_hd__fill_2
XFILLER_97_584 vssd1 vccd1 vssd1 vccd1 SS_sky130_ef_sc_hd__decap_40_12
XFILLER_84_245 vssd1 vccd1 vccd1 vssd1 SS_sky130_fd_sc_hd__fill_4
XFILLER_85_768 vssd1 vccd1 vssd1 vccd1 SS_sky130_ef_sc_hd__decap_40_12
XFILLER_26_813 vssd1 vccd1 vccd1 vssd1 SS_sky130_fd_sc_hd__fill_2
XFILLER_44_109 vssd1 vccd1 vssd1 vccd1 SS_sky130_ef_sc_hd__decap_40_12
X_1219_ vssd1 vccd1 vccd1 vssd1 _1267_/A2 input45/X _1638_/D _1219_/C1 _1218_/X SS_sky130_fd_sc_hd__o211a_2
XFILLER_84_289 vssd1 vccd1 vssd1 vccd1 SS_sky130_ef_sc_hd__decap_40_12
XFILLER_37_161 vssd1 vccd1 vccd1 vssd1 SS_sky130_fd_sc_hd__fill_4
XFILLER_65_470 vssd1 vccd1 vssd1 vccd1 SS_sky130_ef_sc_hd__decap_40_12
XTAP_TAPCELL_ROW_36_841 vccd1 vssd1 SS_sky130_fd_sc_hd__tapvpwrvgnd_1
XFILLER_52_153 vssd1 vccd1 vssd1 vccd1 SS_sky130_ef_sc_hd__decap_40_12
XFILLER_53_654 vssd1 vccd1 vssd1 vccd1 SS_sky130_ef_sc_hd__decap_40_12
XFILLER_13_529 vssd1 vccd1 vssd1 vccd1 SS_sky130_ef_sc_hd__decap_40_12
XFILLER_25_389 vssd1 vccd1 vccd1 vssd1 SS_sky130_fd_sc_hd__fill_2
XFILLER_111_57 vssd1 vccd1 vssd1 vccd1 SS_sky130_ef_sc_hd__decap_40_12
XTAP_TAPCELL_ROW_101_1814 vccd1 vssd1 SS_sky130_fd_sc_hd__tapvpwrvgnd_1
XFILLER_52_197 vssd1 vccd1 vssd1 vccd1 SS_sky130_ef_sc_hd__decap_40_12
XFILLER_21_573 vssd1 vccd1 vssd1 vccd1 SS_sky130_ef_sc_hd__decap_40_12
XTAP_TAPCELL_ROW_134_2313 vccd1 vssd1 SS_sky130_fd_sc_hd__tapvpwrvgnd_1
XFILLER_119_461 vssd1 vccd1 vssd1 vccd1 SS_sky130_ef_sc_hd__decap_40_12
XFILLER_4_249 vssd1 vccd1 vccd1 vssd1 SS_sky130_fd_sc_hd__fill_2
XFILLER_134_442 vccd1 vssd1 vccd1 vssd1 SS_sky130_fd_sc_hd__fill_1
XFILLER_106_133 vssd1 vccd1 vccd1 vssd1 SS_sky130_fd_sc_hd__fill_4
XFILLER_20_65 vssd1 vccd1 vssd1 vccd1 SS_sky130_ef_sc_hd__decap_40_12
XFILLER_121_125 vssd1 vccd1 vssd1 vccd1 SS_sky130_ef_sc_hd__decap_40_12
XFILLER_106_177 vssd1 vccd1 vssd1 vccd1 SS_sky130_ef_sc_hd__decap_40_12
XTAP_TAPCELL_ROW_112_1987 vccd1 vssd1 SS_sky130_fd_sc_hd__tapvpwrvgnd_1
XTAP_TAPCELL_ROW_112_1976 vccd1 vssd1 SS_sky130_fd_sc_hd__tapvpwrvgnd_1
XFILLER_0_477 vssd1 vccd1 vssd1 vccd1 SS_sky130_ef_sc_hd__decap_40_12
XFILLER_76_713 vssd1 vccd1 vssd1 vccd1 SS_sky130_ef_sc_hd__decap_40_12
XFILLER_130_681 vssd1 vccd1 vssd1 vccd1 SS_sky130_ef_sc_hd__decap_40_12
XFILLER_121_169 vssd1 vccd1 vssd1 vccd1 SS_sky130_ef_sc_hd__decap_40_12
XFILLER_102_361 vssd1 vccd1 vccd1 vssd1 SS_sky130_fd_sc_hd__fill_2
XFILLER_75_223 vccd1 vssd1 vccd1 vssd1 SS_sky130_fd_sc_hd__fill_1
XFILLER_76_746 vccd1 vssd1 vccd1 vssd1 SS_sky130_fd_sc_hd__fill_1
XFILLER_29_662 vssd1 vccd1 vccd1 vssd1 SS_sky130_fd_sc_hd__fill_8
XFILLER_29_673 vssd1 vccd1 vssd1 vccd1 SS_sky130_ef_sc_hd__decap_40_12
XFILLER_35_109 vssd1 vccd1 vccd1 vssd1 SS_sky130_fd_sc_hd__fill_2
XFILLER_91_727 vccd1 vssd1 vccd1 vssd1 SS_sky130_fd_sc_hd__fill_1
XFILLER_16_301 vssd1 vccd1 vccd1 vssd1 SS_sky130_fd_sc_hd__fill_4
XFILLER_16_345 vssd1 vccd1 vssd1 vccd1 SS_sky130_ef_sc_hd__decap_40_12
XFILLER_32_805 vssd1 vccd1 vccd1 vssd1 SS_sky130_fd_sc_hd__fill_4
XFILLER_44_643 vccd1 vssd1 vccd1 vssd1 SS_sky130_fd_sc_hd__fill_1
XFILLER_45_51 vssd1 vccd1 vccd1 vssd1 SS_sky130_fd_sc_hd__fill_4
XTAP_TAPCELL_ROW_14_513 vccd1 vssd1 SS_sky130_fd_sc_hd__tapvpwrvgnd_1
XFILLER_16_389 vssd1 vccd1 vssd1 vccd1 SS_sky130_ef_sc_hd__decap_40_12
XFILLER_31_337 vssd1 vccd1 vssd1 vccd1 SS_sky130_ef_sc_hd__decap_40_12
XFILLER_129_225 vssd1 vccd1 vssd1 vccd1 SS_sky130_ef_sc_hd__decap_40_12
XFILLER_8_533 vssd1 vccd1 vssd1 vccd1 SS_sky130_ef_sc_hd__decap_40_12
Xclkbuf_leaf_14_wb_clk_i _1762_/CLK clkbuf_leaf_7_wb_clk_i/A vccd1 vssd1 vssd1 vccd1
+ SS_sky130_fd_sc_hd__clkbuf_8
XTAP_TAPCELL_ROW_74_1404 vccd1 vssd1 SS_sky130_fd_sc_hd__tapvpwrvgnd_1
X_1570_ _1570_/Q _1634_/CLK _1570_/D vccd1 vssd1 vccd1 vssd1 SS_sky130_fd_sc_hd__dfxtp_2
XANTENNA_5 _1485_/Q vssd1 vccd1 vccd1 vssd1 SS_sky130_fd_sc_hd__diode_2
XFILLER_125_420 vssd1 vccd1 vssd1 vccd1 SS_sky130_ef_sc_hd__decap_40_12
XTAP_TAPCELL_ROW_74_1415 vccd1 vssd1 SS_sky130_fd_sc_hd__tapvpwrvgnd_1
XFILLER_113_615 vccd1 vssd1 vccd1 vssd1 SS_sky130_fd_sc_hd__fill_1
XFILLER_113_637 vccd1 vssd1 vccd1 vssd1 SS_sky130_fd_sc_hd__fill_1
XFILLER_3_293 vssd1 vccd1 vssd1 vccd1 SS_sky130_ef_sc_hd__decap_40_12
XFILLER_79_551 vccd1 vssd1 vccd1 vssd1 SS_sky130_fd_sc_hd__fill_1
XFILLER_113_659 vssd1 vccd1 vssd1 vccd1 SS_sky130_ef_sc_hd__decap_40_12
XFILLER_121_670 vssd1 vccd1 vccd1 vssd1 SS_sky130_fd_sc_hd__fill_2
XFILLER_100_309 vssd1 vccd1 vssd1 vccd1 SS_sky130_ef_sc_hd__decap_40_12
XFILLER_66_245 vssd1 vccd1 vccd1 vssd1 SS_sky130_fd_sc_hd__fill_4
XFILLER_94_521 vssd1 vccd1 vccd1 vssd1 SS_sky130_fd_sc_hd__fill_2
XFILLER_26_109 vssd1 vccd1 vssd1 vccd1 SS_sky130_ef_sc_hd__decap_40_12
XFILLER_19_161 vssd1 vccd1 vccd1 vssd1 SS_sky130_fd_sc_hd__fill_4
XFILLER_66_289 vssd1 vccd1 vssd1 vccd1 SS_sky130_ef_sc_hd__decap_40_12
XFILLER_81_237 vssd1 vccd1 vssd1 vccd1 SS_sky130_ef_sc_hd__decap_40_12
XFILLER_35_665 vssd1 vccd1 vccd1 vssd1 SS_sky130_fd_sc_hd__fill_4
X_1004_ vccd1 vssd1 vccd1 vssd1 _1004_/X _1004_/A _1006_/B SS_sky130_fd_sc_hd__or2_2
XFILLER_34_153 vssd1 vccd1 vssd1 vccd1 SS_sky130_ef_sc_hd__decap_40_12
XTAP_TAPCELL_ROW_33_800 vccd1 vssd1 SS_sky130_fd_sc_hd__tapvpwrvgnd_1
XFILLER_50_602 vssd1 vccd1 vssd1 vccd1 SS_sky130_ef_sc_hd__decap_40_12
XTAP_TAPCELL_ROW_85_1577 vccd1 vssd1 SS_sky130_fd_sc_hd__tapvpwrvgnd_1
XFILLER_90_793 vssd1 vccd1 vccd1 vssd1 SS_sky130_fd_sc_hd__fill_4
XFILLER_34_197 vssd1 vccd1 vssd1 vccd1 SS_sky130_ef_sc_hd__decap_40_12
XFILLER_50_635 vssd1 vccd1 vccd1 vssd1 SS_sky130_fd_sc_hd__fill_8
X_1906_ vccd1 vssd1 _1906_/X _1906_/A vccd1 vssd1 SS_sky130_fd_sc_hd__buf_2
X_1837_ vccd1 vssd1 _1837_/X _1837_/A vccd1 vssd1 SS_sky130_fd_sc_hd__buf_2
XFILLER_129_781 vssd1 vccd1 vccd1 vssd1 SS_sky130_fd_sc_hd__fill_2
XFILLER_135_217 vssd1 vccd1 vccd1 vssd1 SS_sky130_fd_sc_hd__fill_4
XTAP_TAPCELL_ROW_116_2043 vccd1 vssd1 SS_sky130_fd_sc_hd__tapvpwrvgnd_1
XFILLER_116_442 vccd1 vssd1 vccd1 vssd1 SS_sky130_fd_sc_hd__fill_1
X_1699_ _1878_/A _1731_/CLK _1699_/D vccd1 vssd1 vccd1 vssd1 SS_sky130_fd_sc_hd__dfxtp_2
Xhold577 _1294_/A _1675_/Q vccd1 vssd1 vssd1 vccd1 SS_sky130_fd_sc_hd__dlygate4sd3_1
Xhold566 _0972_/A _1519_/Q vccd1 vssd1 vssd1 vccd1 SS_sky130_fd_sc_hd__dlygate4sd3_1
Xhold588 _1412_/A _1896_/A vccd1 vssd1 vssd1 vccd1 SS_sky130_fd_sc_hd__dlygate4sd3_1
Xhold599 _1152_/A _1849_/A vccd1 vssd1 vssd1 vccd1 SS_sky130_fd_sc_hd__dlygate4sd3_1
XFILLER_103_125 vssd1 vccd1 vssd1 vccd1 SS_sky130_ef_sc_hd__decap_40_12
XFILLER_112_681 vssd1 vccd1 vssd1 vccd1 SS_sky130_ef_sc_hd__decap_40_12
XFILLER_103_169 vssd1 vccd1 vssd1 vccd1 SS_sky130_ef_sc_hd__decap_40_12
XFILLER_57_223 vccd1 vssd1 vccd1 vssd1 SS_sky130_fd_sc_hd__fill_1
XFILLER_58_757 vssd1 vccd1 vssd1 vccd1 SS_sky130_ef_sc_hd__decap_40_12
XFILLER_17_109 vssd1 vccd1 vccd1 vssd1 SS_sky130_fd_sc_hd__fill_2
XFILLER_73_727 vccd1 vssd1 vccd1 vssd1 SS_sky130_fd_sc_hd__fill_1
XFILLER_45_429 vssd1 vccd1 vccd1 vssd1 SS_sky130_fd_sc_hd__fill_2
XFILLER_14_805 vssd1 vccd1 vccd1 vssd1 SS_sky130_fd_sc_hd__fill_4
XFILLER_53_440 vssd1 vccd1 vccd1 vssd1 SS_sky130_fd_sc_hd__fill_8
XFILLER_82_27 vccd1 vssd1 vccd1 vssd1 SS_sky130_fd_sc_hd__fill_1
XTAP_TAPCELL_ROW_0_285 vccd1 vssd1 SS_sky130_fd_sc_hd__tapvpwrvgnd_1
XTAP_TAPCELL_ROW_0_296 vccd1 vssd1 SS_sky130_fd_sc_hd__tapvpwrvgnd_1
XFILLER_41_613 vssd1 vccd1 vccd1 vssd1 SS_sky130_fd_sc_hd__fill_2
XFILLER_13_337 vssd1 vccd1 vssd1 vccd1 SS_sky130_ef_sc_hd__decap_40_12
XFILLER_40_189 vssd1 vccd1 vccd1 vssd1 SS_sky130_fd_sc_hd__fill_4
XFILLER_5_503 vccd1 vssd1 vccd1 vssd1 SS_sky130_fd_sc_hd__fill_1
XFILLER_31_42 vssd1 vccd1 vssd1 vccd1 SS_sky130_ef_sc_hd__decap_40_12
XFILLER_127_729 vssd1 vccd1 vccd1 vssd1 SS_sky130_fd_sc_hd__fill_4
XTAP_TAPCELL_ROW_56_1134 vccd1 vssd1 SS_sky130_fd_sc_hd__tapvpwrvgnd_1
XTAP_TAPCELL_ROW_56_1145 vccd1 vssd1 SS_sky130_fd_sc_hd__tapvpwrvgnd_1
XFILLER_122_401 vssd1 vccd1 vssd1 vccd1 SS_sky130_ef_sc_hd__decap_40_12
XFILLER_1_753 vssd1 vccd1 vssd1 vccd1 SS_sky130_ef_sc_hd__decap_40_12
Xoutput75 vccd1 vssd1 wire285/A _1909_/X vccd1 vssd1 SS_sky130_fd_sc_hd__buf_4
XFILLER_122_445 vssd1 vccd1 vccd1 vssd1 SS_sky130_fd_sc_hd__fill_2
Xoutput64 vccd1 vssd1 wire296/A _1899_/X vccd1 vssd1 SS_sky130_fd_sc_hd__buf_4
Xoutput86 vccd1 vssd1 wire274/A _1846_/X vccd1 vssd1 SS_sky130_fd_sc_hd__buf_4
Xoutput97 vccd1 vssd1 wire263/A _1856_/X vccd1 vssd1 SS_sky130_fd_sc_hd__buf_4
XFILLER_122_489 vssd1 vccd1 vssd1 vccd1 SS_sky130_ef_sc_hd__decap_40_12
XFILLER_1_797 vssd1 vccd1 vssd1 vccd1 SS_sky130_ef_sc_hd__decap_40_12
XFILLER_48_245 vssd1 vccd1 vccd1 vssd1 SS_sky130_fd_sc_hd__fill_4
XFILLER_76_587 vccd1 vssd1 vccd1 vssd1 SS_sky130_fd_sc_hd__fill_1
XFILLER_48_289 vssd1 vccd1 vssd1 vccd1 SS_sky130_ef_sc_hd__decap_40_12
XFILLER_56_83 vccd1 vssd1 vccd1 vssd1 SS_sky130_fd_sc_hd__fill_1
XFILLER_63_237 vssd1 vccd1 vssd1 vccd1 SS_sky130_ef_sc_hd__decap_40_12
XFILLER_17_665 vssd1 vccd1 vccd1 vssd1 SS_sky130_fd_sc_hd__fill_4
XFILLER_91_557 vssd1 vccd1 vccd1 vssd1 SS_sky130_fd_sc_hd__fill_2
XFILLER_16_153 vssd1 vccd1 vssd1 vccd1 SS_sky130_ef_sc_hd__decap_40_12
XFILLER_16_197 vssd1 vccd1 vssd1 vccd1 SS_sky130_ef_sc_hd__decap_40_12
XFILLER_71_281 vssd1 vccd1 vssd1 vccd1 SS_sky130_ef_sc_hd__decap_40_12
XFILLER_31_167 vccd1 vssd1 vccd1 vssd1 SS_sky130_fd_sc_hd__fill_1
XTAP_TAPCELL_ROW_80_1496 vccd1 vssd1 SS_sky130_fd_sc_hd__tapvpwrvgnd_1
XFILLER_8_363 vccd1 vssd1 vccd1 vssd1 SS_sky130_fd_sc_hd__fill_1
XFILLER_117_217 vssd1 vccd1 vccd1 vssd1 SS_sky130_fd_sc_hd__fill_4
X_1622_ _1622_/Q _1686_/CLK _1622_/D vccd1 vssd1 vccd1 vssd1 SS_sky130_fd_sc_hd__dfxtp_2
XFILLER_132_209 vssd1 vccd1 vssd1 vccd1 SS_sky130_ef_sc_hd__decap_40_12
X_1553_ _1553_/Q _1746_/CLK _1553_/D vccd1 vssd1 vccd1 vssd1 SS_sky130_fd_sc_hd__dfxtp_2
XFILLER_126_795 vccd1 vssd1 vccd1 vssd1 SS_sky130_fd_sc_hd__fill_1
XFILLER_125_261 vssd1 vccd1 vssd1 vccd1 SS_sky130_ef_sc_hd__decap_40_12
XFILLER_99_613 vssd1 vccd1 vccd1 vssd1 SS_sky130_fd_sc_hd__fill_2
X_1484_ _1484_/Q _1741_/CLK _1484_/D vccd1 vssd1 vccd1 vssd1 SS_sky130_fd_sc_hd__dfxtp_2
XFILLER_113_445 vssd1 vccd1 vccd1 vssd1 SS_sky130_fd_sc_hd__fill_2
XFILLER_86_307 vccd1 vssd1 vccd1 vssd1 SS_sky130_fd_sc_hd__fill_1
XFILLER_86_329 vssd1 vccd1 vssd1 vccd1 SS_sky130_ef_sc_hd__decap_40_12
XFILLER_101_629 vssd1 vccd1 vssd1 vccd1 SS_sky130_ef_sc_hd__decap_40_12
XFILLER_98_189 vssd1 vccd1 vccd1 vssd1 SS_sky130_fd_sc_hd__fill_4
XFILLER_39_223 vccd1 vssd1 vccd1 vssd1 SS_sky130_fd_sc_hd__fill_1
XFILLER_100_139 vccd1 vssd1 vccd1 vssd1 SS_sky130_fd_sc_hd__fill_1
XFILLER_95_841 vccd1 vssd1 vccd1 vssd1 SS_sky130_fd_sc_hd__fill_1
XTAP_TAPCELL_ROW_87_1606 vccd1 vssd1 SS_sky130_fd_sc_hd__tapvpwrvgnd_1
XFILLER_27_429 vssd1 vccd1 vssd1 vccd1 SS_sky130_ef_sc_hd__decap_40_12
XFILLER_82_557 vssd1 vccd1 vccd1 vssd1 SS_sky130_fd_sc_hd__fill_8
XFILLER_23_613 vssd1 vccd1 vccd1 vssd1 SS_sky130_fd_sc_hd__fill_2
XFILLER_35_473 vssd1 vccd1 vssd1 vccd1 SS_sky130_ef_sc_hd__decap_40_12
XFILLER_63_771 vccd1 vssd1 vccd1 vssd1 SS_sky130_fd_sc_hd__fill_1
XTAP_TAPCELL_ROW_46_991 vccd1 vssd1 SS_sky130_fd_sc_hd__tapvpwrvgnd_1
XFILLER_50_421 vssd1 vccd1 vssd1 vccd1 SS_sky130_ef_sc_hd__decap_40_12
XFILLER_10_307 vccd1 vssd1 vccd1 vssd1 SS_sky130_fd_sc_hd__fill_1
XFILLER_22_189 vssd1 vccd1 vccd1 vssd1 SS_sky130_fd_sc_hd__fill_4
XFILLER_136_504 vssd1 vccd1 vccd1 vssd1 SS_sky130_fd_sc_hd__fill_2
XFILLER_109_729 vssd1 vccd1 vssd1 vccd1 SS_sky130_ef_sc_hd__decap_40_12
XFILLER_109_718 vssd1 vccd1 vccd1 vssd1 SS_sky130_fd_sc_hd__fill_8
XTAP_TAPCELL_ROW_98_1768 vccd1 vssd1 SS_sky130_fd_sc_hd__tapvpwrvgnd_1
XFILLER_104_412 vssd1 vccd1 vccd1 vssd1 SS_sky130_fd_sc_hd__fill_8
XFILLER_77_27 vssd1 vccd1 vssd1 vccd1 SS_sky130_ef_sc_hd__decap_40_12
XFILLER_132_754 vssd1 vccd1 vccd1 vssd1 SS_sky130_fd_sc_hd__fill_2
XFILLER_104_445 vssd1 vccd1 vssd1 vccd1 SS_sky130_ef_sc_hd__decap_40_12
XFILLER_89_167 vccd1 vssd1 vccd1 vssd1 SS_sky130_fd_sc_hd__fill_1
XFILLER_104_489 vssd1 vccd1 vssd1 vccd1 SS_sky130_ef_sc_hd__decap_40_12
XFILLER_104_467 vccd1 vssd1 vccd1 vssd1 SS_sky130_fd_sc_hd__fill_1
XTAP_TAPCELL_ROW_129_2234 vccd1 vssd1 SS_sky130_fd_sc_hd__tapvpwrvgnd_1
XFILLER_98_690 vssd1 vccd1 vccd1 vssd1 SS_sky130_fd_sc_hd__fill_8
XTAP_TAPCELL_ROW_5_377 vccd1 vssd1 SS_sky130_fd_sc_hd__tapvpwrvgnd_1
XTAP_TAPCELL_ROW_51_1064 vccd1 vssd1 SS_sky130_fd_sc_hd__tapvpwrvgnd_1
XFILLER_58_554 vssd1 vccd1 vssd1 vccd1 SS_sky130_ef_sc_hd__decap_40_12
XFILLER_73_513 vccd1 vssd1 vccd1 vssd1 SS_sky130_fd_sc_hd__fill_1
XFILLER_45_237 vssd1 vccd1 vssd1 vccd1 SS_sky130_ef_sc_hd__decap_40_12
XFILLER_14_613 vssd1 vccd1 vssd1 vccd1 SS_sky130_ef_sc_hd__decap_40_12
XFILLER_26_53 vssd1 vccd1 vssd1 vccd1 SS_sky130_ef_sc_hd__decap_40_12
XFILLER_26_473 vssd1 vccd1 vccd1 vssd1 SS_sky130_fd_sc_hd__fill_2
XFILLER_73_579 vccd1 vssd1 vccd1 vssd1 SS_sky130_fd_sc_hd__fill_1
XFILLER_14_657 vssd1 vccd1 vssd1 vccd1 SS_sky130_ef_sc_hd__decap_40_12
XFILLER_26_97 vssd1 vccd1 vssd1 vccd1 SS_sky130_ef_sc_hd__decap_40_12
XFILLER_53_281 vssd1 vccd1 vssd1 vccd1 SS_sky130_ef_sc_hd__decap_40_12
XFILLER_54_793 vssd1 vccd1 vssd1 vccd1 SS_sky130_ef_sc_hd__decap_40_12
XFILLER_9_105 vssd1 vccd1 vccd1 vssd1 SS_sky130_fd_sc_hd__fill_4
XFILLER_13_167 vccd1 vssd1 vccd1 vssd1 SS_sky130_fd_sc_hd__fill_1
XTAP_TAPCELL_ROW_24_663 vccd1 vssd1 SS_sky130_fd_sc_hd__tapvpwrvgnd_1
XFILLER_9_149 vssd1 vccd1 vssd1 vccd1 SS_sky130_ef_sc_hd__decap_40_12
XFILLER_42_41 vssd1 vccd1 vssd1 vccd1 SS_sky130_ef_sc_hd__decap_40_12
XFILLER_42_85 vssd1 vccd1 vssd1 vccd1 SS_sky130_ef_sc_hd__decap_40_12
XFILLER_5_333 vssd1 vccd1 vccd1 vssd1 SS_sky130_fd_sc_hd__fill_2
XFILLER_114_209 vssd1 vccd1 vssd1 vccd1 SS_sky130_ef_sc_hd__decap_40_12
XFILLER_107_261 vssd1 vccd1 vssd1 vccd1 SS_sky130_ef_sc_hd__decap_40_12
XFILLER_123_765 vssd1 vccd1 vssd1 vccd1 SS_sky130_ef_sc_hd__decap_40_12
XFILLER_1_561 vssd1 vccd1 vssd1 vccd1 SS_sky130_ef_sc_hd__decap_40_12
XFILLER_68_307 vccd1 vssd1 vccd1 vssd1 SS_sky130_fd_sc_hd__fill_1
XFILLER_122_253 vssd1 vccd1 vssd1 vccd1 SS_sky130_ef_sc_hd__decap_40_12
XFILLER_3_57 vssd1 vccd1 vssd1 vccd1 SS_sky130_ef_sc_hd__decap_40_12
XFILLER_77_841 vccd1 vssd1 vccd1 vssd1 SS_sky130_fd_sc_hd__fill_1
XFILLER_122_297 vssd1 vccd1 vccd1 vssd1 SS_sky130_fd_sc_hd__fill_2
XFILLER_95_137 vssd1 vccd1 vssd1 vccd1 SS_sky130_ef_sc_hd__decap_40_12
XFILLER_67_93 vssd1 vccd1 vssd1 vccd1 SS_sky130_ef_sc_hd__decap_40_12
XFILLER_37_727 vccd1 vssd1 vccd1 vssd1 SS_sky130_fd_sc_hd__fill_1
XFILLER_64_524 vssd1 vccd1 vccd1 vssd1 SS_sky130_fd_sc_hd__fill_8
XTAP_TAPCELL_ROW_69_1336 vccd1 vssd1 SS_sky130_fd_sc_hd__tapvpwrvgnd_1
XFILLER_17_473 vssd1 vccd1 vssd1 vccd1 SS_sky130_ef_sc_hd__decap_40_12
XFILLER_32_421 vssd1 vccd1 vssd1 vccd1 SS_sky130_ef_sc_hd__decap_40_12
XTAP_TAPCELL_ROW_82_1525 vccd1 vssd1 SS_sky130_fd_sc_hd__tapvpwrvgnd_1
XTAP_TAPCELL_ROW_82_1536 vccd1 vssd1 SS_sky130_fd_sc_hd__tapvpwrvgnd_1
XFILLER_83_81 vssd1 vccd1 vssd1 vccd1 SS_sky130_ef_sc_hd__decap_40_12
XTAP_TAPCELL_ROW_43_950 vccd1 vssd1 SS_sky130_fd_sc_hd__tapvpwrvgnd_1
XFILLER_80_3 vssd1 vccd1 vssd1 vccd1 SS_sky130_ef_sc_hd__decap_40_12
X_0984_ vccd1 vssd1 vccd1 vssd1 _0984_/X _0984_/A _0984_/B SS_sky130_fd_sc_hd__or2_2
XFILLER_8_193 vssd1 vccd1 vccd1 vssd1 SS_sky130_fd_sc_hd__fill_2
XTAP_TAPCELL_ROW_113_2002 vccd1 vssd1 SS_sky130_fd_sc_hd__tapvpwrvgnd_1
X_1605_ _1848_/A _1608_/CLK _1605_/D vccd1 vssd1 vccd1 vssd1 SS_sky130_fd_sc_hd__dfxtp_2
XFILLER_114_754 vssd1 vccd1 vccd1 vssd1 SS_sky130_fd_sc_hd__fill_2
X_1536_ _1536_/Q _1741_/CLK _1536_/D vccd1 vssd1 vccd1 vssd1 SS_sky130_fd_sc_hd__dfxtp_2
XTAP_TAPCELL_ROW_93_1698 vccd1 vssd1 SS_sky130_fd_sc_hd__tapvpwrvgnd_1
XFILLER_59_329 vssd1 vccd1 vccd1 vssd1 SS_sky130_fd_sc_hd__fill_4
XFILLER_86_137 vssd1 vccd1 vccd1 vssd1 SS_sky130_fd_sc_hd__fill_2
X_1467_ vssd1 vccd1 vccd1 vssd1 _1467_/A2 input40/X _1759_/D _1473_/C1 _1466_/X SS_sky130_fd_sc_hd__o211a_2
X_1398_ vccd1 vssd1 vccd1 vssd1 _1398_/X _1398_/A _1404_/B SS_sky130_fd_sc_hd__or2_2
XTAP_TAPCELL_ROW_2_325 vccd1 vssd1 SS_sky130_fd_sc_hd__tapvpwrvgnd_1
XTAP_TAPCELL_ROW_2_336 vccd1 vssd1 SS_sky130_fd_sc_hd__tapvpwrvgnd_1
XFILLER_95_671 vccd1 vssd1 vccd1 vssd1 SS_sky130_fd_sc_hd__fill_1
XFILLER_27_237 vssd1 vccd1 vssd1 vccd1 SS_sky130_ef_sc_hd__decap_40_12
XTAP_TAPCELL_ROW_124_2153 vccd1 vssd1 SS_sky130_fd_sc_hd__tapvpwrvgnd_1
XFILLER_63_18 vssd1 vccd1 vssd1 vccd1 SS_sky130_ef_sc_hd__decap_40_12
XFILLER_82_365 vssd1 vccd1 vssd1 vccd1 SS_sky130_ef_sc_hd__decap_40_12
XTAP_TAPCELL_ROW_124_2164 vccd1 vssd1 SS_sky130_fd_sc_hd__tapvpwrvgnd_1
XPHY_EDGE_ROW_118_Right_118 vccd1 vssd1 vccd1 vssd1 SS_sky130_fd_sc_hd__decap_3
XFILLER_103_69 vssd1 vccd1 vssd1 vccd1 SS_sky130_ef_sc_hd__decap_40_12
XFILLER_35_281 vssd1 vccd1 vssd1 vccd1 SS_sky130_ef_sc_hd__decap_40_12
XFILLER_36_793 vssd1 vccd1 vssd1 vccd1 SS_sky130_ef_sc_hd__decap_40_12
XFILLER_51_741 vssd1 vccd1 vssd1 vccd1 SS_sky130_ef_sc_hd__decap_40_12
XTAP_TAPCELL_ROW_41_909 vccd1 vssd1 SS_sky130_fd_sc_hd__tapvpwrvgnd_1
XFILLER_50_251 vccd1 vssd1 vccd1 vssd1 SS_sky130_fd_sc_hd__fill_1
XTAP_TAPCELL_ROW_21_611 vccd1 vssd1 SS_sky130_fd_sc_hd__tapvpwrvgnd_1
XFILLER_51_785 vssd1 vccd1 vssd1 vccd1 SS_sky130_ef_sc_hd__decap_40_12
XFILLER_7_609 vssd1 vccd1 vccd1 vssd1 SS_sky130_fd_sc_hd__fill_4
XFILLER_10_137 vssd1 vccd1 vccd1 vssd1 SS_sky130_fd_sc_hd__fill_2
XTAP_TAPCELL_ROW_21_622 vccd1 vssd1 SS_sky130_fd_sc_hd__tapvpwrvgnd_1
XFILLER_136_301 vssd1 vccd1 vccd1 vssd1 SS_sky130_fd_sc_hd__fill_4
XFILLER_12_77 vssd1 vccd1 vccd1 vssd1 SS_sky130_fd_sc_hd__fill_4
XFILLER_109_559 vccd1 vssd1 vccd1 vssd1 SS_sky130_fd_sc_hd__fill_1
XFILLER_3_837 vssd1 vccd1 vccd1 vssd1 SS_sky130_fd_sc_hd__fill_2
XFILLER_88_26 vssd1 vccd1 vccd1 vssd1 SS_sky130_fd_sc_hd__fill_2
XFILLER_128_77 vssd1 vccd1 vccd1 vssd1 SS_sky130_fd_sc_hd__fill_4
XFILLER_124_529 vssd1 vccd1 vccd1 vssd1 SS_sky130_fd_sc_hd__fill_2
XFILLER_105_721 vssd1 vccd1 vccd1 vssd1 SS_sky130_fd_sc_hd__fill_4
XFILLER_105_743 vccd1 vssd1 vccd1 vssd1 SS_sky130_fd_sc_hd__fill_1
XFILLER_120_713 vssd1 vccd1 vssd1 vccd1 SS_sky130_ef_sc_hd__decap_40_12
XFILLER_104_253 vssd1 vccd1 vssd1 vccd1 SS_sky130_ef_sc_hd__decap_40_12
XFILLER_59_841 vccd1 vssd1 vccd1 vssd1 SS_sky130_fd_sc_hd__fill_1
XFILLER_77_137 vssd1 vccd1 vssd1 vccd1 SS_sky130_ef_sc_hd__decap_40_12
XFILLER_120_757 vssd1 vccd1 vssd1 vccd1 SS_sky130_ef_sc_hd__decap_40_12
XFILLER_19_727 vccd1 vssd1 vccd1 vssd1 SS_sky130_fd_sc_hd__fill_1
XFILLER_58_373 vssd1 vccd1 vccd1 vssd1 SS_sky130_fd_sc_hd__fill_2
XFILLER_74_811 vccd1 vssd1 vccd1 vssd1 SS_sky130_fd_sc_hd__fill_1
XFILLER_86_693 vssd1 vccd1 vccd1 vssd1 SS_sky130_fd_sc_hd__fill_4
XTAP_TAPCELL_ROW_109_1937 vccd1 vssd1 SS_sky130_fd_sc_hd__tapvpwrvgnd_1
Xafe_wb_540 afe_wb_540/LO analog_io_oeb[4] vccd1 vssd1 vssd1 vccd1 SS_sky130_fd_sc_hd__conb_1
XTAP_TAPCELL_ROW_29_733 vccd1 vssd1 SS_sky130_fd_sc_hd__tapvpwrvgnd_1
Xafe_wb_551 afe_wb_551/LO analog_io_oeb[15] vccd1 vssd1 vssd1 vccd1 SS_sky130_fd_sc_hd__conb_1
XFILLER_46_557 vssd1 vccd1 vccd1 vssd1 SS_sky130_fd_sc_hd__fill_2
XFILLER_58_395 vssd1 vccd1 vssd1 vccd1 SS_sky130_ef_sc_hd__decap_40_12
Xafe_wb_562 afe_wb_562/LO analog_io_oeb[26] vccd1 vssd1 vssd1 vccd1 SS_sky130_fd_sc_hd__conb_1
XFILLER_85_181 vssd1 vccd1 vssd1 vccd1 SS_sky130_ef_sc_hd__decap_40_12
XFILLER_46_579 vssd1 vccd1 vccd1 vssd1 SS_sky130_fd_sc_hd__fill_8
XFILLER_61_505 vssd1 vccd1 vssd1 vccd1 SS_sky130_ef_sc_hd__decap_40_12
XFILLER_73_354 vssd1 vccd1 vssd1 vccd1 SS_sky130_ef_sc_hd__decap_40_12
XFILLER_14_421 vssd1 vccd1 vssd1 vccd1 SS_sky130_ef_sc_hd__decap_40_12
XFILLER_27_782 vssd1 vccd1 vccd1 vssd1 SS_sky130_fd_sc_hd__fill_2
XTAP_TAPCELL_ROW_64_1255 vccd1 vssd1 SS_sky130_fd_sc_hd__tapvpwrvgnd_1
XTAP_TAPCELL_ROW_64_1266 vccd1 vssd1 SS_sky130_fd_sc_hd__tapvpwrvgnd_1
XFILLER_41_273 vssd1 vccd1 vccd1 vssd1 SS_sky130_fd_sc_hd__fill_4
XFILLER_127_301 vssd1 vccd1 vccd1 vssd1 SS_sky130_fd_sc_hd__fill_2
XFILLER_10_693 vssd1 vccd1 vccd1 vssd1 SS_sky130_fd_sc_hd__fill_4
XFILLER_6_697 vssd1 vccd1 vccd1 vssd1 SS_sky130_fd_sc_hd__fill_2
XFILLER_127_389 vssd1 vccd1 vccd1 vssd1 SS_sky130_fd_sc_hd__fill_2
XFILLER_123_551 vssd1 vccd1 vccd1 vssd1 SS_sky130_fd_sc_hd__fill_8
XFILLER_68_137 vssd1 vccd1 vccd1 vssd1 SS_sky130_fd_sc_hd__fill_2
XFILLER_78_81 vssd1 vccd1 vccd1 vssd1 SS_sky130_fd_sc_hd__fill_2
X_1321_ vssd1 vccd1 vccd1 vssd1 _1339_/A2 input33/X _1688_/D _1451_/C1 _1320_/X SS_sky130_fd_sc_hd__o211a_2
XFILLER_1_391 vccd1 vssd1 vccd1 vssd1 SS_sky130_fd_sc_hd__fill_1
X_1252_ vccd1 vssd1 vccd1 vssd1 _1252_/X _1655_/Q _1264_/B SS_sky130_fd_sc_hd__or2_2
XFILLER_110_245 vssd1 vccd1 vccd1 vssd1 SS_sky130_fd_sc_hd__fill_4
XFILLER_49_373 vssd1 vccd1 vssd1 vccd1 SS_sky130_ef_sc_hd__decap_40_12
XFILLER_65_833 vccd1 vssd1 vccd1 vssd1 SS_sky130_fd_sc_hd__fill_1
XFILLER_110_289 vssd1 vccd1 vssd1 vccd1 SS_sky130_ef_sc_hd__decap_40_12
XFILLER_37_546 vssd1 vccd1 vssd1 vccd1 SS_sky130_ef_sc_hd__decap_40_12
XFILLER_64_321 vssd1 vccd1 vccd1 vssd1 SS_sky130_fd_sc_hd__fill_4
X_1183_ vssd1 vccd1 vccd1 vssd1 _1195_/A2 input29/X _1621_/D _1381_/C1 _1182_/X SS_sky130_fd_sc_hd__o211a_2
XFILLER_92_641 vssd1 vccd1 vccd1 vssd1 SS_sky130_fd_sc_hd__fill_2
XFILLER_64_365 vssd1 vccd1 vssd1 vccd1 SS_sky130_ef_sc_hd__decap_40_12
XFILLER_17_281 vssd1 vccd1 vssd1 vccd1 SS_sky130_ef_sc_hd__decap_40_12
XFILLER_33_741 vssd1 vccd1 vssd1 vccd1 SS_sky130_ef_sc_hd__decap_40_12
XFILLER_20_413 vssd1 vccd1 vccd1 vssd1 SS_sky130_fd_sc_hd__fill_4
XFILLER_32_251 vccd1 vssd1 vccd1 vssd1 SS_sky130_fd_sc_hd__fill_1
XFILLER_33_785 vssd1 vccd1 vccd1 vssd1 SS_sky130_fd_sc_hd__fill_8
XFILLER_20_457 vssd1 vccd1 vssd1 vccd1 SS_sky130_ef_sc_hd__decap_40_12
XFILLER_137_109 vssd1 vccd1 vccd1 vssd1 SS_sky130_fd_sc_hd__fill_2
X_0967_ vssd1 vccd1 vccd1 vssd1 wire253/X wire494/X _1516_/D _1387_/C1 _0966_/X SS_sky130_fd_sc_hd__o211a_2
XFILLER_118_334 vssd1 vccd1 vssd1 vccd1 SS_sky130_ef_sc_hd__decap_40_12
XFILLER_106_507 vssd1 vccd1 vccd1 vssd1 SS_sky130_fd_sc_hd__fill_2
XTAP_TAPCELL_ROW_95_1727 vccd1 vssd1 SS_sky130_fd_sc_hd__tapvpwrvgnd_1
XPHY_EDGE_ROW_12_Right_12 vccd1 vssd1 vccd1 vssd1 SS_sky130_fd_sc_hd__decap_3
X_0898_ vccd1 vssd1 vccd1 vssd1 _0897_/X _1563_/Q _1012_/A _1128_/A wire445/A _0898_/X
+ SS_sky130_fd_sc_hd__a221o_2
XTAP_TAPCELL_ROW_7_406 vccd1 vssd1 SS_sky130_fd_sc_hd__tapvpwrvgnd_1
XFILLER_133_337 vssd1 vccd1 vssd1 vccd1 SS_sky130_ef_sc_hd__decap_40_12
XFILLER_133_359 vssd1 vccd1 vssd1 vccd1 SS_sky130_ef_sc_hd__decap_40_12
XFILLER_58_18 vssd1 vccd1 vccd1 vssd1 SS_sky130_fd_sc_hd__fill_8
XFILLER_58_29 vssd1 vccd1 vssd1 vccd1 SS_sky130_ef_sc_hd__decap_40_12
XFILLER_59_137 vssd1 vccd1 vssd1 vccd1 SS_sky130_ef_sc_hd__decap_40_12
X_1519_ _1519_/Q _1752_/CLK _1519_/D vccd1 vssd1 vccd1 vssd1 SS_sky130_fd_sc_hd__dfxtp_2
XFILLER_101_223 vccd1 vssd1 vccd1 vssd1 SS_sky130_fd_sc_hd__fill_1
XFILLER_99_273 vssd1 vccd1 vccd1 vssd1 SS_sky130_fd_sc_hd__fill_4
XFILLER_102_757 vssd1 vccd1 vssd1 vccd1 SS_sky130_ef_sc_hd__decap_40_12
XFILLER_28_513 vssd1 vccd1 vssd1 vccd1 SS_sky130_ef_sc_hd__decap_40_12
XFILLER_28_557 vssd1 vccd1 vssd1 vccd1 SS_sky130_ef_sc_hd__decap_40_12
XFILLER_67_181 vssd1 vccd1 vssd1 vccd1 SS_sky130_ef_sc_hd__decap_40_12
XFILLER_83_652 vccd1 vssd1 vccd1 vssd1 SS_sky130_fd_sc_hd__fill_1
XPHY_EDGE_ROW_21_Right_21 vccd1 vssd1 vccd1 vssd1 SS_sky130_fd_sc_hd__decap_3
XFILLER_43_505 vccd1 vssd1 vccd1 vssd1 SS_sky130_fd_sc_hd__fill_1
XFILLER_55_365 vssd1 vccd1 vssd1 vccd1 SS_sky130_ef_sc_hd__decap_40_12
XFILLER_83_685 vssd1 vccd1 vssd1 vccd1 SS_sky130_ef_sc_hd__decap_40_12
XFILLER_43_538 vssd1 vccd1 vssd1 vccd1 SS_sky130_ef_sc_hd__decap_40_12
XFILLER_55_387 vssd1 vccd1 vccd1 vssd1 SS_sky130_fd_sc_hd__fill_4
XFILLER_82_195 vccd1 vssd1 vccd1 vssd1 SS_sky130_fd_sc_hd__fill_1
XFILLER_90_27 vccd1 vssd1 vccd1 vssd1 SS_sky130_fd_sc_hd__fill_1
XTAP_TAPCELL_ROW_104_1867 vccd1 vssd1 SS_sky130_fd_sc_hd__tapvpwrvgnd_1
XTAP_TAPCELL_ROW_104_1856 vccd1 vssd1 SS_sky130_fd_sc_hd__tapvpwrvgnd_1
XFILLER_23_273 vssd1 vccd1 vccd1 vssd1 SS_sky130_fd_sc_hd__fill_4
XFILLER_23_54 vssd1 vccd1 vccd1 vssd1 SS_sky130_fd_sc_hd__fill_2
XFILLER_51_593 vssd1 vccd1 vssd1 vccd1 SS_sky130_ef_sc_hd__decap_40_12
Xwire315 vccd1 vssd1 vssd1 vccd1 wire315/A analog_ctrl[60] SS_sky130_fd_sc_hd__buf_12
XFILLER_128_109 vssd1 vccd1 vssd1 vccd1 SS_sky130_ef_sc_hd__decap_40_12
Xwire304 vccd1 vssd1 vssd1 vccd1 wire304/A analog_ctrl[105] SS_sky130_fd_sc_hd__buf_12
XFILLER_7_417 vssd1 vccd1 vssd1 vccd1 SS_sky130_ef_sc_hd__decap_40_12
Xwire337 vccd1 vssd1 vssd1 vccd1 wire337/A analog_ctrl[40] SS_sky130_fd_sc_hd__buf_12
Xwire326 vccd1 vssd1 vssd1 vccd1 wire326/A analog_ctrl[50] SS_sky130_fd_sc_hd__buf_12
XTAP_TAPCELL_ROW_137_2355 vccd1 vssd1 SS_sky130_fd_sc_hd__tapvpwrvgnd_1
XPHY_EDGE_ROW_30_Right_30 vccd1 vssd1 vccd1 vssd1 SS_sky130_fd_sc_hd__decap_3
Xwire359 vccd1 vssd1 vssd1 vccd1 wire359/A wbs_dat_o[3] SS_sky130_fd_sc_hd__buf_12
XFILLER_136_153 vssd1 vccd1 vccd1 vssd1 SS_sky130_fd_sc_hd__fill_8
XFILLER_136_164 vssd1 vccd1 vssd1 vccd1 SS_sky130_ef_sc_hd__decap_40_12
XFILLER_109_389 vssd1 vccd1 vccd1 vssd1 SS_sky130_fd_sc_hd__fill_2
XFILLER_99_69 vssd1 vccd1 vssd1 vccd1 SS_sky130_ef_sc_hd__decap_40_12
XFILLER_136_197 vssd1 vccd1 vccd1 vssd1 SS_sky130_fd_sc_hd__fill_4
XFILLER_2_133 vssd1 vccd1 vccd1 vssd1 SS_sky130_fd_sc_hd__fill_4
XFILLER_2_177 vssd1 vccd1 vssd1 vccd1 SS_sky130_ef_sc_hd__decap_40_12
XFILLER_78_413 vssd1 vccd1 vccd1 vssd1 SS_sky130_fd_sc_hd__fill_4
XFILLER_66_619 vssd1 vccd1 vssd1 vccd1 SS_sky130_ef_sc_hd__decap_40_12
XFILLER_132_392 vssd1 vccd1 vssd1 vccd1 SS_sky130_ef_sc_hd__decap_40_12
XFILLER_93_405 vssd1 vccd1 vssd1 vccd1 SS_sky130_ef_sc_hd__decap_40_12
Xfanout470 vssd1 vccd1 vccd1 vssd1 wire493/X _1165_/C1 SS_sky130_fd_sc_hd__clkdlybuf4s25_1
XFILLER_47_811 vccd1 vssd1 vccd1 vssd1 SS_sky130_fd_sc_hd__fill_1
Xfanout492 vssd1 vccd1 vccd1 vssd1 _0738_/D wire493/A SS_sky130_fd_sc_hd__clkdlybuf4s25_1
XFILLER_120_587 vccd1 vssd1 vccd1 vssd1 SS_sky130_fd_sc_hd__fill_1
XFILLER_19_557 vssd1 vccd1 vccd1 vssd1 SS_sky130_fd_sc_hd__fill_2
XFILLER_46_321 vssd1 vccd1 vssd1 vccd1 SS_sky130_ef_sc_hd__decap_40_12
XFILLER_93_449 vssd1 vccd1 vccd1 vssd1 SS_sky130_fd_sc_hd__fill_4
XFILLER_0_69 vssd1 vccd1 vssd1 vccd1 SS_sky130_ef_sc_hd__decap_40_12
XFILLER_46_365 vssd1 vccd1 vssd1 vccd1 SS_sky130_ef_sc_hd__decap_40_12
XFILLER_15_741 vssd1 vccd1 vssd1 vccd1 SS_sky130_ef_sc_hd__decap_40_12
XFILLER_61_357 vssd1 vccd1 vssd1 vccd1 SS_sky130_ef_sc_hd__decap_40_12
XFILLER_64_83 vccd1 vssd1 vccd1 vssd1 SS_sky130_fd_sc_hd__fill_1
XFILLER_14_251 vccd1 vssd1 vccd1 vssd1 SS_sky130_fd_sc_hd__fill_1
XFILLER_15_785 vssd1 vccd1 vssd1 vccd1 SS_sky130_ef_sc_hd__decap_40_12
XFILLER_30_755 vccd1 vssd1 vccd1 vssd1 SS_sky130_fd_sc_hd__fill_1
X_1870_ vccd1 vssd1 _1870_/X _1870_/A vccd1 vssd1 SS_sky130_fd_sc_hd__buf_2
XFILLER_119_109 vssd1 vccd1 vccd1 vssd1 SS_sky130_fd_sc_hd__fill_2
X_0821_ vccd1 vssd1 vccd1 vssd1 input3/X wire433/X _1856_/A wire443/X _0821_/X SS_sky130_fd_sc_hd__a22o_2
XFILLER_128_632 vssd1 vccd1 vccd1 vssd1 SS_sky130_fd_sc_hd__fill_2
XTAP_TAPCELL_ROW_12_474 vccd1 vssd1 SS_sky130_fd_sc_hd__tapvpwrvgnd_1
XTAP_TAPCELL_ROW_12_485 vccd1 vssd1 SS_sky130_fd_sc_hd__tapvpwrvgnd_1
XFILLER_128_643 vccd1 vssd1 vccd1 vssd1 SS_sky130_fd_sc_hd__fill_1
X_0752_ vccd1 vssd1 vccd1 vssd1 _0754_/D _0755_/C _0755_/B _0755_/A _0753_/B SS_sky130_fd_sc_hd__or4_2
XTAP_TAPCELL_ROW_77_1457 vccd1 vssd1 SS_sky130_fd_sc_hd__tapvpwrvgnd_1
XFILLER_115_348 vssd1 vccd1 vccd1 vssd1 SS_sky130_fd_sc_hd__fill_2
XFILLER_115_337 vssd1 vccd1 vccd1 vssd1 SS_sky130_fd_sc_hd__fill_2
XTAP_TAPCELL_ROW_90_1646 vccd1 vssd1 SS_sky130_fd_sc_hd__tapvpwrvgnd_1
XTAP_TAPCELL_ROW_90_1657 vccd1 vssd1 SS_sky130_fd_sc_hd__tapvpwrvgnd_1
XFILLER_123_370 vssd1 vccd1 vccd1 vssd1 SS_sky130_fd_sc_hd__fill_8
XFILLER_96_221 vssd1 vccd1 vssd1 vccd1 SS_sky130_ef_sc_hd__decap_40_12
X_1304_ vccd1 vssd1 vccd1 vssd1 _1304_/X _1304_/A _1318_/B SS_sky130_fd_sc_hd__or2_2
XFILLER_97_777 vssd1 vccd1 vccd1 vssd1 SS_sky130_fd_sc_hd__fill_4
XFILLER_97_799 vccd1 vssd1 vccd1 vssd1 SS_sky130_fd_sc_hd__fill_1
XFILLER_96_265 vssd1 vccd1 vssd1 vccd1 SS_sky130_ef_sc_hd__decap_40_12
XFILLER_49_181 vssd1 vccd1 vssd1 vccd1 SS_sky130_ef_sc_hd__decap_40_12
XFILLER_65_641 vssd1 vccd1 vssd1 vccd1 SS_sky130_ef_sc_hd__decap_40_12
X_1235_ vssd1 vccd1 vccd1 vssd1 _1261_/A2 wire500/X _1646_/D _1381_/C1 _1234_/X SS_sky130_fd_sc_hd__o211a_2
XFILLER_25_505 vssd1 vccd1 vssd1 vccd1 SS_sky130_ef_sc_hd__decap_40_12
X_1166_ vccd1 vssd1 vccd1 vssd1 _1166_/X _1166_/A _1186_/B SS_sky130_fd_sc_hd__or2_2
XFILLER_64_195 vccd1 vssd1 vccd1 vssd1 SS_sky130_fd_sc_hd__fill_1
XTAP_TAPCELL_ROW_121_2112 vccd1 vssd1 SS_sky130_fd_sc_hd__tapvpwrvgnd_1
X_1097_ vssd1 vccd1 vccd1 vssd1 wire239/X wire495/X _1579_/D wire467/X _1096_/X SS_sky130_fd_sc_hd__o211a_2
XFILLER_52_357 vssd1 vccd1 vccd1 vssd1 SS_sky130_fd_sc_hd__fill_4
XFILLER_21_711 vssd1 vccd1 vssd1 vccd1 SS_sky130_ef_sc_hd__decap_40_12
XFILLER_80_699 vccd1 vssd1 vccd1 vssd1 SS_sky130_fd_sc_hd__fill_1
XFILLER_100_15 vssd1 vccd1 vssd1 vccd1 SS_sky130_ef_sc_hd__decap_40_12
XFILLER_20_221 vssd1 vccd1 vssd1 vccd1 SS_sky130_ef_sc_hd__decap_40_12
XFILLER_20_265 vssd1 vccd1 vssd1 vccd1 SS_sky130_ef_sc_hd__decap_40_12
XFILLER_21_777 vssd1 vccd1 vccd1 vssd1 SS_sky130_fd_sc_hd__fill_4
XTAP_TAPCELL_ROW_31_761 vccd1 vssd1 SS_sky130_fd_sc_hd__tapvpwrvgnd_1
XTAP_TAPCELL_ROW_31_772 vccd1 vssd1 SS_sky130_fd_sc_hd__tapvpwrvgnd_1
XFILLER_119_665 vssd1 vccd1 vccd1 vssd1 SS_sky130_fd_sc_hd__fill_4
XTAP_TAPCELL_ROW_119_2085 vccd1 vssd1 SS_sky130_fd_sc_hd__tapvpwrvgnd_1
XFILLER_118_153 vssd1 vccd1 vssd1 vccd1 SS_sky130_ef_sc_hd__decap_40_12
XFILLER_69_39 vssd1 vccd1 vssd1 vccd1 SS_sky130_ef_sc_hd__decap_40_12
XTAP_TAPCELL_ROW_132_2274 vccd1 vssd1 SS_sky130_fd_sc_hd__tapvpwrvgnd_1
XFILLER_118_197 vssd1 vccd1 vssd1 vccd1 SS_sky130_ef_sc_hd__decap_40_12
XFILLER_109_57 vssd1 vccd1 vssd1 vccd1 SS_sky130_ef_sc_hd__decap_40_12
XFILLER_106_326 vssd1 vccd1 vccd1 vssd1 SS_sky130_fd_sc_hd__fill_8
XFILLER_133_167 vccd1 vssd1 vccd1 vssd1 SS_sky130_fd_sc_hd__fill_1
XTAP_TAPCELL_ROW_132_2285 vccd1 vssd1 SS_sky130_fd_sc_hd__tapvpwrvgnd_1
XFILLER_0_615 vccd1 vssd1 vccd1 vssd1 SS_sky130_fd_sc_hd__fill_1
XFILLER_87_221 vssd1 vccd1 vccd1 vssd1 SS_sky130_fd_sc_hd__fill_2
XFILLER_121_318 vssd1 vccd1 vssd1 vccd1 SS_sky130_ef_sc_hd__decap_40_12
XFILLER_102_510 vssd1 vccd1 vssd1 vccd1 SS_sky130_ef_sc_hd__decap_40_12
XFILLER_88_755 vccd1 vssd1 vccd1 vssd1 SS_sky130_fd_sc_hd__fill_1
XFILLER_85_27 vssd1 vccd1 vssd1 vccd1 SS_sky130_ef_sc_hd__decap_40_12
XFILLER_28_321 vssd1 vccd1 vssd1 vccd1 SS_sky130_ef_sc_hd__decap_40_12
XFILLER_56_630 vssd1 vccd1 vssd1 vccd1 SS_sky130_ef_sc_hd__decap_40_12
XFILLER_75_449 vssd1 vccd1 vssd1 vccd1 SS_sky130_ef_sc_hd__decap_40_12
XFILLER_18_65 vssd1 vccd1 vssd1 vccd1 SS_sky130_ef_sc_hd__decap_40_12
XFILLER_28_365 vssd1 vccd1 vssd1 vccd1 SS_sky130_ef_sc_hd__decap_40_12
XFILLER_44_825 vccd1 vssd1 vccd1 vssd1 SS_sky130_fd_sc_hd__fill_1
XTAP_TAPCELL_ROW_39_883 vccd1 vssd1 SS_sky130_fd_sc_hd__tapvpwrvgnd_1
XFILLER_43_335 vccd1 vssd1 vccd1 vssd1 SS_sky130_fd_sc_hd__fill_1
XTAP_TAPCELL_ROW_48_1014 vccd1 vssd1 SS_sky130_fd_sc_hd__tapvpwrvgnd_1
XTAP_TAPCELL_ROW_48_1025 vccd1 vssd1 SS_sky130_fd_sc_hd__tapvpwrvgnd_1
XFILLER_70_121 vssd1 vccd1 vssd1 vccd1 SS_sky130_ef_sc_hd__decap_40_12
XFILLER_34_53 vssd1 vccd1 vssd1 vccd1 SS_sky130_ef_sc_hd__decap_40_12
XTAP_TAPCELL_ROW_61_1214 vccd1 vssd1 SS_sky130_fd_sc_hd__tapvpwrvgnd_1
XFILLER_70_165 vssd1 vccd1 vssd1 vccd1 SS_sky130_ef_sc_hd__decap_40_12
XFILLER_11_221 vssd1 vccd1 vccd1 vssd1 SS_sky130_fd_sc_hd__fill_2
XFILLER_12_755 vccd1 vssd1 vccd1 vssd1 SS_sky130_fd_sc_hd__fill_1
XFILLER_34_97 vssd1 vccd1 vssd1 vccd1 SS_sky130_ef_sc_hd__decap_40_12
XFILLER_8_737 vssd1 vccd1 vssd1 vccd1 SS_sky130_ef_sc_hd__decap_40_12
XFILLER_129_418 vssd1 vccd1 vssd1 vccd1 SS_sky130_ef_sc_hd__decap_40_12
XFILLER_7_225 vssd1 vccd1 vssd1 vccd1 SS_sky130_ef_sc_hd__decap_40_12
XFILLER_50_41 vssd1 vccd1 vssd1 vccd1 SS_sky130_ef_sc_hd__decap_40_12
XFILLER_50_85 vssd1 vccd1 vssd1 vccd1 SS_sky130_ef_sc_hd__decap_40_12
XFILLER_137_473 vssd1 vccd1 vccd1 vssd1 SS_sky130_fd_sc_hd__fill_2
XFILLER_125_613 vssd1 vccd1 vccd1 vssd1 SS_sky130_fd_sc_hd__fill_2
XFILLER_137_495 vccd1 vssd1 vccd1 vssd1 SS_sky130_fd_sc_hd__fill_1
XTAP_TAPCELL_ROW_59_1187 vccd1 vssd1 SS_sky130_fd_sc_hd__tapvpwrvgnd_1
XFILLER_98_519 vssd1 vccd1 vccd1 vssd1 SS_sky130_fd_sc_hd__fill_8
XFILLER_3_497 vssd1 vccd1 vccd1 vssd1 SS_sky130_fd_sc_hd__fill_4
XFILLER_124_189 vssd1 vccd1 vccd1 vssd1 SS_sky130_fd_sc_hd__fill_4
XTAP_TAPCELL_ROW_72_1376 vccd1 vssd1 SS_sky130_fd_sc_hd__tapvpwrvgnd_1
XTAP_TAPCELL_ROW_72_1387 vccd1 vssd1 SS_sky130_fd_sc_hd__tapvpwrvgnd_1
XFILLER_78_221 vssd1 vccd1 vssd1 vccd1 SS_sky130_ef_sc_hd__decap_40_12
XFILLER_79_777 vssd1 vccd1 vccd1 vssd1 SS_sky130_fd_sc_hd__fill_4
XFILLER_121_841 vccd1 vssd1 vccd1 vssd1 SS_sky130_fd_sc_hd__fill_1
XFILLER_78_265 vssd1 vccd1 vssd1 vccd1 SS_sky130_ef_sc_hd__decap_40_12
XFILLER_94_725 vssd1 vccd1 vssd1 vccd1 SS_sky130_ef_sc_hd__decap_40_12
XFILLER_47_641 vssd1 vccd1 vssd1 vccd1 SS_sky130_ef_sc_hd__decap_40_12
XFILLER_94_747 vccd1 vssd1 vccd1 vssd1 SS_sky130_fd_sc_hd__fill_1
X_1020_ vccd1 vssd1 vccd1 vssd1 _1020_/X _1829_/A _1050_/B SS_sky130_fd_sc_hd__or2_2
XFILLER_93_279 vccd1 vssd1 vccd1 vssd1 SS_sky130_fd_sc_hd__fill_1
XFILLER_47_685 vssd1 vccd1 vssd1 vccd1 SS_sky130_ef_sc_hd__decap_40_12
XFILLER_75_93 vssd1 vccd1 vssd1 vccd1 SS_sky130_ef_sc_hd__decap_40_12
XTAP_TAPCELL_ROW_17_555 vccd1 vssd1 SS_sky130_fd_sc_hd__tapvpwrvgnd_1
XFILLER_34_357 vssd1 vccd1 vccd1 vssd1 SS_sky130_fd_sc_hd__fill_4
XFILLER_46_195 vccd1 vssd1 vccd1 vssd1 SS_sky130_fd_sc_hd__fill_1
XFILLER_62_677 vssd1 vccd1 vssd1 vccd1 SS_sky130_ef_sc_hd__decap_40_12
XFILLER_61_165 vssd1 vccd1 vccd1 vssd1 SS_sky130_fd_sc_hd__fill_2
XFILLER_62_699 vccd1 vssd1 vccd1 vssd1 SS_sky130_fd_sc_hd__fill_1
XFILLER_91_81 vssd1 vccd1 vssd1 vccd1 SS_sky130_ef_sc_hd__decap_40_12
X_1853_ vccd1 vssd1 _1853_/X _1853_/A vccd1 vssd1 SS_sky130_fd_sc_hd__buf_2
XFILLER_30_585 vssd1 vccd1 vccd1 vssd1 SS_sky130_fd_sc_hd__fill_2
X_0804_ vccd1 vssd1 vccd1 vssd1 _1675_/Q _0891_/B1 _1886_/A wire454/A _0804_/X SS_sky130_fd_sc_hd__a22o_2
XFILLER_128_473 vssd1 vccd1 vccd1 vssd1 SS_sky130_fd_sc_hd__fill_2
XFILLER_116_613 vssd1 vccd1 vssd1 vccd1 SS_sky130_ef_sc_hd__decap_40_12
XFILLER_7_781 vssd1 vccd1 vccd1 vssd1 SS_sky130_fd_sc_hd__fill_2
Xhold704 _1130_/A _1596_/Q vccd1 vssd1 vssd1 vccd1 SS_sky130_fd_sc_hd__dlygate4sd3_1
Xhold737 input26/A wbs_dat_i[15] vccd1 vssd1 vssd1 vccd1 SS_sky130_fd_sc_hd__dlygate4sd3_1
XFILLER_116_657 vssd1 vccd1 vssd1 vccd1 SS_sky130_ef_sc_hd__decap_40_12
Xhold726 _1376_/A _1715_/Q vccd1 vssd1 vssd1 vccd1 SS_sky130_fd_sc_hd__dlygate4sd3_1
Xhold715 _1336_/A _1696_/Q vccd1 vssd1 vssd1 vccd1 SS_sky130_fd_sc_hd__dlygate4sd3_1
Xhold759 _1744_/D _1437_/X vccd1 vssd1 vssd1 vccd1 SS_sky130_fd_sc_hd__dlygate4sd3_1
XFILLER_89_519 vccd1 vssd1 vccd1 vssd1 SS_sky130_fd_sc_hd__fill_1
XFILLER_115_167 vccd1 vssd1 vccd1 vssd1 SS_sky130_fd_sc_hd__fill_1
Xhold748 _1388_/A _1721_/Q vccd1 vssd1 vssd1 vccd1 SS_sky130_fd_sc_hd__dlygate4sd3_1
XFILLER_69_221 vssd1 vccd1 vccd1 vssd1 SS_sky130_fd_sc_hd__fill_2
XFILLER_130_137 vssd1 vccd1 vccd1 vssd1 SS_sky130_fd_sc_hd__fill_2
XFILLER_97_541 vssd1 vccd1 vccd1 vssd1 SS_sky130_fd_sc_hd__fill_2
XFILLER_57_405 vssd1 vccd1 vssd1 vccd1 SS_sky130_ef_sc_hd__decap_40_12
XFILLER_85_725 vssd1 vccd1 vccd1 vssd1 SS_sky130_fd_sc_hd__fill_2
XFILLER_97_596 vssd1 vccd1 vssd1 vccd1 SS_sky130_ef_sc_hd__decap_40_12
XFILLER_38_630 vssd1 vccd1 vssd1 vccd1 SS_sky130_ef_sc_hd__decap_40_12
XFILLER_72_419 vccd1 vssd1 vccd1 vssd1 SS_sky130_fd_sc_hd__fill_1
X_1218_ vccd1 vssd1 vccd1 vssd1 _1218_/X _1638_/Q _1272_/B SS_sky130_fd_sc_hd__or2_2
XFILLER_65_482 vssd1 vccd1 vssd1 vccd1 SS_sky130_ef_sc_hd__decap_40_12
XFILLER_93_780 vssd1 vccd1 vccd1 vssd1 SS_sky130_fd_sc_hd__fill_4
XFILLER_25_335 vccd1 vssd1 vccd1 vssd1 SS_sky130_fd_sc_hd__fill_1
X_1149_ vssd1 vccd1 vccd1 vssd1 wire233/X input31/X _1604_/D _1149_/C1 _1148_/X SS_sky130_fd_sc_hd__o211a_2
XTAP_TAPCELL_ROW_36_842 vccd1 vssd1 SS_sky130_fd_sc_hd__tapvpwrvgnd_1
XFILLER_52_121 vssd1 vccd1 vssd1 vccd1 SS_sky130_ef_sc_hd__decap_40_12
XFILLER_53_666 vssd1 vccd1 vccd1 vssd1 SS_sky130_fd_sc_hd__fill_4
XFILLER_40_305 vssd1 vccd1 vccd1 vssd1 SS_sky130_fd_sc_hd__fill_2
XFILLER_41_817 vccd1 vssd1 vccd1 vssd1 SS_sky130_fd_sc_hd__fill_1
XFILLER_52_165 vssd1 vccd1 vssd1 vccd1 SS_sky130_ef_sc_hd__decap_40_12
XFILLER_53_677 vssd1 vccd1 vccd1 vssd1 SS_sky130_fd_sc_hd__fill_2
XFILLER_71_18 vssd1 vccd1 vssd1 vccd1 SS_sky130_ef_sc_hd__decap_40_12
XFILLER_111_69 vssd1 vccd1 vssd1 vccd1 SS_sky130_ef_sc_hd__decap_40_12
XTAP_TAPCELL_ROW_101_1815 vccd1 vssd1 SS_sky130_fd_sc_hd__tapvpwrvgnd_1
XFILLER_21_541 vssd1 vccd1 vssd1 vccd1 SS_sky130_ef_sc_hd__decap_40_12
XFILLER_21_585 vssd1 vccd1 vssd1 vccd1 SS_sky130_ef_sc_hd__decap_40_12
XTAP_TAPCELL_ROW_134_2303 vccd1 vssd1 SS_sky130_fd_sc_hd__tapvpwrvgnd_1
XTAP_TAPCELL_ROW_134_2314 vccd1 vssd1 SS_sky130_fd_sc_hd__tapvpwrvgnd_1
XFILLER_5_729 vssd1 vccd1 vssd1 vccd1 SS_sky130_ef_sc_hd__decap_40_12
XFILLER_119_473 vssd1 vccd1 vssd1 vccd1 SS_sky130_ef_sc_hd__decap_40_12
XFILLER_107_613 vssd1 vccd1 vccd1 vssd1 SS_sky130_fd_sc_hd__fill_2
XFILLER_134_410 vssd1 vccd1 vccd1 vssd1 SS_sky130_fd_sc_hd__fill_2
XFILLER_134_421 vssd1 vccd1 vccd1 vssd1 SS_sky130_fd_sc_hd__fill_4
XFILLER_20_77 vssd1 vccd1 vccd1 vssd1 SS_sky130_fd_sc_hd__fill_4
XFILLER_122_649 vssd1 vccd1 vccd1 vssd1 SS_sky130_fd_sc_hd__fill_2
XFILLER_106_189 vssd1 vccd1 vccd1 vssd1 SS_sky130_fd_sc_hd__fill_4
XFILLER_96_26 vssd1 vccd1 vccd1 vssd1 SS_sky130_fd_sc_hd__fill_2
XFILLER_121_137 vssd1 vccd1 vssd1 vccd1 SS_sky130_ef_sc_hd__decap_40_12
XFILLER_115_690 vccd1 vssd1 vccd1 vssd1 SS_sky130_fd_sc_hd__fill_1
XTAP_TAPCELL_ROW_112_1977 vccd1 vssd1 SS_sky130_fd_sc_hd__tapvpwrvgnd_1
XFILLER_103_841 vccd1 vssd1 vccd1 vssd1 SS_sky130_fd_sc_hd__fill_1
XFILLER_76_725 vssd1 vccd1 vssd1 vccd1 SS_sky130_ef_sc_hd__decap_40_12
XFILLER_130_693 vssd1 vccd1 vccd1 vssd1 SS_sky130_fd_sc_hd__fill_4
XFILLER_75_279 vccd1 vssd1 vccd1 vssd1 SS_sky130_fd_sc_hd__fill_1
XFILLER_91_717 vssd1 vccd1 vccd1 vssd1 SS_sky130_fd_sc_hd__fill_8
XFILLER_29_685 vssd1 vccd1 vccd1 vssd1 SS_sky130_fd_sc_hd__fill_8
XFILLER_44_633 vssd1 vccd1 vccd1 vssd1 SS_sky130_fd_sc_hd__fill_2
XFILLER_16_357 vssd1 vccd1 vccd1 vssd1 SS_sky130_fd_sc_hd__fill_4
XFILLER_28_195 vccd1 vssd1 vccd1 vssd1 SS_sky130_fd_sc_hd__fill_1
XFILLER_44_655 vccd1 vssd1 vccd1 vssd1 SS_sky130_fd_sc_hd__fill_1
XFILLER_90_249 vssd1 vccd1 vccd1 vssd1 SS_sky130_fd_sc_hd__fill_2
XTAP_TAPCELL_ROW_14_503 vccd1 vssd1 SS_sky130_fd_sc_hd__tapvpwrvgnd_1
XFILLER_31_305 vssd1 vccd1 vssd1 vccd1 SS_sky130_ef_sc_hd__decap_40_12
XFILLER_43_165 vssd1 vccd1 vccd1 vssd1 SS_sky130_fd_sc_hd__fill_2
XFILLER_44_699 vccd1 vssd1 vccd1 vssd1 SS_sky130_fd_sc_hd__fill_1
XTAP_TAPCELL_ROW_14_514 vccd1 vssd1 SS_sky130_fd_sc_hd__tapvpwrvgnd_1
XFILLER_31_349 vssd1 vccd1 vssd1 vccd1 SS_sky130_ef_sc_hd__decap_40_12
XFILLER_8_501 vssd1 vccd1 vssd1 vccd1 SS_sky130_ef_sc_hd__decap_40_12
XFILLER_8_545 vssd1 vccd1 vssd1 vccd1 SS_sky130_ef_sc_hd__decap_40_12
XFILLER_12_585 vssd1 vccd1 vccd1 vssd1 SS_sky130_fd_sc_hd__fill_2
XFILLER_129_237 vssd1 vccd1 vssd1 vccd1 SS_sky130_ef_sc_hd__decap_40_12
XFILLER_8_589 vssd1 vccd1 vssd1 vccd1 SS_sky130_ef_sc_hd__decap_40_12
XANTENNA_6 wire207/A vssd1 vccd1 vccd1 vssd1 SS_sky130_fd_sc_hd__diode_2
XFILLER_137_281 vssd1 vccd1 vccd1 vssd1 SS_sky130_fd_sc_hd__fill_2
XFILLER_125_432 vssd1 vccd1 vccd1 vssd1 SS_sky130_fd_sc_hd__fill_8
XTAP_TAPCELL_ROW_74_1405 vccd1 vssd1 SS_sky130_fd_sc_hd__tapvpwrvgnd_1
XTAP_TAPCELL_ROW_74_1416 vccd1 vssd1 SS_sky130_fd_sc_hd__tapvpwrvgnd_1
XFILLER_125_465 vssd1 vccd1 vccd1 vssd1 SS_sky130_fd_sc_hd__fill_4
XFILLER_99_817 vccd1 vssd1 vccd1 vssd1 SS_sky130_fd_sc_hd__fill_1
XFILLER_98_305 vssd1 vccd1 vccd1 vssd1 SS_sky130_fd_sc_hd__fill_2
XFILLER_3_261 vssd1 vccd1 vssd1 vccd1 SS_sky130_ef_sc_hd__decap_40_12
XFILLER_125_476 vssd1 vccd1 vccd1 vssd1 SS_sky130_fd_sc_hd__fill_2
XFILLER_79_541 vssd1 vccd1 vccd1 vssd1 SS_sky130_fd_sc_hd__fill_8
XFILLER_112_137 vssd1 vccd1 vccd1 vssd1 SS_sky130_fd_sc_hd__fill_2
XFILLER_39_405 vssd1 vccd1 vssd1 vccd1 SS_sky130_ef_sc_hd__decap_40_12
XFILLER_39_449 vssd1 vccd1 vccd1 vssd1 SS_sky130_fd_sc_hd__fill_8
XFILLER_86_81 vssd1 vccd1 vccd1 vssd1 SS_sky130_fd_sc_hd__fill_2
XFILLER_94_566 vssd1 vccd1 vccd1 vssd1 SS_sky130_fd_sc_hd__fill_2
XFILLER_35_611 vssd1 vccd1 vccd1 vssd1 SS_sky130_fd_sc_hd__fill_4
XFILLER_81_205 vssd1 vccd1 vssd1 vccd1 SS_sky130_ef_sc_hd__decap_40_12
X_1003_ vssd1 vccd1 vccd1 vssd1 wire253/X input39/X _1534_/D _1465_/C1 _1002_/X SS_sky130_fd_sc_hd__o211a_2
XFILLER_34_121 vssd1 vccd1 vssd1 vccd1 SS_sky130_ef_sc_hd__decap_40_12
XFILLER_81_249 vssd1 vccd1 vssd1 vccd1 SS_sky130_ef_sc_hd__decap_40_12
XFILLER_22_305 vssd1 vccd1 vccd1 vssd1 SS_sky130_fd_sc_hd__fill_2
XFILLER_34_165 vssd1 vccd1 vssd1 vccd1 SS_sky130_ef_sc_hd__decap_40_12
XTAP_TAPCELL_ROW_33_801 vccd1 vssd1 SS_sky130_fd_sc_hd__tapvpwrvgnd_1
XFILLER_62_474 vssd1 vccd1 vccd1 vssd1 SS_sky130_fd_sc_hd__fill_2
XTAP_TAPCELL_ROW_85_1578 vccd1 vssd1 SS_sky130_fd_sc_hd__tapvpwrvgnd_1
X_1905_ vccd1 vssd1 _1905_/X _1905_/A vccd1 vssd1 SS_sky130_fd_sc_hd__buf_2
XPHY_EDGE_ROW_6_Right_6 vccd1 vssd1 vccd1 vssd1 SS_sky130_fd_sc_hd__decap_3
X_1836_ vccd1 vssd1 _1836_/X _1836_/A vccd1 vssd1 SS_sky130_fd_sc_hd__buf_2
XTAP_TAPCELL_ROW_116_2044 vccd1 vssd1 SS_sky130_fd_sc_hd__tapvpwrvgnd_1
XTAP_TAPCELL_ROW_116_2033 vccd1 vssd1 SS_sky130_fd_sc_hd__tapvpwrvgnd_1
XFILLER_116_421 vssd1 vccd1 vccd1 vssd1 SS_sky130_fd_sc_hd__fill_8
Xhold578 _1426_/A _1903_/A vccd1 vssd1 vssd1 vccd1 SS_sky130_fd_sc_hd__dlygate4sd3_1
XFILLER_89_305 vssd1 vccd1 vssd1 vccd1 SS_sky130_ef_sc_hd__decap_40_12
X_1698_ _1698_/Q _1761_/CLK _1698_/D vccd1 vssd1 vccd1 vssd1 SS_sky130_fd_sc_hd__dfxtp_2
Xhold567 input22/A wbs_dat_i[11] vccd1 vssd1 vssd1 vccd1 SS_sky130_fd_sc_hd__dlygate4sd3_1
Xhold589 _1368_/A _1711_/Q vccd1 vssd1 vssd1 vccd1 SS_sky130_fd_sc_hd__dlygate4sd3_1
XFILLER_103_137 vssd1 vccd1 vssd1 vccd1 SS_sky130_ef_sc_hd__decap_40_12
XFILLER_66_18 vssd1 vccd1 vccd1 vssd1 SS_sky130_fd_sc_hd__fill_8
XFILLER_66_29 vssd1 vccd1 vssd1 vccd1 SS_sky130_ef_sc_hd__decap_40_12
XFILLER_85_533 vssd1 vccd1 vssd1 vccd1 SS_sky130_ef_sc_hd__decap_40_12
Xload_slew481 vccd1 vssd1 _1461_/C1 _1329_/C1 vccd1 vssd1 SS_sky130_fd_sc_hd__buf_4
XFILLER_112_693 vssd1 vccd1 vccd1 vssd1 SS_sky130_fd_sc_hd__fill_4
XFILLER_111_181 vssd1 vccd1 vssd1 vccd1 SS_sky130_ef_sc_hd__decap_40_12
XFILLER_97_393 vssd1 vccd1 vssd1 vccd1 SS_sky130_ef_sc_hd__decap_40_12
XFILLER_97_382 vccd1 vssd1 vccd1 vssd1 SS_sky130_fd_sc_hd__fill_1
XFILLER_58_769 vssd1 vccd1 vccd1 vssd1 SS_sky130_fd_sc_hd__fill_4
XFILLER_57_279 vccd1 vssd1 vccd1 vssd1 SS_sky130_fd_sc_hd__fill_1
XFILLER_53_430 vssd1 vccd1 vccd1 vssd1 SS_sky130_fd_sc_hd__fill_4
XFILLER_72_249 vssd1 vccd1 vccd1 vssd1 SS_sky130_fd_sc_hd__fill_2
XTAP_TAPCELL_ROW_0_286 vccd1 vssd1 SS_sky130_fd_sc_hd__tapvpwrvgnd_1
XTAP_TAPCELL_ROW_0_297 vccd1 vssd1 SS_sky130_fd_sc_hd__tapvpwrvgnd_1
XFILLER_13_305 vssd1 vccd1 vssd1 vccd1 SS_sky130_ef_sc_hd__decap_40_12
XFILLER_14_817 vssd1 vccd1 vccd1 vssd1 SS_sky130_fd_sc_hd__fill_2
XFILLER_25_165 vssd1 vccd1 vccd1 vssd1 SS_sky130_fd_sc_hd__fill_2
XFILLER_81_783 vccd1 vssd1 vccd1 vssd1 SS_sky130_fd_sc_hd__fill_1
XFILLER_13_349 vssd1 vccd1 vssd1 vccd1 SS_sky130_ef_sc_hd__decap_40_12
XFILLER_15_55 vccd1 vssd1 vccd1 vssd1 SS_sky130_fd_sc_hd__fill_1
XFILLER_21_393 vssd1 vccd1 vssd1 vccd1 SS_sky130_ef_sc_hd__decap_40_12
XFILLER_31_54 vssd1 vccd1 vccd1 vssd1 SS_sky130_fd_sc_hd__fill_2
XFILLER_119_281 vssd1 vccd1 vssd1 vccd1 SS_sky130_ef_sc_hd__decap_40_12
XFILLER_110_3 vssd1 vccd1 vssd1 vccd1 SS_sky130_ef_sc_hd__decap_40_12
XFILLER_5_559 vccd1 vssd1 vccd1 vssd1 SS_sky130_fd_sc_hd__fill_1
XFILLER_135_741 vssd1 vccd1 vccd1 vssd1 SS_sky130_fd_sc_hd__fill_4
XTAP_TAPCELL_ROW_56_1135 vccd1 vssd1 SS_sky130_fd_sc_hd__tapvpwrvgnd_1
XTAP_TAPCELL_ROW_56_1146 vccd1 vssd1 SS_sky130_fd_sc_hd__tapvpwrvgnd_1
XFILLER_134_251 vccd1 vssd1 vccd1 vssd1 SS_sky130_fd_sc_hd__fill_1
XFILLER_135_785 vssd1 vccd1 vssd1 vccd1 SS_sky130_ef_sc_hd__decap_40_12
XFILLER_122_413 vssd1 vccd1 vccd1 vssd1 SS_sky130_fd_sc_hd__fill_4
XFILLER_1_721 vssd1 vccd1 vccd1 vssd1 SS_sky130_fd_sc_hd__fill_4
Xoutput54 vccd1 vssd1 wire306/A _1826_/X vccd1 vssd1 SS_sky130_fd_sc_hd__buf_4
Xoutput76 vccd1 vssd1 wire284/A _1837_/X vccd1 vssd1 SS_sky130_fd_sc_hd__buf_4
Xoutput65 vccd1 vssd1 wire295/A _1900_/X vccd1 vssd1 SS_sky130_fd_sc_hd__buf_4
XFILLER_0_253 vssd1 vccd1 vssd1 vccd1 SS_sky130_ef_sc_hd__decap_40_12
XFILLER_1_765 vssd1 vccd1 vssd1 vccd1 SS_sky130_ef_sc_hd__decap_40_12
Xoutput87 vccd1 vssd1 wire273/A _1847_/X vccd1 vssd1 SS_sky130_fd_sc_hd__buf_4
Xoutput98 vccd1 vssd1 wire262/A _1857_/X vccd1 vssd1 SS_sky130_fd_sc_hd__buf_4
XFILLER_49_725 vssd1 vccd1 vccd1 vssd1 SS_sky130_fd_sc_hd__fill_2
XFILLER_103_671 vccd1 vssd1 vccd1 vssd1 SS_sky130_fd_sc_hd__fill_1
XFILLER_76_533 vssd1 vccd1 vssd1 vccd1 SS_sky130_ef_sc_hd__decap_40_12
XFILLER_36_419 vccd1 vssd1 vccd1 vssd1 SS_sky130_fd_sc_hd__fill_1
XFILLER_63_205 vssd1 vccd1 vssd1 vccd1 SS_sky130_ef_sc_hd__decap_40_12
XFILLER_16_121 vssd1 vccd1 vssd1 vccd1 SS_sky130_ef_sc_hd__decap_40_12
XFILLER_63_249 vssd1 vccd1 vssd1 vccd1 SS_sky130_ef_sc_hd__decap_40_12
XFILLER_16_165 vssd1 vccd1 vssd1 vccd1 SS_sky130_ef_sc_hd__decap_40_12
XFILLER_72_772 vssd1 vccd1 vccd1 vssd1 SS_sky130_fd_sc_hd__fill_8
XFILLER_31_113 vssd1 vccd1 vssd1 vccd1 SS_sky130_ef_sc_hd__decap_40_12
XFILLER_71_293 vssd1 vccd1 vssd1 vccd1 SS_sky130_ef_sc_hd__decap_40_12
XFILLER_72_83 vccd1 vssd1 vccd1 vssd1 SS_sky130_fd_sc_hd__fill_1
XPHY_EDGE_ROW_59_Right_59 vccd1 vssd1 vccd1 vssd1 SS_sky130_fd_sc_hd__decap_3
XTAP_TAPCELL_ROW_80_1497 vccd1 vssd1 SS_sky130_fd_sc_hd__tapvpwrvgnd_1
X_1621_ _1621_/Q _1751_/CLK _1621_/D vccd1 vssd1 vccd1 vssd1 SS_sky130_fd_sc_hd__dfxtp_2
X_1552_ _1552_/Q clkload5/A _1552_/D vccd1 vssd1 vccd1 vssd1 SS_sky130_fd_sc_hd__dfxtp_2
XFILLER_125_273 vssd1 vccd1 vccd1 vssd1 SS_sky130_fd_sc_hd__fill_4
XFILLER_4_581 vssd1 vccd1 vccd1 vssd1 SS_sky130_fd_sc_hd__fill_4
X_1483_ _1483_/Q _1742_/CLK _1483_/D vccd1 vssd1 vccd1 vssd1 SS_sky130_fd_sc_hd__dfxtp_2
XPHY_EDGE_ROW_68_Right_68 vccd1 vssd1 vccd1 vssd1 SS_sky130_fd_sc_hd__decap_3
XFILLER_79_393 vssd1 vccd1 vccd1 vssd1 SS_sky130_fd_sc_hd__fill_2
XFILLER_95_820 vssd1 vccd1 vccd1 vssd1 SS_sky130_fd_sc_hd__fill_4
XTAP_TAPCELL_ROW_87_1607 vccd1 vssd1 SS_sky130_fd_sc_hd__tapvpwrvgnd_1
XFILLER_39_279 vccd1 vssd1 vccd1 vssd1 SS_sky130_fd_sc_hd__fill_1
XFILLER_94_363 vccd1 vssd1 vccd1 vssd1 SS_sky130_fd_sc_hd__fill_1
XFILLER_35_441 vssd1 vccd1 vccd1 vssd1 SS_sky130_fd_sc_hd__fill_4
XFILLER_54_249 vssd1 vccd1 vccd1 vssd1 SS_sky130_fd_sc_hd__fill_2
XFILLER_35_485 vssd1 vccd1 vssd1 vccd1 SS_sky130_ef_sc_hd__decap_40_12
XTAP_TAPCELL_ROW_46_992 vccd1 vssd1 SS_sky130_fd_sc_hd__tapvpwrvgnd_1
XFILLER_50_433 vssd1 vccd1 vssd1 vccd1 SS_sky130_ef_sc_hd__decap_40_12
XFILLER_11_809 vssd1 vccd1 vccd1 vssd1 SS_sky130_fd_sc_hd__fill_8
XFILLER_23_669 vssd1 vccd1 vccd1 vssd1 SS_sky130_fd_sc_hd__fill_2
XPHY_EDGE_ROW_77_Right_77 vccd1 vssd1 vccd1 vssd1 SS_sky130_fd_sc_hd__decap_3
XFILLER_50_477 vssd1 vccd1 vccd1 vssd1 SS_sky130_fd_sc_hd__fill_2
XTAP_TAPCELL_ROW_98_1769 vccd1 vssd1 SS_sky130_fd_sc_hd__tapvpwrvgnd_1
XFILLER_117_741 vssd1 vccd1 vccd1 vssd1 SS_sky130_fd_sc_hd__fill_8
XFILLER_2_529 vssd1 vccd1 vccd1 vssd1 SS_sky130_fd_sc_hd__fill_2
XFILLER_89_113 vssd1 vccd1 vssd1 vccd1 SS_sky130_ef_sc_hd__decap_40_12
XFILLER_132_722 vssd1 vccd1 vssd1 vccd1 SS_sky130_ef_sc_hd__decap_40_12
XFILLER_117_785 vssd1 vccd1 vssd1 vccd1 SS_sky130_ef_sc_hd__decap_40_12
XFILLER_116_251 vccd1 vssd1 vccd1 vssd1 SS_sky130_fd_sc_hd__fill_1
XFILLER_131_221 vssd1 vccd1 vccd1 vssd1 SS_sky130_fd_sc_hd__fill_2
XFILLER_117_57 vssd1 vccd1 vssd1 vccd1 SS_sky130_ef_sc_hd__decap_40_12
XFILLER_77_39 vssd1 vccd1 vssd1 vccd1 SS_sky130_ef_sc_hd__decap_40_12
XPHY_EDGE_ROW_86_Right_86 vccd1 vssd1 vccd1 vssd1 SS_sky130_fd_sc_hd__decap_3
XFILLER_104_457 vssd1 vccd1 vccd1 vssd1 SS_sky130_fd_sc_hd__fill_8
XFILLER_58_533 vccd1 vssd1 vccd1 vssd1 SS_sky130_fd_sc_hd__fill_1
XTAP_TAPCELL_ROW_129_2235 vccd1 vssd1 SS_sky130_fd_sc_hd__tapvpwrvgnd_1
XTAP_TAPCELL_ROW_5_378 vccd1 vssd1 SS_sky130_fd_sc_hd__tapvpwrvgnd_1
XTAP_TAPCELL_ROW_51_1065 vccd1 vssd1 SS_sky130_fd_sc_hd__tapvpwrvgnd_1
XFILLER_58_566 vssd1 vccd1 vssd1 vccd1 SS_sky130_ef_sc_hd__decap_40_12
XFILLER_100_641 vssd1 vccd1 vccd1 vssd1 SS_sky130_fd_sc_hd__fill_2
XFILLER_18_419 vccd1 vssd1 vccd1 vssd1 SS_sky130_fd_sc_hd__fill_1
XFILLER_45_205 vssd1 vccd1 vssd1 vccd1 SS_sky130_ef_sc_hd__decap_40_12
XFILLER_73_503 vccd1 vssd1 vccd1 vssd1 SS_sky130_fd_sc_hd__fill_1
XFILLER_45_249 vssd1 vccd1 vssd1 vccd1 SS_sky130_ef_sc_hd__decap_40_12
XFILLER_61_709 vssd1 vccd1 vssd1 vccd1 SS_sky130_ef_sc_hd__decap_40_12
XFILLER_26_65 vssd1 vccd1 vssd1 vccd1 SS_sky130_ef_sc_hd__decap_40_12
XFILLER_13_113 vssd1 vccd1 vssd1 vccd1 SS_sky130_ef_sc_hd__decap_40_12
XFILLER_14_625 vssd1 vccd1 vssd1 vccd1 SS_sky130_ef_sc_hd__decap_40_12
XFILLER_53_293 vssd1 vccd1 vssd1 vccd1 SS_sky130_ef_sc_hd__decap_40_12
XTAP_TAPCELL_ROW_107_1898 vccd1 vssd1 SS_sky130_fd_sc_hd__tapvpwrvgnd_1
XPHY_EDGE_ROW_95_Right_95 vccd1 vssd1 vccd1 vssd1 SS_sky130_fd_sc_hd__decap_3
XFILLER_14_669 vssd1 vccd1 vssd1 vccd1 SS_sky130_ef_sc_hd__decap_40_12
XTAP_TAPCELL_ROW_24_653 vccd1 vssd1 SS_sky130_fd_sc_hd__tapvpwrvgnd_1
XTAP_TAPCELL_ROW_24_664 vccd1 vssd1 SS_sky130_fd_sc_hd__tapvpwrvgnd_1
XFILLER_41_477 vssd1 vccd1 vssd1 vccd1 SS_sky130_ef_sc_hd__decap_40_12
XFILLER_42_53 vssd1 vccd1 vssd1 vccd1 SS_sky130_ef_sc_hd__decap_40_12
XFILLER_127_505 vssd1 vccd1 vccd1 vssd1 SS_sky130_fd_sc_hd__fill_8
XFILLER_6_813 vssd1 vccd1 vssd1 vccd1 SS_sky130_ef_sc_hd__decap_40_12
XFILLER_42_97 vssd1 vccd1 vssd1 vccd1 SS_sky130_ef_sc_hd__decap_40_12
XFILLER_108_741 vccd1 vssd1 vccd1 vssd1 SS_sky130_fd_sc_hd__fill_1
XPHY_EDGE_ROW_2_Left_141 vccd1 vssd1 vccd1 vssd1 SS_sky130_fd_sc_hd__decap_3
XFILLER_5_389 vssd1 vccd1 vccd1 vssd1 SS_sky130_fd_sc_hd__fill_2
XPHY_EDGE_ROW_39_Left_178 vccd1 vssd1 vccd1 vssd1 SS_sky130_fd_sc_hd__decap_3
XFILLER_107_273 vssd1 vccd1 vccd1 vssd1 SS_sky130_fd_sc_hd__fill_4
XFILLER_69_809 vssd1 vccd1 vccd1 vssd1 SS_sky130_fd_sc_hd__fill_8
XFILLER_122_221 vssd1 vccd1 vssd1 vccd1 SS_sky130_ef_sc_hd__decap_40_12
XFILLER_123_777 vssd1 vccd1 vccd1 vssd1 SS_sky130_fd_sc_hd__fill_4
XFILLER_122_265 vssd1 vccd1 vssd1 vccd1 SS_sky130_ef_sc_hd__decap_40_12
XFILLER_95_105 vssd1 vccd1 vccd1 vssd1 SS_sky130_fd_sc_hd__fill_4
XFILLER_1_573 vssd1 vccd1 vssd1 vccd1 SS_sky130_ef_sc_hd__decap_40_12
XFILLER_3_69 vssd1 vccd1 vssd1 vccd1 SS_sky130_ef_sc_hd__decap_40_12
XFILLER_95_149 vssd1 vccd1 vssd1 vccd1 SS_sky130_ef_sc_hd__decap_40_12
XTAP_TAPCELL_ROW_69_1337 vccd1 vssd1 SS_sky130_fd_sc_hd__tapvpwrvgnd_1
XFILLER_76_363 vccd1 vssd1 vccd1 vssd1 SS_sky130_fd_sc_hd__fill_1
XFILLER_92_834 vssd1 vccd1 vccd1 vssd1 SS_sky130_fd_sc_hd__fill_2
XFILLER_36_249 vssd1 vccd1 vccd1 vssd1 SS_sky130_fd_sc_hd__fill_2
XFILLER_91_333 vssd1 vccd1 vccd1 vssd1 SS_sky130_fd_sc_hd__fill_2
XFILLER_17_441 vssd1 vccd1 vccd1 vssd1 SS_sky130_fd_sc_hd__fill_4
XFILLER_45_783 vccd1 vssd1 vccd1 vssd1 SS_sky130_fd_sc_hd__fill_1
XPHY_EDGE_ROW_48_Left_187 vccd1 vssd1 vccd1 vssd1 SS_sky130_fd_sc_hd__decap_3
XFILLER_17_485 vssd1 vccd1 vssd1 vccd1 SS_sky130_ef_sc_hd__decap_40_12
XFILLER_32_433 vssd1 vccd1 vssd1 vccd1 SS_sky130_ef_sc_hd__decap_40_12
XFILLER_60_720 vssd1 vccd1 vssd1 vccd1 SS_sky130_ef_sc_hd__decap_40_12
XTAP_TAPCELL_ROW_82_1526 vccd1 vssd1 SS_sky130_fd_sc_hd__tapvpwrvgnd_1
XTAP_TAPCELL_ROW_82_1537 vccd1 vssd1 SS_sky130_fd_sc_hd__tapvpwrvgnd_1
XFILLER_83_93 vssd1 vccd1 vssd1 vccd1 SS_sky130_ef_sc_hd__decap_40_12
XTAP_TAPCELL_ROW_43_940 vccd1 vssd1 SS_sky130_fd_sc_hd__tapvpwrvgnd_1
XTAP_TAPCELL_ROW_43_951 vccd1 vssd1 SS_sky130_fd_sc_hd__tapvpwrvgnd_1
XFILLER_32_477 vssd1 vccd1 vssd1 vccd1 SS_sky130_ef_sc_hd__decap_40_12
X_0983_ vssd1 vccd1 vccd1 vssd1 _0985_/A2 input28/X _1524_/D _1437_/C1 _0982_/X SS_sky130_fd_sc_hd__o211a_2
XFILLER_9_673 vssd1 vccd1 vssd1 vccd1 SS_sky130_ef_sc_hd__decap_40_12
XPHY_EDGE_ROW_57_Left_196 vccd1 vssd1 vccd1 vssd1 SS_sky130_fd_sc_hd__decap_3
X_1604_ _1847_/A clkload9/A _1604_/D vccd1 vssd1 vccd1 vssd1 SS_sky130_fd_sc_hd__dfxtp_2
XFILLER_113_221 vssd1 vccd1 vccd1 vssd1 SS_sky130_fd_sc_hd__fill_2
X_1535_ _1535_/Q _1762_/CLK _1535_/D vccd1 vssd1 vccd1 vssd1 SS_sky130_fd_sc_hd__dfxtp_2
XFILLER_99_488 vccd1 vssd1 vccd1 vssd1 SS_sky130_fd_sc_hd__fill_1
XTAP_TAPCELL_ROW_93_1699 vccd1 vssd1 SS_sky130_fd_sc_hd__tapvpwrvgnd_1
XTAP_TAPCELL_ROW_93_1688 vccd1 vssd1 SS_sky130_fd_sc_hd__tapvpwrvgnd_1
X_1466_ vccd1 vssd1 vccd1 vssd1 _1466_/X _1466_/A _1466_/B SS_sky130_fd_sc_hd__or2_2
XFILLER_67_341 vssd1 vccd1 vccd1 vssd1 SS_sky130_fd_sc_hd__fill_2
X_1397_ vssd1 vccd1 vccd1 vssd1 _1397_/A2 input38/X _1725_/D _1465_/C1 _1396_/X SS_sky130_fd_sc_hd__o211a_2
XFILLER_101_449 vssd1 vccd1 vssd1 vccd1 SS_sky130_ef_sc_hd__decap_40_12
XTAP_TAPCELL_ROW_2_326 vccd1 vssd1 SS_sky130_fd_sc_hd__tapvpwrvgnd_1
XTAP_TAPCELL_ROW_2_337 vccd1 vssd1 SS_sky130_fd_sc_hd__tapvpwrvgnd_1
XFILLER_27_205 vssd1 vccd1 vssd1 vccd1 SS_sky130_ef_sc_hd__decap_40_12
XFILLER_28_728 vssd1 vccd1 vssd1 vccd1 SS_sky130_ef_sc_hd__decap_40_12
XFILLER_55_525 vssd1 vccd1 vccd1 vssd1 SS_sky130_fd_sc_hd__fill_2
XFILLER_67_374 vccd1 vssd1 vccd1 vssd1 SS_sky130_fd_sc_hd__fill_1
XFILLER_27_249 vssd1 vccd1 vssd1 vccd1 SS_sky130_ef_sc_hd__decap_40_12
XTAP_TAPCELL_ROW_124_2154 vccd1 vssd1 SS_sky130_fd_sc_hd__tapvpwrvgnd_1
XFILLER_94_193 vssd1 vccd1 vccd1 vssd1 SS_sky130_fd_sc_hd__fill_2
XFILLER_82_377 vssd1 vccd1 vssd1 vccd1 SS_sky130_ef_sc_hd__decap_40_12
XTAP_TAPCELL_ROW_124_2165 vccd1 vssd1 SS_sky130_fd_sc_hd__tapvpwrvgnd_1
XFILLER_35_293 vssd1 vccd1 vssd1 vccd1 SS_sky130_ef_sc_hd__decap_40_12
XFILLER_51_753 vssd1 vccd1 vssd1 vccd1 SS_sky130_ef_sc_hd__decap_40_12
XFILLER_11_617 vssd1 vccd1 vssd1 vccd1 SS_sky130_ef_sc_hd__decap_40_12
XTAP_TAPCELL_ROW_21_612 vccd1 vssd1 SS_sky130_fd_sc_hd__tapvpwrvgnd_1
XFILLER_51_797 vssd1 vccd1 vccd1 vssd1 SS_sky130_fd_sc_hd__fill_8
XFILLER_109_505 vssd1 vccd1 vssd1 vccd1 SS_sky130_ef_sc_hd__decap_40_12
XFILLER_6_109 vssd1 vccd1 vssd1 vccd1 SS_sky130_ef_sc_hd__decap_40_12
XFILLER_136_313 vssd1 vccd1 vccd1 vssd1 SS_sky130_fd_sc_hd__fill_2
XFILLER_104_221 vssd1 vccd1 vssd1 vccd1 SS_sky130_ef_sc_hd__decap_40_12
XFILLER_132_552 vssd1 vccd1 vssd1 vccd1 SS_sky130_ef_sc_hd__decap_40_12
XFILLER_104_265 vssd1 vccd1 vssd1 vccd1 SS_sky130_ef_sc_hd__decap_40_12
XFILLER_77_105 vssd1 vccd1 vccd1 vssd1 SS_sky130_fd_sc_hd__fill_4
XFILLER_120_725 vssd1 vccd1 vssd1 vccd1 SS_sky130_ef_sc_hd__decap_40_12
XFILLER_77_149 vssd1 vccd1 vssd1 vccd1 SS_sky130_ef_sc_hd__decap_40_12
XFILLER_120_769 vssd1 vccd1 vssd1 vccd1 SS_sky130_ef_sc_hd__decap_40_12
XFILLER_58_363 vccd1 vssd1 vccd1 vssd1 SS_sky130_fd_sc_hd__fill_1
XTAP_TAPCELL_ROW_109_1938 vccd1 vssd1 SS_sky130_fd_sc_hd__tapvpwrvgnd_1
Xafe_wb_541 afe_wb_541/LO analog_io_oeb[5] vccd1 vssd1 vssd1 vccd1 SS_sky130_fd_sc_hd__conb_1
XFILLER_18_249 vssd1 vccd1 vccd1 vssd1 SS_sky130_fd_sc_hd__fill_2
XTAP_TAPCELL_ROW_29_734 vccd1 vssd1 SS_sky130_fd_sc_hd__tapvpwrvgnd_1
Xafe_wb_552 afe_wb_552/LO analog_io_oeb[16] vccd1 vssd1 vssd1 vccd1 SS_sky130_fd_sc_hd__conb_1
Xafe_wb_563 afe_wb_563/LO analog_io_oeb[27] vccd1 vssd1 vssd1 vccd1 SS_sky130_fd_sc_hd__conb_1
XFILLER_85_193 vssd1 vccd1 vssd1 vccd1 SS_sky130_ef_sc_hd__decap_40_12
Xafe_wb_530 analog_io_out[22] afe_wb_530/HI vccd1 vssd1 vssd1 vccd1 SS_sky130_fd_sc_hd__conb_1
XFILLER_73_366 vssd1 vccd1 vssd1 vccd1 SS_sky130_ef_sc_hd__decap_40_12
XFILLER_42_720 vssd1 vccd1 vssd1 vccd1 SS_sky130_ef_sc_hd__decap_40_12
XFILLER_14_433 vssd1 vccd1 vssd1 vccd1 SS_sky130_ef_sc_hd__decap_40_12
XFILLER_53_30 vssd1 vccd1 vssd1 vccd1 SS_sky130_ef_sc_hd__decap_40_12
XTAP_TAPCELL_ROW_64_1256 vccd1 vssd1 SS_sky130_fd_sc_hd__tapvpwrvgnd_1
XTAP_TAPCELL_ROW_64_1267 vccd1 vssd1 SS_sky130_fd_sc_hd__tapvpwrvgnd_1
XFILLER_14_477 vssd1 vccd1 vssd1 vccd1 SS_sky130_ef_sc_hd__decap_40_12
XFILLER_127_324 vssd1 vccd1 vccd1 vssd1 SS_sky130_fd_sc_hd__fill_2
XFILLER_6_643 vccd1 vssd1 vccd1 vssd1 SS_sky130_fd_sc_hd__fill_1
XFILLER_135_390 vssd1 vccd1 vccd1 vssd1 SS_sky130_fd_sc_hd__fill_2
XFILLER_69_617 vssd1 vccd1 vssd1 vccd1 SS_sky130_ef_sc_hd__decap_40_12
X_1320_ vccd1 vssd1 vccd1 vssd1 _1320_/X _1320_/A _1338_/B SS_sky130_fd_sc_hd__or2_2
XFILLER_38_6 vssd1 vccd1 vssd1 vccd1 SS_sky130_ef_sc_hd__decap_40_12
XFILLER_111_725 vssd1 vccd1 vccd1 vssd1 SS_sky130_fd_sc_hd__fill_2
XFILLER_111_758 vssd1 vccd1 vccd1 vssd1 SS_sky130_fd_sc_hd__fill_2
X_1251_ vssd1 vccd1 vccd1 vssd1 _1265_/A2 input30/X _1654_/D _1251_/C1 _1250_/X SS_sky130_fd_sc_hd__o211a_2
XFILLER_37_503 vccd1 vssd1 vccd1 vssd1 SS_sky130_fd_sc_hd__fill_1
X_1182_ vccd1 vssd1 vccd1 vssd1 _1182_/X _1182_/A _1208_/B SS_sky130_fd_sc_hd__or2_2
XFILLER_37_558 vssd1 vccd1 vccd1 vssd1 SS_sky130_fd_sc_hd__fill_2
XFILLER_49_385 vssd1 vccd1 vccd1 vssd1 SS_sky130_fd_sc_hd__fill_4
XFILLER_64_344 vssd1 vccd1 vccd1 vssd1 SS_sky130_fd_sc_hd__fill_8
XFILLER_76_193 vssd1 vccd1 vccd1 vssd1 SS_sky130_fd_sc_hd__fill_2
XFILLER_94_81 vssd1 vccd1 vccd1 vssd1 SS_sky130_fd_sc_hd__fill_2
XFILLER_18_750 vssd1 vccd1 vccd1 vssd1 SS_sky130_fd_sc_hd__fill_4
XFILLER_25_709 vssd1 vccd1 vssd1 vccd1 SS_sky130_ef_sc_hd__decap_40_12
XFILLER_64_377 vssd1 vccd1 vssd1 vccd1 SS_sky130_ef_sc_hd__decap_40_12
XFILLER_52_539 vccd1 vssd1 vccd1 vssd1 SS_sky130_fd_sc_hd__fill_1
XFILLER_17_293 vssd1 vccd1 vssd1 vccd1 SS_sky130_ef_sc_hd__decap_40_12
XFILLER_33_753 vssd1 vccd1 vssd1 vccd1 SS_sky130_ef_sc_hd__decap_40_12
XFILLER_20_469 vssd1 vccd1 vccd1 vssd1 SS_sky130_fd_sc_hd__fill_4
XPHY_EDGE_ROW_65_Left_204 vccd1 vssd1 vccd1 vssd1 SS_sky130_fd_sc_hd__decap_3
X_0966_ vccd1 vssd1 vccd1 vssd1 _0966_/X _0966_/A _1006_/B SS_sky130_fd_sc_hd__or2_2
Xclkbuf_leaf_9_wb_clk_i _1692_/CLK clkbuf_leaf_9_wb_clk_i/A vccd1 vssd1 vssd1 vccd1
+ SS_sky130_fd_sc_hd__clkbuf_8
XFILLER_118_346 vssd1 vccd1 vssd1 vccd1 SS_sky130_ef_sc_hd__decap_40_12
XTAP_TAPCELL_ROW_95_1728 vccd1 vssd1 SS_sky130_fd_sc_hd__tapvpwrvgnd_1
XFILLER_133_305 vssd1 vccd1 vssd1 vccd1 SS_sky130_ef_sc_hd__decap_40_12
Xoutput200 vccd1 vssd1 wire355/A _1482_/Q vccd1 vssd1 SS_sky130_fd_sc_hd__buf_4
X_0897_ vccd1 vssd1 vccd1 vssd1 _1531_/Q _0947_/A _1755_/Q _1409_/A _0897_/X SS_sky130_fd_sc_hd__a22o_2
XFILLER_133_349 vccd1 vssd1 vccd1 vssd1 SS_sky130_fd_sc_hd__fill_1
XTAP_TAPCELL_ROW_7_407 vccd1 vssd1 SS_sky130_fd_sc_hd__tapvpwrvgnd_1
X_1518_ _1518_/Q clkload3/A _1518_/D vccd1 vssd1 vccd1 vssd1 SS_sky130_fd_sc_hd__dfxtp_2
XFILLER_59_105 vssd1 vccd1 vccd1 vssd1 SS_sky130_fd_sc_hd__fill_4
XFILLER_59_149 vssd1 vccd1 vssd1 vccd1 SS_sky130_ef_sc_hd__decap_40_12
XFILLER_87_447 vccd1 vssd1 vccd1 vssd1 SS_sky130_fd_sc_hd__fill_1
X_1449_ vssd1 vccd1 vccd1 vssd1 wire207/A input30/X _1750_/D _1461_/C1 _1448_/X SS_sky130_fd_sc_hd__o211a_2
XFILLER_102_769 vssd1 vccd1 vssd1 vccd1 SS_sky130_ef_sc_hd__decap_40_12
XPHY_EDGE_ROW_74_Left_213 vccd1 vssd1 vccd1 vssd1 SS_sky130_fd_sc_hd__decap_3
XFILLER_101_279 vccd1 vssd1 vccd1 vssd1 SS_sky130_fd_sc_hd__fill_1
XFILLER_28_525 vssd1 vccd1 vccd1 vssd1 SS_sky130_fd_sc_hd__fill_4
XFILLER_67_193 vssd1 vccd1 vssd1 vccd1 SS_sky130_ef_sc_hd__decap_40_12
XFILLER_74_29 vssd1 vccd1 vssd1 vccd1 SS_sky130_ef_sc_hd__decap_40_12
XFILLER_28_569 vssd1 vccd1 vssd1 vccd1 SS_sky130_ef_sc_hd__decap_40_12
XFILLER_82_141 vssd1 vccd1 vssd1 vccd1 SS_sky130_ef_sc_hd__decap_40_12
XFILLER_83_697 vssd1 vccd1 vssd1 vccd1 SS_sky130_ef_sc_hd__decap_40_12
XFILLER_70_347 vssd1 vccd1 vssd1 vccd1 SS_sky130_ef_sc_hd__decap_40_12
XTAP_TAPCELL_ROW_104_1857 vccd1 vssd1 SS_sky130_fd_sc_hd__tapvpwrvgnd_1
XFILLER_24_797 vssd1 vccd1 vccd1 vssd1 SS_sky130_fd_sc_hd__fill_2
XFILLER_11_447 vccd1 vssd1 vccd1 vssd1 SS_sky130_fd_sc_hd__fill_1
XPHY_EDGE_ROW_83_Left_222 vccd1 vssd1 vccd1 vssd1 SS_sky130_fd_sc_hd__decap_3
Xwire305 vccd1 vssd1 vssd1 vccd1 wire305/A analog_ctrl[104] SS_sky130_fd_sc_hd__buf_12
XFILLER_7_429 vssd1 vccd1 vssd1 vccd1 SS_sky130_ef_sc_hd__decap_40_12
Xwire338 vccd1 vssd1 vssd1 vccd1 wire338/A analog_ctrl[3] SS_sky130_fd_sc_hd__buf_12
Xwire327 vccd1 vssd1 vssd1 vccd1 wire327/A analog_ctrl[4] SS_sky130_fd_sc_hd__buf_12
Xwire316 vccd1 vssd1 vssd1 vccd1 wire316/A analog_ctrl[5] SS_sky130_fd_sc_hd__buf_12
XTAP_TAPCELL_ROW_137_2356 vccd1 vssd1 SS_sky130_fd_sc_hd__tapvpwrvgnd_1
XFILLER_136_121 vssd1 vccd1 vssd1 vccd1 SS_sky130_ef_sc_hd__decap_40_12
XFILLER_137_633 vssd1 vccd1 vccd1 vssd1 SS_sky130_fd_sc_hd__fill_8
XFILLER_109_335 vccd1 vssd1 vccd1 vssd1 SS_sky130_fd_sc_hd__fill_1
XFILLER_99_15 vssd1 vccd1 vssd1 vccd1 SS_sky130_ef_sc_hd__decap_40_12
XFILLER_136_176 vssd1 vccd1 vccd1 vssd1 SS_sky130_fd_sc_hd__fill_2
XFILLER_124_305 vssd1 vccd1 vccd1 vssd1 SS_sky130_fd_sc_hd__fill_2
XFILLER_3_613 vssd1 vccd1 vccd1 vssd1 SS_sky130_fd_sc_hd__fill_2
XFILLER_117_390 vssd1 vccd1 vccd1 vssd1 SS_sky130_fd_sc_hd__fill_2
XFILLER_2_189 vssd1 vccd1 vccd1 vssd1 SS_sky130_fd_sc_hd__fill_4
XFILLER_78_425 vccd1 vssd1 vccd1 vssd1 SS_sky130_fd_sc_hd__fill_1
XPHY_EDGE_ROW_92_Left_231 vccd1 vssd1 vccd1 vssd1 SS_sky130_fd_sc_hd__decap_3
XFILLER_48_41 vssd1 vccd1 vssd1 vccd1 SS_sky130_ef_sc_hd__decap_40_12
XFILLER_66_609 vssd1 vccd1 vccd1 vssd1 SS_sky130_fd_sc_hd__fill_2
XFILLER_78_458 vccd1 vssd1 vccd1 vssd1 SS_sky130_fd_sc_hd__fill_1
XFILLER_120_533 vssd1 vccd1 vccd1 vssd1 SS_sky130_fd_sc_hd__fill_2
XFILLER_19_503 vccd1 vssd1 vccd1 vssd1 SS_sky130_fd_sc_hd__fill_1
XFILLER_48_85 vssd1 vccd1 vssd1 vccd1 SS_sky130_ef_sc_hd__decap_40_12
Xfanout482 vssd1 vccd1 vccd1 vssd1 wire493/A _1133_/C1 SS_sky130_fd_sc_hd__clkdlybuf4s25_1
Xfanout460 vssd1 vccd1 vccd1 vssd1 _0738_/D _1459_/C1 SS_sky130_fd_sc_hd__clkdlybuf4s25_1
XFILLER_93_417 vssd1 vccd1 vssd1 vccd1 SS_sky130_ef_sc_hd__decap_40_12
XFILLER_0_15 vssd1 vccd1 vssd1 vccd1 SS_sky130_ef_sc_hd__decap_40_12
XFILLER_46_333 vssd1 vccd1 vssd1 vccd1 SS_sky130_ef_sc_hd__decap_40_12
XFILLER_58_193 vssd1 vccd1 vccd1 vssd1 SS_sky130_fd_sc_hd__fill_2
XFILLER_0_37 vssd1 vccd1 vssd1 vccd1 SS_sky130_ef_sc_hd__decap_40_12
XFILLER_46_377 vssd1 vccd1 vssd1 vccd1 SS_sky130_ef_sc_hd__decap_40_12
XFILLER_61_325 vccd1 vssd1 vccd1 vssd1 SS_sky130_fd_sc_hd__fill_1
XFILLER_74_697 vssd1 vccd1 vccd1 vssd1 SS_sky130_fd_sc_hd__fill_2
XFILLER_15_753 vssd1 vccd1 vssd1 vccd1 SS_sky130_ef_sc_hd__decap_40_12
XFILLER_61_369 vssd1 vccd1 vccd1 vssd1 SS_sky130_fd_sc_hd__fill_4
XFILLER_15_797 vssd1 vccd1 vssd1 vccd1 SS_sky130_ef_sc_hd__decap_40_12
XFILLER_30_701 vssd1 vccd1 vssd1 vccd1 SS_sky130_ef_sc_hd__decap_40_12
XFILLER_9_57 vssd1 vccd1 vssd1 vccd1 SS_sky130_ef_sc_hd__decap_40_12
X_0820_ vccd1 vssd1 vccd1 vssd1 _0819_/X _1906_/A _0874_/A2 _1874_/A _0876_/B1 _0820_/X
+ SS_sky130_fd_sc_hd__a221o_2
XFILLER_80_83 vccd1 vssd1 vccd1 vssd1 SS_sky130_fd_sc_hd__fill_1
XTAP_TAPCELL_ROW_12_475 vccd1 vssd1 SS_sky130_fd_sc_hd__tapvpwrvgnd_1
XTAP_TAPCELL_ROW_12_486 vccd1 vssd1 SS_sky130_fd_sc_hd__tapvpwrvgnd_1
X_0751_ vccd1 vssd1 vccd1 vssd1 _0945_/D _1474_/Q _0945_/C _0945_/B _0751_/X SS_sky130_fd_sc_hd__or4bb_2
XFILLER_116_806 vssd1 vccd1 vccd1 vssd1 SS_sky130_fd_sc_hd__fill_4
XFILLER_128_699 vccd1 vssd1 vccd1 vssd1 SS_sky130_fd_sc_hd__fill_1
XFILLER_127_165 vssd1 vccd1 vccd1 vssd1 SS_sky130_fd_sc_hd__fill_2
XFILLER_116_817 vssd1 vccd1 vccd1 vssd1 SS_sky130_fd_sc_hd__fill_2
XFILLER_6_473 vssd1 vccd1 vccd1 vssd1 SS_sky130_fd_sc_hd__fill_2
XTAP_TAPCELL_ROW_77_1458 vccd1 vssd1 SS_sky130_fd_sc_hd__tapvpwrvgnd_1
XFILLER_89_81 vssd1 vccd1 vssd1 vccd1 SS_sky130_ef_sc_hd__decap_40_12
XTAP_TAPCELL_ROW_90_1647 vccd1 vssd1 SS_sky130_fd_sc_hd__tapvpwrvgnd_1
X_1303_ vssd1 vccd1 vccd1 vssd1 _1337_/A2 wire499/X _1679_/D wire467/X _1302_/X SS_sky130_fd_sc_hd__o211a_2
XFILLER_69_447 vccd1 vssd1 vccd1 vssd1 SS_sky130_fd_sc_hd__fill_1
XFILLER_123_393 vssd1 vccd1 vssd1 vccd1 SS_sky130_ef_sc_hd__decap_40_12
XFILLER_96_233 vssd1 vccd1 vssd1 vccd1 SS_sky130_ef_sc_hd__decap_40_12
X_1234_ vccd1 vssd1 vccd1 vssd1 _1234_/X _1646_/Q _1264_/B SS_sky130_fd_sc_hd__or2_2
XFILLER_84_417 vssd1 vccd1 vccd1 vssd1 SS_sky130_fd_sc_hd__fill_2
XFILLER_111_577 vssd1 vccd1 vccd1 vssd1 SS_sky130_fd_sc_hd__fill_2
XFILLER_96_277 vssd1 vccd1 vssd1 vccd1 SS_sky130_ef_sc_hd__decap_40_12
XFILLER_37_333 vssd1 vccd1 vccd1 vssd1 SS_sky130_fd_sc_hd__fill_2
XFILLER_49_193 vssd1 vccd1 vssd1 vccd1 SS_sky130_ef_sc_hd__decap_40_12
X_1165_ vssd1 vccd1 vccd1 vssd1 wire233/X wire494/X _1612_/D _1165_/C1 _1164_/X SS_sky130_fd_sc_hd__o211a_2
XFILLER_64_141 vssd1 vccd1 vssd1 vccd1 SS_sky130_ef_sc_hd__decap_40_12
XFILLER_65_653 vssd1 vccd1 vssd1 vccd1 SS_sky130_ef_sc_hd__decap_40_12
XFILLER_80_601 vssd1 vccd1 vccd1 vssd1 SS_sky130_fd_sc_hd__fill_4
XFILLER_25_517 vssd1 vccd1 vssd1 vccd1 SS_sky130_ef_sc_hd__decap_40_12
X_1096_ vccd1 vssd1 vccd1 vssd1 _1096_/X _1096_/A _1116_/B SS_sky130_fd_sc_hd__or2_2
XFILLER_65_697 vssd1 vccd1 vssd1 vccd1 SS_sky130_ef_sc_hd__decap_40_12
XTAP_TAPCELL_ROW_121_2113 vccd1 vssd1 SS_sky130_fd_sc_hd__tapvpwrvgnd_1
XFILLER_80_645 vssd1 vccd1 vssd1 vccd1 SS_sky130_ef_sc_hd__decap_40_12
XFILLER_21_701 vssd1 vccd1 vccd1 vssd1 SS_sky130_fd_sc_hd__fill_4
XFILLER_21_723 vssd1 vccd1 vccd1 vssd1 SS_sky130_fd_sc_hd__fill_4
XFILLER_33_561 vssd1 vccd1 vssd1 vccd1 SS_sky130_ef_sc_hd__decap_40_12
XFILLER_100_27 vccd1 vssd1 vccd1 vssd1 SS_sky130_fd_sc_hd__fill_1
XFILLER_20_233 vssd1 vccd1 vssd1 vccd1 SS_sky130_ef_sc_hd__decap_40_12
XTAP_TAPCELL_ROW_31_762 vccd1 vssd1 SS_sky130_fd_sc_hd__tapvpwrvgnd_1
XFILLER_138_419 vccd1 vssd1 vccd1 vssd1 SS_sky130_fd_sc_hd__fill_1
XFILLER_20_277 vssd1 vccd1 vssd1 vccd1 SS_sky130_ef_sc_hd__decap_40_12
XTAP_TAPCELL_ROW_119_2086 vccd1 vssd1 SS_sky130_fd_sc_hd__tapvpwrvgnd_1
XFILLER_118_121 vssd1 vccd1 vssd1 vccd1 SS_sky130_ef_sc_hd__decap_40_12
X_0949_ vssd1 vccd1 vccd1 vssd1 _0989_/A2 input20/X _1507_/D _1149_/C1 _0948_/X SS_sky130_fd_sc_hd__o211a_2
XFILLER_118_165 vssd1 vccd1 vssd1 vccd1 SS_sky130_ef_sc_hd__decap_40_12
XFILLER_106_305 vssd1 vccd1 vccd1 vssd1 SS_sky130_fd_sc_hd__fill_2
XFILLER_133_113 vssd1 vccd1 vssd1 vccd1 SS_sky130_ef_sc_hd__decap_40_12
XFILLER_109_69 vssd1 vccd1 vssd1 vccd1 SS_sky130_ef_sc_hd__decap_40_12
XFILLER_88_701 vssd1 vccd1 vssd1 vccd1 SS_sky130_ef_sc_hd__decap_40_12
XTAP_TAPCELL_ROW_132_2275 vccd1 vssd1 SS_sky130_fd_sc_hd__tapvpwrvgnd_1
XTAP_TAPCELL_ROW_132_2286 vccd1 vssd1 SS_sky130_fd_sc_hd__tapvpwrvgnd_1
XFILLER_121_308 vssd1 vccd1 vccd1 vssd1 SS_sky130_fd_sc_hd__fill_4
XFILLER_102_522 vssd1 vccd1 vccd1 vssd1 SS_sky130_fd_sc_hd__fill_8
XFILLER_125_57 vssd1 vccd1 vssd1 vccd1 SS_sky130_ef_sc_hd__decap_40_12
XFILLER_102_533 vssd1 vccd1 vssd1 vccd1 SS_sky130_ef_sc_hd__decap_40_12
XFILLER_85_39 vssd1 vccd1 vssd1 vccd1 SS_sky130_ef_sc_hd__decap_40_12
XFILLER_87_277 vssd1 vccd1 vccd1 vssd1 SS_sky130_fd_sc_hd__fill_2
XFILLER_28_333 vssd1 vccd1 vssd1 vccd1 SS_sky130_ef_sc_hd__decap_40_12
XFILLER_56_642 vssd1 vccd1 vccd1 vssd1 SS_sky130_fd_sc_hd__fill_2
XFILLER_18_77 vssd1 vccd1 vccd1 vssd1 SS_sky130_fd_sc_hd__fill_4
XFILLER_28_377 vssd1 vccd1 vssd1 vccd1 SS_sky130_ef_sc_hd__decap_40_12
XTAP_TAPCELL_ROW_39_884 vccd1 vssd1 SS_sky130_fd_sc_hd__tapvpwrvgnd_1
XTAP_TAPCELL_ROW_48_1015 vccd1 vssd1 SS_sky130_fd_sc_hd__tapvpwrvgnd_1
XTAP_TAPCELL_ROW_48_1026 vccd1 vssd1 SS_sky130_fd_sc_hd__tapvpwrvgnd_1
XFILLER_56_697 vssd1 vccd1 vccd1 vssd1 SS_sky130_fd_sc_hd__fill_2
XFILLER_70_133 vssd1 vccd1 vccd1 vssd1 SS_sky130_fd_sc_hd__fill_4
XFILLER_12_701 vssd1 vccd1 vssd1 vccd1 SS_sky130_ef_sc_hd__decap_40_12
XTAP_TAPCELL_ROW_61_1215 vccd1 vssd1 SS_sky130_fd_sc_hd__tapvpwrvgnd_1
XFILLER_70_177 vssd1 vccd1 vssd1 vccd1 SS_sky130_ef_sc_hd__decap_40_12
XFILLER_34_65 vssd1 vccd1 vssd1 vccd1 SS_sky130_ef_sc_hd__decap_40_12
XFILLER_51_391 vccd1 vssd1 vccd1 vssd1 SS_sky130_fd_sc_hd__fill_1
XFILLER_7_237 vssd1 vccd1 vssd1 vccd1 SS_sky130_ef_sc_hd__decap_40_12
XFILLER_8_749 vssd1 vccd1 vccd1 vssd1 SS_sky130_fd_sc_hd__fill_4
XFILLER_11_277 vssd1 vccd1 vccd1 vssd1 SS_sky130_fd_sc_hd__fill_2
XFILLER_137_441 vssd1 vccd1 vccd1 vssd1 SS_sky130_fd_sc_hd__fill_4
XFILLER_137_430 vssd1 vccd1 vccd1 vssd1 SS_sky130_fd_sc_hd__fill_4
XFILLER_50_53 vssd1 vccd1 vssd1 vccd1 SS_sky130_ef_sc_hd__decap_40_12
XFILLER_109_165 vssd1 vccd1 vccd1 vssd1 SS_sky130_fd_sc_hd__fill_2
XFILLER_50_97 vssd1 vccd1 vssd1 vccd1 SS_sky130_ef_sc_hd__decap_40_12
XTAP_TAPCELL_ROW_59_1188 vccd1 vssd1 SS_sky130_fd_sc_hd__tapvpwrvgnd_1
XFILLER_113_809 vssd1 vccd1 vccd1 vssd1 SS_sky130_fd_sc_hd__fill_2
XFILLER_59_51 vssd1 vccd1 vccd1 vssd1 SS_sky130_fd_sc_hd__fill_4
XFILLER_121_820 vssd1 vccd1 vccd1 vssd1 SS_sky130_fd_sc_hd__fill_4
XTAP_TAPCELL_ROW_72_1377 vccd1 vssd1 SS_sky130_fd_sc_hd__tapvpwrvgnd_1
XFILLER_78_233 vssd1 vccd1 vssd1 vccd1 SS_sky130_ef_sc_hd__decap_40_12
XFILLER_105_393 vssd1 vccd1 vssd1 vccd1 SS_sky130_ef_sc_hd__decap_40_12
XFILLER_78_277 vssd1 vccd1 vssd1 vccd1 SS_sky130_ef_sc_hd__decap_40_12
XFILLER_120_363 vccd1 vssd1 vccd1 vssd1 SS_sky130_fd_sc_hd__fill_1
XFILLER_94_737 vssd1 vccd1 vccd1 vssd1 SS_sky130_fd_sc_hd__fill_8
XFILLER_120_385 vssd1 vccd1 vccd1 vssd1 SS_sky130_fd_sc_hd__fill_2
XFILLER_93_225 vssd1 vccd1 vssd1 vccd1 SS_sky130_ef_sc_hd__decap_40_12
XFILLER_19_333 vssd1 vccd1 vccd1 vssd1 SS_sky130_fd_sc_hd__fill_2
XFILLER_46_141 vssd1 vccd1 vssd1 vccd1 SS_sky130_ef_sc_hd__decap_40_12
XFILLER_47_653 vssd1 vccd1 vssd1 vccd1 SS_sky130_ef_sc_hd__decap_40_12
XFILLER_47_697 vssd1 vccd1 vssd1 vccd1 SS_sky130_ef_sc_hd__decap_40_12
XFILLER_74_483 vccd1 vssd1 vccd1 vssd1 SS_sky130_fd_sc_hd__fill_1
XFILLER_61_111 vccd1 vssd1 vccd1 vssd1 SS_sky130_fd_sc_hd__fill_1
XFILLER_15_561 vssd1 vccd1 vssd1 vccd1 SS_sky130_ef_sc_hd__decap_40_12
XTAP_TAPCELL_ROW_17_556 vccd1 vssd1 SS_sky130_fd_sc_hd__tapvpwrvgnd_1
XFILLER_62_689 vssd1 vccd1 vccd1 vssd1 SS_sky130_fd_sc_hd__fill_8
XFILLER_30_531 vccd1 vssd1 vccd1 vssd1 SS_sky130_fd_sc_hd__fill_1
XFILLER_91_93 vssd1 vccd1 vssd1 vccd1 SS_sky130_ef_sc_hd__decap_40_12
X_1852_ vccd1 vssd1 _1852_/X _1852_/A vccd1 vssd1 SS_sky130_fd_sc_hd__buf_2
X_0803_ vccd1 vssd1 vccd1 vssd1 _0802_/X _1547_/Q wire424/A _1643_/Q wire431/X _0803_/X
+ SS_sky130_fd_sc_hd__a221o_2
Xhold716 input36/A wbs_dat_i[24] vccd1 vssd1 vssd1 vccd1 SS_sky130_fd_sc_hd__dlygate4sd3_1
Xhold705 _1196_/A _1628_/Q vccd1 vssd1 vssd1 vccd1 SS_sky130_fd_sc_hd__dlygate4sd3_1
XFILLER_116_625 vccd1 vssd1 vccd1 vssd1 SS_sky130_fd_sc_hd__fill_1
XFILLER_115_113 vssd1 vccd1 vssd1 vccd1 SS_sky130_ef_sc_hd__decap_40_12
Xhold727 _1442_/A _1747_/Q vccd1 vssd1 vssd1 vccd1 SS_sky130_fd_sc_hd__dlygate4sd3_1
Xhold738 _1618_/D _1177_/X vccd1 vssd1 vssd1 vccd1 SS_sky130_fd_sc_hd__dlygate4sd3_1
XFILLER_131_606 vssd1 vccd1 vccd1 vssd1 SS_sky130_fd_sc_hd__fill_8
XFILLER_116_669 vssd1 vccd1 vccd1 vssd1 SS_sky130_fd_sc_hd__fill_4
Xhold749 _1454_/A _1753_/Q vccd1 vssd1 vssd1 vccd1 SS_sky130_fd_sc_hd__dlygate4sd3_1
XFILLER_131_617 vssd1 vccd1 vssd1 vccd1 SS_sky130_ef_sc_hd__decap_40_12
XFILLER_57_417 vssd1 vccd1 vssd1 vccd1 SS_sky130_ef_sc_hd__decap_40_12
XFILLER_69_277 vssd1 vccd1 vccd1 vssd1 SS_sky130_fd_sc_hd__fill_2
XFILLER_111_363 vccd1 vssd1 vccd1 vssd1 SS_sky130_fd_sc_hd__fill_1
XFILLER_26_815 vccd1 vssd1 vccd1 vssd1 SS_sky130_fd_sc_hd__fill_1
XFILLER_38_642 vssd1 vccd1 vccd1 vssd1 SS_sky130_fd_sc_hd__fill_2
X_1217_ vssd1 vccd1 vccd1 vssd1 _1273_/A2 input42/X _1637_/D _1417_/C1 _1216_/X SS_sky130_fd_sc_hd__o211a_2
XFILLER_38_697 vssd1 vccd1 vccd1 vssd1 SS_sky130_fd_sc_hd__fill_2
XFILLER_65_461 vccd1 vssd1 vccd1 vssd1 SS_sky130_fd_sc_hd__fill_1
X_1148_ vccd1 vssd1 vccd1 vssd1 _1148_/X _1847_/A _1186_/B SS_sky130_fd_sc_hd__or2_2
XTAP_TAPCELL_ROW_36_843 vccd1 vssd1 SS_sky130_fd_sc_hd__tapvpwrvgnd_1
XFILLER_52_133 vssd1 vccd1 vccd1 vssd1 SS_sky130_fd_sc_hd__fill_4
XFILLER_65_494 vssd1 vccd1 vccd1 vssd1 SS_sky130_fd_sc_hd__fill_8
XFILLER_52_177 vssd1 vccd1 vssd1 vccd1 SS_sky130_ef_sc_hd__decap_40_12
XFILLER_53_689 vssd1 vccd1 vssd1 vccd1 SS_sky130_ef_sc_hd__decap_40_12
XFILLER_80_475 vccd1 vssd1 vccd1 vssd1 SS_sky130_fd_sc_hd__fill_1
X_1079_ vccd1 vssd1 vssd1 vccd1 _1079_/Y _1079_/A _1409_/B SS_sky130_fd_sc_hd__nand2_2
XTAP_TAPCELL_ROW_101_1816 vccd1 vssd1 SS_sky130_fd_sc_hd__tapvpwrvgnd_1
XFILLER_33_391 vccd1 vssd1 vccd1 vssd1 SS_sky130_fd_sc_hd__fill_1
XFILLER_21_553 vssd1 vccd1 vccd1 vssd1 SS_sky130_fd_sc_hd__fill_4
XFILLER_21_597 vssd1 vccd1 vssd1 vccd1 SS_sky130_ef_sc_hd__decap_40_12
XTAP_TAPCELL_ROW_134_2304 vccd1 vssd1 SS_sky130_fd_sc_hd__tapvpwrvgnd_1
XTAP_TAPCELL_ROW_134_2315 vccd1 vssd1 SS_sky130_fd_sc_hd__tapvpwrvgnd_1
XFILLER_138_249 vssd1 vccd1 vccd1 vssd1 SS_sky130_fd_sc_hd__fill_2
XFILLER_119_485 vssd1 vccd1 vssd1 vccd1 SS_sky130_ef_sc_hd__decap_40_12
XFILLER_107_669 vssd1 vccd1 vccd1 vssd1 SS_sky130_fd_sc_hd__fill_2
XFILLER_121_105 vssd1 vccd1 vccd1 vssd1 SS_sky130_fd_sc_hd__fill_4
XFILLER_103_820 vssd1 vccd1 vccd1 vssd1 SS_sky130_fd_sc_hd__fill_4
XFILLER_121_149 vssd1 vccd1 vssd1 vccd1 SS_sky130_ef_sc_hd__decap_40_12
XTAP_TAPCELL_ROW_112_1978 vccd1 vssd1 SS_sky130_fd_sc_hd__tapvpwrvgnd_1
XFILLER_48_417 vssd1 vccd1 vccd1 vssd1 SS_sky130_fd_sc_hd__fill_2
XFILLER_102_363 vccd1 vssd1 vccd1 vssd1 SS_sky130_fd_sc_hd__fill_1
XFILLER_75_225 vssd1 vccd1 vssd1 vccd1 SS_sky130_ef_sc_hd__decap_40_12
XFILLER_76_737 vccd1 vssd1 vccd1 vssd1 SS_sky130_fd_sc_hd__fill_1
XFILLER_102_385 vssd1 vccd1 vccd1 vssd1 SS_sky130_fd_sc_hd__fill_2
XFILLER_28_141 vssd1 vccd1 vssd1 vccd1 SS_sky130_ef_sc_hd__decap_40_12
XFILLER_44_601 vssd1 vccd1 vssd1 vccd1 SS_sky130_ef_sc_hd__decap_40_12
XFILLER_91_729 vssd1 vccd1 vccd1 vssd1 SS_sky130_fd_sc_hd__fill_4
XFILLER_43_111 vccd1 vssd1 vccd1 vssd1 SS_sky130_fd_sc_hd__fill_1
XTAP_TAPCELL_ROW_14_504 vccd1 vssd1 SS_sky130_fd_sc_hd__tapvpwrvgnd_1
XFILLER_31_317 vssd1 vccd1 vssd1 vccd1 SS_sky130_ef_sc_hd__decap_40_12
XTAP_TAPCELL_ROW_14_515 vccd1 vssd1 SS_sky130_fd_sc_hd__tapvpwrvgnd_1
XFILLER_8_513 vssd1 vccd1 vssd1 vccd1 SS_sky130_ef_sc_hd__decap_40_12
XFILLER_12_531 vccd1 vssd1 vccd1 vssd1 SS_sky130_fd_sc_hd__fill_1
XFILLER_61_30 vssd1 vccd1 vssd1 vccd1 SS_sky130_ef_sc_hd__decap_40_12
XFILLER_129_205 vssd1 vccd1 vssd1 vccd1 SS_sky130_ef_sc_hd__decap_40_12
XFILLER_101_81 vssd1 vccd1 vssd1 vccd1 SS_sky130_ef_sc_hd__decap_40_12
XFILLER_129_249 vssd1 vccd1 vssd1 vccd1 SS_sky130_ef_sc_hd__decap_40_12
XFILLER_8_557 vssd1 vccd1 vssd1 vccd1 SS_sky130_ef_sc_hd__decap_40_12
XPHY_EDGE_ROW_20_Left_159 vccd1 vssd1 vccd1 vssd1 SS_sky130_fd_sc_hd__decap_3
XANTENNA_7 _1396_/B vssd1 vccd1 vccd1 vssd1 SS_sky130_fd_sc_hd__diode_2
XTAP_TAPCELL_ROW_74_1406 vccd1 vssd1 SS_sky130_fd_sc_hd__tapvpwrvgnd_1
XTAP_TAPCELL_ROW_74_1417 vccd1 vssd1 SS_sky130_fd_sc_hd__tapvpwrvgnd_1
XFILLER_113_617 vssd1 vccd1 vccd1 vssd1 SS_sky130_fd_sc_hd__fill_2
XFILLER_3_273 vssd1 vccd1 vccd1 vssd1 SS_sky130_fd_sc_hd__fill_4
XFILLER_106_691 vssd1 vccd1 vccd1 vssd1 SS_sky130_fd_sc_hd__fill_8
XFILLER_39_417 vssd1 vccd1 vssd1 vccd1 SS_sky130_ef_sc_hd__decap_40_12
XFILLER_94_501 vssd1 vccd1 vssd1 vccd1 SS_sky130_ef_sc_hd__decap_40_12
Xclkbuf_leaf_23_wb_clk_i clkload7/A clkload1/A vccd1 vssd1 vssd1 vccd1 SS_sky130_fd_sc_hd__clkbuf_8
XFILLER_94_523 vccd1 vssd1 vccd1 vssd1 SS_sky130_fd_sc_hd__fill_1
XFILLER_120_193 vssd1 vccd1 vccd1 vssd1 SS_sky130_fd_sc_hd__fill_2
XFILLER_75_781 vssd1 vccd1 vccd1 vssd1 SS_sky130_fd_sc_hd__fill_2
XFILLER_81_217 vssd1 vccd1 vccd1 vssd1 SS_sky130_fd_sc_hd__fill_4
XFILLER_82_729 vssd1 vccd1 vccd1 vssd1 SS_sky130_fd_sc_hd__fill_2
X_1002_ vccd1 vssd1 vccd1 vssd1 _1002_/X _1002_/A _1006_/B SS_sky130_fd_sc_hd__or2_2
XFILLER_94_589 vssd1 vccd1 vssd1 vccd1 SS_sky130_ef_sc_hd__decap_40_12
XFILLER_34_133 vssd1 vccd1 vccd1 vssd1 SS_sky130_fd_sc_hd__fill_4
XTAP_TAPCELL_ROW_33_802 vccd1 vssd1 SS_sky130_fd_sc_hd__tapvpwrvgnd_1
XFILLER_62_464 vssd1 vccd1 vccd1 vssd1 SS_sky130_fd_sc_hd__fill_2
XTAP_TAPCELL_ROW_85_1568 vccd1 vssd1 SS_sky130_fd_sc_hd__tapvpwrvgnd_1
XTAP_TAPCELL_ROW_85_1579 vccd1 vssd1 SS_sky130_fd_sc_hd__tapvpwrvgnd_1
XFILLER_34_177 vssd1 vccd1 vssd1 vccd1 SS_sky130_ef_sc_hd__decap_40_12
XFILLER_15_391 vccd1 vssd1 vccd1 vssd1 SS_sky130_fd_sc_hd__fill_1
X_1904_ vccd1 vssd1 _1904_/X _1904_/A vccd1 vssd1 SS_sky130_fd_sc_hd__buf_2
XFILLER_30_361 vssd1 vccd1 vccd1 vssd1 SS_sky130_fd_sc_hd__fill_2
X_1835_ vccd1 vssd1 _1835_/X _1835_/A vccd1 vssd1 SS_sky130_fd_sc_hd__buf_2
XTAP_TAPCELL_ROW_116_2034 vccd1 vssd1 SS_sky130_fd_sc_hd__tapvpwrvgnd_1
XFILLER_129_783 vccd1 vssd1 vccd1 vssd1 SS_sky130_fd_sc_hd__fill_1
Xmax_cap210 vccd1 vssd1 _1454_/B _1472_/B vccd1 vssd1 SS_sky130_fd_sc_hd__buf_6
XTAP_TAPCELL_ROW_116_2045 vccd1 vssd1 SS_sky130_fd_sc_hd__tapvpwrvgnd_1
Xhold579 _1360_/A _1886_/A vccd1 vssd1 vssd1 vccd1 SS_sky130_fd_sc_hd__dlygate4sd3_1
XFILLER_89_317 vccd1 vssd1 vccd1 vssd1 SS_sky130_fd_sc_hd__fill_1
X_1697_ _1697_/Q _1761_/CLK _1697_/D vccd1 vssd1 vccd1 vssd1 SS_sky130_fd_sc_hd__dfxtp_2
Xhold568 input46/A wbs_dat_i[4] vccd1 vssd1 vssd1 vccd1 SS_sky130_fd_sc_hd__dlygate4sd3_1
XFILLER_116_477 vssd1 vccd1 vccd1 vssd1 SS_sky130_fd_sc_hd__fill_4
XFILLER_104_639 vssd1 vccd1 vccd1 vssd1 SS_sky130_fd_sc_hd__fill_4
XFILLER_104_628 vssd1 vccd1 vccd1 vssd1 SS_sky130_fd_sc_hd__fill_2
XFILLER_103_105 vssd1 vccd1 vccd1 vssd1 SS_sky130_fd_sc_hd__fill_4
XFILLER_131_425 vssd1 vccd1 vccd1 vssd1 SS_sky130_fd_sc_hd__fill_2
XFILLER_106_26 vssd1 vccd1 vccd1 vssd1 SS_sky130_fd_sc_hd__fill_2
XFILLER_103_149 vssd1 vccd1 vssd1 vccd1 SS_sky130_ef_sc_hd__decap_40_12
XFILLER_85_501 vssd1 vccd1 vccd1 vssd1 SS_sky130_fd_sc_hd__fill_2
Xload_slew471 vccd1 vssd1 _1099_/C1 _1165_/C1 vccd1 vssd1 SS_sky130_fd_sc_hd__buf_4
XFILLER_57_225 vssd1 vccd1 vssd1 vccd1 SS_sky130_ef_sc_hd__decap_40_12
XFILLER_85_545 vssd1 vccd1 vssd1 vccd1 SS_sky130_ef_sc_hd__decap_40_12
XFILLER_85_578 vssd1 vccd1 vssd1 vccd1 SS_sky130_ef_sc_hd__decap_40_12
XFILLER_111_193 vssd1 vccd1 vssd1 vccd1 SS_sky130_ef_sc_hd__decap_40_12
XFILLER_26_601 vssd1 vccd1 vssd1 vccd1 SS_sky130_ef_sc_hd__decap_40_12
XFILLER_66_781 vssd1 vccd1 vccd1 vssd1 SS_sky130_fd_sc_hd__fill_4
XFILLER_73_729 vssd1 vccd1 vssd1 vccd1 SS_sky130_ef_sc_hd__decap_40_12
XFILLER_25_111 vccd1 vssd1 vccd1 vssd1 SS_sky130_fd_sc_hd__fill_1
XFILLER_26_645 vssd1 vccd1 vssd1 vccd1 SS_sky130_ef_sc_hd__decap_40_12
XFILLER_53_420 vssd1 vccd1 vccd1 vssd1 SS_sky130_fd_sc_hd__fill_2
XFILLER_82_29 vssd1 vccd1 vssd1 vccd1 SS_sky130_ef_sc_hd__decap_40_12
XTAP_TAPCELL_ROW_0_287 vccd1 vssd1 SS_sky130_fd_sc_hd__tapvpwrvgnd_1
XFILLER_41_615 vccd1 vssd1 vccd1 vssd1 SS_sky130_fd_sc_hd__fill_1
XTAP_TAPCELL_ROW_0_298 vccd1 vssd1 SS_sky130_fd_sc_hd__tapvpwrvgnd_1
XFILLER_13_317 vssd1 vccd1 vssd1 vccd1 SS_sky130_ef_sc_hd__decap_40_12
XFILLER_21_361 vssd1 vccd1 vssd1 vccd1 SS_sky130_ef_sc_hd__decap_40_12
XFILLER_5_505 vssd1 vccd1 vssd1 vccd1 SS_sky130_ef_sc_hd__decap_40_12
XFILLER_127_709 vssd1 vccd1 vssd1 vccd1 SS_sky130_ef_sc_hd__decap_40_12
XFILLER_119_293 vssd1 vccd1 vccd1 vssd1 SS_sky130_fd_sc_hd__fill_2
XTAP_TAPCELL_ROW_56_1136 vccd1 vssd1 SS_sky130_fd_sc_hd__tapvpwrvgnd_1
XTAP_TAPCELL_ROW_56_1147 vccd1 vssd1 SS_sky130_fd_sc_hd__tapvpwrvgnd_1
XFILLER_135_797 vssd1 vccd1 vccd1 vssd1 SS_sky130_fd_sc_hd__fill_8
XFILLER_0_221 vssd1 vccd1 vccd1 vssd1 SS_sky130_fd_sc_hd__fill_2
Xoutput66 vccd1 vssd1 wire294/A _1901_/X vccd1 vssd1 SS_sky130_fd_sc_hd__buf_4
XFILLER_122_447 vccd1 vssd1 vccd1 vssd1 SS_sky130_fd_sc_hd__fill_1
Xoutput55 vccd1 vssd1 wire305/A _1891_/X vccd1 vssd1 SS_sky130_fd_sc_hd__buf_4
XFILLER_1_777 vssd1 vccd1 vccd1 vssd1 SS_sky130_fd_sc_hd__fill_4
Xoutput77 vccd1 vssd1 wire283/A _1838_/X vccd1 vssd1 SS_sky130_fd_sc_hd__buf_4
Xoutput88 vccd1 vssd1 wire272/A _1848_/X vccd1 vssd1 SS_sky130_fd_sc_hd__buf_4
Xoutput99 vccd1 vssd1 wire261/A _1858_/X vccd1 vssd1 SS_sky130_fd_sc_hd__buf_4
XFILLER_76_501 vssd1 vccd1 vssd1 vccd1 SS_sky130_ef_sc_hd__decap_40_12
XFILLER_103_661 vssd1 vccd1 vccd1 vssd1 SS_sky130_fd_sc_hd__fill_8
XFILLER_0_265 vssd1 vccd1 vssd1 vccd1 SS_sky130_ef_sc_hd__decap_40_12
XFILLER_49_737 vssd1 vccd1 vccd1 vssd1 SS_sky130_fd_sc_hd__fill_2
XFILLER_56_41 vssd1 vccd1 vssd1 vccd1 SS_sky130_ef_sc_hd__decap_40_12
XFILLER_76_545 vssd1 vccd1 vssd1 vccd1 SS_sky130_ef_sc_hd__decap_40_12
XFILLER_102_193 vssd1 vccd1 vccd1 vssd1 SS_sky130_fd_sc_hd__fill_2
XFILLER_29_461 vssd1 vccd1 vssd1 vccd1 SS_sky130_ef_sc_hd__decap_40_12
XFILLER_63_217 vssd1 vccd1 vccd1 vssd1 SS_sky130_fd_sc_hd__fill_4
XFILLER_76_589 vssd1 vccd1 vssd1 vccd1 SS_sky130_ef_sc_hd__decap_40_12
XFILLER_56_85 vssd1 vccd1 vssd1 vccd1 SS_sky130_ef_sc_hd__decap_40_12
XFILLER_91_559 vccd1 vssd1 vccd1 vssd1 SS_sky130_fd_sc_hd__fill_1
XFILLER_16_133 vssd1 vccd1 vccd1 vssd1 SS_sky130_fd_sc_hd__fill_4
XFILLER_44_475 vccd1 vssd1 vccd1 vssd1 SS_sky130_fd_sc_hd__fill_1
XFILLER_16_177 vssd1 vccd1 vssd1 vccd1 SS_sky130_ef_sc_hd__decap_40_12
XFILLER_31_125 vssd1 vccd1 vssd1 vccd1 SS_sky130_ef_sc_hd__decap_40_12
XTAP_TAPCELL_ROW_67_1298 vccd1 vssd1 SS_sky130_fd_sc_hd__tapvpwrvgnd_1
XFILLER_71_261 vssd1 vccd1 vssd1 vccd1 SS_sky130_ef_sc_hd__decap_40_12
XFILLER_8_321 vssd1 vccd1 vssd1 vccd1 SS_sky130_ef_sc_hd__decap_40_12
XFILLER_12_361 vssd1 vccd1 vccd1 vssd1 SS_sky130_fd_sc_hd__fill_2
XFILLER_31_169 vssd1 vccd1 vssd1 vccd1 SS_sky130_ef_sc_hd__decap_40_12
XFILLER_40_681 vssd1 vccd1 vccd1 vssd1 SS_sky130_fd_sc_hd__fill_8
XTAP_TAPCELL_ROW_80_1498 vccd1 vssd1 SS_sky130_fd_sc_hd__tapvpwrvgnd_1
XFILLER_8_365 vssd1 vccd1 vssd1 vccd1 SS_sky130_ef_sc_hd__decap_40_12
XFILLER_68_6 vssd1 vccd1 vssd1 vccd1 SS_sky130_ef_sc_hd__decap_40_12
X_1620_ _1620_/Q _1717_/CLK _1620_/D vccd1 vssd1 vccd1 vssd1 SS_sky130_fd_sc_hd__dfxtp_2
XFILLER_138_591 vccd1 vssd1 vccd1 vssd1 SS_sky130_fd_sc_hd__fill_1
XFILLER_126_753 vssd1 vccd1 vccd1 vssd1 SS_sky130_fd_sc_hd__fill_2
X_1551_ _1551_/Q clkload2/A _1551_/D vccd1 vssd1 vccd1 vssd1 SS_sky130_fd_sc_hd__dfxtp_2
XFILLER_99_615 vccd1 vssd1 vccd1 vssd1 SS_sky130_fd_sc_hd__fill_1
X_1482_ _1482_/Q _1738_/CLK _1482_/D vccd1 vssd1 vccd1 vssd1 SS_sky130_fd_sc_hd__dfxtp_2
XFILLER_113_447 vccd1 vssd1 vccd1 vssd1 SS_sky130_fd_sc_hd__fill_1
XFILLER_86_309 vssd1 vccd1 vssd1 vccd1 SS_sky130_ef_sc_hd__decap_40_12
XFILLER_101_609 vssd1 vccd1 vccd1 vssd1 SS_sky130_fd_sc_hd__fill_4
XFILLER_97_81 vssd1 vccd1 vssd1 vccd1 SS_sky130_ef_sc_hd__decap_40_12
XFILLER_39_225 vssd1 vccd1 vssd1 vccd1 SS_sky130_ef_sc_hd__decap_40_12
XFILLER_79_383 vccd1 vssd1 vccd1 vssd1 SS_sky130_fd_sc_hd__fill_1
XTAP_TAPCELL_ROW_87_1608 vccd1 vssd1 SS_sky130_fd_sc_hd__tapvpwrvgnd_1
XFILLER_48_781 vssd1 vccd1 vccd1 vssd1 SS_sky130_fd_sc_hd__fill_8
XFILLER_55_729 vssd1 vccd1 vssd1 vccd1 SS_sky130_ef_sc_hd__decap_40_12
XFILLER_23_615 vccd1 vssd1 vccd1 vssd1 SS_sky130_fd_sc_hd__fill_1
XFILLER_35_497 vssd1 vccd1 vccd1 vssd1 SS_sky130_fd_sc_hd__fill_4
XTAP_TAPCELL_ROW_46_993 vccd1 vssd1 SS_sky130_fd_sc_hd__tapvpwrvgnd_1
XFILLER_50_401 vssd1 vccd1 vccd1 vssd1 SS_sky130_fd_sc_hd__fill_4
XFILLER_90_581 vssd1 vccd1 vccd1 vssd1 SS_sky130_fd_sc_hd__fill_4
XFILLER_50_445 vssd1 vccd1 vssd1 vccd1 SS_sky130_ef_sc_hd__decap_40_12
XFILLER_10_309 vssd1 vccd1 vssd1 vccd1 SS_sky130_ef_sc_hd__decap_40_12
XFILLER_136_506 vccd1 vssd1 vccd1 vssd1 SS_sky130_fd_sc_hd__fill_1
X_1749_ _1749_/Q clkload2/A _1749_/D vccd1 vssd1 vccd1 vssd1 SS_sky130_fd_sc_hd__dfxtp_2
XFILLER_132_701 vssd1 vccd1 vccd1 vssd1 SS_sky130_fd_sc_hd__fill_8
XFILLER_117_797 vssd1 vccd1 vssd1 vccd1 SS_sky130_ef_sc_hd__decap_40_12
XFILLER_89_125 vssd1 vccd1 vssd1 vccd1 SS_sky130_ef_sc_hd__decap_40_12
XFILLER_132_734 vssd1 vccd1 vssd1 vccd1 SS_sky130_ef_sc_hd__decap_40_12
XFILLER_117_69 vssd1 vccd1 vssd1 vccd1 SS_sky130_ef_sc_hd__decap_40_12
XFILLER_89_169 vssd1 vccd1 vssd1 vccd1 SS_sky130_ef_sc_hd__decap_40_12
XTAP_TAPCELL_ROW_129_2236 vccd1 vssd1 SS_sky130_fd_sc_hd__tapvpwrvgnd_1
XFILLER_98_681 vccd1 vssd1 vccd1 vssd1 SS_sky130_fd_sc_hd__fill_1
XTAP_TAPCELL_ROW_5_368 vccd1 vssd1 SS_sky130_fd_sc_hd__tapvpwrvgnd_1
XTAP_TAPCELL_ROW_5_379 vccd1 vssd1 SS_sky130_fd_sc_hd__tapvpwrvgnd_1
XTAP_TAPCELL_ROW_51_1066 vccd1 vssd1 SS_sky130_fd_sc_hd__tapvpwrvgnd_1
XFILLER_133_57 vssd1 vccd1 vssd1 vccd1 SS_sky130_ef_sc_hd__decap_40_12
XFILLER_39_781 vssd1 vccd1 vccd1 vssd1 SS_sky130_fd_sc_hd__fill_2
XFILLER_45_217 vssd1 vccd1 vccd1 vssd1 SS_sky130_fd_sc_hd__fill_4
XFILLER_58_578 vssd1 vccd1 vccd1 vssd1 SS_sky130_fd_sc_hd__fill_8
XFILLER_58_589 vssd1 vccd1 vssd1 vccd1 SS_sky130_ef_sc_hd__decap_40_12
XFILLER_73_559 vccd1 vssd1 vccd1 vssd1 SS_sky130_fd_sc_hd__fill_1
XFILLER_100_697 vssd1 vccd1 vccd1 vssd1 SS_sky130_fd_sc_hd__fill_2
XFILLER_60_209 vssd1 vccd1 vssd1 vccd1 SS_sky130_ef_sc_hd__decap_40_12
XFILLER_14_637 vssd1 vccd1 vccd1 vssd1 SS_sky130_fd_sc_hd__fill_4
XFILLER_26_77 vssd1 vccd1 vccd1 vssd1 SS_sky130_fd_sc_hd__fill_4
XFILLER_26_475 vccd1 vssd1 vccd1 vssd1 SS_sky130_fd_sc_hd__fill_1
XFILLER_53_261 vssd1 vccd1 vssd1 vccd1 SS_sky130_ef_sc_hd__decap_40_12
XTAP_TAPCELL_ROW_107_1899 vccd1 vssd1 SS_sky130_fd_sc_hd__tapvpwrvgnd_1
XFILLER_13_125 vssd1 vccd1 vssd1 vccd1 SS_sky130_ef_sc_hd__decap_40_12
XTAP_TAPCELL_ROW_24_654 vccd1 vssd1 SS_sky130_fd_sc_hd__tapvpwrvgnd_1
XFILLER_41_445 vssd1 vccd1 vccd1 vssd1 SS_sky130_fd_sc_hd__fill_2
XFILLER_10_810 vssd1 vccd1 vccd1 vssd1 SS_sky130_fd_sc_hd__fill_2
XFILLER_13_169 vssd1 vccd1 vssd1 vccd1 SS_sky130_ef_sc_hd__decap_40_12
XTAP_TAPCELL_ROW_24_665 vccd1 vssd1 SS_sky130_fd_sc_hd__tapvpwrvgnd_1
XFILLER_41_489 vssd1 vccd1 vccd1 vssd1 SS_sky130_fd_sc_hd__fill_4
XFILLER_22_681 vssd1 vccd1 vssd1 vccd1 SS_sky130_ef_sc_hd__decap_40_12
XFILLER_42_65 vssd1 vccd1 vssd1 vccd1 SS_sky130_ef_sc_hd__decap_40_12
XFILLER_6_825 vccd1 vssd1 vccd1 vssd1 SS_sky130_fd_sc_hd__fill_1
XFILLER_5_335 vccd1 vssd1 vccd1 vssd1 SS_sky130_fd_sc_hd__fill_1
XFILLER_135_561 vssd1 vccd1 vssd1 vccd1 SS_sky130_ef_sc_hd__decap_40_12
XFILLER_135_594 vssd1 vccd1 vccd1 vssd1 SS_sky130_fd_sc_hd__fill_4
XFILLER_1_541 vssd1 vccd1 vssd1 vccd1 SS_sky130_ef_sc_hd__decap_40_12
XFILLER_68_309 vssd1 vccd1 vssd1 vccd1 SS_sky130_ef_sc_hd__decap_40_12
XFILLER_122_233 vssd1 vccd1 vssd1 vccd1 SS_sky130_ef_sc_hd__decap_40_12
XFILLER_1_585 vssd1 vccd1 vssd1 vccd1 SS_sky130_ef_sc_hd__decap_40_12
XFILLER_49_501 vssd1 vccd1 vccd1 vssd1 SS_sky130_fd_sc_hd__fill_2
XFILLER_67_51 vssd1 vccd1 vccd1 vssd1 SS_sky130_fd_sc_hd__fill_4
XFILLER_122_299 vccd1 vssd1 vccd1 vssd1 SS_sky130_fd_sc_hd__fill_1
XFILLER_122_277 vssd1 vccd1 vssd1 vccd1 SS_sky130_ef_sc_hd__decap_40_12
XFILLER_37_729 vssd1 vccd1 vssd1 vccd1 SS_sky130_ef_sc_hd__decap_40_12
XTAP_TAPCELL_ROW_69_1338 vccd1 vssd1 SS_sky130_fd_sc_hd__tapvpwrvgnd_1
XPHY_EDGE_ROW_103_Left_242 vccd1 vssd1 vccd1 vssd1 SS_sky130_fd_sc_hd__decap_3
XFILLER_17_497 vssd1 vccd1 vccd1 vssd1 SS_sky130_fd_sc_hd__fill_4
XFILLER_32_401 vssd1 vccd1 vssd1 vccd1 SS_sky130_ef_sc_hd__decap_40_12
XFILLER_60_732 vssd1 vccd1 vssd1 vccd1 SS_sky130_ef_sc_hd__decap_40_12
XFILLER_72_570 vccd1 vssd1 vccd1 vssd1 SS_sky130_fd_sc_hd__fill_1
XTAP_TAPCELL_ROW_82_1527 vccd1 vssd1 SS_sky130_fd_sc_hd__tapvpwrvgnd_1
XFILLER_91_389 vssd1 vccd1 vccd1 vssd1 SS_sky130_fd_sc_hd__fill_2
XFILLER_32_445 vssd1 vccd1 vssd1 vccd1 SS_sky130_ef_sc_hd__decap_40_12
XTAP_TAPCELL_ROW_43_941 vccd1 vssd1 SS_sky130_fd_sc_hd__tapvpwrvgnd_1
XTAP_TAPCELL_ROW_43_952 vccd1 vssd1 SS_sky130_fd_sc_hd__tapvpwrvgnd_1
XFILLER_60_765 vssd1 vccd1 vccd1 vssd1 SS_sky130_fd_sc_hd__fill_4
XFILLER_32_489 vssd1 vccd1 vssd1 vccd1 SS_sky130_ef_sc_hd__decap_40_12
X_0982_ vccd1 vssd1 vccd1 vssd1 _0982_/X _0982_/A _0988_/B SS_sky130_fd_sc_hd__or2_2
XFILLER_9_641 vssd1 vccd1 vssd1 vccd1 SS_sky130_ef_sc_hd__decap_40_12
XFILLER_9_685 vssd1 vccd1 vssd1 vccd1 SS_sky130_ef_sc_hd__decap_40_12
XPHY_EDGE_ROW_132_Right_132 vccd1 vssd1 vccd1 vssd1 SS_sky130_fd_sc_hd__decap_3
XFILLER_8_195 vccd1 vssd1 vccd1 vssd1 SS_sky130_fd_sc_hd__fill_1
X_1603_ _1846_/A _1608_/CLK _1603_/D vccd1 vssd1 vccd1 vssd1 SS_sky130_fd_sc_hd__dfxtp_2
XFILLER_114_701 vssd1 vccd1 vssd1 vccd1 SS_sky130_ef_sc_hd__decap_40_12
XPHY_EDGE_ROW_112_Left_251 vccd1 vssd1 vccd1 vssd1 SS_sky130_fd_sc_hd__decap_3
X_1534_ _1534_/Q _1724_/CLK _1534_/D vccd1 vssd1 vccd1 vssd1 SS_sky130_fd_sc_hd__dfxtp_2
XFILLER_99_445 vssd1 vccd1 vccd1 vssd1 SS_sky130_fd_sc_hd__fill_2
XTAP_TAPCELL_ROW_93_1689 vccd1 vssd1 SS_sky130_fd_sc_hd__tapvpwrvgnd_1
X_1465_ vssd1 vccd1 vccd1 vssd1 _1467_/A2 input39/X _1758_/D _1465_/C1 _1464_/X SS_sky130_fd_sc_hd__o211a_2
XFILLER_113_277 vssd1 vccd1 vccd1 vssd1 SS_sky130_fd_sc_hd__fill_2
XFILLER_101_439 vssd1 vccd1 vccd1 vssd1 SS_sky130_fd_sc_hd__fill_8
XFILLER_86_139 vccd1 vssd1 vccd1 vssd1 SS_sky130_fd_sc_hd__fill_1
X_1396_ vccd1 vssd1 vccd1 vssd1 _1396_/X _1396_/A _1396_/B SS_sky130_fd_sc_hd__or2_2
XTAP_TAPCELL_ROW_2_327 vccd1 vssd1 SS_sky130_fd_sc_hd__tapvpwrvgnd_1
XFILLER_27_217 vssd1 vccd1 vccd1 vssd1 SS_sky130_fd_sc_hd__fill_4
XFILLER_82_301 vssd1 vccd1 vccd1 vssd1 SS_sky130_fd_sc_hd__fill_4
XFILLER_95_673 vssd1 vccd1 vssd1 vccd1 SS_sky130_ef_sc_hd__decap_40_12
XFILLER_55_559 vccd1 vssd1 vccd1 vssd1 SS_sky130_fd_sc_hd__fill_1
XPHY_EDGE_ROW_121_Left_260 vccd1 vssd1 vccd1 vssd1 SS_sky130_fd_sc_hd__decap_3
XFILLER_42_209 vssd1 vccd1 vssd1 vccd1 SS_sky130_ef_sc_hd__decap_40_12
XTAP_TAPCELL_ROW_124_2166 vccd1 vssd1 SS_sky130_fd_sc_hd__tapvpwrvgnd_1
XTAP_TAPCELL_ROW_124_2155 vccd1 vssd1 SS_sky130_fd_sc_hd__tapvpwrvgnd_1
XFILLER_35_261 vssd1 vccd1 vssd1 vccd1 SS_sky130_ef_sc_hd__decap_40_12
XFILLER_82_389 vssd1 vccd1 vssd1 vccd1 SS_sky130_ef_sc_hd__decap_40_12
XFILLER_23_445 vssd1 vccd1 vccd1 vssd1 SS_sky130_fd_sc_hd__fill_2
XFILLER_51_765 vssd1 vccd1 vssd1 vccd1 SS_sky130_ef_sc_hd__decap_40_12
XFILLER_11_629 vssd1 vccd1 vssd1 vccd1 SS_sky130_ef_sc_hd__decap_40_12
XFILLER_50_253 vssd1 vccd1 vssd1 vccd1 SS_sky130_ef_sc_hd__decap_40_12
XFILLER_10_139 vccd1 vssd1 vccd1 vssd1 SS_sky130_fd_sc_hd__fill_1
XTAP_TAPCELL_ROW_21_613 vccd1 vssd1 SS_sky130_fd_sc_hd__tapvpwrvgnd_1
XFILLER_109_517 vssd1 vccd1 vssd1 vccd1 SS_sky130_ef_sc_hd__decap_40_12
XFILLER_136_347 vssd1 vccd1 vssd1 vccd1 SS_sky130_ef_sc_hd__decap_40_12
XFILLER_2_305 vssd1 vccd1 vccd1 vssd1 SS_sky130_fd_sc_hd__fill_2
XFILLER_117_561 vssd1 vccd1 vssd1 vccd1 SS_sky130_ef_sc_hd__decap_40_12
XFILLER_3_839 vccd1 vssd1 vccd1 vssd1 SS_sky130_fd_sc_hd__fill_1
XFILLER_132_531 vccd1 vssd1 vccd1 vssd1 SS_sky130_fd_sc_hd__fill_1
XFILLER_132_542 vssd1 vccd1 vccd1 vssd1 SS_sky130_fd_sc_hd__fill_2
XFILLER_104_233 vssd1 vccd1 vssd1 vccd1 SS_sky130_ef_sc_hd__decap_40_12
XFILLER_132_586 vssd1 vccd1 vccd1 vssd1 SS_sky130_fd_sc_hd__fill_2
XFILLER_120_737 vssd1 vccd1 vccd1 vssd1 SS_sky130_fd_sc_hd__fill_8
XFILLER_104_277 vssd1 vccd1 vssd1 vccd1 SS_sky130_ef_sc_hd__decap_40_12
XFILLER_19_718 vccd1 vssd1 vccd1 vssd1 SS_sky130_fd_sc_hd__fill_1
XFILLER_19_729 vssd1 vccd1 vssd1 vccd1 SS_sky130_ef_sc_hd__decap_40_12
XFILLER_74_813 vssd1 vccd1 vccd1 vssd1 SS_sky130_fd_sc_hd__fill_2
XFILLER_85_161 vssd1 vccd1 vccd1 vssd1 SS_sky130_fd_sc_hd__fill_4
XTAP_TAPCELL_ROW_109_1928 vccd1 vssd1 SS_sky130_fd_sc_hd__tapvpwrvgnd_1
Xafe_wb_520 analog_io_out[12] afe_wb_520/HI vccd1 vssd1 vssd1 vccd1 SS_sky130_fd_sc_hd__conb_1
XFILLER_92_109 vssd1 vccd1 vssd1 vccd1 SS_sky130_ef_sc_hd__decap_40_12
Xafe_wb_542 afe_wb_542/LO analog_io_oeb[6] vccd1 vssd1 vssd1 vccd1 SS_sky130_fd_sc_hd__conb_1
XTAP_TAPCELL_ROW_29_735 vccd1 vssd1 SS_sky130_fd_sc_hd__tapvpwrvgnd_1
Xafe_wb_553 afe_wb_553/LO analog_io_oeb[17] vccd1 vssd1 vssd1 vccd1 SS_sky130_fd_sc_hd__conb_1
Xafe_wb_531 analog_io_out[23] afe_wb_531/HI vccd1 vssd1 vssd1 vccd1 SS_sky130_fd_sc_hd__conb_1
XTAP_TAPCELL_ROW_109_1939 vccd1 vssd1 SS_sky130_fd_sc_hd__tapvpwrvgnd_1
XFILLER_73_378 vssd1 vccd1 vssd1 vccd1 SS_sky130_ef_sc_hd__decap_40_12
XFILLER_14_401 vssd1 vccd1 vssd1 vccd1 SS_sky130_ef_sc_hd__decap_40_12
XFILLER_42_732 vssd1 vccd1 vccd1 vssd1 SS_sky130_fd_sc_hd__fill_2
XFILLER_14_445 vssd1 vccd1 vssd1 vccd1 SS_sky130_ef_sc_hd__decap_40_12
XFILLER_53_42 vssd1 vccd1 vssd1 vccd1 SS_sky130_ef_sc_hd__decap_40_12
XTAP_TAPCELL_ROW_64_1257 vccd1 vssd1 SS_sky130_fd_sc_hd__tapvpwrvgnd_1
XFILLER_14_489 vssd1 vccd1 vssd1 vccd1 SS_sky130_ef_sc_hd__decap_40_12
XTAP_TAPCELL_ROW_40_900 vccd1 vssd1 SS_sky130_fd_sc_hd__tapvpwrvgnd_1
XFILLER_5_165 vssd1 vccd1 vccd1 vssd1 SS_sky130_fd_sc_hd__fill_2
XFILLER_6_699 vccd1 vssd1 vccd1 vssd1 SS_sky130_fd_sc_hd__fill_1
XFILLER_69_629 vssd1 vccd1 vssd1 vccd1 SS_sky130_ef_sc_hd__decap_40_12
XFILLER_78_83 vccd1 vssd1 vccd1 vssd1 SS_sky130_fd_sc_hd__fill_1
XFILLER_96_426 vssd1 vccd1 vssd1 vccd1 SS_sky130_ef_sc_hd__decap_40_12
XFILLER_1_393 vssd1 vccd1 vssd1 vccd1 SS_sky130_ef_sc_hd__decap_40_12
XFILLER_68_139 vccd1 vssd1 vccd1 vssd1 SS_sky130_fd_sc_hd__fill_1
X_1250_ vccd1 vssd1 vccd1 vssd1 _1250_/X _1654_/Q _1264_/B SS_sky130_fd_sc_hd__or2_2
XFILLER_64_301 vssd1 vccd1 vccd1 vssd1 SS_sky130_fd_sc_hd__fill_4
XFILLER_65_802 vssd1 vccd1 vccd1 vssd1 SS_sky130_fd_sc_hd__fill_4
XFILLER_77_673 vssd1 vccd1 vssd1 vccd1 SS_sky130_ef_sc_hd__decap_40_12
X_1181_ vssd1 vccd1 vccd1 vssd1 wire233/A input28/X _1620_/D _1381_/C1 _1180_/X SS_sky130_fd_sc_hd__o211a_2
XFILLER_83_109 vssd1 vccd1 vccd1 vssd1 SS_sky130_fd_sc_hd__fill_2
XFILLER_92_643 vccd1 vssd1 vccd1 vssd1 SS_sky130_fd_sc_hd__fill_1
XFILLER_92_621 vssd1 vccd1 vssd1 vccd1 SS_sky130_ef_sc_hd__decap_40_12
XFILLER_24_209 vssd1 vccd1 vssd1 vccd1 SS_sky130_ef_sc_hd__decap_40_12
XFILLER_80_805 vssd1 vccd1 vccd1 vssd1 SS_sky130_fd_sc_hd__fill_4
XFILLER_17_261 vssd1 vccd1 vssd1 vccd1 SS_sky130_ef_sc_hd__decap_40_12
XFILLER_52_529 vssd1 vccd1 vccd1 vssd1 SS_sky130_fd_sc_hd__fill_2
XFILLER_64_389 vssd1 vccd1 vssd1 vccd1 SS_sky130_ef_sc_hd__decap_40_12
XFILLER_92_687 vssd1 vccd1 vssd1 vccd1 SS_sky130_ef_sc_hd__decap_40_12
XFILLER_33_765 vssd1 vccd1 vssd1 vccd1 SS_sky130_ef_sc_hd__decap_40_12
XFILLER_32_253 vssd1 vccd1 vssd1 vccd1 SS_sky130_ef_sc_hd__decap_40_12
XFILLER_60_562 vssd1 vccd1 vssd1 vccd1 SS_sky130_ef_sc_hd__decap_40_12
X_0965_ vssd1 vccd1 vccd1 vssd1 _0985_/A2 wire495/X _1515_/D wire467/X _0964_/X SS_sky130_fd_sc_hd__o211a_2
XFILLER_118_314 vssd1 vccd1 vccd1 vssd1 SS_sky130_fd_sc_hd__fill_2
X_0896_ vccd1 vssd1 vssd1 vccd1 _0893_/X _0895_/X _0753_/A hold807/X _1498_/D _1327_/C1
+ SS_sky130_fd_sc_hd__o221a_2
XTAP_TAPCELL_ROW_95_1729 vccd1 vssd1 SS_sky130_fd_sc_hd__tapvpwrvgnd_1
XTAP_TAPCELL_ROW_95_1718 vccd1 vssd1 SS_sky130_fd_sc_hd__tapvpwrvgnd_1
XFILLER_133_317 vssd1 vccd1 vssd1 vccd1 SS_sky130_ef_sc_hd__decap_40_12
Xoutput201 vccd1 vssd1 wire354/A _1483_/Q vccd1 vssd1 SS_sky130_fd_sc_hd__buf_4
XFILLER_118_358 vssd1 vccd1 vccd1 vssd1 SS_sky130_fd_sc_hd__fill_4
XFILLER_106_509 vccd1 vssd1 vccd1 vssd1 SS_sky130_fd_sc_hd__fill_1
XFILLER_0_809 vssd1 vccd1 vccd1 vssd1 SS_sky130_fd_sc_hd__fill_2
XTAP_TAPCELL_ROW_7_408 vccd1 vssd1 SS_sky130_fd_sc_hd__tapvpwrvgnd_1
X_1517_ _1517_/Q _1738_/CLK _1517_/D vccd1 vssd1 vccd1 vssd1 SS_sky130_fd_sc_hd__dfxtp_2
XFILLER_114_15 vssd1 vccd1 vssd1 vccd1 SS_sky130_ef_sc_hd__decap_40_12
X_1448_ vccd1 vssd1 vccd1 vssd1 _1448_/X _1448_/A _1472_/B SS_sky130_fd_sc_hd__or2_2
XFILLER_101_225 vssd1 vccd1 vssd1 vccd1 SS_sky130_ef_sc_hd__decap_40_12
XFILLER_74_109 vssd1 vccd1 vssd1 vccd1 SS_sky130_ef_sc_hd__decap_40_12
X_1379_ vssd1 vccd1 vccd1 vssd1 _1385_/A2 input28/X _1716_/D _1437_/C1 _1378_/X SS_sky130_fd_sc_hd__o211a_2
XFILLER_67_161 vssd1 vccd1 vccd1 vssd1 SS_sky130_fd_sc_hd__fill_4
XFILLER_71_816 vssd1 vccd1 vccd1 vssd1 SS_sky130_fd_sc_hd__fill_2
XFILLER_82_153 vssd1 vccd1 vssd1 vccd1 SS_sky130_ef_sc_hd__decap_40_12
XFILLER_70_359 vssd1 vccd1 vccd1 vssd1 SS_sky130_fd_sc_hd__fill_4
XFILLER_82_197 vssd1 vccd1 vssd1 vccd1 SS_sky130_ef_sc_hd__decap_40_12
XTAP_TAPCELL_ROW_104_1858 vccd1 vssd1 SS_sky130_fd_sc_hd__tapvpwrvgnd_1
XFILLER_90_29 vssd1 vccd1 vssd1 vccd1 SS_sky130_ef_sc_hd__decap_40_12
Xwire306 vccd1 vssd1 vssd1 vccd1 wire306/A analog_ctrl[0] SS_sky130_fd_sc_hd__buf_12
Xwire339 vccd1 vssd1 vssd1 vccd1 wire339/A analog_ctrl[39] SS_sky130_fd_sc_hd__buf_12
Xwire328 vccd1 vssd1 vssd1 vccd1 wire328/A analog_ctrl[49] SS_sky130_fd_sc_hd__buf_12
Xwire317 vccd1 vssd1 vssd1 vccd1 wire317/A analog_ctrl[59] SS_sky130_fd_sc_hd__buf_12
XTAP_TAPCELL_ROW_137_2357 vccd1 vssd1 SS_sky130_fd_sc_hd__tapvpwrvgnd_1
XFILLER_136_133 vssd1 vccd1 vccd1 vssd1 SS_sky130_fd_sc_hd__fill_4
XFILLER_99_27 vssd1 vccd1 vssd1 vccd1 SS_sky130_ef_sc_hd__decap_40_12
XFILLER_137_689 vssd1 vccd1 vccd1 vssd1 SS_sky130_fd_sc_hd__fill_2
XFILLER_3_669 vssd1 vccd1 vccd1 vssd1 SS_sky130_fd_sc_hd__fill_2
XFILLER_120_501 vssd1 vccd1 vssd1 vccd1 SS_sky130_ef_sc_hd__decap_40_12
XFILLER_48_53 vssd1 vccd1 vssd1 vccd1 SS_sky130_ef_sc_hd__decap_40_12
XFILLER_59_673 vccd1 vssd1 vccd1 vssd1 SS_sky130_fd_sc_hd__fill_1
XFILLER_65_109 vssd1 vccd1 vccd1 vssd1 SS_sky130_fd_sc_hd__fill_2
Xfanout461 vssd1 vccd1 vccd1 vssd1 _0738_/D _1437_/C1 SS_sky130_fd_sc_hd__clkdlybuf4s25_1
Xfanout472 vssd1 vccd1 vccd1 vssd1 wire493/X _1299_/C1 SS_sky130_fd_sc_hd__clkdlybuf4s25_1
XFILLER_120_589 vssd1 vccd1 vccd1 vssd1 SS_sky130_fd_sc_hd__fill_2
XFILLER_93_429 vssd1 vccd1 vssd1 vccd1 SS_sky130_ef_sc_hd__decap_40_12
XFILLER_46_301 vssd1 vccd1 vccd1 vssd1 SS_sky130_fd_sc_hd__fill_4
XFILLER_48_97 vssd1 vccd1 vssd1 vccd1 SS_sky130_ef_sc_hd__decap_40_12
XFILLER_74_643 vccd1 vssd1 vccd1 vssd1 SS_sky130_fd_sc_hd__fill_1
XFILLER_101_781 vssd1 vccd1 vccd1 vssd1 SS_sky130_fd_sc_hd__fill_2
XFILLER_0_27 vccd1 vssd1 vccd1 vssd1 SS_sky130_fd_sc_hd__fill_1
XFILLER_0_49 vssd1 vccd1 vccd1 vssd1 SS_sky130_fd_sc_hd__fill_4
XFILLER_19_559 vccd1 vssd1 vccd1 vssd1 SS_sky130_fd_sc_hd__fill_1
XFILLER_46_345 vssd1 vccd1 vssd1 vccd1 SS_sky130_ef_sc_hd__decap_40_12
XFILLER_62_805 vssd1 vccd1 vccd1 vssd1 SS_sky130_fd_sc_hd__fill_4
XFILLER_104_81 vssd1 vccd1 vccd1 vssd1 SS_sky130_fd_sc_hd__fill_2
XFILLER_34_529 vssd1 vccd1 vccd1 vssd1 SS_sky130_fd_sc_hd__fill_2
XFILLER_46_389 vssd1 vccd1 vccd1 vssd1 SS_sky130_fd_sc_hd__fill_4
XFILLER_64_41 vssd1 vccd1 vssd1 vccd1 SS_sky130_ef_sc_hd__decap_40_12
XFILLER_64_85 vssd1 vccd1 vssd1 vccd1 SS_sky130_ef_sc_hd__decap_40_12
XFILLER_14_253 vssd1 vccd1 vssd1 vccd1 SS_sky130_ef_sc_hd__decap_40_12
XFILLER_15_765 vssd1 vccd1 vssd1 vccd1 SS_sky130_ef_sc_hd__decap_40_12
XFILLER_30_713 vssd1 vccd1 vssd1 vccd1 SS_sky130_ef_sc_hd__decap_40_12
XFILLER_9_69 vssd1 vccd1 vssd1 vccd1 SS_sky130_ef_sc_hd__decap_40_12
XFILLER_30_757 vssd1 vccd1 vssd1 vccd1 SS_sky130_ef_sc_hd__decap_40_12
XFILLER_128_601 vssd1 vccd1 vccd1 vssd1 SS_sky130_fd_sc_hd__fill_2
XTAP_TAPCELL_ROW_12_476 vccd1 vssd1 SS_sky130_fd_sc_hd__tapvpwrvgnd_1
XTAP_TAPCELL_ROW_12_487 vccd1 vssd1 SS_sky130_fd_sc_hd__tapvpwrvgnd_1
XFILLER_128_645 vssd1 vccd1 vssd1 vccd1 SS_sky130_ef_sc_hd__decap_40_12
X_0750_ vssd1 vccd1 vssd1 vccd1 _1474_/Q _0750_/X _0945_/C _0945_/B _0945_/D SS_sky130_fd_sc_hd__and4bb_2
XFILLER_127_111 vccd1 vssd1 vccd1 vssd1 SS_sky130_fd_sc_hd__fill_1
XTAP_TAPCELL_ROW_77_1448 vccd1 vssd1 SS_sky130_fd_sc_hd__tapvpwrvgnd_1
XFILLER_115_306 vssd1 vccd1 vssd1 vccd1 SS_sky130_ef_sc_hd__decap_40_12
XTAP_TAPCELL_ROW_77_1459 vccd1 vssd1 SS_sky130_fd_sc_hd__tapvpwrvgnd_1
XFILLER_115_339 vccd1 vssd1 vccd1 vssd1 SS_sky130_fd_sc_hd__fill_1
XFILLER_89_93 vssd1 vccd1 vssd1 vccd1 SS_sky130_ef_sc_hd__decap_40_12
XTAP_TAPCELL_ROW_90_1648 vccd1 vssd1 SS_sky130_fd_sc_hd__tapvpwrvgnd_1
XFILLER_111_501 vssd1 vccd1 vccd1 vssd1 SS_sky130_fd_sc_hd__fill_2
X_1302_ vccd1 vssd1 vccd1 vssd1 _1302_/X _1302_/A _1338_/B SS_sky130_fd_sc_hd__or2_2
XFILLER_96_245 vssd1 vccd1 vccd1 vssd1 SS_sky130_fd_sc_hd__fill_4
XFILLER_29_3 vssd1 vccd1 vssd1 vccd1 SS_sky130_ef_sc_hd__decap_40_12
XFILLER_38_802 vssd1 vccd1 vccd1 vssd1 SS_sky130_fd_sc_hd__fill_8
XFILLER_38_813 vssd1 vccd1 vccd1 vssd1 SS_sky130_fd_sc_hd__fill_2
XFILLER_56_109 vssd1 vccd1 vssd1 vccd1 SS_sky130_ef_sc_hd__decap_40_12
X_1233_ vssd1 vccd1 vccd1 vssd1 _1267_/A2 wire501/X _1645_/D _1299_/C1 _1232_/X SS_sky130_fd_sc_hd__o211a_2
XFILLER_49_161 vssd1 vccd1 vccd1 vssd1 SS_sky130_fd_sc_hd__fill_4
XFILLER_77_481 vssd1 vccd1 vssd1 vccd1 SS_sky130_ef_sc_hd__decap_40_12
XFILLER_96_289 vssd1 vccd1 vccd1 vssd1 SS_sky130_fd_sc_hd__fill_2
X_1164_ vccd1 vssd1 vccd1 vssd1 _1164_/X _1872_/A _1186_/B SS_sky130_fd_sc_hd__or2_2
XFILLER_65_665 vssd1 vccd1 vccd1 vssd1 SS_sky130_fd_sc_hd__fill_4
XFILLER_25_529 vssd1 vccd1 vssd1 vccd1 SS_sky130_ef_sc_hd__decap_40_12
X_1095_ vssd1 vccd1 vccd1 vssd1 wire239/X wire496/X _1578_/D wire467/X _1094_/X SS_sky130_fd_sc_hd__o211a_2
XFILLER_37_389 vssd1 vccd1 vccd1 vssd1 SS_sky130_fd_sc_hd__fill_2
XFILLER_64_153 vssd1 vccd1 vssd1 vccd1 SS_sky130_ef_sc_hd__decap_40_12
XTAP_TAPCELL_ROW_121_2114 vccd1 vssd1 SS_sky130_fd_sc_hd__tapvpwrvgnd_1
XFILLER_18_581 vssd1 vccd1 vccd1 vssd1 SS_sky130_fd_sc_hd__fill_4
XFILLER_64_197 vssd1 vccd1 vssd1 vccd1 SS_sky130_ef_sc_hd__decap_40_12
XFILLER_80_657 vssd1 vccd1 vssd1 vccd1 SS_sky130_ef_sc_hd__decap_40_12
XFILLER_33_573 vssd1 vccd1 vssd1 vccd1 SS_sky130_ef_sc_hd__decap_40_12
XFILLER_20_245 vssd1 vccd1 vccd1 vssd1 SS_sky130_fd_sc_hd__fill_4
XFILLER_20_289 vssd1 vccd1 vssd1 vccd1 SS_sky130_ef_sc_hd__decap_40_12
X_0948_ vccd1 vssd1 vccd1 vssd1 _0948_/X _1835_/A _0988_/B SS_sky130_fd_sc_hd__or2_2
XTAP_TAPCELL_ROW_31_763 vccd1 vssd1 SS_sky130_fd_sc_hd__tapvpwrvgnd_1
XTAP_TAPCELL_ROW_119_2087 vccd1 vssd1 SS_sky130_fd_sc_hd__tapvpwrvgnd_1
XFILLER_118_133 vssd1 vccd1 vccd1 vssd1 SS_sky130_fd_sc_hd__fill_4
XFILLER_109_15 vssd1 vccd1 vssd1 vccd1 SS_sky130_ef_sc_hd__decap_40_12
XFILLER_133_125 vssd1 vccd1 vssd1 vccd1 SS_sky130_ef_sc_hd__decap_40_12
XFILLER_118_177 vssd1 vccd1 vssd1 vccd1 SS_sky130_ef_sc_hd__decap_40_12
XFILLER_106_317 vssd1 vccd1 vccd1 vssd1 SS_sky130_fd_sc_hd__fill_2
X_0879_ vccd1 vssd1 vccd1 vssd1 _1528_/Q _0930_/B1 _1752_/Q wire435/A _0879_/X SS_sky130_fd_sc_hd__a22o_2
XTAP_TAPCELL_ROW_132_2276 vccd1 vssd1 SS_sky130_fd_sc_hd__tapvpwrvgnd_1
XTAP_TAPCELL_ROW_132_2287 vccd1 vssd1 SS_sky130_fd_sc_hd__tapvpwrvgnd_1
XFILLER_0_617 vssd1 vccd1 vccd1 vssd1 SS_sky130_fd_sc_hd__fill_4
XFILLER_88_713 vssd1 vccd1 vssd1 vccd1 SS_sky130_ef_sc_hd__decap_40_12
XFILLER_133_169 vssd1 vccd1 vssd1 vccd1 SS_sky130_ef_sc_hd__decap_40_12
XFILLER_87_223 vccd1 vssd1 vccd1 vssd1 SS_sky130_fd_sc_hd__fill_1
XFILLER_88_757 vssd1 vccd1 vssd1 vccd1 SS_sky130_ef_sc_hd__decap_40_12
XFILLER_102_545 vssd1 vccd1 vssd1 vccd1 SS_sky130_ef_sc_hd__decap_40_12
XFILLER_29_813 vccd1 vssd1 vccd1 vssd1 SS_sky130_fd_sc_hd__fill_1
XFILLER_47_109 vssd1 vccd1 vccd1 vssd1 SS_sky130_fd_sc_hd__fill_2
XFILLER_125_69 vssd1 vccd1 vssd1 vccd1 SS_sky130_ef_sc_hd__decap_40_12
XFILLER_102_589 vssd1 vccd1 vssd1 vccd1 SS_sky130_ef_sc_hd__decap_40_12
XFILLER_28_301 vssd1 vccd1 vccd1 vssd1 SS_sky130_fd_sc_hd__fill_4
XFILLER_28_345 vssd1 vccd1 vssd1 vccd1 SS_sky130_ef_sc_hd__decap_40_12
XFILLER_44_805 vccd1 vssd1 vccd1 vssd1 SS_sky130_fd_sc_hd__fill_1
XFILLER_16_529 vssd1 vccd1 vccd1 vssd1 SS_sky130_fd_sc_hd__fill_2
XFILLER_28_389 vssd1 vccd1 vssd1 vccd1 SS_sky130_ef_sc_hd__decap_40_12
XTAP_TAPCELL_ROW_39_885 vccd1 vssd1 SS_sky130_fd_sc_hd__tapvpwrvgnd_1
XTAP_TAPCELL_ROW_48_1016 vccd1 vssd1 SS_sky130_fd_sc_hd__tapvpwrvgnd_1
XTAP_TAPCELL_ROW_48_1027 vccd1 vssd1 SS_sky130_fd_sc_hd__tapvpwrvgnd_1
XFILLER_71_613 vssd1 vccd1 vccd1 vssd1 SS_sky130_fd_sc_hd__fill_2
XFILLER_43_337 vssd1 vccd1 vssd1 vccd1 SS_sky130_ef_sc_hd__decap_40_12
XFILLER_71_668 vssd1 vccd1 vccd1 vssd1 SS_sky130_fd_sc_hd__fill_4
XFILLER_12_713 vssd1 vccd1 vssd1 vccd1 SS_sky130_ef_sc_hd__decap_40_12
XFILLER_11_223 vccd1 vssd1 vccd1 vssd1 SS_sky130_fd_sc_hd__fill_1
XFILLER_34_77 vssd1 vccd1 vccd1 vssd1 SS_sky130_fd_sc_hd__fill_4
XTAP_TAPCELL_ROW_61_1216 vccd1 vssd1 SS_sky130_fd_sc_hd__tapvpwrvgnd_1
XFILLER_70_189 vssd1 vccd1 vccd1 vssd1 SS_sky130_fd_sc_hd__fill_4
XFILLER_7_205 vssd1 vccd1 vssd1 vccd1 SS_sky130_ef_sc_hd__decap_40_12
XFILLER_12_757 vssd1 vccd1 vssd1 vccd1 SS_sky130_ef_sc_hd__decap_40_12
XFILLER_109_111 vccd1 vssd1 vccd1 vssd1 SS_sky130_fd_sc_hd__fill_1
XFILLER_7_249 vssd1 vccd1 vssd1 vccd1 SS_sky130_ef_sc_hd__decap_40_12
XFILLER_50_65 vssd1 vccd1 vssd1 vccd1 SS_sky130_ef_sc_hd__decap_40_12
XFILLER_125_615 vccd1 vssd1 vccd1 vssd1 SS_sky130_fd_sc_hd__fill_1
XTAP_TAPCELL_ROW_59_1178 vccd1 vssd1 SS_sky130_fd_sc_hd__tapvpwrvgnd_1
XTAP_TAPCELL_ROW_59_1189 vccd1 vssd1 SS_sky130_fd_sc_hd__tapvpwrvgnd_1
XFILLER_112_309 vssd1 vccd1 vccd1 vssd1 SS_sky130_fd_sc_hd__fill_8
XTAP_TAPCELL_ROW_72_1378 vccd1 vssd1 SS_sky130_fd_sc_hd__tapvpwrvgnd_1
XFILLER_78_245 vssd1 vccd1 vccd1 vssd1 SS_sky130_fd_sc_hd__fill_4
XFILLER_38_109 vssd1 vccd1 vssd1 vccd1 SS_sky130_ef_sc_hd__decap_40_12
XFILLER_66_418 vssd1 vccd1 vccd1 vssd1 SS_sky130_fd_sc_hd__fill_2
XFILLER_59_481 vssd1 vccd1 vccd1 vssd1 SS_sky130_fd_sc_hd__fill_2
XFILLER_78_289 vssd1 vccd1 vssd1 vccd1 SS_sky130_ef_sc_hd__decap_40_12
XFILLER_93_237 vssd1 vccd1 vssd1 vccd1 SS_sky130_ef_sc_hd__decap_40_12
XFILLER_47_665 vssd1 vccd1 vccd1 vssd1 SS_sky130_fd_sc_hd__fill_4
XFILLER_75_51 vssd1 vccd1 vccd1 vssd1 SS_sky130_fd_sc_hd__fill_4
XFILLER_19_389 vssd1 vccd1 vccd1 vssd1 SS_sky130_fd_sc_hd__fill_2
XFILLER_46_153 vssd1 vccd1 vssd1 vccd1 SS_sky130_ef_sc_hd__decap_40_12
XFILLER_46_197 vssd1 vccd1 vssd1 vccd1 SS_sky130_ef_sc_hd__decap_40_12
XTAP_TAPCELL_ROW_17_557 vccd1 vssd1 SS_sky130_fd_sc_hd__tapvpwrvgnd_1
XFILLER_61_167 vccd1 vssd1 vccd1 vssd1 SS_sky130_fd_sc_hd__fill_1
XFILLER_15_573 vssd1 vccd1 vssd1 vccd1 SS_sky130_ef_sc_hd__decap_40_12
XFILLER_98_6 vssd1 vccd1 vssd1 vccd1 SS_sky130_ef_sc_hd__decap_40_12
X_1851_ vccd1 vssd1 _1851_/X _1851_/A vccd1 vssd1 SS_sky130_fd_sc_hd__buf_2
XFILLER_30_587 vccd1 vssd1 vccd1 vssd1 SS_sky130_fd_sc_hd__fill_1
X_0802_ vccd1 vssd1 vccd1 vssd1 input11/X wire433/X _1853_/A wire443/X _0802_/X SS_sky130_fd_sc_hd__a22o_2
XFILLER_7_783 vccd1 vssd1 vccd1 vssd1 SS_sky130_fd_sc_hd__fill_1
XFILLER_128_475 vccd1 vssd1 vccd1 vssd1 SS_sky130_fd_sc_hd__fill_1
Xhold717 _1563_/D _1063_/X vccd1 vssd1 vssd1 vccd1 SS_sky130_fd_sc_hd__dlygate4sd3_1
Xhold706 _0998_/A _1532_/Q vccd1 vssd1 vssd1 vccd1 SS_sky130_fd_sc_hd__dlygate4sd3_1
Xhold728 _1112_/A _1861_/A vccd1 vssd1 vssd1 vccd1 SS_sky130_fd_sc_hd__dlygate4sd3_1
XFILLER_115_125 vssd1 vccd1 vssd1 vccd1 SS_sky130_ef_sc_hd__decap_40_12
Xhold739 _0978_/A _1522_/Q vccd1 vssd1 vssd1 vccd1 SS_sky130_fd_sc_hd__dlygate4sd3_1
XFILLER_131_629 vssd1 vccd1 vssd1 vccd1 SS_sky130_ef_sc_hd__decap_40_12
XFILLER_115_169 vssd1 vccd1 vssd1 vccd1 SS_sky130_ef_sc_hd__decap_40_12
XFILLER_112_821 vccd1 vssd1 vccd1 vssd1 SS_sky130_fd_sc_hd__fill_1
XFILLER_103_309 vssd1 vccd1 vccd1 vssd1 SS_sky130_fd_sc_hd__fill_2
XFILLER_69_223 vccd1 vssd1 vccd1 vssd1 SS_sky130_fd_sc_hd__fill_1
XFILLER_130_139 vccd1 vssd1 vccd1 vssd1 SS_sky130_fd_sc_hd__fill_1
XFILLER_29_109 vssd1 vccd1 vccd1 vssd1 SS_sky130_fd_sc_hd__fill_2
XFILLER_85_727 vccd1 vssd1 vccd1 vssd1 SS_sky130_fd_sc_hd__fill_1
XFILLER_97_565 vssd1 vccd1 vccd1 vssd1 SS_sky130_fd_sc_hd__fill_2
XFILLER_57_429 vssd1 vccd1 vssd1 vccd1 SS_sky130_ef_sc_hd__decap_40_12
XFILLER_85_749 vssd1 vccd1 vccd1 vssd1 SS_sky130_fd_sc_hd__fill_2
X_1216_ vccd1 vssd1 vccd1 vssd1 _1216_/X _1637_/Q _1272_/B SS_sky130_fd_sc_hd__or2_2
XFILLER_1_81 vssd1 vccd1 vssd1 vccd1 SS_sky130_ef_sc_hd__decap_40_12
X_1147_ vssd1 vccd1 vccd1 vssd1 wire233/X input20/X _1603_/D _1151_/C1 _1146_/X SS_sky130_fd_sc_hd__o211a_2
XFILLER_25_337 vssd1 vccd1 vssd1 vccd1 SS_sky130_ef_sc_hd__decap_40_12
XTAP_TAPCELL_ROW_36_833 vccd1 vssd1 SS_sky130_fd_sc_hd__tapvpwrvgnd_1
XTAP_TAPCELL_ROW_36_844 vccd1 vssd1 SS_sky130_fd_sc_hd__tapvpwrvgnd_1
XFILLER_80_421 vssd1 vccd1 vssd1 vccd1 SS_sky130_ef_sc_hd__decap_40_12
XFILLER_40_307 vccd1 vssd1 vccd1 vssd1 SS_sky130_fd_sc_hd__fill_1
XFILLER_53_679 vccd1 vssd1 vccd1 vssd1 SS_sky130_fd_sc_hd__fill_1
X_1078_ vccd1 vssd1 _1079_/A _1142_/B _1409_/B vccd1 vssd1 SS_sky130_fd_sc_hd__and2_2
XFILLER_52_189 vssd1 vccd1 vccd1 vssd1 SS_sky130_fd_sc_hd__fill_4
XTAP_TAPCELL_ROW_101_1817 vccd1 vssd1 SS_sky130_fd_sc_hd__tapvpwrvgnd_1
XTAP_TAPCELL_ROW_134_2305 vccd1 vssd1 SS_sky130_fd_sc_hd__tapvpwrvgnd_1
XTAP_TAPCELL_ROW_134_2316 vccd1 vssd1 SS_sky130_fd_sc_hd__tapvpwrvgnd_1
XFILLER_119_420 vssd1 vccd1 vccd1 vssd1 SS_sky130_fd_sc_hd__fill_2
XFILLER_5_709 vssd1 vccd1 vssd1 vccd1 SS_sky130_ef_sc_hd__decap_40_12
XFILLER_119_497 vssd1 vccd1 vccd1 vssd1 SS_sky130_fd_sc_hd__fill_4
XFILLER_107_615 vccd1 vssd1 vccd1 vssd1 SS_sky130_fd_sc_hd__fill_1
XFILLER_115_670 vssd1 vccd1 vccd1 vssd1 SS_sky130_fd_sc_hd__fill_2
XFILLER_88_521 vssd1 vccd1 vccd1 vssd1 SS_sky130_fd_sc_hd__fill_2
XTAP_TAPCELL_ROW_112_1979 vccd1 vssd1 SS_sky130_fd_sc_hd__tapvpwrvgnd_1
XFILLER_0_447 vccd1 vssd1 vccd1 vssd1 SS_sky130_fd_sc_hd__fill_1
XFILLER_29_55 vccd1 vssd1 vccd1 vssd1 SS_sky130_fd_sc_hd__fill_1
XFILLER_75_237 vssd1 vccd1 vssd1 vccd1 SS_sky130_ef_sc_hd__decap_40_12
XFILLER_28_153 vssd1 vccd1 vssd1 vccd1 SS_sky130_ef_sc_hd__decap_40_12
XFILLER_44_613 vssd1 vccd1 vssd1 vccd1 SS_sky130_ef_sc_hd__decap_40_12
XFILLER_56_473 vssd1 vccd1 vccd1 vssd1 SS_sky130_fd_sc_hd__fill_2
XFILLER_28_197 vssd1 vccd1 vssd1 vccd1 SS_sky130_ef_sc_hd__decap_40_12
XFILLER_44_635 vccd1 vssd1 vccd1 vssd1 SS_sky130_fd_sc_hd__fill_1
XFILLER_71_421 vssd1 vccd1 vccd1 vssd1 SS_sky130_fd_sc_hd__fill_2
XFILLER_83_281 vssd1 vccd1 vssd1 vccd1 SS_sky130_ef_sc_hd__decap_40_12
XFILLER_43_167 vccd1 vssd1 vccd1 vssd1 SS_sky130_fd_sc_hd__fill_1
XTAP_TAPCELL_ROW_14_505 vccd1 vssd1 SS_sky130_fd_sc_hd__tapvpwrvgnd_1
XTAP_TAPCELL_ROW_14_516 vccd1 vssd1 SS_sky130_fd_sc_hd__tapvpwrvgnd_1
XFILLER_31_329 vssd1 vccd1 vccd1 vssd1 SS_sky130_fd_sc_hd__fill_4
XFILLER_61_42 vssd1 vccd1 vssd1 vccd1 SS_sky130_ef_sc_hd__decap_40_12
XFILLER_129_217 vssd1 vccd1 vccd1 vssd1 SS_sky130_fd_sc_hd__fill_4
XFILLER_101_93 vssd1 vccd1 vssd1 vccd1 SS_sky130_ef_sc_hd__decap_40_12
XFILLER_8_525 vssd1 vccd1 vccd1 vssd1 SS_sky130_fd_sc_hd__fill_4
XFILLER_12_587 vccd1 vssd1 vccd1 vssd1 SS_sky130_fd_sc_hd__fill_1
XFILLER_8_569 vssd1 vccd1 vssd1 vccd1 SS_sky130_ef_sc_hd__decap_40_12
XFILLER_6_26 vssd1 vccd1 vccd1 vssd1 SS_sky130_fd_sc_hd__fill_2
XANTENNA_8 _1318_/B vssd1 vccd1 vccd1 vssd1 SS_sky130_fd_sc_hd__diode_2
XFILLER_4_753 vssd1 vccd1 vccd1 vssd1 SS_sky130_fd_sc_hd__fill_2
XTAP_TAPCELL_ROW_74_1407 vccd1 vssd1 SS_sky130_fd_sc_hd__tapvpwrvgnd_1
XFILLER_125_478 vccd1 vssd1 vccd1 vssd1 SS_sky130_fd_sc_hd__fill_1
XFILLER_98_307 vccd1 vssd1 vccd1 vssd1 SS_sky130_fd_sc_hd__fill_1
XFILLER_112_139 vccd1 vssd1 vccd1 vssd1 SS_sky130_fd_sc_hd__fill_1
XFILLER_121_662 vssd1 vccd1 vccd1 vssd1 SS_sky130_fd_sc_hd__fill_8
XFILLER_39_429 vssd1 vccd1 vssd1 vccd1 SS_sky130_ef_sc_hd__decap_40_12
XFILLER_67_727 vccd1 vssd1 vccd1 vssd1 SS_sky130_fd_sc_hd__fill_1
XFILLER_86_83 vccd1 vssd1 vccd1 vssd1 SS_sky130_fd_sc_hd__fill_1
XFILLER_121_673 vssd1 vccd1 vssd1 vccd1 SS_sky130_ef_sc_hd__decap_40_12
XFILLER_94_513 vssd1 vccd1 vccd1 vssd1 SS_sky130_fd_sc_hd__fill_8
XFILLER_13_6 vssd1 vccd1 vssd1 vccd1 SS_sky130_ef_sc_hd__decap_40_12
XFILLER_94_568 vccd1 vssd1 vccd1 vssd1 SS_sky130_fd_sc_hd__fill_1
X_1001_ vssd1 vccd1 vccd1 vssd1 wire253/A input38/X _1533_/D _1465_/C1 _1000_/X SS_sky130_fd_sc_hd__o211a_2
XFILLER_62_421 vssd1 vccd1 vccd1 vssd1 SS_sky130_fd_sc_hd__fill_4
XFILLER_22_307 vccd1 vssd1 vccd1 vssd1 SS_sky130_fd_sc_hd__fill_1
XFILLER_62_443 vssd1 vccd1 vccd1 vssd1 SS_sky130_fd_sc_hd__fill_4
XTAP_TAPCELL_ROW_85_1569 vccd1 vssd1 SS_sky130_fd_sc_hd__tapvpwrvgnd_1
XFILLER_34_189 vssd1 vccd1 vccd1 vssd1 SS_sky130_fd_sc_hd__fill_4
XFILLER_62_498 vccd1 vssd1 vccd1 vssd1 SS_sky130_fd_sc_hd__fill_1
XFILLER_31_841 vccd1 vssd1 vccd1 vssd1 SS_sky130_fd_sc_hd__fill_1
X_1903_ vccd1 vssd1 _1903_/X _1903_/A vccd1 vssd1 SS_sky130_fd_sc_hd__buf_2
X_1834_ vccd1 vssd1 _1834_/X _1834_/A vccd1 vssd1 SS_sky130_fd_sc_hd__buf_2
XTAP_TAPCELL_ROW_116_2035 vccd1 vssd1 SS_sky130_fd_sc_hd__tapvpwrvgnd_1
XFILLER_129_795 vssd1 vccd1 vssd1 vccd1 SS_sky130_ef_sc_hd__decap_40_12
XTAP_TAPCELL_ROW_116_2046 vccd1 vssd1 SS_sky130_fd_sc_hd__tapvpwrvgnd_1
XFILLER_116_401 vssd1 vccd1 vssd1 vccd1 SS_sky130_ef_sc_hd__decap_40_12
Xhold569 _1671_/D _1287_/X vccd1 vssd1 vssd1 vccd1 SS_sky130_fd_sc_hd__dlygate4sd3_1
X_1696_ _1696_/Q _1741_/CLK _1696_/D vccd1 vssd1 vccd1 vssd1 SS_sky130_fd_sc_hd__dfxtp_2
XFILLER_100_802 vssd1 vccd1 vccd1 vssd1 SS_sky130_fd_sc_hd__fill_2
Xload_slew483 vccd1 vssd1 _1465_/C1 _1133_/C1 vccd1 vssd1 SS_sky130_fd_sc_hd__buf_4
Xload_slew450 vccd1 vssd1 _0891_/B1 _1277_/A vccd1 vssd1 SS_sky130_fd_sc_hd__buf_4
XFILLER_111_161 vssd1 vccd1 vccd1 vssd1 SS_sky130_fd_sc_hd__fill_4
XFILLER_100_835 vccd1 vssd1 vccd1 vssd1 SS_sky130_fd_sc_hd__fill_1
XFILLER_100_813 vccd1 vssd1 vccd1 vssd1 SS_sky130_fd_sc_hd__fill_1
XFILLER_57_237 vssd1 vccd1 vssd1 vccd1 SS_sky130_ef_sc_hd__decap_40_12
XFILLER_85_557 vssd1 vccd1 vccd1 vssd1 SS_sky130_fd_sc_hd__fill_2
XFILLER_26_613 vssd1 vccd1 vssd1 vccd1 SS_sky130_ef_sc_hd__decap_40_12
XFILLER_122_15 vssd1 vccd1 vssd1 vccd1 SS_sky130_ef_sc_hd__decap_40_12
XFILLER_26_657 vssd1 vccd1 vssd1 vccd1 SS_sky130_ef_sc_hd__decap_40_12
XFILLER_65_281 vssd1 vccd1 vssd1 vccd1 SS_sky130_ef_sc_hd__decap_40_12
XTAP_TAPCELL_ROW_0_288 vccd1 vssd1 SS_sky130_fd_sc_hd__tapvpwrvgnd_1
XFILLER_14_819 vccd1 vssd1 vccd1 vssd1 SS_sky130_fd_sc_hd__fill_1
XFILLER_25_167 vccd1 vssd1 vccd1 vssd1 SS_sky130_fd_sc_hd__fill_1
XFILLER_80_251 vccd1 vssd1 vccd1 vssd1 SS_sky130_fd_sc_hd__fill_1
XFILLER_81_785 vssd1 vccd1 vssd1 vccd1 SS_sky130_ef_sc_hd__decap_40_12
XTAP_TAPCELL_ROW_0_299 vccd1 vssd1 SS_sky130_fd_sc_hd__tapvpwrvgnd_1
XFILLER_13_329 vssd1 vccd1 vccd1 vssd1 SS_sky130_fd_sc_hd__fill_4
XFILLER_15_57 vssd1 vccd1 vssd1 vccd1 SS_sky130_ef_sc_hd__decap_40_12
XFILLER_40_137 vssd1 vccd1 vccd1 vssd1 SS_sky130_fd_sc_hd__fill_2
XFILLER_21_373 vssd1 vccd1 vssd1 vccd1 SS_sky130_ef_sc_hd__decap_40_12
XFILLER_5_517 vssd1 vccd1 vssd1 vccd1 SS_sky130_ef_sc_hd__decap_40_12
XFILLER_126_209 vssd1 vccd1 vssd1 vccd1 SS_sky130_ef_sc_hd__decap_40_12
XFILLER_119_261 vssd1 vccd1 vssd1 vccd1 SS_sky130_ef_sc_hd__decap_40_12
XFILLER_107_445 vssd1 vccd1 vccd1 vssd1 SS_sky130_fd_sc_hd__fill_2
XTAP_TAPCELL_ROW_56_1137 vccd1 vssd1 SS_sky130_fd_sc_hd__tapvpwrvgnd_1
XFILLER_134_253 vssd1 vccd1 vssd1 vccd1 SS_sky130_ef_sc_hd__decap_40_12
XFILLER_89_841 vccd1 vssd1 vccd1 vssd1 SS_sky130_fd_sc_hd__fill_1
Xoutput67 vccd1 vssd1 wire293/A _1902_/X vccd1 vssd1 SS_sky130_fd_sc_hd__buf_4
Xoutput56 vccd1 vssd1 wire304/A _1892_/X vccd1 vssd1 SS_sky130_fd_sc_hd__buf_4
XFILLER_0_233 vssd1 vccd1 vssd1 vccd1 SS_sky130_ef_sc_hd__decap_40_12
Xoutput78 vccd1 vssd1 wire282/A _1839_/X vccd1 vssd1 SS_sky130_fd_sc_hd__buf_4
Xoutput89 vccd1 vssd1 wire271/A _1849_/X vccd1 vssd1 SS_sky130_fd_sc_hd__buf_4
XFILLER_0_277 vssd1 vccd1 vccd1 vssd1 SS_sky130_fd_sc_hd__fill_2
XFILLER_49_727 vccd1 vssd1 vccd1 vssd1 SS_sky130_fd_sc_hd__fill_1
XFILLER_76_513 vssd1 vccd1 vssd1 vccd1 SS_sky130_ef_sc_hd__decap_40_12
XFILLER_103_673 vssd1 vccd1 vssd1 vccd1 SS_sky130_ef_sc_hd__decap_40_12
XFILLER_0_299 vssd1 vccd1 vccd1 vssd1 SS_sky130_fd_sc_hd__fill_8
XFILLER_76_557 vssd1 vccd1 vssd1 vccd1 SS_sky130_ef_sc_hd__decap_40_12
XFILLER_17_613 vssd1 vccd1 vccd1 vssd1 SS_sky130_fd_sc_hd__fill_2
XFILLER_29_473 vssd1 vccd1 vssd1 vccd1 SS_sky130_ef_sc_hd__decap_40_12
XFILLER_56_53 vssd1 vccd1 vssd1 vccd1 SS_sky130_ef_sc_hd__decap_40_12
XFILLER_91_505 vssd1 vccd1 vssd1 vccd1 SS_sky130_ef_sc_hd__decap_40_12
XFILLER_44_421 vssd1 vccd1 vssd1 vccd1 SS_sky130_ef_sc_hd__decap_40_12
XFILLER_56_97 vssd1 vccd1 vssd1 vccd1 SS_sky130_ef_sc_hd__decap_40_12
XFILLER_57_793 vssd1 vccd1 vccd1 vssd1 SS_sky130_fd_sc_hd__fill_8
XFILLER_32_605 vssd1 vccd1 vssd1 vccd1 SS_sky130_ef_sc_hd__decap_40_12
XPHY_EDGE_ROW_113_Right_113 vccd1 vssd1 vccd1 vssd1 SS_sky130_fd_sc_hd__decap_3
XFILLER_16_189 vssd1 vccd1 vccd1 vssd1 SS_sky130_fd_sc_hd__fill_4
XFILLER_32_649 vssd1 vccd1 vssd1 vccd1 SS_sky130_ef_sc_hd__decap_40_12
XTAP_TAPCELL_ROW_67_1299 vccd1 vssd1 SS_sky130_fd_sc_hd__tapvpwrvgnd_1
XFILLER_71_273 vssd1 vccd1 vccd1 vssd1 SS_sky130_fd_sc_hd__fill_4
XFILLER_72_41 vssd1 vccd1 vssd1 vccd1 SS_sky130_ef_sc_hd__decap_40_12
XFILLER_112_81 vssd1 vccd1 vccd1 vssd1 SS_sky130_fd_sc_hd__fill_2
XFILLER_13_841 vccd1 vssd1 vccd1 vssd1 SS_sky130_fd_sc_hd__fill_1
XFILLER_31_137 vssd1 vccd1 vssd1 vccd1 SS_sky130_ef_sc_hd__decap_40_12
XFILLER_72_85 vssd1 vccd1 vssd1 vccd1 SS_sky130_ef_sc_hd__decap_40_12
XFILLER_8_333 vssd1 vccd1 vssd1 vccd1 SS_sky130_ef_sc_hd__decap_40_12
XTAP_TAPCELL_ROW_80_1499 vccd1 vssd1 SS_sky130_fd_sc_hd__tapvpwrvgnd_1
XFILLER_8_377 vssd1 vccd1 vssd1 vccd1 SS_sky130_ef_sc_hd__decap_40_12
X_1550_ _1550_/Q _1748_/CLK _1550_/D vccd1 vssd1 vccd1 vssd1 SS_sky130_fd_sc_hd__dfxtp_2
XFILLER_126_787 vssd1 vccd1 vccd1 vssd1 SS_sky130_fd_sc_hd__fill_8
XFILLER_126_765 vccd1 vssd1 vccd1 vssd1 SS_sky130_fd_sc_hd__fill_1
X_1481_ _1481_/Q _1738_/CLK _1481_/D vccd1 vssd1 vccd1 vssd1 SS_sky130_fd_sc_hd__dfxtp_2
XFILLER_98_137 vssd1 vccd1 vccd1 vssd1 SS_sky130_fd_sc_hd__fill_2
XFILLER_100_109 vssd1 vccd1 vssd1 vccd1 SS_sky130_ef_sc_hd__decap_40_12
XFILLER_97_93 vssd1 vccd1 vssd1 vccd1 SS_sky130_ef_sc_hd__decap_40_12
XFILLER_39_237 vssd1 vccd1 vssd1 vccd1 SS_sky130_ef_sc_hd__decap_40_12
XFILLER_79_395 vccd1 vssd1 vccd1 vssd1 SS_sky130_fd_sc_hd__fill_1
XTAP_TAPCELL_ROW_87_1609 vccd1 vssd1 SS_sky130_fd_sc_hd__tapvpwrvgnd_1
XFILLER_94_365 vssd1 vccd1 vssd1 vccd1 SS_sky130_ef_sc_hd__decap_40_12
XFILLER_47_281 vssd1 vccd1 vssd1 vccd1 SS_sky130_ef_sc_hd__decap_40_12
XFILLER_63_741 vssd1 vccd1 vssd1 vccd1 SS_sky130_ef_sc_hd__decap_40_12
XFILLER_62_251 vccd1 vssd1 vccd1 vssd1 SS_sky130_fd_sc_hd__fill_1
XTAP_TAPCELL_ROW_46_983 vccd1 vssd1 SS_sky130_fd_sc_hd__tapvpwrvgnd_1
XTAP_TAPCELL_ROW_46_994 vccd1 vssd1 SS_sky130_fd_sc_hd__tapvpwrvgnd_1
XFILLER_63_785 vssd1 vccd1 vssd1 vccd1 SS_sky130_ef_sc_hd__decap_40_12
XFILLER_22_137 vssd1 vccd1 vccd1 vssd1 SS_sky130_fd_sc_hd__fill_2
XFILLER_50_457 vssd1 vccd1 vssd1 vccd1 SS_sky130_ef_sc_hd__decap_40_12
XFILLER_136_529 vssd1 vccd1 vccd1 vssd1 SS_sky130_fd_sc_hd__fill_2
XFILLER_108_209 vssd1 vccd1 vssd1 vccd1 SS_sky130_ef_sc_hd__decap_40_12
X_1748_ _1748_/Q _1748_/CLK _1748_/D vccd1 vssd1 vccd1 vssd1 SS_sky130_fd_sc_hd__dfxtp_2
XFILLER_117_15 vssd1 vccd1 vssd1 vccd1 SS_sky130_ef_sc_hd__decap_40_12
XFILLER_116_253 vssd1 vccd1 vssd1 vccd1 SS_sky130_ef_sc_hd__decap_40_12
X_1679_ _1679_/Q clkload4/A _1679_/D vccd1 vssd1 vccd1 vssd1 SS_sky130_fd_sc_hd__dfxtp_2
XFILLER_89_137 vssd1 vccd1 vssd1 vccd1 SS_sky130_ef_sc_hd__decap_40_12
XFILLER_131_223 vccd1 vssd1 vccd1 vssd1 SS_sky130_fd_sc_hd__fill_1
XFILLER_132_746 vssd1 vccd1 vccd1 vssd1 SS_sky130_fd_sc_hd__fill_8
XFILLER_132_757 vssd1 vccd1 vssd1 vccd1 SS_sky130_ef_sc_hd__decap_40_12
XFILLER_58_513 vssd1 vccd1 vssd1 vccd1 SS_sky130_ef_sc_hd__decap_40_12
XFILLER_86_811 vccd1 vssd1 vccd1 vssd1 SS_sky130_fd_sc_hd__fill_1
XTAP_TAPCELL_ROW_129_2237 vccd1 vssd1 SS_sky130_fd_sc_hd__tapvpwrvgnd_1
XTAP_TAPCELL_ROW_5_369 vccd1 vssd1 SS_sky130_fd_sc_hd__tapvpwrvgnd_1
XTAP_TAPCELL_ROW_51_1067 vccd1 vssd1 SS_sky130_fd_sc_hd__tapvpwrvgnd_1
XFILLER_100_643 vccd1 vssd1 vccd1 vssd1 SS_sky130_fd_sc_hd__fill_1
XFILLER_97_181 vssd1 vccd1 vssd1 vccd1 SS_sky130_ef_sc_hd__decap_40_12
XFILLER_73_505 vssd1 vccd1 vccd1 vssd1 SS_sky130_fd_sc_hd__fill_8
XFILLER_133_69 vssd1 vccd1 vssd1 vccd1 SS_sky130_ef_sc_hd__decap_40_12
XFILLER_93_18 vssd1 vccd1 vssd1 vccd1 SS_sky130_ef_sc_hd__decap_40_12
XFILLER_26_421 vssd1 vccd1 vssd1 vccd1 SS_sky130_ef_sc_hd__decap_40_12
XFILLER_53_273 vssd1 vccd1 vccd1 vssd1 SS_sky130_fd_sc_hd__fill_4
XFILLER_81_571 vssd1 vccd1 vssd1 vccd1 SS_sky130_ef_sc_hd__decap_40_12
XFILLER_13_137 vssd1 vccd1 vssd1 vccd1 SS_sky130_ef_sc_hd__decap_40_12
XTAP_TAPCELL_ROW_24_655 vccd1 vssd1 SS_sky130_fd_sc_hd__tapvpwrvgnd_1
XTAP_TAPCELL_ROW_24_666 vccd1 vssd1 SS_sky130_fd_sc_hd__tapvpwrvgnd_1
XFILLER_21_181 vssd1 vccd1 vssd1 vccd1 SS_sky130_ef_sc_hd__decap_40_12
XFILLER_22_693 vssd1 vccd1 vccd1 vssd1 SS_sky130_fd_sc_hd__fill_4
XFILLER_42_77 vssd1 vccd1 vccd1 vssd1 SS_sky130_fd_sc_hd__fill_4
XFILLER_108_721 vssd1 vccd1 vssd1 vccd1 SS_sky130_ef_sc_hd__decap_40_12
XFILLER_135_573 vssd1 vccd1 vccd1 vssd1 SS_sky130_fd_sc_hd__fill_4
XFILLER_1_553 vssd1 vccd1 vccd1 vssd1 SS_sky130_fd_sc_hd__fill_4
XFILLER_122_245 vssd1 vccd1 vccd1 vssd1 SS_sky130_fd_sc_hd__fill_4
XFILLER_77_811 vssd1 vccd1 vccd1 vssd1 SS_sky130_fd_sc_hd__fill_4
XFILLER_122_289 vssd1 vccd1 vccd1 vssd1 SS_sky130_fd_sc_hd__fill_8
XFILLER_110_429 vssd1 vccd1 vssd1 vccd1 SS_sky130_ef_sc_hd__decap_40_12
XFILLER_107_81 vssd1 vccd1 vssd1 vccd1 SS_sky130_ef_sc_hd__decap_40_12
XFILLER_1_597 vssd1 vccd1 vssd1 vccd1 SS_sky130_ef_sc_hd__decap_40_12
XFILLER_76_321 vssd1 vccd1 vssd1 vccd1 SS_sky130_ef_sc_hd__decap_40_12
XTAP_TAPCELL_ROW_69_1328 vccd1 vssd1 SS_sky130_fd_sc_hd__tapvpwrvgnd_1
XFILLER_76_365 vssd1 vccd1 vssd1 vccd1 SS_sky130_ef_sc_hd__decap_40_12
XFILLER_29_281 vssd1 vccd1 vssd1 vccd1 SS_sky130_ef_sc_hd__decap_40_12
XTAP_TAPCELL_ROW_69_1339 vccd1 vssd1 SS_sky130_fd_sc_hd__tapvpwrvgnd_1
XFILLER_91_335 vccd1 vssd1 vccd1 vssd1 SS_sky130_fd_sc_hd__fill_1
XFILLER_45_741 vssd1 vccd1 vssd1 vccd1 SS_sky130_ef_sc_hd__decap_40_12
XFILLER_32_413 vssd1 vccd1 vccd1 vssd1 SS_sky130_fd_sc_hd__fill_4
XFILLER_44_251 vccd1 vssd1 vccd1 vssd1 SS_sky130_fd_sc_hd__fill_1
XFILLER_45_785 vssd1 vccd1 vssd1 vccd1 SS_sky130_ef_sc_hd__decap_40_12
XFILLER_60_711 vccd1 vssd1 vccd1 vssd1 SS_sky130_fd_sc_hd__fill_1
XTAP_TAPCELL_ROW_82_1528 vccd1 vssd1 SS_sky130_fd_sc_hd__tapvpwrvgnd_1
XFILLER_32_457 vssd1 vccd1 vssd1 vccd1 SS_sky130_ef_sc_hd__decap_40_12
XTAP_TAPCELL_ROW_43_942 vccd1 vssd1 SS_sky130_fd_sc_hd__tapvpwrvgnd_1
XFILLER_60_744 vssd1 vccd1 vccd1 vssd1 SS_sky130_fd_sc_hd__fill_8
XFILLER_13_671 vccd1 vssd1 vccd1 vssd1 SS_sky130_fd_sc_hd__fill_1
XFILLER_60_777 vssd1 vccd1 vssd1 vccd1 SS_sky130_ef_sc_hd__decap_40_12
X_0981_ vssd1 vccd1 vccd1 vssd1 wire253/A input27/X _1523_/D _1441_/C1 _0980_/X SS_sky130_fd_sc_hd__o211a_2
XFILLER_9_653 vssd1 vccd1 vssd1 vccd1 SS_sky130_ef_sc_hd__decap_40_12
XFILLER_8_141 vssd1 vccd1 vssd1 vccd1 SS_sky130_ef_sc_hd__decap_40_12
XFILLER_9_697 vssd1 vccd1 vssd1 vccd1 SS_sky130_ef_sc_hd__decap_40_12
X_1602_ _1602_/Q _1634_/CLK _1602_/D vccd1 vssd1 vccd1 vssd1 SS_sky130_fd_sc_hd__dfxtp_2
XTAP_TAPCELL_ROW_97_1760 vccd1 vssd1 SS_sky130_fd_sc_hd__tapvpwrvgnd_1
XFILLER_59_3 vssd1 vccd1 vssd1 vccd1 SS_sky130_ef_sc_hd__decap_40_12
XFILLER_114_713 vssd1 vccd1 vssd1 vccd1 SS_sky130_ef_sc_hd__decap_40_12
X_1533_ _1533_/Q _1758_/CLK _1533_/D vccd1 vssd1 vccd1 vssd1 SS_sky130_fd_sc_hd__dfxtp_2
XFILLER_114_746 vssd1 vccd1 vccd1 vssd1 SS_sky130_fd_sc_hd__fill_8
XFILLER_113_223 vccd1 vssd1 vccd1 vssd1 SS_sky130_fd_sc_hd__fill_1
X_1464_ vccd1 vssd1 vccd1 vssd1 _1464_/X _1464_/A _1466_/B SS_sky130_fd_sc_hd__or2_2
XFILLER_114_757 vssd1 vccd1 vssd1 vccd1 SS_sky130_ef_sc_hd__decap_40_12
XFILLER_68_811 vccd1 vssd1 vccd1 vssd1 SS_sky130_fd_sc_hd__fill_1
XFILLER_113_289 vssd1 vccd1 vccd1 vssd1 SS_sky130_fd_sc_hd__fill_2
XFILLER_67_343 vccd1 vssd1 vccd1 vssd1 SS_sky130_fd_sc_hd__fill_1
XFILLER_79_181 vssd1 vccd1 vssd1 vccd1 SS_sky130_ef_sc_hd__decap_40_12
X_1395_ vssd1 vccd1 vccd1 vssd1 _1397_/A2 input37/X _1395_/X _1465_/C1 _1394_/X SS_sky130_fd_sc_hd__o211a_2
XFILLER_95_641 vssd1 vccd1 vssd1 vccd1 SS_sky130_ef_sc_hd__decap_40_12
XTAP_TAPCELL_ROW_2_328 vccd1 vssd1 SS_sky130_fd_sc_hd__tapvpwrvgnd_1
XFILLER_55_505 vssd1 vccd1 vssd1 vccd1 SS_sky130_ef_sc_hd__decap_40_12
XFILLER_67_354 vssd1 vccd1 vssd1 vccd1 SS_sky130_ef_sc_hd__decap_40_12
XFILLER_95_685 vssd1 vccd1 vssd1 vccd1 SS_sky130_ef_sc_hd__decap_40_12
XFILLER_94_195 vccd1 vssd1 vccd1 vssd1 SS_sky130_fd_sc_hd__fill_1
XTAP_TAPCELL_ROW_124_2167 vccd1 vssd1 SS_sky130_fd_sc_hd__tapvpwrvgnd_1
XTAP_TAPCELL_ROW_124_2156 vccd1 vssd1 SS_sky130_fd_sc_hd__tapvpwrvgnd_1
XFILLER_35_273 vssd1 vccd1 vccd1 vssd1 SS_sky130_fd_sc_hd__fill_4
XFILLER_50_221 vssd1 vccd1 vssd1 vccd1 SS_sky130_ef_sc_hd__decap_40_12
XFILLER_50_265 vssd1 vccd1 vssd1 vccd1 SS_sky130_ef_sc_hd__decap_40_12
XFILLER_51_777 vssd1 vccd1 vccd1 vssd1 SS_sky130_fd_sc_hd__fill_4
XTAP_TAPCELL_ROW_21_614 vccd1 vssd1 SS_sky130_fd_sc_hd__tapvpwrvgnd_1
XFILLER_109_529 vssd1 vccd1 vssd1 vccd1 SS_sky130_ef_sc_hd__decap_40_12
XFILLER_88_18 vssd1 vccd1 vccd1 vssd1 SS_sky130_fd_sc_hd__fill_8
XFILLER_136_359 vssd1 vccd1 vccd1 vssd1 SS_sky130_fd_sc_hd__fill_4
XFILLER_88_29 vssd1 vccd1 vssd1 vccd1 SS_sky130_ef_sc_hd__decap_40_12
XFILLER_117_573 vssd1 vccd1 vssd1 vccd1 SS_sky130_ef_sc_hd__decap_40_12
XFILLER_104_245 vssd1 vccd1 vccd1 vssd1 SS_sky130_fd_sc_hd__fill_4
XFILLER_104_289 vssd1 vccd1 vssd1 vccd1 SS_sky130_ef_sc_hd__decap_40_12
XFILLER_58_321 vssd1 vccd1 vssd1 vccd1 SS_sky130_ef_sc_hd__decap_40_12
XFILLER_86_641 vssd1 vccd1 vccd1 vssd1 SS_sky130_fd_sc_hd__fill_2
XFILLER_58_365 vssd1 vccd1 vccd1 vssd1 SS_sky130_fd_sc_hd__fill_8
Xafe_wb_510 analog_io_out[2] afe_wb_510/HI vccd1 vssd1 vssd1 vccd1 SS_sky130_fd_sc_hd__conb_1
XTAP_TAPCELL_ROW_109_1929 vccd1 vssd1 SS_sky130_fd_sc_hd__tapvpwrvgnd_1
Xafe_wb_543 afe_wb_543/LO analog_io_oeb[7] vccd1 vssd1 vssd1 vccd1 SS_sky130_fd_sc_hd__conb_1
XTAP_TAPCELL_ROW_29_736 vccd1 vssd1 SS_sky130_fd_sc_hd__tapvpwrvgnd_1
XFILLER_37_55 vccd1 vssd1 vccd1 vssd1 SS_sky130_fd_sc_hd__fill_1
Xafe_wb_554 afe_wb_554/LO analog_io_oeb[18] vccd1 vssd1 vssd1 vccd1 SS_sky130_fd_sc_hd__conb_1
Xafe_wb_532 analog_io_out[24] afe_wb_532/HI vccd1 vssd1 vssd1 vccd1 SS_sky130_fd_sc_hd__conb_1
Xafe_wb_521 analog_io_out[13] afe_wb_521/HI vccd1 vssd1 vssd1 vccd1 SS_sky130_fd_sc_hd__conb_1
XFILLER_27_741 vssd1 vccd1 vssd1 vccd1 SS_sky130_ef_sc_hd__decap_40_12
XFILLER_14_413 vssd1 vccd1 vccd1 vssd1 SS_sky130_fd_sc_hd__fill_4
XFILLER_26_251 vccd1 vssd1 vccd1 vssd1 SS_sky130_fd_sc_hd__fill_1
XFILLER_27_785 vssd1 vccd1 vssd1 vccd1 SS_sky130_ef_sc_hd__decap_40_12
XFILLER_41_221 vssd1 vccd1 vccd1 vssd1 SS_sky130_fd_sc_hd__fill_2
XFILLER_53_54 vssd1 vccd1 vccd1 vssd1 SS_sky130_fd_sc_hd__fill_2
XTAP_TAPCELL_ROW_64_1258 vccd1 vssd1 SS_sky130_fd_sc_hd__tapvpwrvgnd_1
XFILLER_14_457 vssd1 vccd1 vssd1 vccd1 SS_sky130_ef_sc_hd__decap_40_12
XTAP_TAPCELL_ROW_40_901 vccd1 vssd1 SS_sky130_fd_sc_hd__tapvpwrvgnd_1
XFILLER_42_777 vssd1 vccd1 vssd1 vccd1 SS_sky130_ef_sc_hd__decap_40_12
XFILLER_6_601 vssd1 vccd1 vssd1 vccd1 SS_sky130_ef_sc_hd__decap_40_12
XFILLER_10_641 vssd1 vccd1 vccd1 vssd1 SS_sky130_fd_sc_hd__fill_2
XFILLER_5_111 vccd1 vssd1 vccd1 vssd1 SS_sky130_fd_sc_hd__fill_1
XFILLER_6_645 vssd1 vccd1 vssd1 vccd1 SS_sky130_ef_sc_hd__decap_40_12
XFILLER_127_337 vssd1 vccd1 vssd1 vccd1 SS_sky130_ef_sc_hd__decap_40_12
XFILLER_127_326 vccd1 vssd1 vccd1 vssd1 SS_sky130_fd_sc_hd__fill_1
XTAP_TAPCELL_ROW_79_1490 vccd1 vssd1 SS_sky130_fd_sc_hd__tapvpwrvgnd_1
XFILLER_1_361 vssd1 vccd1 vssd1 vccd1 SS_sky130_ef_sc_hd__decap_40_12
XFILLER_111_727 vccd1 vssd1 vccd1 vssd1 SS_sky130_fd_sc_hd__fill_1
XFILLER_77_641 vssd1 vccd1 vssd1 vccd1 SS_sky130_ef_sc_hd__decap_40_12
XFILLER_96_438 vssd1 vccd1 vssd1 vccd1 SS_sky130_ef_sc_hd__decap_40_12
XFILLER_37_505 vssd1 vccd1 vssd1 vccd1 SS_sky130_ef_sc_hd__decap_40_12
X_1180_ vccd1 vssd1 vccd1 vssd1 _1180_/X _1180_/A _1186_/B SS_sky130_fd_sc_hd__or2_2
XFILLER_77_685 vssd1 vccd1 vssd1 vccd1 SS_sky130_ef_sc_hd__decap_40_12
XFILLER_92_633 vssd1 vccd1 vccd1 vssd1 SS_sky130_fd_sc_hd__fill_8
XFILLER_76_195 vccd1 vssd1 vccd1 vssd1 SS_sky130_fd_sc_hd__fill_1
XFILLER_94_83 vccd1 vssd1 vccd1 vssd1 SS_sky130_fd_sc_hd__fill_1
XFILLER_17_273 vssd1 vccd1 vccd1 vssd1 SS_sky130_fd_sc_hd__fill_4
XFILLER_18_774 vssd1 vccd1 vssd1 vccd1 SS_sky130_ef_sc_hd__decap_40_12
XFILLER_33_711 vssd1 vccd1 vccd1 vssd1 SS_sky130_fd_sc_hd__fill_8
XFILLER_91_165 vssd1 vccd1 vccd1 vssd1 SS_sky130_fd_sc_hd__fill_2
XFILLER_92_699 vccd1 vssd1 vccd1 vssd1 SS_sky130_fd_sc_hd__fill_1
XFILLER_32_221 vssd1 vccd1 vssd1 vccd1 SS_sky130_ef_sc_hd__decap_40_12
XFILLER_32_265 vssd1 vccd1 vssd1 vccd1 SS_sky130_ef_sc_hd__decap_40_12
XFILLER_33_777 vssd1 vccd1 vccd1 vssd1 SS_sky130_fd_sc_hd__fill_4
XFILLER_60_574 vssd1 vccd1 vssd1 vccd1 SS_sky130_ef_sc_hd__decap_40_12
XFILLER_119_805 vssd1 vccd1 vccd1 vssd1 SS_sky130_fd_sc_hd__fill_2
XFILLER_9_461 vssd1 vccd1 vssd1 vccd1 SS_sky130_ef_sc_hd__decap_40_12
X_0964_ vccd1 vssd1 vccd1 vssd1 _0964_/X _0964_/A _0988_/B SS_sky130_fd_sc_hd__or2_2
X_0895_ vssd1 vccd1 vccd1 vssd1 _0895_/B _0895_/C _0943_/A _0895_/X SS_sky130_fd_sc_hd__or3_2
XTAP_TAPCELL_ROW_95_1719 vccd1 vssd1 SS_sky130_fd_sc_hd__tapvpwrvgnd_1
XFILLER_134_808 vssd1 vccd1 vccd1 vssd1 SS_sky130_fd_sc_hd__fill_4
XFILLER_133_329 vccd1 vssd1 vccd1 vssd1 SS_sky130_fd_sc_hd__fill_1
Xoutput202 vccd1 vssd1 wire353/A _1484_/Q vccd1 vssd1 SS_sky130_fd_sc_hd__buf_4
XFILLER_114_521 vssd1 vccd1 vccd1 vssd1 SS_sky130_fd_sc_hd__fill_2
XTAP_TAPCELL_ROW_7_409 vccd1 vssd1 SS_sky130_fd_sc_hd__tapvpwrvgnd_1
X_1516_ _1516_/Q _1741_/CLK _1516_/D vccd1 vssd1 vccd1 vssd1 SS_sky130_fd_sc_hd__dfxtp_2
XFILLER_99_221 vssd1 vccd1 vccd1 vssd1 SS_sky130_fd_sc_hd__fill_2
XFILLER_87_405 vccd1 vssd1 vccd1 vssd1 SS_sky130_fd_sc_hd__fill_1
XFILLER_102_705 vccd1 vssd1 vccd1 vssd1 SS_sky130_fd_sc_hd__fill_1
XFILLER_4_81 vssd1 vccd1 vccd1 vssd1 SS_sky130_fd_sc_hd__fill_2
XFILLER_68_641 vssd1 vccd1 vccd1 vssd1 SS_sky130_fd_sc_hd__fill_2
X_1447_ vssd1 vccd1 vccd1 vssd1 wire207/X input29/X _1749_/D _1447_/C1 _1446_/X SS_sky130_fd_sc_hd__o211a_2
XFILLER_87_449 vssd1 vccd1 vssd1 vccd1 SS_sky130_ef_sc_hd__decap_40_12
XFILLER_101_237 vssd1 vccd1 vssd1 vccd1 SS_sky130_ef_sc_hd__decap_40_12
X_1378_ vccd1 vssd1 vccd1 vssd1 _1378_/X _1378_/A _1396_/B SS_sky130_fd_sc_hd__or2_2
XFILLER_114_27 vccd1 vssd1 vccd1 vssd1 SS_sky130_fd_sc_hd__fill_1
XFILLER_83_622 vssd1 vccd1 vssd1 vccd1 SS_sky130_ef_sc_hd__decap_40_12
XFILLER_110_771 vssd1 vccd1 vssd1 vccd1 SS_sky130_ef_sc_hd__decap_40_12
XFILLER_82_121 vssd1 vccd1 vssd1 vccd1 SS_sky130_ef_sc_hd__decap_40_12
XFILLER_83_666 vssd1 vccd1 vccd1 vssd1 SS_sky130_fd_sc_hd__fill_4
XFILLER_70_305 vssd1 vccd1 vccd1 vssd1 SS_sky130_fd_sc_hd__fill_2
XFILLER_71_839 vccd1 vssd1 vccd1 vssd1 SS_sky130_fd_sc_hd__fill_1
XFILLER_82_165 vssd1 vccd1 vssd1 vccd1 SS_sky130_ef_sc_hd__decap_40_12
XFILLER_130_15 vssd1 vccd1 vssd1 vccd1 SS_sky130_ef_sc_hd__decap_40_12
XFILLER_23_221 vssd1 vccd1 vccd1 vssd1 SS_sky130_fd_sc_hd__fill_2
XFILLER_51_541 vssd1 vccd1 vccd1 vssd1 SS_sky130_fd_sc_hd__fill_2
XFILLER_70_338 vccd1 vssd1 vccd1 vssd1 SS_sky130_fd_sc_hd__fill_1
XTAP_TAPCELL_ROW_104_1859 vccd1 vssd1 SS_sky130_fd_sc_hd__tapvpwrvgnd_1
XFILLER_11_405 vssd1 vccd1 vssd1 vccd1 SS_sky130_ef_sc_hd__decap_40_12
XFILLER_11_449 vssd1 vccd1 vssd1 vccd1 SS_sky130_ef_sc_hd__decap_40_12
Xwire307 vccd1 vssd1 vssd1 vccd1 wire307/A analog_ctrl[9] SS_sky130_fd_sc_hd__buf_12
XFILLER_23_57 vssd1 vccd1 vssd1 vccd1 SS_sky130_ef_sc_hd__decap_40_12
Xwire329 vccd1 vssd1 vssd1 vccd1 wire329/A analog_ctrl[48] SS_sky130_fd_sc_hd__buf_12
Xwire318 vccd1 vssd1 vssd1 vccd1 wire318/A analog_ctrl[58] SS_sky130_fd_sc_hd__buf_12
XTAP_TAPCELL_ROW_137_2358 vccd1 vssd1 SS_sky130_fd_sc_hd__tapvpwrvgnd_1
XFILLER_137_613 vssd1 vccd1 vccd1 vssd1 SS_sky130_fd_sc_hd__fill_2
XFILLER_128_6 vssd1 vccd1 vssd1 vccd1 SS_sky130_ef_sc_hd__decap_40_12
XFILLER_137_657 vssd1 vccd1 vccd1 vssd1 SS_sky130_fd_sc_hd__fill_4
XFILLER_109_337 vssd1 vccd1 vccd1 vssd1 SS_sky130_fd_sc_hd__fill_4
XFILLER_124_307 vccd1 vssd1 vccd1 vssd1 SS_sky130_fd_sc_hd__fill_1
XFILLER_99_39 vssd1 vccd1 vssd1 vccd1 SS_sky130_ef_sc_hd__decap_40_12
XFILLER_3_615 vccd1 vssd1 vccd1 vssd1 SS_sky130_fd_sc_hd__fill_1
XFILLER_136_178 vccd1 vssd1 vccd1 vssd1 SS_sky130_fd_sc_hd__fill_1
XFILLER_133_841 vccd1 vssd1 vccd1 vssd1 SS_sky130_fd_sc_hd__fill_1
XFILLER_132_362 vssd1 vccd1 vccd1 vssd1 SS_sky130_fd_sc_hd__fill_2
XFILLER_132_373 vssd1 vccd1 vccd1 vssd1 SS_sky130_fd_sc_hd__fill_2
XFILLER_120_513 vssd1 vccd1 vssd1 vccd1 SS_sky130_ef_sc_hd__decap_40_12
XFILLER_105_565 vccd1 vssd1 vccd1 vssd1 SS_sky130_fd_sc_hd__fill_1
Xfanout440 vssd1 vccd1 vccd1 vssd1 _0744_/X _0876_/B1 SS_sky130_fd_sc_hd__clkdlybuf4s25_1
XFILLER_19_505 vssd1 vccd1 vssd1 vccd1 SS_sky130_ef_sc_hd__decap_40_12
XFILLER_48_65 vssd1 vccd1 vssd1 vccd1 SS_sky130_ef_sc_hd__decap_40_12
XFILLER_59_652 vssd1 vccd1 vssd1 vccd1 SS_sky130_ef_sc_hd__decap_40_12
Xfanout451 vssd1 vccd1 vccd1 vssd1 wire454/A _1343_/A SS_sky130_fd_sc_hd__clkdlybuf4s25_1
Xfanout484 vssd1 vccd1 vccd1 vssd1 _1471_/C1 _1387_/C1 SS_sky130_fd_sc_hd__clkdlybuf4s25_1
XFILLER_46_357 vssd1 vccd1 vccd1 vssd1 SS_sky130_fd_sc_hd__fill_4
XFILLER_58_195 vccd1 vssd1 vccd1 vssd1 SS_sky130_fd_sc_hd__fill_1
XFILLER_15_711 vccd1 vssd1 vccd1 vssd1 SS_sky130_fd_sc_hd__fill_1
XFILLER_61_305 vssd1 vccd1 vssd1 vccd1 SS_sky130_ef_sc_hd__decap_40_12
XFILLER_64_53 vssd1 vccd1 vssd1 vccd1 SS_sky130_ef_sc_hd__decap_40_12
XFILLER_73_165 vssd1 vccd1 vccd1 vssd1 SS_sky130_fd_sc_hd__fill_2
XFILLER_74_699 vccd1 vssd1 vccd1 vssd1 SS_sky130_fd_sc_hd__fill_1
XFILLER_14_221 vssd1 vccd1 vssd1 vccd1 SS_sky130_ef_sc_hd__decap_40_12
XFILLER_64_97 vssd1 vccd1 vssd1 vccd1 SS_sky130_ef_sc_hd__decap_40_12
XFILLER_9_15 vssd1 vccd1 vssd1 vccd1 SS_sky130_ef_sc_hd__decap_40_12
XFILLER_14_265 vssd1 vccd1 vssd1 vccd1 SS_sky130_ef_sc_hd__decap_40_12
XFILLER_15_777 vssd1 vccd1 vccd1 vssd1 SS_sky130_fd_sc_hd__fill_4
XFILLER_30_725 vssd1 vccd1 vssd1 vccd1 SS_sky130_ef_sc_hd__decap_40_12
XFILLER_80_41 vssd1 vccd1 vssd1 vccd1 SS_sky130_ef_sc_hd__decap_40_12
XFILLER_120_81 vssd1 vccd1 vccd1 vssd1 SS_sky130_fd_sc_hd__fill_2
XFILLER_30_769 vssd1 vccd1 vccd1 vssd1 SS_sky130_fd_sc_hd__fill_4
XTAP_TAPCELL_ROW_12_477 vccd1 vssd1 SS_sky130_fd_sc_hd__tapvpwrvgnd_1
XFILLER_80_85 vssd1 vccd1 vssd1 vccd1 SS_sky130_ef_sc_hd__decap_40_12
Xclkbuf_leaf_17_wb_clk_i clkload6/A clkload1/A vccd1 vssd1 vssd1 vccd1 SS_sky130_fd_sc_hd__clkbuf_8
XFILLER_128_657 vssd1 vccd1 vssd1 vccd1 SS_sky130_ef_sc_hd__decap_40_12
XFILLER_116_819 vccd1 vssd1 vccd1 vssd1 SS_sky130_fd_sc_hd__fill_1
XFILLER_6_475 vccd1 vssd1 vccd1 vssd1 SS_sky130_fd_sc_hd__fill_1
XTAP_TAPCELL_ROW_77_1449 vccd1 vssd1 SS_sky130_fd_sc_hd__tapvpwrvgnd_1
XFILLER_127_167 vccd1 vssd1 vccd1 vssd1 SS_sky130_fd_sc_hd__fill_1
XFILLER_115_318 vssd1 vccd1 vssd1 vccd1 SS_sky130_ef_sc_hd__decap_40_12
XFILLER_43_6 vssd1 vccd1 vssd1 vccd1 SS_sky130_ef_sc_hd__decap_40_12
XFILLER_69_405 vssd1 vccd1 vssd1 vccd1 SS_sky130_ef_sc_hd__decap_40_12
XTAP_TAPCELL_ROW_90_1649 vccd1 vssd1 SS_sky130_fd_sc_hd__tapvpwrvgnd_1
XFILLER_97_725 vssd1 vccd1 vccd1 vssd1 SS_sky130_fd_sc_hd__fill_2
XFILLER_2_681 vssd1 vccd1 vssd1 vccd1 SS_sky130_ef_sc_hd__decap_40_12
X_1301_ vssd1 vccd1 vccd1 vssd1 _1319_/A2 wire500/X _1678_/D wire467/X _1300_/X SS_sky130_fd_sc_hd__o211a_2
XFILLER_69_449 vssd1 vccd1 vssd1 vccd1 SS_sky130_ef_sc_hd__decap_40_12
X_1232_ vccd1 vssd1 vccd1 vssd1 _1232_/X _1645_/Q _1272_/B SS_sky130_fd_sc_hd__or2_2
XFILLER_84_419 vccd1 vssd1 vccd1 vssd1 SS_sky130_fd_sc_hd__fill_1
XFILLER_111_557 vssd1 vccd1 vccd1 vssd1 SS_sky130_fd_sc_hd__fill_2
XFILLER_77_493 vssd1 vccd1 vccd1 vssd1 SS_sky130_fd_sc_hd__fill_8
XFILLER_37_335 vccd1 vssd1 vccd1 vssd1 SS_sky130_fd_sc_hd__fill_1
X_1163_ vssd1 vccd1 vccd1 vssd1 wire233/A wire495/X _1611_/D wire467/X _1162_/X SS_sky130_fd_sc_hd__o211a_2
XFILLER_64_121 vssd1 vccd1 vssd1 vccd1 SS_sky130_ef_sc_hd__decap_40_12
X_1094_ vccd1 vssd1 vccd1 vssd1 _1094_/X _1094_/A _1116_/B SS_sky130_fd_sc_hd__or2_2
XFILLER_52_305 vssd1 vccd1 vccd1 vssd1 SS_sky130_fd_sc_hd__fill_2
XFILLER_64_165 vssd1 vccd1 vssd1 vccd1 SS_sky130_ef_sc_hd__decap_40_12
XFILLER_80_625 vssd1 vccd1 vssd1 vccd1 SS_sky130_ef_sc_hd__decap_40_12
XTAP_TAPCELL_ROW_121_2115 vccd1 vssd1 SS_sky130_fd_sc_hd__tapvpwrvgnd_1
XFILLER_80_669 vssd1 vccd1 vssd1 vccd1 SS_sky130_ef_sc_hd__decap_40_12
XFILLER_33_541 vssd1 vccd1 vssd1 vccd1 SS_sky130_ef_sc_hd__decap_40_12
XFILLER_33_585 vssd1 vccd1 vssd1 vccd1 SS_sky130_ef_sc_hd__decap_40_12
XFILLER_100_29 vssd1 vccd1 vssd1 vccd1 SS_sky130_ef_sc_hd__decap_40_12
XFILLER_119_613 vssd1 vccd1 vccd1 vssd1 SS_sky130_fd_sc_hd__fill_2
XTAP_TAPCELL_ROW_31_764 vccd1 vssd1 SS_sky130_fd_sc_hd__tapvpwrvgnd_1
X_0947_ vccd1 vssd1 vssd1 vccd1 _0947_/Y _0947_/A _1409_/B SS_sky130_fd_sc_hd__nand2_2
XTAP_TAPCELL_ROW_119_2088 vccd1 vssd1 SS_sky130_fd_sc_hd__tapvpwrvgnd_1
XFILLER_109_27 vssd1 vccd1 vssd1 vccd1 SS_sky130_ef_sc_hd__decap_40_12
X_0878_ vccd1 vssd1 vssd1 vccd1 _0874_/X _0877_/X _0878_/A2 hold808/X _1495_/D _1451_/C1
+ SS_sky130_fd_sc_hd__o221a_2
XFILLER_118_189 vssd1 vccd1 vccd1 vssd1 SS_sky130_fd_sc_hd__fill_4
XFILLER_106_307 vccd1 vssd1 vccd1 vssd1 SS_sky130_fd_sc_hd__fill_1
XFILLER_133_137 vssd1 vccd1 vssd1 vccd1 SS_sky130_ef_sc_hd__decap_40_12
XTAP_TAPCELL_ROW_132_2277 vccd1 vssd1 SS_sky130_fd_sc_hd__tapvpwrvgnd_1
XFILLER_115_841 vccd1 vssd1 vccd1 vssd1 SS_sky130_fd_sc_hd__fill_1
XFILLER_0_629 vssd1 vccd1 vssd1 vccd1 SS_sky130_ef_sc_hd__decap_40_12
XFILLER_88_725 vssd1 vccd1 vssd1 vccd1 SS_sky130_ef_sc_hd__decap_40_12
XFILLER_130_811 vccd1 vssd1 vccd1 vssd1 SS_sky130_fd_sc_hd__fill_1
XFILLER_125_15 vssd1 vccd1 vssd1 vccd1 SS_sky130_ef_sc_hd__decap_40_12
XFILLER_88_769 vssd1 vccd1 vssd1 vccd1 SS_sky130_ef_sc_hd__decap_40_12
XFILLER_87_279 vccd1 vssd1 vccd1 vssd1 SS_sky130_fd_sc_hd__fill_1
XFILLER_102_579 vccd1 vssd1 vccd1 vssd1 SS_sky130_fd_sc_hd__fill_1
XFILLER_102_557 vssd1 vccd1 vssd1 vccd1 SS_sky130_ef_sc_hd__decap_40_12
XFILLER_28_357 vssd1 vccd1 vccd1 vssd1 SS_sky130_fd_sc_hd__fill_4
XTAP_TAPCELL_ROW_39_886 vccd1 vssd1 SS_sky130_fd_sc_hd__tapvpwrvgnd_1
XFILLER_43_305 vssd1 vccd1 vssd1 vccd1 SS_sky130_ef_sc_hd__decap_40_12
XTAP_TAPCELL_ROW_48_1017 vccd1 vssd1 SS_sky130_fd_sc_hd__tapvpwrvgnd_1
XFILLER_55_165 vssd1 vccd1 vccd1 vssd1 SS_sky130_fd_sc_hd__fill_2
XFILLER_56_699 vccd1 vssd1 vccd1 vssd1 SS_sky130_fd_sc_hd__fill_1
XFILLER_43_349 vssd1 vccd1 vssd1 vccd1 SS_sky130_ef_sc_hd__decap_40_12
XFILLER_71_658 vssd1 vccd1 vccd1 vssd1 SS_sky130_fd_sc_hd__fill_2
XFILLER_12_725 vssd1 vccd1 vssd1 vccd1 SS_sky130_ef_sc_hd__decap_40_12
XFILLER_24_585 vssd1 vccd1 vccd1 vssd1 SS_sky130_fd_sc_hd__fill_2
XTAP_TAPCELL_ROW_61_1217 vccd1 vssd1 SS_sky130_fd_sc_hd__tapvpwrvgnd_1
XFILLER_12_769 vssd1 vccd1 vssd1 vccd1 SS_sky130_ef_sc_hd__decap_40_12
XFILLER_51_393 vssd1 vccd1 vssd1 vccd1 SS_sky130_ef_sc_hd__decap_40_12
XFILLER_7_217 vssd1 vccd1 vccd1 vssd1 SS_sky130_fd_sc_hd__fill_4
XFILLER_11_279 vccd1 vssd1 vccd1 vssd1 SS_sky130_fd_sc_hd__fill_1
Xclkload0 vccd1 vssd1 vccd1 vssd1 clkload0/Y clkload0/A SS_sky130_fd_sc_hd__inv_6
XFILLER_137_465 vssd1 vccd1 vccd1 vssd1 SS_sky130_fd_sc_hd__fill_8
XFILLER_50_77 vssd1 vccd1 vccd1 vssd1 SS_sky130_fd_sc_hd__fill_4
XFILLER_109_167 vccd1 vssd1 vccd1 vssd1 SS_sky130_fd_sc_hd__fill_1
XFILLER_3_445 vssd1 vccd1 vccd1 vssd1 SS_sky130_fd_sc_hd__fill_2
XTAP_TAPCELL_ROW_59_1179 vccd1 vssd1 SS_sky130_fd_sc_hd__tapvpwrvgnd_1
XFILLER_125_649 vccd1 vssd1 vccd1 vssd1 SS_sky130_fd_sc_hd__fill_1
XFILLER_124_137 vssd1 vccd1 vccd1 vssd1 SS_sky130_fd_sc_hd__fill_2
XFILLER_79_725 vssd1 vccd1 vccd1 vssd1 SS_sky130_fd_sc_hd__fill_2
XFILLER_133_682 vssd1 vccd1 vssd1 vccd1 SS_sky130_ef_sc_hd__decap_40_12
XTAP_TAPCELL_ROW_72_1379 vccd1 vssd1 SS_sky130_fd_sc_hd__tapvpwrvgnd_1
XFILLER_120_365 vssd1 vccd1 vssd1 vccd1 SS_sky130_ef_sc_hd__decap_40_12
XFILLER_120_387 vccd1 vssd1 vccd1 vssd1 SS_sky130_fd_sc_hd__fill_1
XFILLER_115_81 vssd1 vccd1 vssd1 vccd1 SS_sky130_ef_sc_hd__decap_40_12
XFILLER_93_205 vssd1 vccd1 vssd1 vccd1 SS_sky130_ef_sc_hd__decap_40_12
XFILLER_19_335 vccd1 vssd1 vccd1 vssd1 SS_sky130_fd_sc_hd__fill_1
XFILLER_46_121 vssd1 vccd1 vssd1 vccd1 SS_sky130_ef_sc_hd__decap_40_12
XFILLER_93_249 vssd1 vccd1 vssd1 vccd1 SS_sky130_ef_sc_hd__decap_40_12
XFILLER_34_305 vssd1 vccd1 vccd1 vssd1 SS_sky130_fd_sc_hd__fill_2
XFILLER_46_165 vssd1 vccd1 vssd1 vccd1 SS_sky130_ef_sc_hd__decap_40_12
XFILLER_61_113 vssd1 vccd1 vssd1 vccd1 SS_sky130_ef_sc_hd__decap_40_12
XFILLER_74_496 vssd1 vccd1 vssd1 vccd1 SS_sky130_ef_sc_hd__decap_40_12
XFILLER_15_541 vssd1 vccd1 vssd1 vccd1 SS_sky130_ef_sc_hd__decap_40_12
XTAP_TAPCELL_ROW_17_558 vccd1 vssd1 SS_sky130_fd_sc_hd__tapvpwrvgnd_1
XFILLER_50_809 vssd1 vccd1 vccd1 vssd1 SS_sky130_fd_sc_hd__fill_2
XFILLER_15_585 vssd1 vccd1 vssd1 vccd1 SS_sky130_ef_sc_hd__decap_40_12
XFILLER_70_680 vssd1 vccd1 vssd1 vccd1 SS_sky130_ef_sc_hd__decap_40_12
XFILLER_30_533 vssd1 vccd1 vssd1 vccd1 SS_sky130_ef_sc_hd__decap_40_12
X_1850_ vccd1 vssd1 _1850_/X _1850_/A vccd1 vssd1 SS_sky130_fd_sc_hd__buf_2
X_0801_ vccd1 vssd1 vccd1 vssd1 _1515_/Q wire421/X _1871_/A _0876_/B1 _0801_/X SS_sky130_fd_sc_hd__a22o_2
XFILLER_128_421 vssd1 vccd1 vssd1 vccd1 SS_sky130_ef_sc_hd__decap_40_12
Xmax_cap426 vccd1 vssd1 _1013_/A _1012_/A vccd1 vssd1 SS_sky130_fd_sc_hd__buf_6
Xhold718 _0996_/A _1531_/Q vccd1 vssd1 vssd1 vccd1 SS_sky130_fd_sc_hd__dlygate4sd3_1
Xhold707 _1460_/A _1756_/Q vccd1 vssd1 vssd1 vccd1 SS_sky130_fd_sc_hd__dlygate4sd3_1
XFILLER_115_137 vssd1 vccd1 vssd1 vccd1 SS_sky130_ef_sc_hd__decap_40_12
Xhold729 _1178_/A _1619_/Q vccd1 vssd1 vssd1 vccd1 SS_sky130_fd_sc_hd__dlygate4sd3_1
XFILLER_112_811 vccd1 vssd1 vccd1 vssd1 SS_sky130_fd_sc_hd__fill_1
XFILLER_123_181 vssd1 vccd1 vssd1 vccd1 SS_sky130_ef_sc_hd__decap_40_12
XFILLER_97_555 vssd1 vccd1 vccd1 vssd1 SS_sky130_fd_sc_hd__fill_4
XFILLER_69_279 vccd1 vssd1 vccd1 vssd1 SS_sky130_fd_sc_hd__fill_1
XPHY_EDGE_ROW_127_Right_127 vccd1 vssd1 vccd1 vssd1 SS_sky130_fd_sc_hd__decap_3
XFILLER_65_441 vssd1 vccd1 vccd1 vssd1 SS_sky130_fd_sc_hd__fill_4
X_1215_ vssd1 vccd1 vccd1 vssd1 _1273_/A2 input31/X _1636_/D _1439_/C1 _1214_/X SS_sky130_fd_sc_hd__o211a_2
XFILLER_84_249 vssd1 vccd1 vccd1 vssd1 SS_sky130_fd_sc_hd__fill_2
XFILLER_25_305 vssd1 vccd1 vssd1 vccd1 SS_sky130_ef_sc_hd__decap_40_12
X_1146_ vccd1 vssd1 vccd1 vssd1 _1146_/X _1846_/A _1186_/B SS_sky130_fd_sc_hd__or2_2
XFILLER_37_165 vssd1 vccd1 vccd1 vssd1 SS_sky130_fd_sc_hd__fill_2
XFILLER_38_699 vccd1 vssd1 vccd1 vssd1 SS_sky130_fd_sc_hd__fill_1
XFILLER_1_93 vssd1 vccd1 vssd1 vccd1 SS_sky130_ef_sc_hd__decap_40_12
XFILLER_25_349 vssd1 vccd1 vssd1 vccd1 SS_sky130_ef_sc_hd__decap_40_12
XTAP_TAPCELL_ROW_36_834 vccd1 vssd1 SS_sky130_fd_sc_hd__tapvpwrvgnd_1
XTAP_TAPCELL_ROW_36_845 vccd1 vssd1 SS_sky130_fd_sc_hd__tapvpwrvgnd_1
XFILLER_80_433 vssd1 vccd1 vccd1 vssd1 SS_sky130_fd_sc_hd__fill_4
XFILLER_80_477 vssd1 vccd1 vssd1 vccd1 SS_sky130_ef_sc_hd__decap_40_12
X_1077_ vssd1 vccd1 vccd1 vssd1 _1077_/A2 input44/X _1570_/D _1143_/C1 _1076_/X SS_sky130_fd_sc_hd__o211a_2
XTAP_TAPCELL_ROW_101_1818 vccd1 vssd1 SS_sky130_fd_sc_hd__tapvpwrvgnd_1
XFILLER_33_393 vssd1 vccd1 vssd1 vccd1 SS_sky130_ef_sc_hd__decap_40_12
XTAP_TAPCELL_ROW_134_2306 vccd1 vssd1 SS_sky130_fd_sc_hd__tapvpwrvgnd_1
XTAP_TAPCELL_ROW_134_2317 vccd1 vssd1 SS_sky130_fd_sc_hd__tapvpwrvgnd_1
XFILLER_119_443 vssd1 vccd1 vccd1 vssd1 SS_sky130_fd_sc_hd__fill_4
XFILLER_4_209 vssd1 vccd1 vssd1 vccd1 SS_sky130_ef_sc_hd__decap_40_12
XFILLER_134_402 vssd1 vccd1 vccd1 vssd1 SS_sky130_fd_sc_hd__fill_8
XFILLER_106_137 vssd1 vccd1 vccd1 vssd1 SS_sky130_fd_sc_hd__fill_2
XFILLER_88_533 vssd1 vccd1 vssd1 vccd1 SS_sky130_ef_sc_hd__decap_40_12
XFILLER_102_321 vssd1 vccd1 vssd1 vccd1 SS_sky130_ef_sc_hd__decap_40_12
XFILLER_96_29 vssd1 vccd1 vssd1 vccd1 SS_sky130_ef_sc_hd__decap_40_12
XFILLER_96_18 vssd1 vccd1 vccd1 vssd1 SS_sky130_fd_sc_hd__fill_8
XFILLER_130_641 vssd1 vccd1 vccd1 vssd1 SS_sky130_fd_sc_hd__fill_2
XFILLER_48_419 vccd1 vssd1 vccd1 vssd1 SS_sky130_fd_sc_hd__fill_1
XFILLER_75_205 vssd1 vccd1 vssd1 vccd1 SS_sky130_ef_sc_hd__decap_40_12
XFILLER_102_365 vssd1 vccd1 vssd1 vccd1 SS_sky130_ef_sc_hd__decap_40_12
XFILLER_28_121 vssd1 vccd1 vssd1 vccd1 SS_sky130_ef_sc_hd__decap_40_12
XFILLER_75_249 vssd1 vccd1 vssd1 vccd1 SS_sky130_ef_sc_hd__decap_40_12
XFILLER_16_305 vssd1 vccd1 vccd1 vssd1 SS_sky130_fd_sc_hd__fill_2
XFILLER_28_165 vssd1 vccd1 vssd1 vccd1 SS_sky130_ef_sc_hd__decap_40_12
XFILLER_43_113 vssd1 vccd1 vssd1 vccd1 SS_sky130_ef_sc_hd__decap_40_12
XFILLER_44_625 vssd1 vccd1 vccd1 vssd1 SS_sky130_fd_sc_hd__fill_8
XFILLER_45_55 vccd1 vssd1 vccd1 vssd1 SS_sky130_fd_sc_hd__fill_1
XFILLER_83_293 vssd1 vccd1 vssd1 vccd1 SS_sky130_ef_sc_hd__decap_40_12
XFILLER_32_809 vssd1 vccd1 vccd1 vssd1 SS_sky130_fd_sc_hd__fill_2
XTAP_TAPCELL_ROW_14_506 vccd1 vssd1 SS_sky130_fd_sc_hd__tapvpwrvgnd_1
XTAP_TAPCELL_ROW_14_517 vccd1 vssd1 SS_sky130_fd_sc_hd__tapvpwrvgnd_1
XFILLER_71_499 vssd1 vccd1 vccd1 vssd1 SS_sky130_fd_sc_hd__fill_4
XFILLER_12_533 vssd1 vccd1 vssd1 vccd1 SS_sky130_ef_sc_hd__decap_40_12
XFILLER_61_54 vssd1 vccd1 vccd1 vssd1 SS_sky130_fd_sc_hd__fill_2
XANTENNA_9 _1008_/B vssd1 vccd1 vccd1 vssd1 SS_sky130_fd_sc_hd__diode_2
XFILLER_138_785 vssd1 vccd1 vccd1 vssd1 SS_sky130_fd_sc_hd__fill_2
XFILLER_137_273 vssd1 vccd1 vccd1 vssd1 SS_sky130_fd_sc_hd__fill_4
XFILLER_137_262 vssd1 vccd1 vccd1 vssd1 SS_sky130_fd_sc_hd__fill_4
XTAP_TAPCELL_ROW_74_1408 vccd1 vssd1 SS_sky130_fd_sc_hd__tapvpwrvgnd_1
XFILLER_99_809 vssd1 vccd1 vccd1 vssd1 SS_sky130_fd_sc_hd__fill_8
XFILLER_105_181 vssd1 vccd1 vssd1 vccd1 SS_sky130_ef_sc_hd__decap_40_12
XFILLER_121_685 vssd1 vccd1 vssd1 vccd1 SS_sky130_ef_sc_hd__decap_40_12
XFILLER_66_249 vssd1 vccd1 vccd1 vssd1 SS_sky130_fd_sc_hd__fill_2
XFILLER_82_709 vssd1 vccd1 vccd1 vssd1 SS_sky130_fd_sc_hd__fill_2
XTAP_TAPCELL_ROW_89_1640 vccd1 vssd1 SS_sky130_fd_sc_hd__tapvpwrvgnd_1
XFILLER_120_195 vccd1 vssd1 vccd1 vssd1 SS_sky130_fd_sc_hd__fill_1
XFILLER_19_165 vssd1 vccd1 vccd1 vssd1 SS_sky130_fd_sc_hd__fill_2
XFILLER_47_474 vssd1 vccd1 vssd1 vccd1 SS_sky130_ef_sc_hd__decap_40_12
XFILLER_75_783 vccd1 vssd1 vccd1 vssd1 SS_sky130_fd_sc_hd__fill_1
X_1000_ vccd1 vssd1 vccd1 vssd1 _1000_/X _1000_/A _1008_/B SS_sky130_fd_sc_hd__or2_2
XFILLER_90_731 vssd1 vccd1 vssd1 vccd1 SS_sky130_ef_sc_hd__decap_40_12
XFILLER_35_669 vssd1 vccd1 vccd1 vssd1 SS_sky130_fd_sc_hd__fill_2
XFILLER_90_797 vssd1 vccd1 vccd1 vssd1 SS_sky130_fd_sc_hd__fill_2
XFILLER_15_393 vssd1 vccd1 vssd1 vccd1 SS_sky130_ef_sc_hd__decap_40_12
Xclkbuf_leaf_32_wb_clk_i clkload4/A clkload0/A vccd1 vssd1 vssd1 vccd1 SS_sky130_fd_sc_hd__clkbuf_8
X_1902_ vccd1 vssd1 _1902_/X _1902_/A vccd1 vssd1 SS_sky130_fd_sc_hd__buf_2
XFILLER_30_363 vccd1 vssd1 vccd1 vssd1 SS_sky130_fd_sc_hd__fill_1
XFILLER_89_3 vssd1 vccd1 vssd1 vccd1 SS_sky130_ef_sc_hd__decap_40_12
X_1833_ vccd1 vssd1 _1833_/X _1833_/A vccd1 vssd1 SS_sky130_fd_sc_hd__buf_2
XFILLER_129_741 vssd1 vccd1 vssd1 vccd1 SS_sky130_ef_sc_hd__decap_40_12
XFILLER_128_251 vccd1 vssd1 vccd1 vssd1 SS_sky130_fd_sc_hd__fill_1
XFILLER_129_785 vccd1 vssd1 vccd1 vssd1 SS_sky130_fd_sc_hd__fill_1
XTAP_TAPCELL_ROW_116_2047 vccd1 vssd1 SS_sky130_fd_sc_hd__tapvpwrvgnd_1
XFILLER_116_413 vssd1 vccd1 vccd1 vssd1 SS_sky130_fd_sc_hd__fill_4
XTAP_TAPCELL_ROW_116_2036 vccd1 vssd1 SS_sky130_fd_sc_hd__tapvpwrvgnd_1
XFILLER_131_405 vssd1 vccd1 vssd1 vccd1 SS_sky130_ef_sc_hd__decap_40_12
Xmax_cap245 vccd1 vssd1 _1126_/B _1140_/B vccd1 vssd1 SS_sky130_fd_sc_hd__buf_6
X_1695_ _1695_/Q _1727_/CLK _1695_/D vccd1 vssd1 vccd1 vssd1 SS_sky130_fd_sc_hd__dfxtp_2
XFILLER_131_427 vccd1 vssd1 vccd1 vssd1 SS_sky130_fd_sc_hd__fill_1
XFILLER_131_449 vssd1 vccd1 vssd1 vccd1 SS_sky130_ef_sc_hd__decap_40_12
XFILLER_57_205 vssd1 vccd1 vssd1 vccd1 SS_sky130_ef_sc_hd__decap_40_12
Xload_slew462 vccd1 vssd1 _1445_/C1 _1437_/C1 vccd1 vssd1 SS_sky130_fd_sc_hd__buf_4
Xload_slew473 vccd1 vssd1 _1423_/C1 _1299_/C1 vccd1 vssd1 SS_sky130_fd_sc_hd__buf_4
XFILLER_85_503 vccd1 vssd1 vccd1 vssd1 SS_sky130_fd_sc_hd__fill_1
XFILLER_97_374 vssd1 vccd1 vccd1 vssd1 SS_sky130_fd_sc_hd__fill_8
XFILLER_57_249 vssd1 vccd1 vssd1 vccd1 SS_sky130_ef_sc_hd__decap_40_12
XFILLER_73_709 vssd1 vccd1 vssd1 vccd1 SS_sky130_ef_sc_hd__decap_40_12
XFILLER_85_569 vccd1 vssd1 vccd1 vssd1 SS_sky130_fd_sc_hd__fill_1
XTAP_TAPCELL_ROW_127_2198 vccd1 vssd1 SS_sky130_fd_sc_hd__tapvpwrvgnd_1
XFILLER_122_27 vccd1 vssd1 vccd1 vssd1 SS_sky130_fd_sc_hd__fill_1
XFILLER_25_113 vssd1 vccd1 vssd1 vccd1 SS_sky130_ef_sc_hd__decap_40_12
XFILLER_26_625 vssd1 vccd1 vssd1 vccd1 SS_sky130_ef_sc_hd__decap_40_12
XFILLER_65_293 vssd1 vccd1 vssd1 vccd1 SS_sky130_ef_sc_hd__decap_40_12
XFILLER_81_731 vccd1 vssd1 vccd1 vssd1 SS_sky130_fd_sc_hd__fill_1
XFILLER_93_591 vssd1 vccd1 vssd1 vccd1 SS_sky130_ef_sc_hd__decap_40_12
XTAP_TAPCELL_ROW_0_278 vccd1 vssd1 SS_sky130_fd_sc_hd__tapvpwrvgnd_1
XFILLER_14_809 vssd1 vccd1 vccd1 vssd1 SS_sky130_fd_sc_hd__fill_2
XFILLER_26_669 vssd1 vccd1 vssd1 vccd1 SS_sky130_ef_sc_hd__decap_40_12
XFILLER_53_466 vssd1 vccd1 vssd1 vccd1 SS_sky130_ef_sc_hd__decap_40_12
X_1129_ vssd1 vccd1 vccd1 vssd1 _1141_/A2 input36/X _1595_/D _1329_/C1 _1128_/X SS_sky130_fd_sc_hd__o211a_2
XTAP_TAPCELL_ROW_0_289 vccd1 vssd1 SS_sky130_fd_sc_hd__tapvpwrvgnd_1
XFILLER_41_617 vssd1 vccd1 vssd1 vccd1 SS_sky130_ef_sc_hd__decap_40_12
XFILLER_41_639 vssd1 vccd1 vssd1 vccd1 SS_sky130_ef_sc_hd__decap_40_12
XFILLER_81_797 vssd1 vccd1 vssd1 vccd1 SS_sky130_ef_sc_hd__decap_40_12
XFILLER_15_69 vssd1 vccd1 vssd1 vccd1 SS_sky130_ef_sc_hd__decap_40_12
XFILLER_21_385 vssd1 vccd1 vccd1 vssd1 SS_sky130_fd_sc_hd__fill_4
XFILLER_5_529 vssd1 vccd1 vssd1 vccd1 SS_sky130_ef_sc_hd__decap_40_12
XFILLER_31_57 vssd1 vccd1 vssd1 vccd1 SS_sky130_ef_sc_hd__decap_40_12
XFILLER_119_273 vssd1 vccd1 vccd1 vssd1 SS_sky130_fd_sc_hd__fill_4
XFILLER_134_221 vssd1 vccd1 vssd1 vccd1 SS_sky130_ef_sc_hd__decap_40_12
XFILLER_119_295 vccd1 vssd1 vccd1 vssd1 SS_sky130_fd_sc_hd__fill_1
XTAP_TAPCELL_ROW_56_1138 vccd1 vssd1 SS_sky130_fd_sc_hd__tapvpwrvgnd_1
XFILLER_134_265 vssd1 vccd1 vssd1 vccd1 SS_sky130_ef_sc_hd__decap_40_12
Xoutput57 vccd1 vssd1 wire303/A _1893_/X vccd1 vssd1 SS_sky130_fd_sc_hd__buf_4
XFILLER_0_223 vccd1 vssd1 vccd1 vssd1 SS_sky130_fd_sc_hd__fill_1
XFILLER_0_245 vssd1 vccd1 vccd1 vssd1 SS_sky130_fd_sc_hd__fill_4
Xoutput79 vccd1 vssd1 wire281/A _1840_/X vccd1 vssd1 SS_sky130_fd_sc_hd__buf_4
Xoutput68 vccd1 vssd1 wire292/A _1903_/X vccd1 vssd1 SS_sky130_fd_sc_hd__buf_4
XFILLER_49_739 vccd1 vssd1 vccd1 vssd1 SS_sky130_fd_sc_hd__fill_1
XFILLER_76_525 vssd1 vccd1 vccd1 vssd1 SS_sky130_fd_sc_hd__fill_4
XFILLER_103_685 vssd1 vccd1 vssd1 vccd1 SS_sky130_ef_sc_hd__decap_40_12
XFILLER_0_289 vssd1 vccd1 vccd1 vssd1 SS_sky130_fd_sc_hd__fill_2
XFILLER_48_249 vssd1 vccd1 vccd1 vssd1 SS_sky130_fd_sc_hd__fill_2
XFILLER_76_569 vssd1 vccd1 vssd1 vccd1 SS_sky130_ef_sc_hd__decap_40_12
XFILLER_102_195 vccd1 vssd1 vccd1 vssd1 SS_sky130_fd_sc_hd__fill_1
XFILLER_29_441 vssd1 vccd1 vccd1 vssd1 SS_sky130_fd_sc_hd__fill_4
XFILLER_56_65 vssd1 vccd1 vssd1 vccd1 SS_sky130_ef_sc_hd__decap_40_12
XFILLER_91_517 vssd1 vccd1 vssd1 vccd1 SS_sky130_ef_sc_hd__decap_40_12
XFILLER_29_485 vssd1 vccd1 vssd1 vccd1 SS_sky130_ef_sc_hd__decap_40_12
XFILLER_57_783 vccd1 vssd1 vccd1 vssd1 SS_sky130_fd_sc_hd__fill_1
XFILLER_17_669 vssd1 vccd1 vccd1 vssd1 SS_sky130_fd_sc_hd__fill_2
XPHY_EDGE_ROW_19_Right_19 vccd1 vssd1 vccd1 vssd1 SS_sky130_fd_sc_hd__decap_3
XFILLER_44_433 vccd1 vssd1 vccd1 vssd1 SS_sky130_fd_sc_hd__fill_1
XFILLER_31_105 vssd1 vccd1 vccd1 vssd1 SS_sky130_fd_sc_hd__fill_4
XFILLER_32_617 vssd1 vccd1 vssd1 vccd1 SS_sky130_ef_sc_hd__decap_40_12
XFILLER_44_477 vssd1 vccd1 vssd1 vccd1 SS_sky130_ef_sc_hd__decap_40_12
XFILLER_72_53 vssd1 vccd1 vssd1 vccd1 SS_sky130_ef_sc_hd__decap_40_12
XFILLER_31_149 vssd1 vccd1 vssd1 vccd1 SS_sky130_ef_sc_hd__decap_40_12
XFILLER_8_301 vssd1 vccd1 vccd1 vssd1 SS_sky130_fd_sc_hd__fill_4
XFILLER_12_363 vccd1 vssd1 vccd1 vssd1 SS_sky130_fd_sc_hd__fill_1
XFILLER_72_97 vssd1 vccd1 vssd1 vccd1 SS_sky130_ef_sc_hd__decap_40_12
XFILLER_8_345 vssd1 vccd1 vssd1 vccd1 SS_sky130_ef_sc_hd__decap_40_12
XFILLER_8_389 vssd1 vccd1 vssd1 vccd1 SS_sky130_ef_sc_hd__decap_40_12
XFILLER_126_755 vccd1 vssd1 vccd1 vssd1 SS_sky130_fd_sc_hd__fill_1
XFILLER_125_221 vssd1 vccd1 vccd1 vssd1 SS_sky130_fd_sc_hd__fill_2
XPHY_EDGE_ROW_28_Right_28 vccd1 vssd1 vccd1 vssd1 SS_sky130_fd_sc_hd__decap_3
XFILLER_113_405 vssd1 vccd1 vssd1 vccd1 SS_sky130_ef_sc_hd__decap_40_12
XFILLER_99_617 vssd1 vccd1 vssd1 vccd1 SS_sky130_ef_sc_hd__decap_40_12
X_1480_ _1480_/Q _1727_/CLK _1480_/D vccd1 vssd1 vccd1 vssd1 SS_sky130_fd_sc_hd__dfxtp_2
XFILLER_113_449 vssd1 vccd1 vssd1 vccd1 SS_sky130_ef_sc_hd__decap_40_12
XFILLER_39_205 vssd1 vccd1 vssd1 vccd1 SS_sky130_ef_sc_hd__decap_40_12
XFILLER_39_249 vssd1 vccd1 vssd1 vccd1 SS_sky130_ef_sc_hd__decap_40_12
XFILLER_67_536 vssd1 vccd1 vccd1 vssd1 SS_sky130_fd_sc_hd__fill_4
XFILLER_67_558 vssd1 vccd1 vccd1 vssd1 SS_sky130_fd_sc_hd__fill_2
XFILLER_94_322 vssd1 vccd1 vssd1 vccd1 SS_sky130_ef_sc_hd__decap_40_12
XFILLER_94_377 vssd1 vccd1 vssd1 vccd1 SS_sky130_ef_sc_hd__decap_40_12
XPHY_EDGE_ROW_37_Right_37 vccd1 vssd1 vccd1 vssd1 SS_sky130_fd_sc_hd__decap_3
XFILLER_47_293 vssd1 vccd1 vssd1 vccd1 SS_sky130_ef_sc_hd__decap_40_12
XFILLER_63_753 vssd1 vccd1 vccd1 vssd1 SS_sky130_fd_sc_hd__fill_4
XFILLER_23_617 vssd1 vccd1 vssd1 vccd1 SS_sky130_ef_sc_hd__decap_40_12
XTAP_TAPCELL_ROW_46_984 vccd1 vssd1 SS_sky130_fd_sc_hd__tapvpwrvgnd_1
XTAP_TAPCELL_ROW_46_995 vccd1 vssd1 SS_sky130_fd_sc_hd__tapvpwrvgnd_1
XFILLER_63_797 vssd1 vccd1 vccd1 vssd1 SS_sky130_fd_sc_hd__fill_8
XFILLER_31_661 vssd1 vccd1 vccd1 vssd1 SS_sky130_fd_sc_hd__fill_2
XFILLER_50_469 vssd1 vccd1 vccd1 vssd1 SS_sky130_fd_sc_hd__fill_4
XFILLER_30_193 vssd1 vccd1 vccd1 vssd1 SS_sky130_fd_sc_hd__fill_2
XPHY_EDGE_ROW_46_Right_46 vccd1 vssd1 vccd1 vssd1 SS_sky130_fd_sc_hd__decap_3
XFILLER_117_711 vssd1 vccd1 vssd1 vccd1 SS_sky130_ef_sc_hd__decap_40_12
XFILLER_7_81 vssd1 vccd1 vssd1 vccd1 SS_sky130_ef_sc_hd__decap_40_12
XFILLER_116_221 vssd1 vccd1 vssd1 vccd1 SS_sky130_ef_sc_hd__decap_40_12
XFILLER_117_766 vssd1 vccd1 vssd1 vccd1 SS_sky130_ef_sc_hd__decap_40_12
XFILLER_117_27 vssd1 vccd1 vssd1 vccd1 SS_sky130_ef_sc_hd__decap_40_12
X_1747_ _1747_/Q _1747_/CLK _1747_/D vccd1 vssd1 vccd1 vssd1 SS_sky130_fd_sc_hd__dfxtp_2
X_1678_ _1678_/Q clkload3/A _1678_/D vccd1 vssd1 vccd1 vssd1 SS_sky130_fd_sc_hd__dfxtp_2
XFILLER_89_105 vssd1 vccd1 vccd1 vssd1 SS_sky130_fd_sc_hd__fill_4
XFILLER_116_265 vssd1 vccd1 vssd1 vccd1 SS_sky130_ef_sc_hd__decap_40_12
XFILLER_89_149 vssd1 vccd1 vssd1 vccd1 SS_sky130_ef_sc_hd__decap_40_12
XFILLER_132_769 vssd1 vccd1 vssd1 vccd1 SS_sky130_ef_sc_hd__decap_40_12
XFILLER_58_525 vssd1 vccd1 vccd1 vssd1 SS_sky130_fd_sc_hd__fill_4
XTAP_TAPCELL_ROW_129_2238 vccd1 vssd1 SS_sky130_fd_sc_hd__tapvpwrvgnd_1
XTAP_TAPCELL_ROW_51_1068 vccd1 vssd1 SS_sky130_fd_sc_hd__tapvpwrvgnd_1
XFILLER_85_333 vssd1 vccd1 vccd1 vssd1 SS_sky130_fd_sc_hd__fill_2
XFILLER_97_193 vssd1 vccd1 vssd1 vccd1 SS_sky130_ef_sc_hd__decap_40_12
XPHY_EDGE_ROW_55_Right_55 vccd1 vssd1 vccd1 vssd1 SS_sky130_fd_sc_hd__decap_3
XFILLER_39_783 vccd1 vssd1 vccd1 vssd1 SS_sky130_fd_sc_hd__fill_1
XFILLER_73_539 vssd1 vccd1 vccd1 vssd1 SS_sky130_fd_sc_hd__fill_8
XFILLER_85_388 vssd1 vccd1 vccd1 vssd1 SS_sky130_fd_sc_hd__fill_4
XFILLER_100_699 vccd1 vssd1 vccd1 vssd1 SS_sky130_fd_sc_hd__fill_1
XFILLER_26_433 vssd1 vccd1 vssd1 vccd1 SS_sky130_ef_sc_hd__decap_40_12
XFILLER_54_753 vssd1 vccd1 vccd1 vssd1 SS_sky130_fd_sc_hd__fill_2
XFILLER_13_105 vssd1 vccd1 vccd1 vssd1 SS_sky130_fd_sc_hd__fill_4
XFILLER_26_477 vssd1 vccd1 vssd1 vccd1 SS_sky130_ef_sc_hd__decap_40_12
XFILLER_81_561 vssd1 vccd1 vccd1 vssd1 SS_sky130_fd_sc_hd__fill_2
XFILLER_81_583 vssd1 vccd1 vssd1 vccd1 SS_sky130_ef_sc_hd__decap_40_12
XFILLER_13_149 vssd1 vccd1 vssd1 vccd1 SS_sky130_ef_sc_hd__decap_40_12
XFILLER_41_447 vccd1 vssd1 vccd1 vssd1 SS_sky130_fd_sc_hd__fill_1
XFILLER_9_109 vssd1 vccd1 vccd1 vssd1 SS_sky130_fd_sc_hd__fill_2
XTAP_TAPCELL_ROW_24_656 vccd1 vssd1 SS_sky130_fd_sc_hd__tapvpwrvgnd_1
XTAP_TAPCELL_ROW_24_667 vccd1 vssd1 SS_sky130_fd_sc_hd__tapvpwrvgnd_1
XPHY_EDGE_ROW_64_Right_64 vccd1 vssd1 vccd1 vssd1 SS_sky130_fd_sc_hd__decap_3
XFILLER_6_805 vssd1 vccd1 vccd1 vssd1 SS_sky130_fd_sc_hd__fill_4
XFILLER_21_193 vssd1 vccd1 vssd1 vccd1 SS_sky130_ef_sc_hd__decap_40_12
XFILLER_5_337 vssd1 vccd1 vssd1 vccd1 SS_sky130_ef_sc_hd__decap_40_12
XFILLER_108_733 vssd1 vccd1 vccd1 vssd1 SS_sky130_fd_sc_hd__fill_8
XFILLER_107_221 vssd1 vccd1 vccd1 vssd1 SS_sky130_fd_sc_hd__fill_2
XFILLER_135_552 vssd1 vccd1 vccd1 vssd1 SS_sky130_fd_sc_hd__fill_8
XFILLER_49_503 vccd1 vssd1 vccd1 vssd1 SS_sky130_fd_sc_hd__fill_1
XFILLER_107_93 vssd1 vccd1 vssd1 vccd1 SS_sky130_ef_sc_hd__decap_40_12
XPHY_EDGE_ROW_73_Right_73 vccd1 vssd1 vccd1 vssd1 SS_sky130_fd_sc_hd__decap_3
XFILLER_76_333 vssd1 vccd1 vssd1 vccd1 SS_sky130_ef_sc_hd__decap_40_12
XFILLER_88_193 vssd1 vccd1 vccd1 vssd1 SS_sky130_fd_sc_hd__fill_2
XFILLER_37_709 vssd1 vccd1 vssd1 vccd1 SS_sky130_ef_sc_hd__decap_40_12
XFILLER_76_377 vssd1 vccd1 vssd1 vccd1 SS_sky130_ef_sc_hd__decap_40_12
XTAP_TAPCELL_ROW_69_1329 vccd1 vssd1 SS_sky130_fd_sc_hd__tapvpwrvgnd_1
XFILLER_29_293 vssd1 vccd1 vssd1 vccd1 SS_sky130_ef_sc_hd__decap_40_12
XFILLER_45_753 vssd1 vccd1 vssd1 vccd1 SS_sky130_ef_sc_hd__decap_40_12
XFILLER_83_30 vssd1 vccd1 vssd1 vccd1 SS_sky130_ef_sc_hd__decap_40_12
XFILLER_123_81 vssd1 vccd1 vssd1 vccd1 SS_sky130_ef_sc_hd__decap_40_12
XFILLER_45_797 vccd1 vssd1 vccd1 vssd1 SS_sky130_fd_sc_hd__fill_1
XFILLER_60_701 vssd1 vccd1 vccd1 vssd1 SS_sky130_fd_sc_hd__fill_2
XTAP_TAPCELL_ROW_82_1529 vccd1 vssd1 SS_sky130_fd_sc_hd__tapvpwrvgnd_1
XTAP_TAPCELL_ROW_43_943 vccd1 vssd1 SS_sky130_fd_sc_hd__tapvpwrvgnd_1
XPHY_EDGE_ROW_17_Left_156 vccd1 vssd1 vccd1 vssd1 SS_sky130_fd_sc_hd__decap_3
XFILLER_32_469 vssd1 vccd1 vccd1 vssd1 SS_sky130_fd_sc_hd__fill_4
XFILLER_60_789 vssd1 vccd1 vssd1 vccd1 SS_sky130_ef_sc_hd__decap_40_12
XPHY_EDGE_ROW_82_Right_82 vccd1 vssd1 vccd1 vssd1 SS_sky130_fd_sc_hd__decap_3
X_0980_ vccd1 vssd1 vccd1 vssd1 _0980_/X _0980_/A _1008_/B SS_sky130_fd_sc_hd__or2_2
XFILLER_8_153 vssd1 vccd1 vssd1 vccd1 SS_sky130_ef_sc_hd__decap_40_12
XFILLER_9_665 vssd1 vccd1 vccd1 vssd1 SS_sky130_fd_sc_hd__fill_4
XFILLER_12_193 vssd1 vccd1 vccd1 vssd1 SS_sky130_fd_sc_hd__fill_2
XFILLER_73_6 vssd1 vccd1 vssd1 vccd1 SS_sky130_ef_sc_hd__decap_40_12
XFILLER_8_197 vssd1 vccd1 vssd1 vccd1 SS_sky130_ef_sc_hd__decap_40_12
X_1601_ _1601_/Q _1760_/CLK _1601_/D vccd1 vssd1 vccd1 vssd1 SS_sky130_fd_sc_hd__dfxtp_2
XTAP_TAPCELL_ROW_97_1761 vccd1 vssd1 SS_sky130_fd_sc_hd__tapvpwrvgnd_1
XTAP_TAPCELL_ROW_97_1750 vccd1 vssd1 SS_sky130_fd_sc_hd__tapvpwrvgnd_1
XFILLER_126_585 vssd1 vccd1 vccd1 vssd1 SS_sky130_fd_sc_hd__fill_2
X_1532_ _1532_/Q _1756_/CLK _1532_/D vccd1 vssd1 vccd1 vssd1 SS_sky130_fd_sc_hd__dfxtp_2
XFILLER_114_725 vssd1 vccd1 vssd1 vccd1 SS_sky130_ef_sc_hd__decap_40_12
X_1463_ vssd1 vccd1 vccd1 vssd1 _1463_/A2 input38/X _1757_/D _1465_/C1 _1462_/X SS_sky130_fd_sc_hd__o211a_2
XFILLER_114_769 vssd1 vccd1 vssd1 vccd1 SS_sky130_ef_sc_hd__decap_40_12
XFILLER_99_447 vccd1 vssd1 vccd1 vssd1 SS_sky130_fd_sc_hd__fill_1
XPHY_EDGE_ROW_26_Left_165 vccd1 vssd1 vccd1 vssd1 SS_sky130_fd_sc_hd__decap_3
XFILLER_113_279 vccd1 vssd1 vccd1 vssd1 SS_sky130_fd_sc_hd__fill_1
XPHY_EDGE_ROW_91_Right_91 vccd1 vssd1 vccd1 vssd1 SS_sky130_fd_sc_hd__decap_3
XFILLER_67_333 vssd1 vccd1 vccd1 vssd1 SS_sky130_fd_sc_hd__fill_2
XFILLER_79_193 vssd1 vccd1 vssd1 vccd1 SS_sky130_ef_sc_hd__decap_40_12
X_1394_ vccd1 vssd1 vccd1 vssd1 _1394_/X _1724_/Q _1396_/B SS_sky130_fd_sc_hd__or2_2
XTAP_TAPCELL_ROW_2_329 vccd1 vssd1 SS_sky130_fd_sc_hd__tapvpwrvgnd_1
XFILLER_55_517 vssd1 vccd1 vccd1 vssd1 SS_sky130_fd_sc_hd__fill_8
XFILLER_67_366 vssd1 vccd1 vccd1 vssd1 SS_sky130_fd_sc_hd__fill_8
XFILLER_95_653 vssd1 vccd1 vssd1 vccd1 SS_sky130_ef_sc_hd__decap_40_12
XFILLER_94_141 vssd1 vccd1 vssd1 vccd1 SS_sky130_ef_sc_hd__decap_40_12
XFILLER_103_18 vssd1 vccd1 vssd1 vccd1 SS_sky130_ef_sc_hd__decap_40_12
XFILLER_95_697 vssd1 vccd1 vssd1 vccd1 SS_sky130_ef_sc_hd__decap_40_12
XFILLER_36_753 vssd1 vccd1 vccd1 vssd1 SS_sky130_fd_sc_hd__fill_2
XTAP_TAPCELL_ROW_124_2157 vccd1 vssd1 SS_sky130_fd_sc_hd__tapvpwrvgnd_1
XFILLER_63_561 vssd1 vccd1 vssd1 vccd1 SS_sky130_ef_sc_hd__decap_40_12
XFILLER_23_447 vccd1 vssd1 vccd1 vssd1 SS_sky130_fd_sc_hd__fill_1
XPHY_EDGE_ROW_35_Left_174 vccd1 vssd1 vccd1 vssd1 SS_sky130_fd_sc_hd__decap_3
XFILLER_50_233 vssd1 vccd1 vssd1 vccd1 SS_sky130_ef_sc_hd__decap_40_12
XTAP_TAPCELL_ROW_106_1890 vccd1 vssd1 SS_sky130_fd_sc_hd__tapvpwrvgnd_1
XFILLER_11_609 vssd1 vccd1 vccd1 vssd1 SS_sky130_fd_sc_hd__fill_4
XTAP_TAPCELL_ROW_21_615 vccd1 vssd1 SS_sky130_fd_sc_hd__tapvpwrvgnd_1
XFILLER_50_277 vssd1 vccd1 vssd1 vccd1 SS_sky130_ef_sc_hd__decap_40_12
XFILLER_12_15 vssd1 vccd1 vssd1 vccd1 SS_sky130_ef_sc_hd__decap_40_12
XFILLER_136_305 vssd1 vccd1 vccd1 vssd1 SS_sky130_fd_sc_hd__fill_2
XFILLER_128_26 vssd1 vccd1 vccd1 vssd1 SS_sky130_fd_sc_hd__fill_2
XFILLER_117_541 vssd1 vccd1 vssd1 vccd1 SS_sky130_ef_sc_hd__decap_40_12
XFILLER_2_307 vccd1 vssd1 vccd1 vssd1 SS_sky130_fd_sc_hd__fill_1
XPHY_EDGE_ROW_44_Left_183 vccd1 vssd1 vccd1 vssd1 SS_sky130_fd_sc_hd__decap_3
XFILLER_117_585 vssd1 vccd1 vssd1 vccd1 SS_sky130_ef_sc_hd__decap_40_12
XFILLER_105_725 vssd1 vccd1 vccd1 vssd1 SS_sky130_fd_sc_hd__fill_2
XFILLER_58_333 vssd1 vccd1 vssd1 vccd1 SS_sky130_ef_sc_hd__decap_40_12
XFILLER_113_780 vssd1 vccd1 vccd1 vssd1 SS_sky130_fd_sc_hd__fill_4
XFILLER_74_815 vccd1 vssd1 vccd1 vssd1 SS_sky130_fd_sc_hd__fill_1
Xafe_wb_511 analog_io_out[3] afe_wb_511/HI vccd1 vssd1 vssd1 vccd1 SS_sky130_fd_sc_hd__conb_1
Xafe_wb_544 afe_wb_544/LO analog_io_oeb[8] vccd1 vssd1 vssd1 vccd1 SS_sky130_fd_sc_hd__conb_1
XTAP_TAPCELL_ROW_29_737 vccd1 vssd1 SS_sky130_fd_sc_hd__tapvpwrvgnd_1
XFILLER_73_325 vssd1 vccd1 vccd1 vssd1 SS_sky130_fd_sc_hd__fill_2
XFILLER_86_697 vssd1 vccd1 vccd1 vssd1 SS_sky130_fd_sc_hd__fill_2
Xafe_wb_533 analog_io_out[25] afe_wb_533/HI vccd1 vssd1 vssd1 vccd1 SS_sky130_fd_sc_hd__conb_1
Xafe_wb_522 analog_io_out[14] afe_wb_522/HI vccd1 vssd1 vssd1 vccd1 SS_sky130_fd_sc_hd__conb_1
XFILLER_27_753 vssd1 vccd1 vccd1 vssd1 SS_sky130_fd_sc_hd__fill_4
Xafe_wb_555 afe_wb_555/LO analog_io_oeb[19] vccd1 vssd1 vssd1 vccd1 SS_sky130_fd_sc_hd__conb_1
XFILLER_27_797 vssd1 vccd1 vssd1 vccd1 SS_sky130_ef_sc_hd__decap_40_12
XFILLER_42_701 vssd1 vccd1 vccd1 vssd1 SS_sky130_fd_sc_hd__fill_4
XPHY_EDGE_ROW_53_Left_192 vccd1 vssd1 vccd1 vssd1 SS_sky130_fd_sc_hd__decap_3
XFILLER_81_391 vccd1 vssd1 vccd1 vssd1 SS_sky130_fd_sc_hd__fill_1
XFILLER_14_469 vssd1 vccd1 vccd1 vssd1 SS_sky130_fd_sc_hd__fill_4
XTAP_TAPCELL_ROW_40_902 vccd1 vssd1 SS_sky130_fd_sc_hd__tapvpwrvgnd_1
XFILLER_42_789 vssd1 vccd1 vssd1 vccd1 SS_sky130_ef_sc_hd__decap_40_12
XTAP_TAPCELL_ROW_64_1259 vccd1 vssd1 SS_sky130_fd_sc_hd__tapvpwrvgnd_1
XFILLER_41_277 vssd1 vccd1 vccd1 vssd1 SS_sky130_fd_sc_hd__fill_2
XFILLER_6_613 vssd1 vccd1 vssd1 vccd1 SS_sky130_ef_sc_hd__decap_40_12
XFILLER_127_349 vssd1 vccd1 vssd1 vccd1 SS_sky130_ef_sc_hd__decap_40_12
XFILLER_127_316 vssd1 vccd1 vccd1 vssd1 SS_sky130_fd_sc_hd__fill_2
XFILLER_6_657 vssd1 vccd1 vssd1 vccd1 SS_sky130_ef_sc_hd__decap_40_12
XFILLER_10_697 vssd1 vccd1 vccd1 vssd1 SS_sky130_fd_sc_hd__fill_2
XTAP_TAPCELL_ROW_79_1480 vccd1 vssd1 SS_sky130_fd_sc_hd__tapvpwrvgnd_1
XFILLER_108_530 vssd1 vccd1 vccd1 vssd1 SS_sky130_fd_sc_hd__fill_2
XFILLER_5_167 vccd1 vssd1 vccd1 vssd1 SS_sky130_fd_sc_hd__fill_1
XTAP_TAPCELL_ROW_79_1491 vccd1 vssd1 SS_sky130_fd_sc_hd__tapvpwrvgnd_1
XFILLER_135_360 vssd1 vccd1 vccd1 vssd1 SS_sky130_fd_sc_hd__fill_4
XFILLER_108_574 vssd1 vccd1 vssd1 vccd1 SS_sky130_ef_sc_hd__decap_40_12
XFILLER_2_841 vccd1 vssd1 vccd1 vssd1 SS_sky130_fd_sc_hd__fill_1
XTAP_TAPCELL_ROW_9_440 vccd1 vssd1 SS_sky130_fd_sc_hd__tapvpwrvgnd_1
XFILLER_69_609 vssd1 vccd1 vccd1 vssd1 SS_sky130_fd_sc_hd__fill_4
XFILLER_78_41 vssd1 vccd1 vssd1 vccd1 SS_sky130_ef_sc_hd__decap_40_12
XFILLER_135_393 vssd1 vccd1 vssd1 vccd1 SS_sky130_ef_sc_hd__decap_40_12
XFILLER_123_533 vccd1 vssd1 vccd1 vssd1 SS_sky130_fd_sc_hd__fill_1
XFILLER_118_81 vssd1 vccd1 vccd1 vssd1 SS_sky130_fd_sc_hd__fill_2
XFILLER_78_85 vssd1 vccd1 vssd1 vccd1 SS_sky130_ef_sc_hd__decap_40_12
XTAP_TAPCELL_ROW_92_1680 vccd1 vssd1 SS_sky130_fd_sc_hd__tapvpwrvgnd_1
XFILLER_1_373 vssd1 vccd1 vssd1 vccd1 SS_sky130_ef_sc_hd__decap_40_12
XFILLER_49_333 vssd1 vccd1 vccd1 vssd1 SS_sky130_fd_sc_hd__fill_2
XFILLER_76_141 vssd1 vccd1 vssd1 vccd1 SS_sky130_ef_sc_hd__decap_40_12
XFILLER_77_653 vccd1 vssd1 vccd1 vssd1 SS_sky130_fd_sc_hd__fill_1
XFILLER_110_249 vssd1 vccd1 vccd1 vssd1 SS_sky130_fd_sc_hd__fill_2
XFILLER_37_517 vssd1 vccd1 vccd1 vssd1 SS_sky130_fd_sc_hd__fill_4
XFILLER_64_325 vssd1 vccd1 vccd1 vssd1 SS_sky130_fd_sc_hd__fill_2
XFILLER_77_697 vssd1 vccd1 vssd1 vccd1 SS_sky130_ef_sc_hd__decap_40_12
XFILLER_91_111 vccd1 vssd1 vccd1 vssd1 SS_sky130_fd_sc_hd__fill_1
XFILLER_92_645 vssd1 vccd1 vssd1 vccd1 SS_sky130_ef_sc_hd__decap_40_12
XFILLER_18_786 vssd1 vccd1 vssd1 vccd1 SS_sky130_ef_sc_hd__decap_40_12
XFILLER_45_561 vssd1 vccd1 vssd1 vccd1 SS_sky130_ef_sc_hd__decap_40_12
XFILLER_60_520 vssd1 vccd1 vssd1 vccd1 SS_sky130_ef_sc_hd__decap_40_12
XFILLER_32_233 vssd1 vccd1 vssd1 vccd1 SS_sky130_ef_sc_hd__decap_40_12
XFILLER_20_417 vssd1 vccd1 vccd1 vssd1 SS_sky130_fd_sc_hd__fill_2
XFILLER_32_277 vssd1 vccd1 vssd1 vccd1 SS_sky130_ef_sc_hd__decap_40_12
XFILLER_60_586 vssd1 vccd1 vccd1 vssd1 SS_sky130_fd_sc_hd__fill_2
X_0963_ vssd1 vccd1 vccd1 vssd1 _0989_/A2 wire496/X _1514_/D wire467/X _0962_/X SS_sky130_fd_sc_hd__o211a_2
XFILLER_9_473 vssd1 vccd1 vssd1 vccd1 SS_sky130_ef_sc_hd__decap_40_12
X_0894_ vccd1 vssd1 vccd1 vssd1 _1658_/Q _0894_/B1 _1626_/Q _1145_/A _0895_/C SS_sky130_fd_sc_hd__a22o_2
XFILLER_126_360 vssd1 vccd1 vccd1 vssd1 SS_sky130_fd_sc_hd__fill_4
X_1515_ _1515_/Q clkload3/A _1515_/D vccd1 vssd1 vccd1 vssd1 SS_sky130_fd_sc_hd__dfxtp_2
XFILLER_126_393 vssd1 vccd1 vccd1 vssd1 SS_sky130_fd_sc_hd__fill_2
XFILLER_114_533 vssd1 vccd1 vssd1 vccd1 SS_sky130_ef_sc_hd__decap_40_12
XFILLER_114_577 vssd1 vccd1 vccd1 vssd1 SS_sky130_fd_sc_hd__fill_2
XFILLER_101_205 vssd1 vccd1 vssd1 vccd1 SS_sky130_ef_sc_hd__decap_40_12
XFILLER_99_277 vssd1 vccd1 vccd1 vssd1 SS_sky130_fd_sc_hd__fill_2
X_1446_ vccd1 vssd1 vccd1 vssd1 _1446_/X _1446_/A _1454_/B SS_sky130_fd_sc_hd__or2_2
X_1377_ vssd1 vccd1 vccd1 vssd1 _1391_/A2 input27/X _1715_/D _1459_/C1 _1376_/X SS_sky130_fd_sc_hd__o211a_2
XFILLER_101_249 vssd1 vccd1 vssd1 vccd1 SS_sky130_ef_sc_hd__decap_40_12
XFILLER_55_325 vssd1 vccd1 vccd1 vssd1 SS_sky130_fd_sc_hd__fill_2
XFILLER_83_634 vssd1 vccd1 vssd1 vccd1 SS_sky130_ef_sc_hd__decap_40_12
XFILLER_110_783 vssd1 vccd1 vssd1 vccd1 SS_sky130_ef_sc_hd__decap_40_12
XFILLER_95_461 vssd1 vccd1 vssd1 vccd1 SS_sky130_ef_sc_hd__decap_40_12
XFILLER_82_133 vssd1 vccd1 vccd1 vssd1 SS_sky130_fd_sc_hd__fill_4
XFILLER_24_701 vssd1 vccd1 vssd1 vccd1 SS_sky130_ef_sc_hd__decap_40_12
XFILLER_82_177 vssd1 vccd1 vssd1 vccd1 SS_sky130_ef_sc_hd__decap_40_12
XFILLER_130_27 vccd1 vssd1 vccd1 vssd1 SS_sky130_fd_sc_hd__fill_1
XFILLER_63_380 vssd1 vccd1 vssd1 vccd1 SS_sky130_ef_sc_hd__decap_40_12
XFILLER_11_417 vssd1 vccd1 vssd1 vccd1 SS_sky130_ef_sc_hd__decap_40_12
XFILLER_23_277 vssd1 vccd1 vccd1 vssd1 SS_sky130_fd_sc_hd__fill_2
XFILLER_23_69 vssd1 vccd1 vssd1 vccd1 SS_sky130_ef_sc_hd__decap_40_12
Xwire319 vccd1 vssd1 vssd1 vccd1 wire319/A analog_ctrl[57] SS_sky130_fd_sc_hd__buf_12
XTAP_TAPCELL_ROW_137_2359 vccd1 vssd1 SS_sky130_fd_sc_hd__tapvpwrvgnd_1
XTAP_TAPCELL_ROW_137_2348 vccd1 vssd1 SS_sky130_fd_sc_hd__tapvpwrvgnd_1
XFILLER_109_305 vssd1 vccd1 vssd1 vccd1 SS_sky130_ef_sc_hd__decap_40_12
Xwire308 vccd1 vssd1 vssd1 vccd1 wire308/A analog_ctrl[97] SS_sky130_fd_sc_hd__buf_12
XFILLER_109_349 vssd1 vccd1 vssd1 vccd1 SS_sky130_ef_sc_hd__decap_40_12
XFILLER_2_137 vssd1 vccd1 vccd1 vssd1 SS_sky130_fd_sc_hd__fill_2
XFILLER_3_6 vssd1 vccd1 vssd1 vccd1 SS_sky130_ef_sc_hd__decap_40_12
XFILLER_132_330 vssd1 vccd1 vssd1 vccd1 SS_sky130_ef_sc_hd__decap_40_12
XFILLER_105_544 vssd1 vccd1 vssd1 vccd1 SS_sky130_ef_sc_hd__decap_40_12
XFILLER_78_417 vssd1 vccd1 vccd1 vssd1 SS_sky130_fd_sc_hd__fill_2
XFILLER_120_525 vssd1 vccd1 vccd1 vssd1 SS_sky130_fd_sc_hd__fill_4
XFILLER_58_141 vssd1 vccd1 vssd1 vccd1 SS_sky130_ef_sc_hd__decap_40_12
XFILLER_59_664 vssd1 vccd1 vccd1 vssd1 SS_sky130_fd_sc_hd__fill_8
Xfanout463 vssd1 vccd1 vccd1 vssd1 wire467/A _1295_/C1 SS_sky130_fd_sc_hd__clkdlybuf4s25_1
Xfanout474 vssd1 vccd1 vccd1 vssd1 wire493/X _1219_/C1 SS_sky130_fd_sc_hd__clkdlybuf4s25_1
XFILLER_19_517 vssd1 vccd1 vssd1 vccd1 SS_sky130_ef_sc_hd__decap_40_12
XFILLER_48_77 vssd1 vccd1 vccd1 vssd1 SS_sky130_fd_sc_hd__fill_4
XFILLER_101_783 vccd1 vssd1 vccd1 vssd1 SS_sky130_fd_sc_hd__fill_1
XPHY_EDGE_ROW_61_Left_200 vccd1 vssd1 vccd1 vssd1 SS_sky130_fd_sc_hd__decap_3
XFILLER_73_111 vccd1 vssd1 vccd1 vssd1 SS_sky130_fd_sc_hd__fill_1
XFILLER_74_645 vssd1 vccd1 vssd1 vccd1 SS_sky130_ef_sc_hd__decap_40_12
XFILLER_27_561 vssd1 vccd1 vssd1 vccd1 SS_sky130_ef_sc_hd__decap_40_12
XFILLER_61_317 vssd1 vccd1 vccd1 vssd1 SS_sky130_fd_sc_hd__fill_8
XFILLER_104_83 vccd1 vssd1 vccd1 vssd1 SS_sky130_fd_sc_hd__fill_1
XFILLER_64_65 vssd1 vccd1 vssd1 vccd1 SS_sky130_ef_sc_hd__decap_40_12
XFILLER_9_27 vssd1 vccd1 vssd1 vccd1 SS_sky130_ef_sc_hd__decap_40_12
XFILLER_14_233 vssd1 vccd1 vssd1 vccd1 SS_sky130_ef_sc_hd__decap_40_12
XFILLER_42_564 vssd1 vccd1 vssd1 vccd1 SS_sky130_ef_sc_hd__decap_40_12
XFILLER_14_277 vssd1 vccd1 vssd1 vccd1 SS_sky130_ef_sc_hd__decap_40_12
XFILLER_30_737 vssd1 vccd1 vssd1 vccd1 SS_sky130_ef_sc_hd__decap_40_12
XFILLER_80_53 vssd1 vccd1 vssd1 vccd1 SS_sky130_ef_sc_hd__decap_40_12
XTAP_TAPCELL_ROW_12_478 vccd1 vssd1 SS_sky130_fd_sc_hd__tapvpwrvgnd_1
XFILLER_80_97 vssd1 vccd1 vssd1 vccd1 SS_sky130_ef_sc_hd__decap_40_12
XFILLER_127_113 vssd1 vccd1 vssd1 vccd1 SS_sky130_ef_sc_hd__decap_40_12
XFILLER_6_421 vssd1 vccd1 vssd1 vccd1 SS_sky130_ef_sc_hd__decap_40_12
XFILLER_128_669 vssd1 vccd1 vssd1 vccd1 SS_sky130_ef_sc_hd__decap_40_12
XFILLER_89_51 vssd1 vccd1 vccd1 vssd1 SS_sky130_fd_sc_hd__fill_4
XPHY_EDGE_ROW_108_Right_108 vccd1 vssd1 vccd1 vssd1 SS_sky130_fd_sc_hd__decap_3
XFILLER_123_330 vssd1 vccd1 vccd1 vssd1 SS_sky130_fd_sc_hd__fill_4
XFILLER_69_417 vssd1 vccd1 vccd1 vssd1 SS_sky130_fd_sc_hd__fill_8
XFILLER_111_503 vccd1 vssd1 vccd1 vssd1 SS_sky130_fd_sc_hd__fill_1
XFILLER_2_693 vssd1 vccd1 vccd1 vssd1 SS_sky130_fd_sc_hd__fill_4
XFILLER_36_6 vssd1 vccd1 vssd1 vccd1 SS_sky130_ef_sc_hd__decap_40_12
X_1300_ vccd1 vssd1 vccd1 vssd1 _1300_/X _1300_/A _1318_/B SS_sky130_fd_sc_hd__or2_2
XFILLER_1_181 vssd1 vccd1 vssd1 vccd1 SS_sky130_ef_sc_hd__decap_40_12
X_1231_ vssd1 vccd1 vccd1 vssd1 _1267_/A2 wire494/X _1644_/D _1387_/C1 _1230_/X SS_sky130_fd_sc_hd__o211a_2
XFILLER_38_815 vccd1 vssd1 vccd1 vssd1 SS_sky130_fd_sc_hd__fill_1
X_1162_ vccd1 vssd1 vccd1 vssd1 _1162_/X _1162_/A _1186_/B SS_sky130_fd_sc_hd__or2_2
XFILLER_64_133 vssd1 vccd1 vccd1 vssd1 SS_sky130_fd_sc_hd__fill_4
X_1093_ vssd1 vccd1 vccd1 vssd1 wire239/X wire497/X _1577_/D _1099_/C1 _1092_/X SS_sky130_fd_sc_hd__o211a_2
XFILLER_64_177 vssd1 vccd1 vssd1 vccd1 SS_sky130_ef_sc_hd__decap_40_12
XTAP_TAPCELL_ROW_121_2116 vccd1 vssd1 SS_sky130_fd_sc_hd__tapvpwrvgnd_1
XFILLER_92_475 vccd1 vssd1 vccd1 vssd1 SS_sky130_fd_sc_hd__fill_1
XFILLER_80_637 vssd1 vccd1 vccd1 vssd1 SS_sky130_fd_sc_hd__fill_4
XFILLER_33_553 vssd1 vccd1 vccd1 vssd1 SS_sky130_fd_sc_hd__fill_4
XFILLER_45_391 vccd1 vssd1 vccd1 vssd1 SS_sky130_fd_sc_hd__fill_1
XFILLER_33_597 vssd1 vccd1 vssd1 vccd1 SS_sky130_ef_sc_hd__decap_40_12
XFILLER_60_361 vssd1 vccd1 vccd1 vssd1 SS_sky130_fd_sc_hd__fill_2
XTAP_TAPCELL_ROW_31_765 vccd1 vssd1 SS_sky130_fd_sc_hd__tapvpwrvgnd_1
X_0946_ vccd1 vssd1 _0947_/A _1010_/B _1409_/B vccd1 vssd1 SS_sky130_fd_sc_hd__and2_2
XTAP_TAPCELL_ROW_119_2078 vccd1 vssd1 SS_sky130_fd_sc_hd__tapvpwrvgnd_1
XFILLER_9_281 vssd1 vccd1 vssd1 vccd1 SS_sky130_ef_sc_hd__decap_40_12
XFILLER_119_669 vssd1 vccd1 vccd1 vssd1 SS_sky130_fd_sc_hd__fill_2
XTAP_TAPCELL_ROW_119_2089 vccd1 vssd1 SS_sky130_fd_sc_hd__tapvpwrvgnd_1
X_0877_ vssd1 vccd1 vssd1 vccd1 wire445/X _1120_/A wire347/X _0875_/X _0877_/X _0876_/X
+ SS_sky130_fd_sc_hd__a2111o_2
XFILLER_133_105 vssd1 vccd1 vccd1 vssd1 SS_sky130_fd_sc_hd__fill_4
XFILLER_109_39 vssd1 vccd1 vssd1 vccd1 SS_sky130_ef_sc_hd__decap_40_12
XFILLER_106_319 vccd1 vssd1 vccd1 vssd1 SS_sky130_fd_sc_hd__fill_1
XFILLER_133_149 vssd1 vccd1 vssd1 vccd1 SS_sky130_ef_sc_hd__decap_40_12
XTAP_TAPCELL_ROW_132_2278 vccd1 vssd1 SS_sky130_fd_sc_hd__tapvpwrvgnd_1
XFILLER_114_363 vccd1 vssd1 vccd1 vssd1 SS_sky130_fd_sc_hd__fill_1
XFILLER_87_225 vssd1 vccd1 vssd1 vccd1 SS_sky130_ef_sc_hd__decap_40_12
XFILLER_88_737 vssd1 vccd1 vssd1 vccd1 SS_sky130_ef_sc_hd__decap_40_12
XFILLER_125_27 vssd1 vccd1 vssd1 vccd1 SS_sky130_ef_sc_hd__decap_40_12
X_1429_ vssd1 vccd1 vccd1 vssd1 _1439_/A2 wire494/X _1429_/X _1431_/C1 _1428_/X SS_sky130_fd_sc_hd__o211a_2
XFILLER_102_569 vssd1 vccd1 vccd1 vssd1 SS_sky130_fd_sc_hd__fill_4
XFILLER_96_781 vssd1 vccd1 vssd1 vccd1 SS_sky130_ef_sc_hd__decap_40_12
XFILLER_55_111 vccd1 vssd1 vccd1 vssd1 SS_sky130_fd_sc_hd__fill_1
XFILLER_56_645 vssd1 vccd1 vssd1 vccd1 SS_sky130_ef_sc_hd__decap_40_12
XFILLER_83_442 vssd1 vccd1 vccd1 vssd1 SS_sky130_fd_sc_hd__fill_4
XTAP_TAPCELL_ROW_39_887 vccd1 vssd1 SS_sky130_fd_sc_hd__tapvpwrvgnd_1
XFILLER_43_317 vssd1 vccd1 vssd1 vccd1 SS_sky130_ef_sc_hd__decap_40_12
XTAP_TAPCELL_ROW_48_1018 vccd1 vssd1 SS_sky130_fd_sc_hd__tapvpwrvgnd_1
XFILLER_71_615 vccd1 vssd1 vccd1 vssd1 SS_sky130_fd_sc_hd__fill_1
XFILLER_83_486 vccd1 vssd1 vccd1 vssd1 SS_sky130_fd_sc_hd__fill_1
XFILLER_24_531 vccd1 vssd1 vccd1 vssd1 SS_sky130_fd_sc_hd__fill_1
XFILLER_12_737 vssd1 vccd1 vssd1 vccd1 SS_sky130_ef_sc_hd__decap_40_12
XFILLER_51_361 vssd1 vccd1 vssd1 vccd1 SS_sky130_ef_sc_hd__decap_40_12
XTAP_TAPCELL_ROW_61_1218 vccd1 vssd1 SS_sky130_fd_sc_hd__tapvpwrvgnd_1
XFILLER_11_225 vssd1 vccd1 vssd1 vccd1 SS_sky130_ef_sc_hd__decap_40_12
Xclkload1 clkload1/X clkload1/A vccd1 vssd1 vssd1 vccd1 SS_sky130_fd_sc_hd__clkbuf_8
XFILLER_109_113 vssd1 vccd1 vssd1 vccd1 SS_sky130_ef_sc_hd__decap_40_12
XFILLER_20_792 vssd1 vccd1 vccd1 vssd1 SS_sky130_fd_sc_hd__fill_2
XFILLER_125_617 vssd1 vccd1 vssd1 vccd1 SS_sky130_ef_sc_hd__decap_40_12
XFILLER_119_3 vssd1 vccd1 vssd1 vccd1 SS_sky130_ef_sc_hd__decap_40_12
XFILLER_121_801 vssd1 vccd1 vccd1 vssd1 SS_sky130_fd_sc_hd__fill_2
XFILLER_133_694 vssd1 vccd1 vssd1 vccd1 SS_sky130_ef_sc_hd__decap_40_12
XFILLER_132_193 vssd1 vccd1 vccd1 vssd1 SS_sky130_fd_sc_hd__fill_2
XFILLER_59_461 vssd1 vccd1 vssd1 vccd1 SS_sky130_ef_sc_hd__decap_40_12
XFILLER_59_483 vccd1 vssd1 vccd1 vssd1 SS_sky130_fd_sc_hd__fill_1
XFILLER_87_781 vssd1 vccd1 vccd1 vssd1 SS_sky130_fd_sc_hd__fill_2
XFILLER_120_377 vssd1 vccd1 vccd1 vssd1 SS_sky130_fd_sc_hd__fill_8
XFILLER_93_217 vssd1 vccd1 vccd1 vssd1 SS_sky130_fd_sc_hd__fill_4
XFILLER_46_133 vssd1 vccd1 vccd1 vssd1 SS_sky130_fd_sc_hd__fill_4
XFILLER_115_93 vssd1 vccd1 vssd1 vccd1 SS_sky130_ef_sc_hd__decap_40_12
XFILLER_46_177 vssd1 vccd1 vssd1 vccd1 SS_sky130_ef_sc_hd__decap_40_12
XFILLER_61_125 vssd1 vccd1 vssd1 vccd1 SS_sky130_ef_sc_hd__decap_40_12
XFILLER_15_553 vssd1 vccd1 vccd1 vssd1 SS_sky130_fd_sc_hd__fill_4
XTAP_TAPCELL_ROW_17_548 vccd1 vssd1 SS_sky130_fd_sc_hd__tapvpwrvgnd_1
XTAP_TAPCELL_ROW_17_559 vccd1 vssd1 SS_sky130_fd_sc_hd__tapvpwrvgnd_1
XFILLER_27_391 vccd1 vssd1 vccd1 vssd1 SS_sky130_fd_sc_hd__fill_1
XFILLER_61_169 vssd1 vccd1 vssd1 vccd1 SS_sky130_ef_sc_hd__decap_40_12
XFILLER_91_30 vssd1 vccd1 vssd1 vccd1 SS_sky130_ef_sc_hd__decap_40_12
XFILLER_131_81 vssd1 vccd1 vssd1 vccd1 SS_sky130_ef_sc_hd__decap_40_12
XFILLER_15_597 vssd1 vccd1 vssd1 vccd1 SS_sky130_ef_sc_hd__decap_40_12
XFILLER_30_501 vssd1 vccd1 vssd1 vccd1 SS_sky130_ef_sc_hd__decap_40_12
XFILLER_42_361 vssd1 vccd1 vccd1 vssd1 SS_sky130_fd_sc_hd__fill_2
XFILLER_30_545 vssd1 vccd1 vssd1 vccd1 SS_sky130_ef_sc_hd__decap_40_12
XFILLER_70_692 vssd1 vccd1 vccd1 vssd1 SS_sky130_fd_sc_hd__fill_8
XFILLER_30_589 vssd1 vccd1 vssd1 vccd1 SS_sky130_ef_sc_hd__decap_40_12
X_0800_ vccd1 vssd1 vssd1 vccd1 _0796_/X _0799_/X _0860_/A2 _1482_/Q _1482_/D _1447_/C1
+ SS_sky130_fd_sc_hd__o221a_2
XFILLER_7_741 vssd1 vccd1 vssd1 vccd1 SS_sky130_ef_sc_hd__decap_40_12
XFILLER_128_433 vssd1 vccd1 vssd1 vccd1 SS_sky130_ef_sc_hd__decap_40_12
XFILLER_6_251 vccd1 vssd1 vccd1 vssd1 SS_sky130_fd_sc_hd__fill_1
XFILLER_7_785 vssd1 vccd1 vssd1 vccd1 SS_sky130_ef_sc_hd__decap_40_12
XFILLER_128_477 vssd1 vccd1 vccd1 vssd1 SS_sky130_fd_sc_hd__fill_4
Xhold719 _1128_/A _1595_/Q vccd1 vssd1 vssd1 vccd1 SS_sky130_fd_sc_hd__dlygate4sd3_1
Xhold708 input41/A wbs_dat_i[29] vccd1 vssd1 vssd1 vccd1 SS_sky130_fd_sc_hd__dlygate4sd3_1
XFILLER_115_105 vssd1 vccd1 vccd1 vssd1 SS_sky130_fd_sc_hd__fill_4
XFILLER_128_499 vssd1 vccd1 vccd1 vssd1 SS_sky130_fd_sc_hd__fill_2
XFILLER_115_149 vssd1 vccd1 vssd1 vccd1 SS_sky130_ef_sc_hd__decap_40_12
XFILLER_97_501 vssd1 vccd1 vccd1 vssd1 SS_sky130_fd_sc_hd__fill_2
XFILLER_34_3 vssd1 vccd1 vssd1 vccd1 SS_sky130_ef_sc_hd__decap_40_12
XFILLER_69_225 vssd1 vccd1 vssd1 vccd1 SS_sky130_ef_sc_hd__decap_40_12
XFILLER_123_193 vssd1 vccd1 vssd1 vccd1 SS_sky130_ef_sc_hd__decap_40_12
XFILLER_111_333 vssd1 vccd1 vccd1 vssd1 SS_sky130_fd_sc_hd__fill_2
XFILLER_97_567 vccd1 vssd1 vccd1 vssd1 SS_sky130_fd_sc_hd__fill_1
XFILLER_38_601 vssd1 vccd1 vccd1 vssd1 SS_sky130_fd_sc_hd__fill_4
XFILLER_78_781 vssd1 vccd1 vssd1 vccd1 SS_sky130_ef_sc_hd__decap_40_12
XFILLER_85_729 vssd1 vccd1 vssd1 vccd1 SS_sky130_ef_sc_hd__decap_40_12
XFILLER_37_111 vccd1 vssd1 vccd1 vssd1 SS_sky130_fd_sc_hd__fill_1
XFILLER_38_645 vssd1 vccd1 vccd1 vssd1 SS_sky130_fd_sc_hd__fill_4
X_1214_ vccd1 vssd1 vccd1 vssd1 _1214_/X _1636_/Q _1272_/B SS_sky130_fd_sc_hd__or2_2
XFILLER_26_807 vccd1 vssd1 vccd1 vssd1 SS_sky130_fd_sc_hd__fill_1
X_1145_ vccd1 vssd1 vssd1 vccd1 _1145_/Y _1145_/A _1409_/B SS_sky130_fd_sc_hd__nand2_2
XFILLER_25_317 vssd1 vccd1 vssd1 vccd1 SS_sky130_ef_sc_hd__decap_40_12
XTAP_TAPCELL_ROW_36_835 vccd1 vssd1 SS_sky130_fd_sc_hd__tapvpwrvgnd_1
XFILLER_111_18 vssd1 vccd1 vssd1 vccd1 SS_sky130_ef_sc_hd__decap_40_12
XPHY_EDGE_ROW_9_Left_148 vccd1 vssd1 vccd1 vssd1 SS_sky130_fd_sc_hd__decap_3
XTAP_TAPCELL_ROW_36_846 vccd1 vssd1 SS_sky130_fd_sc_hd__tapvpwrvgnd_1
X_1076_ vccd1 vssd1 vccd1 vssd1 _1076_/X _1076_/A _1076_/B SS_sky130_fd_sc_hd__or2_2
XFILLER_21_501 vssd1 vccd1 vccd1 vssd1 SS_sky130_fd_sc_hd__fill_2
XFILLER_33_361 vssd1 vccd1 vssd1 vccd1 SS_sky130_ef_sc_hd__decap_40_12
XFILLER_40_309 vssd1 vccd1 vssd1 vccd1 SS_sky130_ef_sc_hd__decap_40_12
XFILLER_80_489 vssd1 vccd1 vssd1 vccd1 SS_sky130_ef_sc_hd__decap_40_12
XTAP_TAPCELL_ROW_101_1819 vccd1 vssd1 SS_sky130_fd_sc_hd__tapvpwrvgnd_1
XTAP_TAPCELL_ROW_101_1808 vccd1 vssd1 SS_sky130_fd_sc_hd__tapvpwrvgnd_1
XTAP_TAPCELL_ROW_134_2307 vccd1 vssd1 SS_sky130_fd_sc_hd__tapvpwrvgnd_1
XFILLER_20_15 vssd1 vccd1 vssd1 vccd1 SS_sky130_ef_sc_hd__decap_40_12
X_0929_ vccd1 vssd1 vccd1 vssd1 _0928_/X _1568_/Q _1012_/A _1600_/Q wire445/A _0929_/X
+ SS_sky130_fd_sc_hd__a221o_2
XFILLER_107_617 vssd1 vccd1 vssd1 vccd1 SS_sky130_ef_sc_hd__decap_40_12
XFILLER_136_26 vssd1 vccd1 vccd1 vssd1 SS_sky130_fd_sc_hd__fill_2
XFILLER_136_48 vssd1 vccd1 vssd1 vccd1 SS_sky130_ef_sc_hd__decap_40_12
XFILLER_0_405 vssd1 vccd1 vssd1 vccd1 SS_sky130_ef_sc_hd__decap_40_12
XFILLER_103_812 vssd1 vccd1 vccd1 vssd1 SS_sky130_fd_sc_hd__fill_2
XFILLER_0_449 vssd1 vccd1 vssd1 vccd1 SS_sky130_ef_sc_hd__decap_40_12
XFILLER_88_545 vssd1 vccd1 vssd1 vccd1 SS_sky130_ef_sc_hd__decap_40_12
XFILLER_114_193 vssd1 vccd1 vccd1 vssd1 SS_sky130_fd_sc_hd__fill_2
XFILLER_102_333 vssd1 vccd1 vccd1 vssd1 SS_sky130_fd_sc_hd__fill_4
XFILLER_29_57 vssd1 vccd1 vssd1 vccd1 SS_sky130_ef_sc_hd__decap_40_12
XFILLER_69_781 vssd1 vccd1 vccd1 vssd1 SS_sky130_fd_sc_hd__fill_2
XFILLER_75_217 vssd1 vccd1 vccd1 vssd1 SS_sky130_fd_sc_hd__fill_4
XFILLER_88_589 vssd1 vccd1 vssd1 vccd1 SS_sky130_ef_sc_hd__decap_40_12
XFILLER_130_697 vssd1 vccd1 vccd1 vssd1 SS_sky130_fd_sc_hd__fill_2
Xclkbuf_leaf_2_wb_clk_i _1755_/CLK clkbuf_leaf_9_wb_clk_i/A vccd1 vssd1 vssd1 vccd1
+ SS_sky130_fd_sc_hd__clkbuf_8
XFILLER_102_377 vssd1 vccd1 vccd1 vssd1 SS_sky130_fd_sc_hd__fill_8
XFILLER_28_133 vssd1 vccd1 vccd1 vssd1 SS_sky130_fd_sc_hd__fill_4
XFILLER_56_475 vccd1 vssd1 vccd1 vssd1 SS_sky130_fd_sc_hd__fill_1
XFILLER_90_209 vssd1 vccd1 vssd1 vccd1 SS_sky130_ef_sc_hd__decap_40_12
XFILLER_28_177 vssd1 vccd1 vssd1 vccd1 SS_sky130_ef_sc_hd__decap_40_12
XFILLER_43_125 vssd1 vccd1 vssd1 vccd1 SS_sky130_ef_sc_hd__decap_40_12
XFILLER_71_401 vssd1 vccd1 vssd1 vccd1 SS_sky130_ef_sc_hd__decap_40_12
XFILLER_83_261 vssd1 vccd1 vssd1 vccd1 SS_sky130_ef_sc_hd__decap_40_12
XFILLER_12_501 vssd1 vccd1 vssd1 vccd1 SS_sky130_ef_sc_hd__decap_40_12
XTAP_TAPCELL_ROW_14_507 vccd1 vssd1 SS_sky130_fd_sc_hd__tapvpwrvgnd_1
XFILLER_24_361 vssd1 vccd1 vccd1 vssd1 SS_sky130_fd_sc_hd__fill_2
XFILLER_43_169 vssd1 vccd1 vssd1 vccd1 SS_sky130_ef_sc_hd__decap_40_12
XFILLER_12_545 vssd1 vccd1 vssd1 vccd1 SS_sky130_ef_sc_hd__decap_40_12
XFILLER_12_589 vssd1 vccd1 vssd1 vccd1 SS_sky130_ef_sc_hd__decap_40_12
XFILLER_138_753 vssd1 vccd1 vccd1 vssd1 SS_sky130_fd_sc_hd__fill_2
XTAP_TAPCELL_ROW_74_1409 vccd1 vssd1 SS_sky130_fd_sc_hd__tapvpwrvgnd_1
XFILLER_3_221 vssd1 vccd1 vccd1 vssd1 SS_sky130_fd_sc_hd__fill_2
XFILLER_4_755 vccd1 vssd1 vccd1 vssd1 SS_sky130_fd_sc_hd__fill_1
XFILLER_79_501 vssd1 vccd1 vccd1 vssd1 SS_sky130_fd_sc_hd__fill_2
XFILLER_125_469 vssd1 vccd1 vccd1 vssd1 SS_sky130_fd_sc_hd__fill_2
XFILLER_106_661 vccd1 vssd1 vccd1 vssd1 SS_sky130_fd_sc_hd__fill_1
XFILLER_98_309 vssd1 vccd1 vssd1 vccd1 SS_sky130_ef_sc_hd__decap_40_12
XFILLER_10_81 vssd1 vccd1 vccd1 vssd1 SS_sky130_fd_sc_hd__fill_2
XFILLER_126_81 vssd1 vccd1 vccd1 vssd1 SS_sky130_fd_sc_hd__fill_2
XFILLER_105_193 vssd1 vccd1 vssd1 vccd1 SS_sky130_ef_sc_hd__decap_40_12
XFILLER_67_729 vssd1 vccd1 vssd1 vccd1 SS_sky130_ef_sc_hd__decap_40_12
XFILLER_86_41 vssd1 vccd1 vssd1 vccd1 SS_sky130_ef_sc_hd__decap_40_12
XFILLER_121_697 vssd1 vccd1 vccd1 vssd1 SS_sky130_fd_sc_hd__fill_8
XFILLER_120_141 vssd1 vccd1 vssd1 vccd1 SS_sky130_ef_sc_hd__decap_40_12
XFILLER_19_111 vccd1 vssd1 vccd1 vssd1 SS_sky130_fd_sc_hd__fill_1
XFILLER_47_431 vssd1 vccd1 vssd1 vccd1 SS_sky130_ef_sc_hd__decap_40_12
XFILLER_86_85 vssd1 vccd1 vssd1 vccd1 SS_sky130_ef_sc_hd__decap_40_12
XTAP_TAPCELL_ROW_89_1630 vccd1 vssd1 SS_sky130_fd_sc_hd__tapvpwrvgnd_1
XTAP_TAPCELL_ROW_89_1641 vccd1 vssd1 SS_sky130_fd_sc_hd__tapvpwrvgnd_1
XFILLER_35_615 vccd1 vssd1 vccd1 vssd1 SS_sky130_fd_sc_hd__fill_1
XFILLER_47_486 vssd1 vccd1 vccd1 vssd1 SS_sky130_fd_sc_hd__fill_8
XFILLER_62_456 vssd1 vccd1 vccd1 vssd1 SS_sky130_fd_sc_hd__fill_8
XFILLER_90_743 vssd1 vccd1 vssd1 vccd1 SS_sky130_ef_sc_hd__decap_40_12
XFILLER_15_361 vssd1 vccd1 vssd1 vccd1 SS_sky130_ef_sc_hd__decap_40_12
XFILLER_22_309 vssd1 vccd1 vssd1 vccd1 SS_sky130_ef_sc_hd__decap_40_12
X_1901_ vccd1 vssd1 _1901_/X _1901_/A vccd1 vssd1 SS_sky130_fd_sc_hd__buf_2
X_1832_ vccd1 vssd1 _1832_/X _1832_/A vccd1 vssd1 SS_sky130_fd_sc_hd__buf_2
XFILLER_129_753 vssd1 vccd1 vssd1 vccd1 SS_sky130_ef_sc_hd__decap_40_12
XTAP_TAPCELL_ROW_116_2037 vccd1 vssd1 SS_sky130_fd_sc_hd__tapvpwrvgnd_1
Xmax_cap235 vccd1 vssd1 _1209_/A2 _1195_/A2 vccd1 vssd1 SS_sky130_fd_sc_hd__buf_6
X_1694_ _1694_/Q _1724_/CLK _1694_/D vccd1 vssd1 vccd1 vssd1 SS_sky130_fd_sc_hd__dfxtp_2
XFILLER_131_417 vssd1 vccd1 vccd1 vssd1 SS_sky130_fd_sc_hd__fill_8
XFILLER_106_18 vssd1 vccd1 vccd1 vssd1 SS_sky130_fd_sc_hd__fill_8
XFILLER_106_29 vssd1 vccd1 vssd1 vccd1 SS_sky130_ef_sc_hd__decap_40_12
Xload_slew441 vccd1 vssd1 _0828_/B1 _0876_/B1 vccd1 vssd1 SS_sky130_fd_sc_hd__buf_4
XFILLER_57_217 vssd1 vccd1 vccd1 vssd1 SS_sky130_fd_sc_hd__fill_4
XTAP_TAPCELL_ROW_111_1970 vccd1 vssd1 SS_sky130_fd_sc_hd__tapvpwrvgnd_1
XFILLER_85_559 vccd1 vssd1 vccd1 vssd1 SS_sky130_fd_sc_hd__fill_1
XFILLER_112_697 vssd1 vccd1 vccd1 vssd1 SS_sky130_fd_sc_hd__fill_2
Xload_slew485 vccd1 vssd1 _1431_/C1 _1387_/C1 vccd1 vssd1 SS_sky130_fd_sc_hd__buf_4
XFILLER_66_751 vssd1 vccd1 vccd1 vssd1 SS_sky130_fd_sc_hd__fill_4
XFILLER_72_209 vssd1 vccd1 vssd1 vccd1 SS_sky130_ef_sc_hd__decap_40_12
XFILLER_26_637 vssd1 vccd1 vccd1 vssd1 SS_sky130_fd_sc_hd__fill_2
XFILLER_65_261 vssd1 vccd1 vssd1 vccd1 SS_sky130_ef_sc_hd__decap_40_12
XTAP_TAPCELL_ROW_127_2199 vccd1 vssd1 SS_sky130_fd_sc_hd__tapvpwrvgnd_1
XTAP_TAPCELL_ROW_0_279 vccd1 vssd1 SS_sky130_fd_sc_hd__tapvpwrvgnd_1
XFILLER_25_125 vssd1 vccd1 vssd1 vccd1 SS_sky130_ef_sc_hd__decap_40_12
X_1128_ vccd1 vssd1 vccd1 vssd1 _1128_/X _1128_/A _1140_/B SS_sky130_fd_sc_hd__or2_2
XFILLER_15_15 vssd1 vccd1 vssd1 vccd1 SS_sky130_ef_sc_hd__decap_40_12
XFILLER_25_169 vssd1 vccd1 vssd1 vccd1 SS_sky130_ef_sc_hd__decap_40_12
XFILLER_41_629 vssd1 vccd1 vccd1 vssd1 SS_sky130_fd_sc_hd__fill_2
XFILLER_53_478 vssd1 vccd1 vssd1 vccd1 SS_sky130_ef_sc_hd__decap_40_12
XFILLER_80_253 vssd1 vccd1 vssd1 vccd1 SS_sky130_ef_sc_hd__decap_40_12
X_1059_ vssd1 vccd1 vccd1 vssd1 _1065_/A2 input34/X _1561_/D _1457_/C1 _1058_/X SS_sky130_fd_sc_hd__o211a_2
XFILLER_34_681 vssd1 vccd1 vssd1 vccd1 SS_sky130_ef_sc_hd__decap_40_12
XFILLER_40_139 vccd1 vssd1 vccd1 vssd1 SS_sky130_fd_sc_hd__fill_1
XFILLER_31_69 vssd1 vccd1 vssd1 vccd1 SS_sky130_ef_sc_hd__decap_40_12
XFILLER_135_723 vssd1 vccd1 vccd1 vssd1 SS_sky130_fd_sc_hd__fill_4
XFILLER_135_745 vssd1 vccd1 vccd1 vssd1 SS_sky130_fd_sc_hd__fill_2
XFILLER_107_447 vccd1 vssd1 vccd1 vssd1 SS_sky130_fd_sc_hd__fill_1
XTAP_TAPCELL_ROW_56_1139 vccd1 vssd1 SS_sky130_fd_sc_hd__tapvpwrvgnd_1
XFILLER_134_233 vssd1 vccd1 vssd1 vccd1 SS_sky130_ef_sc_hd__decap_40_12
XFILLER_135_778 vssd1 vccd1 vccd1 vssd1 SS_sky130_fd_sc_hd__fill_4
XFILLER_107_469 vssd1 vccd1 vccd1 vssd1 SS_sky130_fd_sc_hd__fill_2
XFILLER_103_6 vssd1 vccd1 vssd1 vccd1 SS_sky130_ef_sc_hd__decap_40_12
XFILLER_1_725 vssd1 vccd1 vccd1 vssd1 SS_sky130_fd_sc_hd__fill_2
XFILLER_134_277 vssd1 vccd1 vssd1 vccd1 SS_sky130_ef_sc_hd__decap_40_12
XFILLER_122_417 vssd1 vccd1 vccd1 vssd1 SS_sky130_fd_sc_hd__fill_2
Xoutput58 vccd1 vssd1 wire302/A _1894_/X vccd1 vssd1 SS_sky130_fd_sc_hd__buf_4
Xoutput69 vccd1 vssd1 wire291/A _1904_/X vccd1 vssd1 SS_sky130_fd_sc_hd__buf_4
XFILLER_0_279 vccd1 vssd1 vccd1 vssd1 SS_sky130_fd_sc_hd__fill_1
XFILLER_49_729 vssd1 vccd1 vccd1 vssd1 SS_sky130_fd_sc_hd__fill_8
XFILLER_102_141 vssd1 vccd1 vssd1 vccd1 SS_sky130_ef_sc_hd__decap_40_12
XFILLER_130_494 vssd1 vccd1 vssd1 vccd1 SS_sky130_ef_sc_hd__decap_40_12
XFILLER_103_697 vssd1 vccd1 vssd1 vccd1 SS_sky130_ef_sc_hd__decap_40_12
XFILLER_17_615 vccd1 vssd1 vccd1 vssd1 SS_sky130_fd_sc_hd__fill_1
XFILLER_29_497 vssd1 vccd1 vccd1 vssd1 SS_sky130_fd_sc_hd__fill_4
XFILLER_44_401 vssd1 vccd1 vssd1 vccd1 SS_sky130_ef_sc_hd__decap_40_12
XFILLER_56_77 vssd1 vccd1 vccd1 vssd1 SS_sky130_fd_sc_hd__fill_4
XFILLER_84_581 vssd1 vccd1 vccd1 vssd1 SS_sky130_fd_sc_hd__fill_4
XFILLER_91_529 vssd1 vccd1 vssd1 vccd1 SS_sky130_ef_sc_hd__decap_40_12
XFILLER_25_670 vssd1 vccd1 vccd1 vssd1 SS_sky130_fd_sc_hd__fill_2
XFILLER_32_629 vssd1 vccd1 vccd1 vssd1 SS_sky130_fd_sc_hd__fill_4
XFILLER_44_489 vssd1 vccd1 vssd1 vccd1 SS_sky130_ef_sc_hd__decap_40_12
XFILLER_72_798 vssd1 vccd1 vccd1 vssd1 SS_sky130_fd_sc_hd__fill_4
XTAP_TAPCELL_ROW_84_1560 vccd1 vssd1 SS_sky130_fd_sc_hd__tapvpwrvgnd_1
XFILLER_112_83 vccd1 vssd1 vccd1 vssd1 SS_sky130_fd_sc_hd__fill_1
XTAP_TAPCELL_ROW_27_698 vccd1 vssd1 SS_sky130_fd_sc_hd__tapvpwrvgnd_1
XFILLER_72_65 vssd1 vccd1 vssd1 vccd1 SS_sky130_ef_sc_hd__decap_40_12
XFILLER_40_695 vssd1 vccd1 vccd1 vssd1 SS_sky130_fd_sc_hd__fill_4
XFILLER_8_357 vssd1 vccd1 vccd1 vssd1 SS_sky130_fd_sc_hd__fill_4
XFILLER_126_701 vccd1 vssd1 vccd1 vssd1 SS_sky130_fd_sc_hd__fill_1
XFILLER_4_585 vssd1 vccd1 vccd1 vssd1 SS_sky130_fd_sc_hd__fill_2
XFILLER_125_277 vssd1 vccd1 vccd1 vssd1 SS_sky130_fd_sc_hd__fill_2
XFILLER_113_417 vssd1 vccd1 vssd1 vccd1 SS_sky130_ef_sc_hd__decap_40_12
XFILLER_99_629 vssd1 vccd1 vssd1 vccd1 SS_sky130_ef_sc_hd__decap_40_12
XFILLER_98_139 vccd1 vssd1 vccd1 vssd1 SS_sky130_fd_sc_hd__fill_1
XFILLER_97_51 vssd1 vccd1 vccd1 vssd1 SS_sky130_fd_sc_hd__fill_4
XFILLER_79_375 vssd1 vccd1 vccd1 vssd1 SS_sky130_fd_sc_hd__fill_8
XFILLER_121_461 vssd1 vccd1 vssd1 vccd1 SS_sky130_ef_sc_hd__decap_40_12
XFILLER_95_802 vssd1 vccd1 vccd1 vssd1 SS_sky130_fd_sc_hd__fill_8
XFILLER_94_301 vssd1 vccd1 vccd1 vssd1 SS_sky130_fd_sc_hd__fill_4
XFILLER_39_217 vssd1 vccd1 vccd1 vssd1 SS_sky130_fd_sc_hd__fill_4
XFILLER_94_334 vssd1 vccd1 vccd1 vssd1 SS_sky130_fd_sc_hd__fill_2
XFILLER_48_751 vssd1 vccd1 vccd1 vssd1 SS_sky130_fd_sc_hd__fill_4
XFILLER_54_209 vssd1 vccd1 vssd1 vccd1 SS_sky130_ef_sc_hd__decap_40_12
XFILLER_82_507 vssd1 vccd1 vssd1 vccd1 SS_sky130_ef_sc_hd__decap_40_12
XFILLER_47_261 vssd1 vccd1 vssd1 vccd1 SS_sky130_ef_sc_hd__decap_40_12
XFILLER_63_721 vssd1 vccd1 vccd1 vssd1 SS_sky130_fd_sc_hd__fill_4
XFILLER_82_529 vssd1 vccd1 vccd1 vssd1 SS_sky130_fd_sc_hd__fill_2
XFILLER_94_389 vssd1 vccd1 vssd1 vccd1 SS_sky130_ef_sc_hd__decap_40_12
XFILLER_35_445 vssd1 vccd1 vccd1 vssd1 SS_sky130_fd_sc_hd__fill_2
XFILLER_23_629 vssd1 vccd1 vssd1 vccd1 SS_sky130_ef_sc_hd__decap_40_12
XTAP_TAPCELL_ROW_46_985 vccd1 vssd1 SS_sky130_fd_sc_hd__tapvpwrvgnd_1
XFILLER_50_415 vssd1 vccd1 vccd1 vssd1 SS_sky130_fd_sc_hd__fill_4
XFILLER_62_253 vssd1 vccd1 vssd1 vccd1 SS_sky130_ef_sc_hd__decap_40_12
XFILLER_22_139 vccd1 vssd1 vccd1 vssd1 SS_sky130_fd_sc_hd__fill_1
XTAP_TAPCELL_ROW_46_996 vccd1 vssd1 SS_sky130_fd_sc_hd__tapvpwrvgnd_1
XPHY_EDGE_ROW_99_Left_238 vccd1 vssd1 vccd1 vssd1 SS_sky130_fd_sc_hd__decap_3
XFILLER_129_561 vssd1 vccd1 vccd1 vssd1 SS_sky130_fd_sc_hd__fill_4
X_1746_ _1746_/Q _1746_/CLK _1746_/D vccd1 vssd1 vccd1 vssd1 SS_sky130_fd_sc_hd__dfxtp_2
XFILLER_117_723 vssd1 vccd1 vccd1 vssd1 SS_sky130_fd_sc_hd__fill_4
XFILLER_7_93 vssd1 vccd1 vssd1 vccd1 SS_sky130_ef_sc_hd__decap_40_12
XFILLER_117_778 vssd1 vccd1 vccd1 vssd1 SS_sky130_fd_sc_hd__fill_4
XFILLER_116_233 vssd1 vccd1 vssd1 vccd1 SS_sky130_ef_sc_hd__decap_40_12
X_1677_ _1677_/Q _1738_/CLK _1677_/D vccd1 vssd1 vccd1 vssd1 SS_sky130_fd_sc_hd__dfxtp_2
XFILLER_117_39 vssd1 vccd1 vssd1 vccd1 SS_sky130_ef_sc_hd__decap_40_12
XFILLER_116_277 vssd1 vccd1 vssd1 vccd1 SS_sky130_ef_sc_hd__decap_40_12
XFILLER_131_225 vssd1 vccd1 vssd1 vccd1 SS_sky130_ef_sc_hd__decap_40_12
XFILLER_86_813 vccd1 vssd1 vccd1 vssd1 SS_sky130_fd_sc_hd__fill_1
XTAP_TAPCELL_ROW_129_2228 vccd1 vssd1 SS_sky130_fd_sc_hd__tapvpwrvgnd_1
XTAP_TAPCELL_ROW_129_2239 vccd1 vssd1 SS_sky130_fd_sc_hd__tapvpwrvgnd_1
XFILLER_100_601 vssd1 vccd1 vssd1 vccd1 SS_sky130_ef_sc_hd__decap_40_12
XFILLER_98_673 vccd1 vssd1 vccd1 vssd1 SS_sky130_fd_sc_hd__fill_1
XFILLER_97_161 vssd1 vccd1 vccd1 vssd1 SS_sky130_fd_sc_hd__fill_4
XTAP_TAPCELL_ROW_51_1058 vccd1 vssd1 SS_sky130_fd_sc_hd__tapvpwrvgnd_1
XTAP_TAPCELL_ROW_51_1069 vccd1 vssd1 SS_sky130_fd_sc_hd__tapvpwrvgnd_1
Xload_slew260 vccd1 vssd1 _0988_/B _0984_/B vccd1 vssd1 SS_sky130_fd_sc_hd__buf_4
XFILLER_100_645 vssd1 vccd1 vssd1 vccd1 SS_sky130_ef_sc_hd__decap_40_12
XFILLER_26_401 vssd1 vccd1 vssd1 vccd1 SS_sky130_ef_sc_hd__decap_40_12
XFILLER_100_689 vssd1 vccd1 vccd1 vssd1 SS_sky130_fd_sc_hd__fill_8
XFILLER_26_445 vssd1 vccd1 vssd1 vccd1 SS_sky130_ef_sc_hd__decap_40_12
XFILLER_26_489 vssd1 vccd1 vssd1 vccd1 SS_sky130_ef_sc_hd__decap_40_12
XTAP_TAPCELL_ROW_66_1290 vccd1 vssd1 SS_sky130_fd_sc_hd__tapvpwrvgnd_1
XFILLER_81_595 vssd1 vccd1 vssd1 vccd1 SS_sky130_ef_sc_hd__decap_40_12
XTAP_TAPCELL_ROW_24_657 vccd1 vssd1 SS_sky130_fd_sc_hd__tapvpwrvgnd_1
XFILLER_10_813 vssd1 vccd1 vccd1 vssd1 SS_sky130_fd_sc_hd__fill_4
XFILLER_21_161 vssd1 vccd1 vccd1 vssd1 SS_sky130_fd_sc_hd__fill_4
XFILLER_5_305 vssd1 vccd1 vssd1 vccd1 SS_sky130_ef_sc_hd__decap_40_12
XFILLER_5_349 vssd1 vccd1 vssd1 vccd1 SS_sky130_ef_sc_hd__decap_40_12
XFILLER_107_277 vssd1 vccd1 vccd1 vssd1 SS_sky130_fd_sc_hd__fill_2
XFILLER_3_18 vssd1 vccd1 vssd1 vccd1 SS_sky130_ef_sc_hd__decap_40_12
XFILLER_76_301 vssd1 vccd1 vccd1 vssd1 SS_sky130_fd_sc_hd__fill_4
XFILLER_89_673 vssd1 vccd1 vssd1 vccd1 SS_sky130_ef_sc_hd__decap_40_12
XFILLER_103_461 vssd1 vccd1 vssd1 vccd1 SS_sky130_ef_sc_hd__decap_40_12
XFILLER_95_109 vssd1 vccd1 vccd1 vssd1 SS_sky130_fd_sc_hd__fill_2
XFILLER_131_781 vssd1 vccd1 vccd1 vssd1 SS_sky130_fd_sc_hd__fill_2
XTAP_TAPCELL_ROW_4_360 vccd1 vssd1 SS_sky130_fd_sc_hd__tapvpwrvgnd_1
XFILLER_76_345 vssd1 vccd1 vssd1 vccd1 SS_sky130_ef_sc_hd__decap_40_12
XFILLER_29_261 vssd1 vccd1 vssd1 vccd1 SS_sky130_ef_sc_hd__decap_40_12
XFILLER_36_209 vssd1 vccd1 vssd1 vccd1 SS_sky130_ef_sc_hd__decap_40_12
XFILLER_76_389 vssd1 vccd1 vssd1 vccd1 SS_sky130_ef_sc_hd__decap_40_12
XFILLER_17_445 vssd1 vccd1 vccd1 vssd1 SS_sky130_fd_sc_hd__fill_2
XFILLER_83_42 vssd1 vccd1 vssd1 vccd1 SS_sky130_ef_sc_hd__decap_40_12
XFILLER_91_337 vssd1 vccd1 vssd1 vccd1 SS_sky130_ef_sc_hd__decap_40_12
XFILLER_123_93 vssd1 vccd1 vssd1 vccd1 SS_sky130_ef_sc_hd__decap_40_12
XFILLER_44_253 vssd1 vccd1 vssd1 vccd1 SS_sky130_ef_sc_hd__decap_40_12
XFILLER_45_765 vssd1 vccd1 vssd1 vccd1 SS_sky130_ef_sc_hd__decap_40_12
XTAP_TAPCELL_ROW_43_944 vccd1 vssd1 SS_sky130_fd_sc_hd__tapvpwrvgnd_1
XFILLER_60_757 vssd1 vccd1 vccd1 vssd1 SS_sky130_fd_sc_hd__fill_2
XFILLER_8_121 vssd1 vccd1 vssd1 vccd1 SS_sky130_ef_sc_hd__decap_40_12
XFILLER_13_673 vssd1 vccd1 vssd1 vccd1 SS_sky130_ef_sc_hd__decap_40_12
XFILLER_8_165 vssd1 vccd1 vssd1 vccd1 SS_sky130_ef_sc_hd__decap_40_12
XFILLER_66_6 vssd1 vccd1 vssd1 vccd1 SS_sky130_ef_sc_hd__decap_40_12
X_1600_ _1600_/Q _1634_/CLK _1600_/D vccd1 vssd1 vccd1 vssd1 SS_sky130_fd_sc_hd__dfxtp_2
XFILLER_126_520 vssd1 vccd1 vccd1 vssd1 SS_sky130_fd_sc_hd__fill_4
XTAP_TAPCELL_ROW_97_1751 vccd1 vssd1 SS_sky130_fd_sc_hd__tapvpwrvgnd_1
XTAP_TAPCELL_ROW_97_1762 vccd1 vssd1 SS_sky130_fd_sc_hd__tapvpwrvgnd_1
X_1531_ _1531_/Q _1755_/CLK _1531_/D vccd1 vssd1 vccd1 vssd1 SS_sky130_fd_sc_hd__dfxtp_2
XFILLER_114_737 vccd1 vssd1 vccd1 vssd1 SS_sky130_fd_sc_hd__fill_1
X_1462_ vccd1 vssd1 vccd1 vssd1 _1462_/X _1462_/A _1466_/B SS_sky130_fd_sc_hd__or2_2
XFILLER_113_225 vssd1 vccd1 vssd1 vccd1 SS_sky130_ef_sc_hd__decap_40_12
XFILLER_68_813 vssd1 vccd1 vccd1 vssd1 SS_sky130_fd_sc_hd__fill_2
XFILLER_86_109 vssd1 vccd1 vssd1 vccd1 SS_sky130_ef_sc_hd__decap_40_12
XFILLER_79_161 vssd1 vccd1 vccd1 vssd1 SS_sky130_fd_sc_hd__fill_4
XFILLER_122_781 vssd1 vccd1 vssd1 vccd1 SS_sky130_ef_sc_hd__decap_40_12
X_1393_ vssd1 vccd1 vccd1 vssd1 _1397_/A2 input36/X _1723_/D _1461_/C1 _1392_/X SS_sky130_fd_sc_hd__o211a_2
XFILLER_95_665 vssd1 vccd1 vccd1 vssd1 SS_sky130_fd_sc_hd__fill_4
XFILLER_94_153 vssd1 vccd1 vssd1 vccd1 SS_sky130_ef_sc_hd__decap_40_12
XFILLER_82_337 vccd1 vssd1 vccd1 vssd1 SS_sky130_fd_sc_hd__fill_1
XTAP_TAPCELL_ROW_124_2158 vccd1 vssd1 SS_sky130_fd_sc_hd__tapvpwrvgnd_1
XFILLER_94_197 vssd1 vccd1 vssd1 vccd1 SS_sky130_ef_sc_hd__decap_40_12
XFILLER_63_573 vssd1 vccd1 vssd1 vccd1 SS_sky130_ef_sc_hd__decap_40_12
XFILLER_90_392 vssd1 vccd1 vssd1 vccd1 SS_sky130_ef_sc_hd__decap_40_12
XTAP_TAPCELL_ROW_106_1891 vccd1 vssd1 SS_sky130_fd_sc_hd__tapvpwrvgnd_1
XFILLER_50_245 vssd1 vccd1 vccd1 vssd1 SS_sky130_fd_sc_hd__fill_4
XFILLER_10_109 vssd1 vccd1 vssd1 vccd1 SS_sky130_ef_sc_hd__decap_40_12
XTAP_TAPCELL_ROW_21_616 vccd1 vssd1 SS_sky130_fd_sc_hd__tapvpwrvgnd_1
XFILLER_50_289 vssd1 vccd1 vssd1 vccd1 SS_sky130_ef_sc_hd__decap_40_12
XFILLER_12_27 vccd1 vssd1 vccd1 vssd1 SS_sky130_fd_sc_hd__fill_1
XFILLER_3_809 vssd1 vccd1 vssd1 vccd1 SS_sky130_ef_sc_hd__decap_40_12
XFILLER_129_391 vccd1 vssd1 vccd1 vssd1 SS_sky130_fd_sc_hd__fill_1
XFILLER_117_553 vssd1 vccd1 vccd1 vssd1 SS_sky130_fd_sc_hd__fill_4
X_1729_ _1729_/Q _1760_/CLK _1729_/D vccd1 vssd1 vccd1 vssd1 SS_sky130_fd_sc_hd__dfxtp_2
XFILLER_117_597 vssd1 vccd1 vssd1 vccd1 SS_sky130_ef_sc_hd__decap_40_12
XFILLER_59_813 vccd1 vssd1 vccd1 vssd1 SS_sky130_fd_sc_hd__fill_1
XFILLER_77_109 vssd1 vccd1 vccd1 vssd1 SS_sky130_fd_sc_hd__fill_2
XFILLER_132_589 vssd1 vccd1 vssd1 vccd1 SS_sky130_ef_sc_hd__decap_40_12
XFILLER_58_301 vssd1 vccd1 vccd1 vssd1 SS_sky130_fd_sc_hd__fill_4
XFILLER_58_345 vssd1 vccd1 vssd1 vccd1 SS_sky130_ef_sc_hd__decap_40_12
XFILLER_74_805 vssd1 vccd1 vccd1 vssd1 SS_sky130_fd_sc_hd__fill_4
XFILLER_86_643 vccd1 vssd1 vccd1 vssd1 SS_sky130_fd_sc_hd__fill_1
XFILLER_18_209 vssd1 vccd1 vssd1 vccd1 SS_sky130_ef_sc_hd__decap_40_12
Xafe_wb_545 afe_wb_545/LO analog_io_oeb[9] vccd1 vssd1 vssd1 vccd1 SS_sky130_fd_sc_hd__conb_1
XFILLER_37_57 vssd1 vccd1 vssd1 vccd1 SS_sky130_ef_sc_hd__decap_40_12
Xafe_wb_512 analog_io_out[4] afe_wb_512/HI vccd1 vssd1 vssd1 vccd1 SS_sky130_fd_sc_hd__conb_1
Xafe_wb_534 analog_io_out[26] afe_wb_534/HI vccd1 vssd1 vssd1 vccd1 SS_sky130_fd_sc_hd__conb_1
Xafe_wb_523 analog_io_out[15] afe_wb_523/HI vccd1 vssd1 vssd1 vccd1 SS_sky130_fd_sc_hd__conb_1
XFILLER_100_475 vccd1 vssd1 vccd1 vssd1 SS_sky130_fd_sc_hd__fill_1
XTAP_TAPCELL_ROW_29_738 vccd1 vssd1 SS_sky130_fd_sc_hd__tapvpwrvgnd_1
Xafe_wb_556 afe_wb_556/LO analog_io_oeb[20] vccd1 vssd1 vssd1 vccd1 SS_sky130_fd_sc_hd__conb_1
XFILLER_26_253 vssd1 vccd1 vssd1 vccd1 SS_sky130_ef_sc_hd__decap_40_12
XFILLER_54_551 vccd1 vssd1 vccd1 vssd1 SS_sky130_fd_sc_hd__fill_1
XFILLER_41_223 vccd1 vssd1 vccd1 vssd1 SS_sky130_fd_sc_hd__fill_1
XTAP_TAPCELL_ROW_40_903 vccd1 vssd1 SS_sky130_fd_sc_hd__tapvpwrvgnd_1
XFILLER_42_757 vssd1 vccd1 vccd1 vssd1 SS_sky130_fd_sc_hd__fill_2
XFILLER_10_643 vccd1 vssd1 vccd1 vssd1 SS_sky130_fd_sc_hd__fill_1
XFILLER_5_113 vssd1 vccd1 vssd1 vccd1 SS_sky130_ef_sc_hd__decap_40_12
XFILLER_6_625 vssd1 vccd1 vssd1 vccd1 SS_sky130_ef_sc_hd__decap_40_12
XFILLER_6_669 vssd1 vccd1 vssd1 vccd1 SS_sky130_ef_sc_hd__decap_40_12
XTAP_TAPCELL_ROW_79_1481 vccd1 vssd1 SS_sky130_fd_sc_hd__tapvpwrvgnd_1
XTAP_TAPCELL_ROW_79_1492 vccd1 vssd1 SS_sky130_fd_sc_hd__tapvpwrvgnd_1
XFILLER_123_501 vssd1 vccd1 vccd1 vssd1 SS_sky130_fd_sc_hd__fill_2
XFILLER_108_586 vssd1 vccd1 vccd1 vssd1 SS_sky130_fd_sc_hd__fill_2
XTAP_TAPCELL_ROW_9_430 vccd1 vssd1 SS_sky130_fd_sc_hd__tapvpwrvgnd_1
XTAP_TAPCELL_ROW_9_441 vccd1 vssd1 SS_sky130_fd_sc_hd__tapvpwrvgnd_1
XFILLER_68_109 vssd1 vccd1 vssd1 vccd1 SS_sky130_ef_sc_hd__decap_40_12
XFILLER_78_53 vssd1 vccd1 vssd1 vccd1 SS_sky130_ef_sc_hd__decap_40_12
XFILLER_123_578 vssd1 vccd1 vssd1 vccd1 SS_sky130_ef_sc_hd__decap_40_12
XFILLER_111_729 vssd1 vccd1 vccd1 vssd1 SS_sky130_fd_sc_hd__fill_4
XFILLER_96_407 vssd1 vccd1 vccd1 vssd1 SS_sky130_fd_sc_hd__fill_4
XTAP_TAPCELL_ROW_92_1681 vccd1 vssd1 SS_sky130_fd_sc_hd__tapvpwrvgnd_1
XFILLER_1_385 vssd1 vccd1 vccd1 vssd1 SS_sky130_fd_sc_hd__fill_4
XFILLER_78_97 vssd1 vccd1 vssd1 vccd1 SS_sky130_ef_sc_hd__decap_40_12
XFILLER_134_70 vssd1 vccd1 vssd1 vccd1 SS_sky130_ef_sc_hd__decap_40_12
XFILLER_49_389 vssd1 vccd1 vccd1 vssd1 SS_sky130_fd_sc_hd__fill_2
XFILLER_76_153 vssd1 vccd1 vssd1 vccd1 SS_sky130_ef_sc_hd__decap_40_12
XFILLER_94_41 vssd1 vccd1 vssd1 vccd1 SS_sky130_ef_sc_hd__decap_40_12
XFILLER_92_613 vssd1 vccd1 vccd1 vssd1 SS_sky130_fd_sc_hd__fill_2
XFILLER_18_754 vssd1 vccd1 vccd1 vssd1 SS_sky130_fd_sc_hd__fill_2
XFILLER_76_197 vssd1 vccd1 vssd1 vccd1 SS_sky130_ef_sc_hd__decap_40_12
XFILLER_94_85 vssd1 vccd1 vssd1 vccd1 SS_sky130_ef_sc_hd__decap_40_12
XFILLER_92_657 vssd1 vccd1 vssd1 vccd1 SS_sky130_ef_sc_hd__decap_40_12
XFILLER_45_573 vssd1 vccd1 vccd1 vssd1 SS_sky130_fd_sc_hd__fill_8
XFILLER_91_167 vccd1 vssd1 vccd1 vssd1 SS_sky130_fd_sc_hd__fill_1
XFILLER_18_798 vccd1 vssd1 vccd1 vssd1 SS_sky130_fd_sc_hd__fill_1
XFILLER_72_381 vccd1 vssd1 vccd1 vssd1 SS_sky130_fd_sc_hd__fill_1
XFILLER_32_245 vssd1 vccd1 vccd1 vssd1 SS_sky130_fd_sc_hd__fill_4
XFILLER_32_289 vssd1 vccd1 vssd1 vccd1 SS_sky130_ef_sc_hd__decap_40_12
X_0962_ vccd1 vssd1 vccd1 vssd1 _0962_/X _0962_/A _0988_/B SS_sky130_fd_sc_hd__or2_2
XFILLER_9_441 vssd1 vccd1 vccd1 vssd1 SS_sky130_fd_sc_hd__fill_4
XFILLER_9_485 vssd1 vccd1 vssd1 vccd1 SS_sky130_ef_sc_hd__decap_40_12
X_0893_ vccd1 vssd1 vccd1 vssd1 _0892_/X _1562_/Q _1012_/A _1126_/A wire445/A _0893_/X
+ SS_sky130_fd_sc_hd__a221o_2
XFILLER_64_3 vssd1 vccd1 vssd1 vccd1 SS_sky130_ef_sc_hd__decap_40_12
XFILLER_114_501 vssd1 vccd1 vssd1 vccd1 SS_sky130_ef_sc_hd__decap_40_12
X_1514_ _1837_/A _1610_/CLK _1514_/D vccd1 vssd1 vccd1 vssd1 SS_sky130_fd_sc_hd__dfxtp_2
XFILLER_114_545 vssd1 vccd1 vssd1 vccd1 SS_sky130_ef_sc_hd__decap_40_12
XFILLER_114_523 vccd1 vssd1 vccd1 vssd1 SS_sky130_fd_sc_hd__fill_1
XFILLER_99_223 vccd1 vssd1 vccd1 vssd1 SS_sky130_fd_sc_hd__fill_1
XFILLER_59_109 vssd1 vccd1 vccd1 vssd1 SS_sky130_fd_sc_hd__fill_2
XFILLER_102_729 vssd1 vccd1 vssd1 vccd1 SS_sky130_ef_sc_hd__decap_40_12
XFILLER_4_83 vccd1 vssd1 vccd1 vssd1 SS_sky130_fd_sc_hd__fill_1
X_1445_ vssd1 vccd1 vccd1 vssd1 wire207/X input28/X _1748_/D _1445_/C1 _1444_/X SS_sky130_fd_sc_hd__o211a_2
XFILLER_87_429 vccd1 vssd1 vccd1 vssd1 SS_sky130_fd_sc_hd__fill_1
XFILLER_101_217 vssd1 vccd1 vccd1 vssd1 SS_sky130_fd_sc_hd__fill_4
XFILLER_68_643 vccd1 vssd1 vccd1 vssd1 SS_sky130_fd_sc_hd__fill_1
XFILLER_114_29 vssd1 vccd1 vssd1 vccd1 SS_sky130_ef_sc_hd__decap_40_12
X_1376_ vccd1 vssd1 vccd1 vssd1 _1376_/X _1376_/A _1396_/B SS_sky130_fd_sc_hd__or2_2
XFILLER_28_529 vssd1 vccd1 vccd1 vssd1 SS_sky130_fd_sc_hd__fill_2
XFILLER_83_613 vssd1 vccd1 vccd1 vssd1 SS_sky130_fd_sc_hd__fill_2
XFILLER_110_795 vssd1 vccd1 vssd1 vccd1 SS_sky130_ef_sc_hd__decap_40_12
XFILLER_95_473 vssd1 vccd1 vssd1 vccd1 SS_sky130_ef_sc_hd__decap_40_12
XFILLER_55_337 vssd1 vccd1 vccd1 vssd1 SS_sky130_fd_sc_hd__fill_2
XFILLER_83_646 vssd1 vccd1 vccd1 vssd1 SS_sky130_fd_sc_hd__fill_4
XTAP_TAPCELL_ROW_108_1920 vccd1 vssd1 SS_sky130_fd_sc_hd__tapvpwrvgnd_1
XFILLER_24_713 vssd1 vccd1 vssd1 vccd1 SS_sky130_ef_sc_hd__decap_40_12
XFILLER_36_551 vssd1 vccd1 vccd1 vssd1 SS_sky130_fd_sc_hd__fill_2
XFILLER_36_562 vssd1 vccd1 vssd1 vccd1 SS_sky130_ef_sc_hd__decap_40_12
XFILLER_70_307 vccd1 vssd1 vccd1 vssd1 SS_sky130_fd_sc_hd__fill_1
XFILLER_23_223 vccd1 vssd1 vccd1 vssd1 SS_sky130_fd_sc_hd__fill_1
XFILLER_82_189 vssd1 vccd1 vccd1 vssd1 SS_sky130_fd_sc_hd__fill_4
XFILLER_24_757 vssd1 vccd1 vssd1 vccd1 SS_sky130_ef_sc_hd__decap_40_12
XFILLER_11_429 vssd1 vccd1 vssd1 vccd1 SS_sky130_ef_sc_hd__decap_40_12
XTAP_TAPCELL_ROW_137_2349 vccd1 vssd1 SS_sky130_fd_sc_hd__tapvpwrvgnd_1
Xwire309 vccd1 vssd1 vssd1 vccd1 wire309/A analog_ctrl[96] SS_sky130_fd_sc_hd__buf_12
XFILLER_137_615 vccd1 vssd1 vccd1 vssd1 SS_sky130_fd_sc_hd__fill_1
XFILLER_109_317 vssd1 vccd1 vssd1 vccd1 SS_sky130_ef_sc_hd__decap_40_12
XFILLER_3_617 vssd1 vccd1 vssd1 vccd1 SS_sky130_ef_sc_hd__decap_40_12
XFILLER_133_821 vssd1 vccd1 vccd1 vssd1 SS_sky130_fd_sc_hd__fill_2
XFILLER_124_309 vssd1 vccd1 vssd1 vccd1 SS_sky130_ef_sc_hd__decap_40_12
XFILLER_117_361 vssd1 vccd1 vssd1 vccd1 SS_sky130_ef_sc_hd__decap_40_12
XFILLER_105_501 vssd1 vccd1 vccd1 vssd1 SS_sky130_fd_sc_hd__fill_2
XFILLER_132_342 vssd1 vccd1 vssd1 vccd1 SS_sky130_ef_sc_hd__decap_40_12
XFILLER_105_556 vssd1 vccd1 vccd1 vssd1 SS_sky130_fd_sc_hd__fill_4
Xfanout420 vssd1 vccd1 vccd1 vssd1 _0755_/Y wire421/A SS_sky130_fd_sc_hd__clkdlybuf4s25_1
XFILLER_132_375 vccd1 vssd1 vccd1 vssd1 SS_sky130_fd_sc_hd__fill_1
Xfanout442 vssd1 vccd1 vccd1 vssd1 wire445/X wire443/A SS_sky130_fd_sc_hd__clkdlybuf4s25_1
XFILLER_86_451 vssd1 vccd1 vssd1 vccd1 SS_sky130_ef_sc_hd__decap_40_12
XFILLER_120_548 vssd1 vccd1 vssd1 vccd1 SS_sky130_ef_sc_hd__decap_40_12
Xfanout453 vssd1 vccd1 vccd1 vssd1 _0739_/Y wire454/A SS_sky130_fd_sc_hd__clkdlybuf4s25_1
XFILLER_19_529 vssd1 vccd1 vssd1 vccd1 SS_sky130_ef_sc_hd__decap_40_12
XFILLER_58_153 vssd1 vccd1 vssd1 vccd1 SS_sky130_ef_sc_hd__decap_40_12
Xfanout486 vssd1 vccd1 vccd1 vssd1 _1471_/C1 _1439_/C1 SS_sky130_fd_sc_hd__clkdlybuf4s25_1
XFILLER_58_197 vssd1 vccd1 vssd1 vccd1 SS_sky130_ef_sc_hd__decap_40_12
XFILLER_74_657 vssd1 vccd1 vssd1 vccd1 SS_sky130_ef_sc_hd__decap_40_12
XFILLER_73_167 vccd1 vssd1 vccd1 vssd1 SS_sky130_fd_sc_hd__fill_1
XFILLER_27_573 vssd1 vccd1 vssd1 vccd1 SS_sky130_ef_sc_hd__decap_40_12
XFILLER_64_77 vssd1 vccd1 vccd1 vssd1 SS_sky130_fd_sc_hd__fill_4
XFILLER_14_245 vssd1 vccd1 vccd1 vssd1 SS_sky130_fd_sc_hd__fill_4
XFILLER_9_39 vssd1 vccd1 vssd1 vccd1 SS_sky130_ef_sc_hd__decap_40_12
XFILLER_14_289 vssd1 vccd1 vssd1 vccd1 SS_sky130_ef_sc_hd__decap_40_12
XFILLER_42_576 vssd1 vccd1 vssd1 vccd1 SS_sky130_ef_sc_hd__decap_40_12
XFILLER_120_83 vccd1 vssd1 vccd1 vssd1 SS_sky130_fd_sc_hd__fill_1
XFILLER_30_749 vssd1 vccd1 vccd1 vssd1 SS_sky130_fd_sc_hd__fill_4
XFILLER_80_65 vssd1 vccd1 vssd1 vccd1 SS_sky130_ef_sc_hd__decap_40_12
XTAP_TAPCELL_ROW_12_479 vccd1 vssd1 SS_sky130_fd_sc_hd__tapvpwrvgnd_1
XFILLER_6_433 vssd1 vccd1 vssd1 vccd1 SS_sky130_ef_sc_hd__decap_40_12
XFILLER_10_473 vssd1 vccd1 vccd1 vssd1 SS_sky130_fd_sc_hd__fill_2
XFILLER_13_81 vssd1 vccd1 vssd1 vccd1 SS_sky130_ef_sc_hd__decap_40_12
XFILLER_127_125 vssd1 vccd1 vssd1 vccd1 SS_sky130_ef_sc_hd__decap_40_12
XFILLER_6_477 vssd1 vccd1 vssd1 vccd1 SS_sky130_ef_sc_hd__decap_40_12
XFILLER_129_81 vssd1 vccd1 vssd1 vccd1 SS_sky130_ef_sc_hd__decap_40_12
XFILLER_127_169 vssd1 vccd1 vssd1 vccd1 SS_sky130_ef_sc_hd__decap_40_12
XFILLER_108_361 vssd1 vccd1 vccd1 vssd1 SS_sky130_fd_sc_hd__fill_2
XTAP_TAPCELL_ROW_94_1710 vccd1 vssd1 SS_sky130_fd_sc_hd__tapvpwrvgnd_1
XFILLER_136_681 vssd1 vccd1 vssd1 vccd1 SS_sky130_ef_sc_hd__decap_40_12
XFILLER_97_727 vccd1 vssd1 vccd1 vssd1 SS_sky130_fd_sc_hd__fill_1
XFILLER_97_705 vssd1 vccd1 vccd1 vssd1 SS_sky130_fd_sc_hd__fill_2
XFILLER_1_193 vssd1 vccd1 vssd1 vccd1 SS_sky130_ef_sc_hd__decap_40_12
X_1230_ vccd1 vssd1 vccd1 vssd1 _1230_/X _1644_/Q _1272_/B SS_sky130_fd_sc_hd__or2_2
XFILLER_111_559 vccd1 vssd1 vccd1 vssd1 SS_sky130_fd_sc_hd__fill_1
X_1161_ vssd1 vccd1 vccd1 vssd1 wire233/X wire496/X _1161_/X wire467/X _1160_/X SS_sky130_fd_sc_hd__o211a_2
Xclkbuf_leaf_26_wb_clk_i clkload9/A clkload1/A vccd1 vssd1 vssd1 vccd1 SS_sky130_fd_sc_hd__clkbuf_8
XFILLER_37_337 vssd1 vccd1 vssd1 vccd1 SS_sky130_ef_sc_hd__decap_40_12
XFILLER_92_421 vssd1 vccd1 vssd1 vccd1 SS_sky130_ef_sc_hd__decap_40_12
X_1092_ vccd1 vssd1 vccd1 vssd1 _1092_/X _1092_/A _1116_/B SS_sky130_fd_sc_hd__or2_2
XFILLER_52_307 vccd1 vssd1 vccd1 vssd1 SS_sky130_fd_sc_hd__fill_1
XFILLER_65_679 vccd1 vssd1 vccd1 vssd1 SS_sky130_fd_sc_hd__fill_1
XFILLER_80_605 vssd1 vccd1 vccd1 vssd1 SS_sky130_fd_sc_hd__fill_2
XTAP_TAPCELL_ROW_121_2117 vccd1 vssd1 SS_sky130_fd_sc_hd__tapvpwrvgnd_1
XFILLER_64_189 vssd1 vccd1 vccd1 vssd1 SS_sky130_fd_sc_hd__fill_4
XFILLER_21_705 vccd1 vssd1 vccd1 vssd1 SS_sky130_fd_sc_hd__fill_1
XFILLER_61_841 vccd1 vssd1 vccd1 vssd1 SS_sky130_fd_sc_hd__fill_1
XFILLER_21_727 vccd1 vssd1 vccd1 vssd1 SS_sky130_fd_sc_hd__fill_1
XTAP_TAPCELL_ROW_103_1850 vccd1 vssd1 SS_sky130_fd_sc_hd__tapvpwrvgnd_1
XTAP_TAPCELL_ROW_31_766 vccd1 vssd1 SS_sky130_fd_sc_hd__tapvpwrvgnd_1
X_0945_ vccd1 vssd1 vssd1 vccd1 _1474_/Q _0945_/B _0945_/C _0945_/D _1409_/B SS_sky130_fd_sc_hd__and4b_2
XFILLER_119_615 vccd1 vssd1 vccd1 vssd1 SS_sky130_fd_sc_hd__fill_1
XFILLER_9_293 vssd1 vccd1 vssd1 vccd1 SS_sky130_ef_sc_hd__decap_40_12
X_0876_ vccd1 vssd1 vccd1 vssd1 _1623_/Q _0876_/B1 _1719_/Q wire454/X _0876_/X SS_sky130_fd_sc_hd__a22o_2
XTAP_TAPCELL_ROW_119_2079 vccd1 vssd1 SS_sky130_fd_sc_hd__tapvpwrvgnd_1
XFILLER_127_670 vssd1 vccd1 vccd1 vssd1 SS_sky130_fd_sc_hd__fill_2
XFILLER_106_309 vssd1 vccd1 vccd1 vssd1 SS_sky130_fd_sc_hd__fill_8
XTAP_TAPCELL_ROW_132_2279 vccd1 vssd1 SS_sky130_fd_sc_hd__tapvpwrvgnd_1
XFILLER_130_813 vssd1 vccd1 vccd1 vssd1 SS_sky130_fd_sc_hd__fill_4
XFILLER_88_749 vssd1 vccd1 vccd1 vssd1 SS_sky130_fd_sc_hd__fill_4
XFILLER_125_39 vssd1 vccd1 vssd1 vccd1 SS_sky130_ef_sc_hd__decap_40_12
XFILLER_87_237 vssd1 vccd1 vssd1 vccd1 SS_sky130_ef_sc_hd__decap_40_12
X_1428_ vccd1 vssd1 vccd1 vssd1 _1428_/X _1904_/A _1466_/B SS_sky130_fd_sc_hd__or2_2
XFILLER_18_26 vssd1 vccd1 vccd1 vssd1 SS_sky130_fd_sc_hd__fill_2
XFILLER_68_473 vssd1 vccd1 vccd1 vssd1 SS_sky130_fd_sc_hd__fill_2
XFILLER_56_657 vssd1 vccd1 vssd1 vccd1 SS_sky130_ef_sc_hd__decap_40_12
X_1359_ vssd1 vccd1 vccd1 vssd1 _1369_/A2 wire496/X _1706_/D _1425_/C1 _1358_/X SS_sky130_fd_sc_hd__o211a_2
XFILLER_83_421 vssd1 vccd1 vccd1 vssd1 SS_sky130_fd_sc_hd__fill_2
XFILLER_83_432 vssd1 vccd1 vccd1 vssd1 SS_sky130_fd_sc_hd__fill_2
XFILLER_110_581 vssd1 vccd1 vccd1 vssd1 SS_sky130_fd_sc_hd__fill_4
XFILLER_96_793 vssd1 vccd1 vssd1 vccd1 SS_sky130_ef_sc_hd__decap_40_12
XFILLER_95_281 vssd1 vccd1 vssd1 vccd1 SS_sky130_ef_sc_hd__decap_40_12
XTAP_TAPCELL_ROW_48_1019 vccd1 vssd1 SS_sky130_fd_sc_hd__tapvpwrvgnd_1
XFILLER_55_167 vccd1 vssd1 vccd1 vssd1 SS_sky130_fd_sc_hd__fill_1
XFILLER_71_605 vssd1 vccd1 vccd1 vssd1 SS_sky130_fd_sc_hd__fill_8
XTAP_TAPCELL_ROW_39_888 vccd1 vssd1 SS_sky130_fd_sc_hd__tapvpwrvgnd_1
XFILLER_43_329 vssd1 vccd1 vccd1 vssd1 SS_sky130_fd_sc_hd__fill_4
XTAP_TAPCELL_ROW_19_590 vccd1 vssd1 SS_sky130_fd_sc_hd__tapvpwrvgnd_1
XFILLER_70_137 vssd1 vccd1 vccd1 vssd1 SS_sky130_fd_sc_hd__fill_2
XFILLER_24_587 vccd1 vssd1 vccd1 vssd1 SS_sky130_fd_sc_hd__fill_1
XFILLER_51_373 vssd1 vccd1 vssd1 vccd1 SS_sky130_ef_sc_hd__decap_40_12
XTAP_TAPCELL_ROW_61_1208 vccd1 vssd1 SS_sky130_fd_sc_hd__tapvpwrvgnd_1
XTAP_TAPCELL_ROW_61_1219 vccd1 vssd1 SS_sky130_fd_sc_hd__tapvpwrvgnd_1
XFILLER_11_237 vssd1 vccd1 vssd1 vccd1 SS_sky130_ef_sc_hd__decap_40_12
XFILLER_12_749 vssd1 vccd1 vccd1 vssd1 SS_sky130_fd_sc_hd__fill_4
Xclkload2 vssd1 vccd1 clkload2/A clkload2/X vccd1 vssd1 SS_sky130_fd_sc_hd__clkbuf_4
XFILLER_133_6 vssd1 vccd1 vssd1 vccd1 SS_sky130_ef_sc_hd__decap_40_12
XFILLER_137_445 vssd1 vccd1 vccd1 vssd1 SS_sky130_fd_sc_hd__fill_2
XFILLER_137_434 vccd1 vssd1 vccd1 vssd1 SS_sky130_fd_sc_hd__fill_1
XFILLER_109_125 vssd1 vccd1 vssd1 vccd1 SS_sky130_ef_sc_hd__decap_40_12
XFILLER_137_489 vssd1 vccd1 vccd1 vssd1 SS_sky130_fd_sc_hd__fill_4
XFILLER_125_629 vssd1 vccd1 vssd1 vccd1 SS_sky130_ef_sc_hd__decap_40_12
XFILLER_109_169 vssd1 vccd1 vssd1 vccd1 SS_sky130_ef_sc_hd__decap_40_12
XTAP_TAPCELL_ROW_76_1440 vccd1 vssd1 SS_sky130_fd_sc_hd__tapvpwrvgnd_1
XFILLER_124_139 vccd1 vssd1 vccd1 vssd1 SS_sky130_fd_sc_hd__fill_1
XFILLER_105_320 vssd1 vccd1 vccd1 vssd1 SS_sky130_fd_sc_hd__fill_4
XFILLER_3_447 vccd1 vssd1 vccd1 vssd1 SS_sky130_fd_sc_hd__fill_1
XFILLER_59_55 vccd1 vssd1 vccd1 vssd1 SS_sky130_fd_sc_hd__fill_1
XFILLER_79_727 vccd1 vssd1 vccd1 vssd1 SS_sky130_fd_sc_hd__fill_1
Xfanout250 vssd1 vccd1 vccd1 vssd1 _1012_/X _1050_/B SS_sky130_fd_sc_hd__clkdlybuf4s25_1
XFILLER_59_473 vssd1 vccd1 vccd1 vssd1 SS_sky130_fd_sc_hd__fill_8
XFILLER_19_337 vssd1 vccd1 vssd1 vccd1 SS_sky130_ef_sc_hd__decap_40_12
XFILLER_74_421 vssd1 vccd1 vssd1 vccd1 SS_sky130_ef_sc_hd__decap_40_12
XFILLER_34_307 vccd1 vssd1 vccd1 vssd1 SS_sky130_fd_sc_hd__fill_1
XFILLER_46_189 vssd1 vccd1 vccd1 vssd1 SS_sky130_fd_sc_hd__fill_4
XTAP_TAPCELL_ROW_17_549 vccd1 vssd1 SS_sky130_fd_sc_hd__tapvpwrvgnd_1
XFILLER_43_841 vccd1 vssd1 vccd1 vssd1 SS_sky130_fd_sc_hd__fill_1
XFILLER_61_137 vssd1 vccd1 vssd1 vccd1 SS_sky130_ef_sc_hd__decap_40_12
XFILLER_91_42 vssd1 vccd1 vssd1 vccd1 SS_sky130_ef_sc_hd__decap_40_12
XFILLER_131_93 vssd1 vccd1 vssd1 vccd1 SS_sky130_ef_sc_hd__decap_40_12
XFILLER_30_513 vssd1 vccd1 vssd1 vccd1 SS_sky130_ef_sc_hd__decap_40_12
XFILLER_30_557 vssd1 vccd1 vssd1 vccd1 SS_sky130_ef_sc_hd__decap_40_12
XFILLER_128_445 vssd1 vccd1 vssd1 vccd1 SS_sky130_ef_sc_hd__decap_40_12
XFILLER_7_753 vssd1 vccd1 vssd1 vccd1 SS_sky130_ef_sc_hd__decap_40_12
XFILLER_128_489 vssd1 vccd1 vccd1 vssd1 SS_sky130_fd_sc_hd__fill_2
Xhold709 _1760_/D _1469_/X vccd1 vssd1 vssd1 vccd1 SS_sky130_fd_sc_hd__dlygate4sd3_1
XFILLER_7_797 vssd1 vccd1 vssd1 vccd1 SS_sky130_ef_sc_hd__decap_40_12
Xmax_cap439 vccd1 vssd1 _0927_/A2 _1145_/A vccd1 vssd1 SS_sky130_fd_sc_hd__buf_6
XFILLER_130_109 vssd1 vccd1 vssd1 vccd1 SS_sky130_ef_sc_hd__decap_40_12
XFILLER_123_161 vssd1 vccd1 vccd1 vssd1 SS_sky130_fd_sc_hd__fill_4
XFILLER_112_813 vssd1 vccd1 vccd1 vssd1 SS_sky130_fd_sc_hd__fill_8
XFILLER_69_237 vssd1 vccd1 vssd1 vccd1 SS_sky130_ef_sc_hd__decap_40_12
XFILLER_27_3 vssd1 vccd1 vssd1 vccd1 SS_sky130_ef_sc_hd__decap_40_12
X_1213_ vssd1 vccd1 vccd1 vssd1 _1267_/A2 input20/X _1635_/D _1417_/C1 _1212_/X SS_sky130_fd_sc_hd__o211a_2
XFILLER_77_281 vssd1 vccd1 vssd1 vccd1 SS_sky130_ef_sc_hd__decap_40_12
XFILLER_78_793 vssd1 vccd1 vccd1 vssd1 SS_sky130_fd_sc_hd__fill_8
XFILLER_38_657 vssd1 vccd1 vssd1 vccd1 SS_sky130_ef_sc_hd__decap_40_12
XFILLER_53_605 vssd1 vccd1 vccd1 vssd1 SS_sky130_fd_sc_hd__fill_2
X_1144_ vccd1 vssd1 _1145_/A _1144_/X _1409_/B vccd1 vssd1 SS_sky130_fd_sc_hd__and2_2
XFILLER_92_251 vccd1 vssd1 vccd1 vssd1 SS_sky130_fd_sc_hd__fill_1
XFILLER_25_329 vssd1 vccd1 vccd1 vssd1 SS_sky130_fd_sc_hd__fill_4
XTAP_TAPCELL_ROW_36_836 vccd1 vssd1 SS_sky130_fd_sc_hd__tapvpwrvgnd_1
XFILLER_37_167 vccd1 vssd1 vccd1 vssd1 SS_sky130_fd_sc_hd__fill_1
X_1075_ vssd1 vccd1 vccd1 vssd1 _1077_/A2 input43/X _1569_/D _1401_/C1 _1074_/X SS_sky130_fd_sc_hd__o211a_2
XFILLER_93_785 vssd1 vccd1 vssd1 vccd1 SS_sky130_ef_sc_hd__decap_40_12
XTAP_TAPCELL_ROW_36_847 vccd1 vssd1 SS_sky130_fd_sc_hd__tapvpwrvgnd_1
XFILLER_52_137 vssd1 vccd1 vccd1 vssd1 SS_sky130_fd_sc_hd__fill_2
XFILLER_33_373 vssd1 vccd1 vssd1 vccd1 SS_sky130_ef_sc_hd__decap_40_12
XFILLER_61_660 vssd1 vccd1 vssd1 vccd1 SS_sky130_ef_sc_hd__decap_40_12
XPHY_EDGE_ROW_80_Left_219 vccd1 vssd1 vccd1 vssd1 SS_sky130_fd_sc_hd__decap_3
XTAP_TAPCELL_ROW_101_1809 vccd1 vssd1 SS_sky130_fd_sc_hd__tapvpwrvgnd_1
XFILLER_21_557 vssd1 vccd1 vccd1 vssd1 SS_sky130_fd_sc_hd__fill_2
XTAP_TAPCELL_ROW_134_2308 vccd1 vssd1 SS_sky130_fd_sc_hd__tapvpwrvgnd_1
X_0928_ vccd1 vssd1 vccd1 vssd1 _1760_/Q wire435/X _1728_/Q wire455/X _0928_/X SS_sky130_fd_sc_hd__a22o_2
XFILLER_107_629 vssd1 vccd1 vssd1 vccd1 SS_sky130_ef_sc_hd__decap_40_12
XFILLER_20_27 vccd1 vssd1 vccd1 vssd1 SS_sky130_fd_sc_hd__fill_1
X_0859_ vssd1 vccd1 vssd1 vccd1 _0874_/A2 _1748_/Q wire347/X _0857_/X _0859_/X _0858_/X
+ SS_sky130_fd_sc_hd__a2111o_2
XFILLER_106_139 vccd1 vssd1 vccd1 vssd1 SS_sky130_fd_sc_hd__fill_1
XTAP_TAPCELL_ROW_58_1170 vccd1 vssd1 SS_sky130_fd_sc_hd__tapvpwrvgnd_1
XFILLER_136_38 vccd1 vssd1 vccd1 vssd1 SS_sky130_fd_sc_hd__fill_1
XFILLER_0_417 vssd1 vccd1 vccd1 vssd1 SS_sky130_fd_sc_hd__fill_2
XFILLER_121_109 vssd1 vccd1 vccd1 vssd1 SS_sky130_fd_sc_hd__fill_2
XFILLER_115_684 vssd1 vccd1 vccd1 vssd1 SS_sky130_fd_sc_hd__fill_4
XFILLER_115_673 vssd1 vccd1 vccd1 vssd1 SS_sky130_fd_sc_hd__fill_4
XFILLER_102_301 vssd1 vccd1 vccd1 vssd1 SS_sky130_fd_sc_hd__fill_4
XFILLER_88_557 vssd1 vccd1 vssd1 vccd1 SS_sky130_ef_sc_hd__decap_40_12
XFILLER_130_643 vccd1 vssd1 vccd1 vssd1 SS_sky130_fd_sc_hd__fill_1
XFILLER_102_345 vssd1 vccd1 vssd1 vccd1 SS_sky130_ef_sc_hd__decap_40_12
XFILLER_29_69 vssd1 vccd1 vssd1 vccd1 SS_sky130_ef_sc_hd__decap_40_12
XFILLER_29_613 vssd1 vccd1 vccd1 vssd1 SS_sky130_fd_sc_hd__fill_2
XTAP_TAPCELL_ROW_71_1370 vccd1 vssd1 SS_sky130_fd_sc_hd__tapvpwrvgnd_1
XFILLER_56_421 vssd1 vccd1 vssd1 vccd1 SS_sky130_ef_sc_hd__decap_40_12
XFILLER_16_307 vccd1 vssd1 vccd1 vssd1 SS_sky130_fd_sc_hd__fill_1
XFILLER_28_189 vssd1 vccd1 vccd1 vssd1 SS_sky130_fd_sc_hd__fill_4
XFILLER_71_413 vssd1 vccd1 vccd1 vssd1 SS_sky130_fd_sc_hd__fill_8
XFILLER_83_273 vssd1 vccd1 vccd1 vssd1 SS_sky130_fd_sc_hd__fill_4
XFILLER_84_785 vssd1 vccd1 vccd1 vssd1 SS_sky130_fd_sc_hd__fill_2
XFILLER_84_796 vssd1 vccd1 vssd1 vccd1 SS_sky130_ef_sc_hd__decap_40_12
XFILLER_25_841 vccd1 vssd1 vccd1 vssd1 SS_sky130_fd_sc_hd__fill_1
XFILLER_43_137 vssd1 vccd1 vssd1 vccd1 SS_sky130_ef_sc_hd__decap_40_12
XFILLER_45_57 vssd1 vccd1 vssd1 vccd1 SS_sky130_ef_sc_hd__decap_40_12
XFILLER_71_457 vssd1 vccd1 vssd1 vccd1 SS_sky130_ef_sc_hd__decap_40_12
XPHY_EDGE_ROW_119_Left_258 vccd1 vssd1 vccd1 vssd1 SS_sky130_fd_sc_hd__decap_3
XTAP_TAPCELL_ROW_14_508 vccd1 vssd1 SS_sky130_fd_sc_hd__tapvpwrvgnd_1
XFILLER_52_671 vccd1 vssd1 vccd1 vssd1 SS_sky130_fd_sc_hd__fill_1
XFILLER_101_30 vssd1 vccd1 vssd1 vccd1 SS_sky130_ef_sc_hd__decap_40_12
XFILLER_12_513 vssd1 vccd1 vssd1 vccd1 SS_sky130_ef_sc_hd__decap_40_12
XFILLER_51_181 vssd1 vccd1 vssd1 vccd1 SS_sky130_ef_sc_hd__decap_40_12
XFILLER_12_557 vssd1 vccd1 vssd1 vccd1 SS_sky130_ef_sc_hd__decap_40_12
XFILLER_137_231 vccd1 vssd1 vccd1 vssd1 SS_sky130_fd_sc_hd__fill_1
XFILLER_4_701 vssd1 vccd1 vssd1 vccd1 SS_sky130_ef_sc_hd__decap_40_12
XFILLER_6_18 vssd1 vccd1 vccd1 vssd1 SS_sky130_fd_sc_hd__fill_8
XFILLER_6_29 vssd1 vccd1 vssd1 vccd1 SS_sky130_ef_sc_hd__decap_40_12
XPHY_EDGE_ROW_128_Left_267 vccd1 vssd1 vccd1 vssd1 SS_sky130_fd_sc_hd__decap_3
XFILLER_137_297 vssd1 vccd1 vccd1 vssd1 SS_sky130_fd_sc_hd__fill_8
XFILLER_137_286 vssd1 vccd1 vccd1 vssd1 SS_sky130_fd_sc_hd__fill_4
XFILLER_3_277 vssd1 vccd1 vccd1 vssd1 SS_sky130_fd_sc_hd__fill_2
XFILLER_133_470 vssd1 vccd1 vccd1 vssd1 SS_sky130_fd_sc_hd__fill_8
XFILLER_112_109 vssd1 vccd1 vssd1 vccd1 SS_sky130_ef_sc_hd__decap_40_12
XFILLER_105_161 vssd1 vccd1 vccd1 vssd1 SS_sky130_fd_sc_hd__fill_4
XFILLER_86_53 vssd1 vccd1 vssd1 vccd1 SS_sky130_ef_sc_hd__decap_40_12
XFILLER_120_153 vssd1 vccd1 vssd1 vccd1 SS_sky130_ef_sc_hd__decap_40_12
XFILLER_59_281 vssd1 vccd1 vssd1 vccd1 SS_sky130_ef_sc_hd__decap_40_12
XFILLER_86_97 vssd1 vccd1 vssd1 vccd1 SS_sky130_ef_sc_hd__decap_40_12
XTAP_TAPCELL_ROW_89_1631 vccd1 vssd1 SS_sky130_fd_sc_hd__tapvpwrvgnd_1
XFILLER_120_197 vssd1 vccd1 vssd1 vccd1 SS_sky130_ef_sc_hd__decap_40_12
XFILLER_47_443 vssd1 vccd1 vccd1 vssd1 SS_sky130_fd_sc_hd__fill_4
XTAP_TAPCELL_ROW_89_1642 vccd1 vssd1 SS_sky130_fd_sc_hd__tapvpwrvgnd_1
XFILLER_19_167 vccd1 vssd1 vccd1 vssd1 SS_sky130_fd_sc_hd__fill_1
XFILLER_74_251 vccd1 vssd1 vccd1 vssd1 SS_sky130_fd_sc_hd__fill_1
XFILLER_75_785 vssd1 vccd1 vssd1 vccd1 SS_sky130_ef_sc_hd__decap_40_12
XPHY_EDGE_ROW_137_Left_276 vccd1 vssd1 vccd1 vssd1 SS_sky130_fd_sc_hd__decap_3
XFILLER_34_137 vssd1 vccd1 vccd1 vssd1 SS_sky130_fd_sc_hd__fill_2
XFILLER_90_755 vccd1 vssd1 vccd1 vssd1 SS_sky130_fd_sc_hd__fill_1
XFILLER_43_671 vccd1 vssd1 vccd1 vssd1 SS_sky130_fd_sc_hd__fill_1
XFILLER_15_373 vssd1 vccd1 vssd1 vccd1 SS_sky130_ef_sc_hd__decap_40_12
XFILLER_30_321 vssd1 vccd1 vssd1 vccd1 SS_sky130_ef_sc_hd__decap_40_12
X_1900_ vccd1 vssd1 _1900_/X _1900_/A vccd1 vssd1 SS_sky130_fd_sc_hd__buf_2
XFILLER_96_6 vssd1 vccd1 vssd1 vccd1 SS_sky130_ef_sc_hd__decap_40_12
X_1831_ vccd1 vssd1 _1831_/X _1831_/A vccd1 vssd1 SS_sky130_fd_sc_hd__buf_2
XFILLER_30_365 vssd1 vccd1 vssd1 vccd1 SS_sky130_ef_sc_hd__decap_40_12
XFILLER_128_253 vssd1 vccd1 vssd1 vccd1 SS_sky130_ef_sc_hd__decap_40_12
XFILLER_129_765 vssd1 vccd1 vssd1 vccd1 SS_sky130_ef_sc_hd__decap_40_12
X_1762_ _1762_/Q _1762_/CLK _1762_/D vccd1 vssd1 vccd1 vssd1 SS_sky130_fd_sc_hd__dfxtp_2
XTAP_TAPCELL_ROW_116_2038 vccd1 vssd1 SS_sky130_fd_sc_hd__tapvpwrvgnd_1
XFILLER_7_561 vssd1 vccd1 vssd1 vccd1 SS_sky130_ef_sc_hd__decap_40_12
XFILLER_128_297 vssd1 vccd1 vccd1 vssd1 SS_sky130_fd_sc_hd__fill_2
X_1693_ _1693_/Q _1758_/CLK _1693_/D vccd1 vssd1 vccd1 vssd1 SS_sky130_fd_sc_hd__dfxtp_2
XFILLER_103_109 vssd1 vccd1 vccd1 vssd1 SS_sky130_fd_sc_hd__fill_2
XFILLER_98_811 vccd1 vssd1 vccd1 vssd1 SS_sky130_fd_sc_hd__fill_1
XFILLER_112_621 vccd1 vssd1 vccd1 vssd1 SS_sky130_fd_sc_hd__fill_1
Xload_slew464 vccd1 vssd1 _1447_/C1 _1295_/C1 vccd1 vssd1 SS_sky130_fd_sc_hd__buf_6
XFILLER_85_505 vssd1 vccd1 vssd1 vccd1 SS_sky130_ef_sc_hd__decap_40_12
XTAP_TAPCELL_ROW_111_1971 vccd1 vssd1 SS_sky130_fd_sc_hd__tapvpwrvgnd_1
XTAP_TAPCELL_ROW_111_1960 vccd1 vssd1 SS_sky130_fd_sc_hd__tapvpwrvgnd_1
XFILLER_38_421 vssd1 vccd1 vssd1 vccd1 SS_sky130_ef_sc_hd__decap_40_12
Xload_slew475 vccd1 vssd1 _1417_/C1 _1219_/C1 vccd1 vssd1 SS_sky130_fd_sc_hd__buf_4
XFILLER_38_465 vssd1 vccd1 vccd1 vssd1 SS_sky130_fd_sc_hd__fill_2
XFILLER_122_29 vssd1 vccd1 vssd1 vccd1 SS_sky130_ef_sc_hd__decap_40_12
XFILLER_65_273 vssd1 vccd1 vccd1 vssd1 SS_sky130_fd_sc_hd__fill_4
X_1127_ vssd1 vccd1 vccd1 vssd1 wire241/A input35/X _1594_/D _1327_/C1 _1126_/X SS_sky130_fd_sc_hd__o211a_2
XFILLER_25_137 vssd1 vccd1 vssd1 vccd1 SS_sky130_ef_sc_hd__decap_40_12
XFILLER_80_221 vssd1 vccd1 vssd1 vccd1 SS_sky130_ef_sc_hd__decap_40_12
XFILLER_15_27 vssd1 vccd1 vssd1 vccd1 SS_sky130_ef_sc_hd__decap_40_12
XFILLER_80_265 vssd1 vccd1 vssd1 vccd1 SS_sky130_ef_sc_hd__decap_40_12
X_1058_ vccd1 vssd1 vccd1 vssd1 _1058_/X _1058_/A _1076_/B SS_sky130_fd_sc_hd__or2_2
XFILLER_33_181 vssd1 vccd1 vssd1 vccd1 SS_sky130_ef_sc_hd__decap_40_12
XFILLER_34_693 vssd1 vccd1 vccd1 vssd1 SS_sky130_fd_sc_hd__fill_4
XFILLER_61_490 vssd1 vccd1 vssd1 vccd1 SS_sky130_ef_sc_hd__decap_40_12
XPHY_EDGE_ROW_1_Right_1 vccd1 vssd1 vccd1 vssd1 SS_sky130_fd_sc_hd__decap_3
XFILLER_134_245 vssd1 vccd1 vccd1 vssd1 SS_sky130_fd_sc_hd__fill_4
XFILLER_134_289 vssd1 vccd1 vssd1 vccd1 SS_sky130_ef_sc_hd__decap_40_12
Xoutput59 vccd1 vssd1 wire301/A _1895_/X vccd1 vssd1 SS_sky130_fd_sc_hd__buf_4
XFILLER_88_365 vssd1 vccd1 vssd1 vccd1 SS_sky130_ef_sc_hd__decap_40_12
XFILLER_102_153 vssd1 vccd1 vssd1 vccd1 SS_sky130_ef_sc_hd__decap_40_12
XFILLER_130_473 vssd1 vccd1 vccd1 vssd1 SS_sky130_fd_sc_hd__fill_2
XFILLER_102_197 vssd1 vccd1 vssd1 vccd1 SS_sky130_ef_sc_hd__decap_40_12
XFILLER_44_413 vssd1 vccd1 vccd1 vssd1 SS_sky130_fd_sc_hd__fill_4
XFILLER_56_251 vccd1 vssd1 vccd1 vssd1 SS_sky130_fd_sc_hd__fill_1
XFILLER_57_785 vssd1 vccd1 vccd1 vssd1 SS_sky130_fd_sc_hd__fill_2
XFILLER_16_137 vssd1 vccd1 vccd1 vssd1 SS_sky130_fd_sc_hd__fill_2
XFILLER_71_221 vssd1 vccd1 vccd1 vssd1 SS_sky130_fd_sc_hd__fill_2
XFILLER_72_744 vssd1 vccd1 vssd1 vccd1 SS_sky130_ef_sc_hd__decap_40_12
XTAP_TAPCELL_ROW_84_1561 vccd1 vssd1 SS_sky130_fd_sc_hd__tapvpwrvgnd_1
XFILLER_12_321 vssd1 vccd1 vssd1 vccd1 SS_sky130_ef_sc_hd__decap_40_12
XTAP_TAPCELL_ROW_27_699 vccd1 vssd1 SS_sky130_fd_sc_hd__tapvpwrvgnd_1
XFILLER_72_77 vssd1 vccd1 vccd1 vssd1 SS_sky130_fd_sc_hd__fill_4
XFILLER_12_365 vssd1 vccd1 vssd1 vccd1 SS_sky130_ef_sc_hd__decap_40_12
XFILLER_4_531 vccd1 vssd1 vccd1 vssd1 SS_sky130_fd_sc_hd__fill_1
XFILLER_21_81 vssd1 vccd1 vssd1 vccd1 SS_sky130_ef_sc_hd__decap_40_12
XFILLER_126_757 vssd1 vccd1 vccd1 vssd1 SS_sky130_fd_sc_hd__fill_8
XFILLER_125_223 vccd1 vssd1 vccd1 vssd1 SS_sky130_fd_sc_hd__fill_1
XFILLER_125_289 vssd1 vccd1 vccd1 vssd1 SS_sky130_fd_sc_hd__fill_2
XFILLER_113_429 vssd1 vccd1 vssd1 vccd1 SS_sky130_ef_sc_hd__decap_40_12
XFILLER_79_321 vccd1 vssd1 vccd1 vssd1 SS_sky130_fd_sc_hd__fill_1
XFILLER_67_505 vssd1 vccd1 vssd1 vccd1 SS_sky130_ef_sc_hd__decap_40_12
XFILLER_79_365 vssd1 vccd1 vccd1 vssd1 SS_sky130_fd_sc_hd__fill_2
XFILLER_0_781 vssd1 vccd1 vccd1 vssd1 SS_sky130_fd_sc_hd__fill_2
XFILLER_121_473 vssd1 vccd1 vssd1 vccd1 SS_sky130_ef_sc_hd__decap_40_12
XFILLER_11_6 vssd1 vccd1 vssd1 vccd1 SS_sky130_ef_sc_hd__decap_40_12
XFILLER_47_273 vssd1 vccd1 vccd1 vssd1 SS_sky130_fd_sc_hd__fill_4
XFILLER_82_519 vssd1 vccd1 vccd1 vssd1 SS_sky130_fd_sc_hd__fill_4
XFILLER_62_221 vssd1 vccd1 vssd1 vccd1 SS_sky130_ef_sc_hd__decap_40_12
XTAP_TAPCELL_ROW_46_986 vccd1 vssd1 SS_sky130_fd_sc_hd__tapvpwrvgnd_1
XFILLER_50_405 vssd1 vccd1 vccd1 vssd1 SS_sky130_fd_sc_hd__fill_2
XFILLER_62_265 vssd1 vccd1 vssd1 vccd1 SS_sky130_ef_sc_hd__decap_40_12
XTAP_TAPCELL_ROW_46_997 vccd1 vssd1 SS_sky130_fd_sc_hd__tapvpwrvgnd_1
XFILLER_90_585 vssd1 vccd1 vccd1 vssd1 SS_sky130_fd_sc_hd__fill_2
XFILLER_15_181 vssd1 vccd1 vssd1 vccd1 SS_sky130_ef_sc_hd__decap_40_12
XFILLER_31_641 vssd1 vccd1 vssd1 vccd1 SS_sky130_ef_sc_hd__decap_40_12
XFILLER_31_663 vccd1 vssd1 vccd1 vssd1 SS_sky130_fd_sc_hd__fill_1
XFILLER_94_3 vssd1 vccd1 vssd1 vccd1 SS_sky130_ef_sc_hd__decap_40_12
XFILLER_30_195 vccd1 vssd1 vccd1 vssd1 SS_sky130_fd_sc_hd__fill_1
XFILLER_129_551 vccd1 vssd1 vccd1 vssd1 SS_sky130_fd_sc_hd__fill_1
X_1745_ _1909_/A _1745_/CLK _1745_/D vccd1 vssd1 vccd1 vssd1 SS_sky130_fd_sc_hd__dfxtp_2
XFILLER_7_391 vccd1 vssd1 vccd1 vssd1 SS_sky130_fd_sc_hd__fill_1
XFILLER_116_245 vssd1 vccd1 vccd1 vssd1 SS_sky130_fd_sc_hd__fill_4
X_1676_ _1676_/Q clkload6/A _1676_/D vccd1 vssd1 vccd1 vssd1 SS_sky130_fd_sc_hd__dfxtp_2
XFILLER_116_289 vssd1 vccd1 vssd1 vccd1 SS_sky130_ef_sc_hd__decap_40_12
XFILLER_131_237 vssd1 vccd1 vssd1 vccd1 SS_sky130_ef_sc_hd__decap_40_12
XFILLER_98_641 vssd1 vccd1 vccd1 vssd1 SS_sky130_fd_sc_hd__fill_2
XTAP_TAPCELL_ROW_129_2229 vccd1 vssd1 SS_sky130_fd_sc_hd__tapvpwrvgnd_1
XTAP_TAPCELL_ROW_51_1059 vccd1 vssd1 SS_sky130_fd_sc_hd__tapvpwrvgnd_1
XFILLER_85_335 vccd1 vssd1 vccd1 vssd1 SS_sky130_fd_sc_hd__fill_1
XFILLER_112_473 vssd1 vccd1 vccd1 vssd1 SS_sky130_fd_sc_hd__fill_2
XFILLER_100_613 vssd1 vccd1 vssd1 vccd1 SS_sky130_ef_sc_hd__decap_40_12
XFILLER_39_741 vssd1 vccd1 vssd1 vccd1 SS_sky130_ef_sc_hd__decap_40_12
XFILLER_100_657 vssd1 vccd1 vccd1 vssd1 SS_sky130_fd_sc_hd__fill_4
XFILLER_26_413 vssd1 vccd1 vccd1 vssd1 SS_sky130_fd_sc_hd__fill_4
XFILLER_38_251 vccd1 vssd1 vccd1 vssd1 SS_sky130_fd_sc_hd__fill_1
XFILLER_39_785 vssd1 vccd1 vccd1 vssd1 SS_sky130_fd_sc_hd__fill_4
XFILLER_26_26 vssd1 vccd1 vccd1 vssd1 SS_sky130_fd_sc_hd__fill_2
XFILLER_53_221 vssd1 vccd1 vccd1 vssd1 SS_sky130_fd_sc_hd__fill_2
XFILLER_54_755 vccd1 vssd1 vccd1 vssd1 SS_sky130_fd_sc_hd__fill_1
XFILLER_81_541 vssd1 vccd1 vssd1 vccd1 SS_sky130_ef_sc_hd__decap_40_12
XFILLER_93_390 vssd1 vccd1 vccd1 vssd1 SS_sky130_fd_sc_hd__fill_2
XFILLER_26_457 vssd1 vccd1 vssd1 vccd1 SS_sky130_ef_sc_hd__decap_40_12
XFILLER_41_405 vssd1 vccd1 vssd1 vccd1 SS_sky130_ef_sc_hd__decap_40_12
XFILLER_41_449 vssd1 vccd1 vssd1 vccd1 SS_sky130_ef_sc_hd__decap_40_12
XTAP_TAPCELL_ROW_24_658 vccd1 vssd1 SS_sky130_fd_sc_hd__tapvpwrvgnd_1
XTAP_TAPCELL_ROW_66_1291 vccd1 vssd1 SS_sky130_fd_sc_hd__tapvpwrvgnd_1
XFILLER_5_317 vssd1 vccd1 vssd1 vccd1 SS_sky130_ef_sc_hd__decap_40_12
XFILLER_108_757 vssd1 vccd1 vssd1 vccd1 SS_sky130_ef_sc_hd__decap_40_12
XFILLER_107_223 vccd1 vssd1 vccd1 vssd1 SS_sky130_fd_sc_hd__fill_1
XFILLER_1_501 vssd1 vccd1 vccd1 vssd1 SS_sky130_fd_sc_hd__fill_2
XFILLER_135_598 vccd1 vssd1 vccd1 vssd1 SS_sky130_fd_sc_hd__fill_1
XFILLER_123_716 vssd1 vccd1 vssd1 vccd1 SS_sky130_ef_sc_hd__decap_40_12
XFILLER_123_705 vssd1 vccd1 vccd1 vssd1 SS_sky130_fd_sc_hd__fill_2
XFILLER_89_641 vssd1 vccd1 vccd1 vssd1 SS_sky130_fd_sc_hd__fill_4
XFILLER_49_505 vssd1 vccd1 vssd1 vccd1 SS_sky130_ef_sc_hd__decap_40_12
XFILLER_107_51 vssd1 vccd1 vccd1 vssd1 SS_sky130_fd_sc_hd__fill_4
XFILLER_67_55 vccd1 vssd1 vccd1 vssd1 SS_sky130_fd_sc_hd__fill_1
XFILLER_89_685 vssd1 vccd1 vssd1 vccd1 SS_sky130_ef_sc_hd__decap_40_12
XFILLER_103_473 vssd1 vccd1 vssd1 vccd1 SS_sky130_ef_sc_hd__decap_40_12
XFILLER_76_357 vssd1 vccd1 vccd1 vssd1 SS_sky130_fd_sc_hd__fill_4
XFILLER_88_195 vccd1 vssd1 vccd1 vssd1 SS_sky130_fd_sc_hd__fill_1
XTAP_TAPCELL_ROW_4_361 vccd1 vssd1 SS_sky130_fd_sc_hd__tapvpwrvgnd_1
XFILLER_29_273 vssd1 vccd1 vccd1 vssd1 SS_sky130_fd_sc_hd__fill_4
XFILLER_91_305 vssd1 vccd1 vssd1 vccd1 SS_sky130_ef_sc_hd__decap_40_12
XFILLER_44_221 vssd1 vccd1 vssd1 vccd1 SS_sky130_ef_sc_hd__decap_40_12
XFILLER_91_349 vssd1 vccd1 vssd1 vccd1 SS_sky130_ef_sc_hd__decap_40_12
XFILLER_44_265 vssd1 vccd1 vssd1 vccd1 SS_sky130_ef_sc_hd__decap_40_12
XFILLER_45_777 vssd1 vccd1 vccd1 vssd1 SS_sky130_fd_sc_hd__fill_4
XFILLER_60_703 vccd1 vssd1 vccd1 vssd1 SS_sky130_fd_sc_hd__fill_1
XFILLER_83_54 vssd1 vccd1 vccd1 vssd1 SS_sky130_fd_sc_hd__fill_2
XTAP_TAPCELL_ROW_43_945 vccd1 vssd1 SS_sky130_fd_sc_hd__tapvpwrvgnd_1
XFILLER_13_641 vssd1 vccd1 vssd1 vccd1 SS_sky130_ef_sc_hd__decap_40_12
XFILLER_16_81 vssd1 vccd1 vccd1 vssd1 SS_sky130_fd_sc_hd__fill_2
XFILLER_13_685 vssd1 vccd1 vssd1 vccd1 SS_sky130_ef_sc_hd__decap_40_12
XFILLER_8_133 vssd1 vccd1 vccd1 vssd1 SS_sky130_fd_sc_hd__fill_4
XFILLER_12_195 vccd1 vssd1 vccd1 vssd1 SS_sky130_fd_sc_hd__fill_1
XFILLER_8_177 vssd1 vccd1 vssd1 vccd1 SS_sky130_ef_sc_hd__decap_40_12
XTAP_TAPCELL_ROW_97_1752 vccd1 vssd1 SS_sky130_fd_sc_hd__tapvpwrvgnd_1
XFILLER_4_361 vssd1 vccd1 vccd1 vssd1 SS_sky130_fd_sc_hd__fill_2
X_1530_ _1530_/Q _1754_/CLK _1530_/D vccd1 vssd1 vccd1 vssd1 SS_sky130_fd_sc_hd__dfxtp_2
XFILLER_126_587 vccd1 vssd1 vccd1 vssd1 SS_sky130_fd_sc_hd__fill_1
XFILLER_126_565 vssd1 vccd1 vssd1 vccd1 SS_sky130_ef_sc_hd__decap_40_12
XFILLER_99_405 vssd1 vccd1 vssd1 vccd1 SS_sky130_ef_sc_hd__decap_40_12
X_1461_ vssd1 vccd1 vccd1 vssd1 wire207/A input37/X _1756_/D _1461_/C1 _1460_/X SS_sky130_fd_sc_hd__o211a_2
XFILLER_113_237 vssd1 vccd1 vssd1 vccd1 SS_sky130_ef_sc_hd__decap_40_12
XFILLER_99_449 vssd1 vccd1 vssd1 vccd1 SS_sky130_ef_sc_hd__decap_40_12
X_1392_ vccd1 vssd1 vccd1 vssd1 _1392_/X _1392_/A _1396_/B SS_sky130_fd_sc_hd__or2_2
XFILLER_122_793 vssd1 vccd1 vccd1 vssd1 SS_sky130_fd_sc_hd__fill_8
XFILLER_67_335 vccd1 vssd1 vccd1 vssd1 SS_sky130_fd_sc_hd__fill_1
XFILLER_121_281 vssd1 vccd1 vssd1 vccd1 SS_sky130_ef_sc_hd__decap_40_12
XFILLER_94_121 vssd1 vccd1 vssd1 vccd1 SS_sky130_ef_sc_hd__decap_40_12
XFILLER_82_305 vssd1 vccd1 vccd1 vssd1 SS_sky130_fd_sc_hd__fill_2
XFILLER_94_165 vssd1 vccd1 vssd1 vccd1 SS_sky130_ef_sc_hd__decap_40_12
XFILLER_35_221 vssd1 vccd1 vccd1 vssd1 SS_sky130_fd_sc_hd__fill_2
XFILLER_36_755 vccd1 vssd1 vccd1 vssd1 SS_sky130_fd_sc_hd__fill_1
XFILLER_82_349 vssd1 vccd1 vssd1 vccd1 SS_sky130_ef_sc_hd__decap_40_12
XTAP_TAPCELL_ROW_124_2159 vccd1 vssd1 SS_sky130_fd_sc_hd__tapvpwrvgnd_1
XFILLER_23_405 vssd1 vccd1 vssd1 vccd1 SS_sky130_ef_sc_hd__decap_40_12
XFILLER_63_541 vssd1 vccd1 vssd1 vccd1 SS_sky130_ef_sc_hd__decap_40_12
XFILLER_63_585 vssd1 vccd1 vccd1 vssd1 SS_sky130_fd_sc_hd__fill_4
XFILLER_23_449 vssd1 vccd1 vssd1 vccd1 SS_sky130_ef_sc_hd__decap_40_12
XTAP_TAPCELL_ROW_106_1892 vccd1 vssd1 SS_sky130_fd_sc_hd__tapvpwrvgnd_1
XTAP_TAPCELL_ROW_21_617 vccd1 vssd1 SS_sky130_fd_sc_hd__tapvpwrvgnd_1
XFILLER_136_307 vccd1 vssd1 vccd1 vssd1 SS_sky130_fd_sc_hd__fill_1
XFILLER_137_819 vssd1 vccd1 vccd1 vssd1 SS_sky130_fd_sc_hd__fill_4
XFILLER_2_309 vssd1 vccd1 vssd1 vccd1 SS_sky130_ef_sc_hd__decap_40_12
X_1728_ _1728_/Q _1760_/CLK _1728_/D vccd1 vssd1 vccd1 vssd1 SS_sky130_fd_sc_hd__dfxtp_2
XFILLER_105_727 vccd1 vssd1 vccd1 vssd1 SS_sky130_fd_sc_hd__fill_1
X_1659_ _1659_/Q _1756_/CLK _1659_/D vccd1 vssd1 vccd1 vssd1 SS_sky130_fd_sc_hd__dfxtp_2
XFILLER_100_410 vccd1 vssd1 vccd1 vssd1 SS_sky130_fd_sc_hd__fill_1
XFILLER_58_357 vssd1 vccd1 vccd1 vssd1 SS_sky130_fd_sc_hd__fill_4
Xafe_wb_502 analog_ctrl[98] afe_wb_502/HI vccd1 vssd1 vssd1 vccd1 SS_sky130_fd_sc_hd__conb_1
XFILLER_100_421 vssd1 vccd1 vccd1 vssd1 SS_sky130_fd_sc_hd__fill_4
XTAP_TAPCELL_ROW_29_728 vccd1 vssd1 SS_sky130_fd_sc_hd__tapvpwrvgnd_1
XFILLER_73_305 vssd1 vccd1 vssd1 vccd1 SS_sky130_ef_sc_hd__decap_40_12
Xafe_wb_513 analog_io_out[5] afe_wb_513/HI vccd1 vssd1 vssd1 vccd1 SS_sky130_fd_sc_hd__conb_1
XFILLER_85_165 vssd1 vccd1 vccd1 vssd1 SS_sky130_fd_sc_hd__fill_2
XFILLER_86_699 vccd1 vssd1 vccd1 vssd1 SS_sky130_fd_sc_hd__fill_1
Xafe_wb_535 analog_io_out[27] afe_wb_535/HI vccd1 vssd1 vssd1 vccd1 SS_sky130_fd_sc_hd__conb_1
Xafe_wb_524 analog_io_out[16] afe_wb_524/HI vccd1 vssd1 vssd1 vccd1 SS_sky130_fd_sc_hd__conb_1
XFILLER_100_487 vssd1 vccd1 vssd1 vccd1 SS_sky130_ef_sc_hd__decap_40_12
XTAP_TAPCELL_ROW_1_320 vccd1 vssd1 SS_sky130_fd_sc_hd__tapvpwrvgnd_1
Xafe_wb_546 afe_wb_546/LO analog_io_oeb[10] vccd1 vssd1 vssd1 vccd1 SS_sky130_fd_sc_hd__conb_1
XFILLER_26_221 vssd1 vccd1 vssd1 vccd1 SS_sky130_ef_sc_hd__decap_40_12
XTAP_TAPCELL_ROW_29_739 vccd1 vssd1 SS_sky130_fd_sc_hd__tapvpwrvgnd_1
XFILLER_37_69 vssd1 vccd1 vssd1 vccd1 SS_sky130_ef_sc_hd__decap_40_12
Xafe_wb_557 afe_wb_557/LO analog_io_oeb[21] vccd1 vssd1 vssd1 vccd1 SS_sky130_fd_sc_hd__conb_1
XTAP_TAPCELL_ROW_68_1320 vccd1 vssd1 SS_sky130_fd_sc_hd__tapvpwrvgnd_1
XFILLER_73_327 vccd1 vssd1 vccd1 vssd1 SS_sky130_fd_sc_hd__fill_1
XFILLER_26_265 vssd1 vccd1 vssd1 vccd1 SS_sky130_ef_sc_hd__decap_40_12
XFILLER_54_585 vssd1 vccd1 vccd1 vssd1 SS_sky130_fd_sc_hd__fill_2
XFILLER_53_57 vssd1 vccd1 vssd1 vccd1 SS_sky130_ef_sc_hd__decap_40_12
XFILLER_81_393 vssd1 vccd1 vssd1 vccd1 SS_sky130_ef_sc_hd__decap_40_12
XTAP_TAPCELL_ROW_81_1520 vccd1 vssd1 SS_sky130_fd_sc_hd__tapvpwrvgnd_1
XTAP_TAPCELL_ROW_40_904 vccd1 vssd1 SS_sky130_fd_sc_hd__tapvpwrvgnd_1
XFILLER_41_279 vccd1 vssd1 vccd1 vssd1 SS_sky130_fd_sc_hd__fill_1
XFILLER_127_318 vccd1 vssd1 vccd1 vssd1 SS_sky130_fd_sc_hd__fill_1
XFILLER_5_125 vssd1 vccd1 vssd1 vccd1 SS_sky130_ef_sc_hd__decap_40_12
XFILLER_6_637 vssd1 vccd1 vccd1 vssd1 SS_sky130_fd_sc_hd__fill_4
XFILLER_10_699 vccd1 vssd1 vccd1 vssd1 SS_sky130_fd_sc_hd__fill_1
XFILLER_5_169 vssd1 vccd1 vssd1 vccd1 SS_sky130_ef_sc_hd__decap_40_12
XTAP_TAPCELL_ROW_79_1482 vccd1 vssd1 SS_sky130_fd_sc_hd__tapvpwrvgnd_1
XTAP_TAPCELL_ROW_9_431 vccd1 vssd1 SS_sky130_fd_sc_hd__tapvpwrvgnd_1
XTAP_TAPCELL_ROW_9_442 vccd1 vssd1 SS_sky130_fd_sc_hd__tapvpwrvgnd_1
XFILLER_118_83 vccd1 vssd1 vccd1 vssd1 SS_sky130_fd_sc_hd__fill_1
XFILLER_78_65 vssd1 vccd1 vssd1 vccd1 SS_sky130_ef_sc_hd__decap_40_12
XTAP_TAPCELL_ROW_92_1682 vccd1 vssd1 SS_sky130_fd_sc_hd__tapvpwrvgnd_1
XFILLER_49_335 vccd1 vssd1 vccd1 vssd1 SS_sky130_fd_sc_hd__fill_1
XFILLER_76_121 vssd1 vccd1 vssd1 vccd1 SS_sky130_ef_sc_hd__decap_40_12
XFILLER_103_281 vssd1 vccd1 vssd1 vccd1 SS_sky130_ef_sc_hd__decap_40_12
XFILLER_64_305 vssd1 vccd1 vccd1 vssd1 SS_sky130_fd_sc_hd__fill_2
XFILLER_76_165 vssd1 vccd1 vssd1 vccd1 SS_sky130_ef_sc_hd__decap_40_12
XFILLER_134_82 vssd1 vccd1 vccd1 vssd1 SS_sky130_fd_sc_hd__fill_2
XFILLER_94_53 vssd1 vccd1 vssd1 vccd1 SS_sky130_ef_sc_hd__decap_40_12
XFILLER_17_221 vssd1 vccd1 vccd1 vssd1 SS_sky130_fd_sc_hd__fill_2
XFILLER_80_809 vccd1 vssd1 vccd1 vssd1 SS_sky130_fd_sc_hd__fill_1
XFILLER_91_113 vssd1 vccd1 vssd1 vccd1 SS_sky130_ef_sc_hd__decap_40_12
XFILLER_94_97 vssd1 vccd1 vssd1 vccd1 SS_sky130_ef_sc_hd__decap_40_12
XFILLER_92_669 vssd1 vccd1 vccd1 vssd1 SS_sky130_fd_sc_hd__fill_4
XFILLER_60_533 vssd1 vccd1 vccd1 vssd1 SS_sky130_fd_sc_hd__fill_4
XFILLER_60_544 vccd1 vssd1 vccd1 vssd1 SS_sky130_fd_sc_hd__fill_1
XFILLER_20_419 vccd1 vssd1 vccd1 vssd1 SS_sky130_fd_sc_hd__fill_1
X_0961_ vssd1 vccd1 vccd1 vssd1 _0989_/A2 wire497/X _1513_/D _1099_/C1 _0960_/X SS_sky130_fd_sc_hd__o211a_2
XFILLER_60_599 vssd1 vccd1 vssd1 vccd1 SS_sky130_ef_sc_hd__decap_40_12
X_0892_ vccd1 vssd1 vccd1 vssd1 _1530_/Q _0947_/A _1754_/Q _1409_/A _0892_/X SS_sky130_fd_sc_hd__a22o_2
XFILLER_9_497 vssd1 vccd1 vccd1 vssd1 SS_sky130_fd_sc_hd__fill_4
XFILLER_127_841 vccd1 vssd1 vccd1 vssd1 SS_sky130_fd_sc_hd__fill_1
XFILLER_57_3 vssd1 vccd1 vssd1 vccd1 SS_sky130_ef_sc_hd__decap_40_12
X_1513_ _1839_/A _1576_/CLK _1513_/D vccd1 vssd1 vccd1 vssd1 SS_sky130_fd_sc_hd__dfxtp_2
XFILLER_114_513 vssd1 vccd1 vccd1 vssd1 SS_sky130_fd_sc_hd__fill_8
XFILLER_114_579 vccd1 vssd1 vccd1 vssd1 SS_sky130_fd_sc_hd__fill_1
XFILLER_114_557 vssd1 vccd1 vssd1 vccd1 SS_sky130_ef_sc_hd__decap_40_12
X_1444_ vccd1 vssd1 vccd1 vssd1 _1444_/X _1444_/A _1454_/B SS_sky130_fd_sc_hd__or2_2
XFILLER_99_279 vccd1 vssd1 vccd1 vssd1 SS_sky130_fd_sc_hd__fill_1
XFILLER_56_806 vssd1 vccd1 vccd1 vssd1 SS_sky130_fd_sc_hd__fill_4
X_1375_ vssd1 vccd1 vccd1 vssd1 _1391_/A2 input26/X _1714_/D _1459_/C1 _1374_/X SS_sky130_fd_sc_hd__o211a_2
XFILLER_55_305 vssd1 vccd1 vssd1 vccd1 SS_sky130_ef_sc_hd__decap_40_12
XFILLER_67_165 vssd1 vccd1 vccd1 vssd1 SS_sky130_fd_sc_hd__fill_2
XFILLER_68_699 vccd1 vssd1 vccd1 vssd1 SS_sky130_fd_sc_hd__fill_1
XFILLER_95_485 vssd1 vccd1 vssd1 vccd1 SS_sky130_ef_sc_hd__decap_40_12
XFILLER_55_327 vccd1 vssd1 vccd1 vssd1 SS_sky130_fd_sc_hd__fill_1
XTAP_TAPCELL_ROW_108_1921 vccd1 vssd1 SS_sky130_fd_sc_hd__tapvpwrvgnd_1
XFILLER_48_390 vssd1 vccd1 vccd1 vssd1 SS_sky130_fd_sc_hd__fill_2
XFILLER_24_725 vssd1 vccd1 vssd1 vccd1 SS_sky130_ef_sc_hd__decap_40_12
XFILLER_36_574 vssd1 vccd1 vccd1 vssd1 SS_sky130_fd_sc_hd__fill_4
XFILLER_130_29 vssd1 vccd1 vssd1 vccd1 SS_sky130_ef_sc_hd__decap_40_12
XFILLER_24_769 vssd1 vccd1 vssd1 vccd1 SS_sky130_ef_sc_hd__decap_40_12
XFILLER_63_393 vssd1 vccd1 vccd1 vssd1 SS_sky130_fd_sc_hd__fill_4
XFILLER_23_279 vccd1 vssd1 vccd1 vssd1 SS_sky130_fd_sc_hd__fill_1
XTAP_TAPCELL_ROW_63_1250 vccd1 vssd1 SS_sky130_fd_sc_hd__tapvpwrvgnd_1
XFILLER_109_329 vssd1 vccd1 vccd1 vssd1 SS_sky130_fd_sc_hd__fill_4
XFILLER_136_137 vssd1 vccd1 vccd1 vssd1 SS_sky130_fd_sc_hd__fill_2
XFILLER_3_629 vssd1 vccd1 vssd1 vccd1 SS_sky130_ef_sc_hd__decap_40_12
XFILLER_117_373 vssd1 vccd1 vccd1 vssd1 SS_sky130_fd_sc_hd__fill_8
XFILLER_105_524 vssd1 vccd1 vccd1 vssd1 SS_sky130_fd_sc_hd__fill_2
XFILLER_105_513 vssd1 vccd1 vccd1 vssd1 SS_sky130_fd_sc_hd__fill_2
XFILLER_2_139 vccd1 vssd1 vccd1 vssd1 SS_sky130_fd_sc_hd__fill_1
XFILLER_132_354 vssd1 vccd1 vccd1 vssd1 SS_sky130_fd_sc_hd__fill_8
XFILLER_59_600 vssd1 vccd1 vssd1 vccd1 SS_sky130_ef_sc_hd__decap_40_12
XFILLER_78_419 vccd1 vssd1 vccd1 vssd1 SS_sky130_fd_sc_hd__fill_1
XFILLER_132_365 vssd1 vccd1 vccd1 vssd1 SS_sky130_fd_sc_hd__fill_8
XFILLER_58_121 vssd1 vccd1 vssd1 vccd1 SS_sky130_ef_sc_hd__decap_40_12
XFILLER_59_633 vssd1 vccd1 vccd1 vssd1 SS_sky130_fd_sc_hd__fill_2
Xfanout465 vssd1 vccd1 vccd1 vssd1 wire467/A _1425_/C1 SS_sky130_fd_sc_hd__clkdlybuf4s25_1
XFILLER_101_741 vssd1 vccd1 vssd1 vccd1 SS_sky130_ef_sc_hd__decap_40_12
XFILLER_46_305 vssd1 vccd1 vccd1 vssd1 SS_sky130_fd_sc_hd__fill_2
XFILLER_58_165 vssd1 vccd1 vssd1 vccd1 SS_sky130_ef_sc_hd__decap_40_12
XFILLER_59_699 vssd1 vccd1 vccd1 vssd1 SS_sky130_fd_sc_hd__fill_4
XFILLER_86_463 vssd1 vccd1 vssd1 vccd1 SS_sky130_ef_sc_hd__decap_40_12
Xfanout487 vssd1 vccd1 vccd1 vssd1 _1471_/C1 _1403_/C1 SS_sky130_fd_sc_hd__clkdlybuf4s25_1
XPHY_EDGE_ROW_122_Right_122 vccd1 vssd1 vccd1 vssd1 SS_sky130_fd_sc_hd__decap_3
Xfanout476 vssd1 vccd1 vccd1 vssd1 wire493/X _1251_/C1 SS_sky130_fd_sc_hd__clkdlybuf4s25_1
XFILLER_101_785 vssd1 vccd1 vssd1 vccd1 SS_sky130_ef_sc_hd__decap_40_12
XFILLER_100_251 vccd1 vssd1 vccd1 vssd1 SS_sky130_fd_sc_hd__fill_1
XFILLER_73_113 vssd1 vccd1 vssd1 vccd1 SS_sky130_ef_sc_hd__decap_40_12
XFILLER_104_41 vssd1 vccd1 vssd1 vccd1 SS_sky130_ef_sc_hd__decap_40_12
XFILLER_27_541 vssd1 vccd1 vssd1 vccd1 SS_sky130_ef_sc_hd__decap_40_12
XFILLER_62_809 vssd1 vccd1 vccd1 vssd1 SS_sky130_fd_sc_hd__fill_2
XFILLER_74_669 vssd1 vccd1 vssd1 vccd1 SS_sky130_ef_sc_hd__decap_40_12
XFILLER_104_85 vssd1 vccd1 vssd1 vccd1 SS_sky130_ef_sc_hd__decap_40_12
XPHY_EDGE_ROW_100_Left_239 vccd1 vssd1 vccd1 vssd1 SS_sky130_fd_sc_hd__decap_3
XFILLER_27_585 vssd1 vccd1 vssd1 vccd1 SS_sky130_ef_sc_hd__decap_40_12
XFILLER_42_533 vssd1 vccd1 vssd1 vccd1 SS_sky130_ef_sc_hd__decap_40_12
XFILLER_6_401 vssd1 vccd1 vssd1 vccd1 SS_sky130_ef_sc_hd__decap_40_12
XFILLER_80_77 vssd1 vccd1 vccd1 vssd1 SS_sky130_fd_sc_hd__fill_4
XFILLER_6_445 vssd1 vccd1 vssd1 vccd1 SS_sky130_ef_sc_hd__decap_40_12
XFILLER_13_93 vssd1 vccd1 vssd1 vccd1 SS_sky130_ef_sc_hd__decap_40_12
XFILLER_127_137 vssd1 vccd1 vssd1 vccd1 SS_sky130_ef_sc_hd__decap_40_12
XFILLER_109_841 vccd1 vssd1 vccd1 vssd1 SS_sky130_fd_sc_hd__fill_1
XFILLER_129_93 vssd1 vccd1 vssd1 vccd1 SS_sky130_ef_sc_hd__decap_40_12
XFILLER_124_811 vccd1 vssd1 vccd1 vssd1 SS_sky130_fd_sc_hd__fill_1
XTAP_TAPCELL_ROW_94_1711 vccd1 vssd1 SS_sky130_fd_sc_hd__tapvpwrvgnd_1
XFILLER_6_489 vssd1 vccd1 vssd1 vccd1 SS_sky130_ef_sc_hd__decap_40_12
XFILLER_135_181 vssd1 vccd1 vssd1 vccd1 SS_sky130_ef_sc_hd__decap_40_12
XFILLER_136_693 vssd1 vccd1 vccd1 vssd1 SS_sky130_fd_sc_hd__fill_4
XFILLER_97_717 vssd1 vccd1 vccd1 vssd1 SS_sky130_fd_sc_hd__fill_8
XFILLER_1_161 vssd1 vccd1 vccd1 vssd1 SS_sky130_fd_sc_hd__fill_4
XFILLER_111_505 vssd1 vccd1 vssd1 vccd1 SS_sky130_ef_sc_hd__decap_40_12
XFILLER_96_249 vssd1 vccd1 vccd1 vssd1 SS_sky130_fd_sc_hd__fill_2
XFILLER_37_305 vssd1 vccd1 vssd1 vccd1 SS_sky130_ef_sc_hd__decap_40_12
X_1160_ vccd1 vssd1 vccd1 vssd1 _1160_/X _1870_/A _1186_/B SS_sky130_fd_sc_hd__or2_2
XFILLER_49_165 vssd1 vccd1 vccd1 vssd1 SS_sky130_fd_sc_hd__fill_2
XFILLER_37_349 vssd1 vccd1 vssd1 vccd1 SS_sky130_ef_sc_hd__decap_40_12
XFILLER_92_433 vssd1 vccd1 vssd1 vccd1 SS_sky130_ef_sc_hd__decap_40_12
X_1091_ vssd1 vccd1 vccd1 vssd1 wire239/X input47/X _1576_/D _1099_/C1 _1090_/X SS_sky130_fd_sc_hd__o211a_2
XFILLER_53_809 vssd1 vccd1 vccd1 vssd1 SS_sky130_fd_sc_hd__fill_4
XFILLER_65_669 vssd1 vccd1 vccd1 vssd1 SS_sky130_fd_sc_hd__fill_2
XTAP_TAPCELL_ROW_121_2118 vccd1 vssd1 SS_sky130_fd_sc_hd__tapvpwrvgnd_1
XFILLER_92_477 vssd1 vccd1 vssd1 vccd1 SS_sky130_ef_sc_hd__decap_40_12
XFILLER_18_585 vssd1 vccd1 vccd1 vssd1 SS_sky130_fd_sc_hd__fill_2
XFILLER_45_393 vssd1 vccd1 vssd1 vccd1 SS_sky130_ef_sc_hd__decap_40_12
XFILLER_60_363 vccd1 vssd1 vccd1 vssd1 SS_sky130_fd_sc_hd__fill_1
XTAP_TAPCELL_ROW_103_1851 vccd1 vssd1 SS_sky130_fd_sc_hd__tapvpwrvgnd_1
XTAP_TAPCELL_ROW_103_1840 vccd1 vssd1 SS_sky130_fd_sc_hd__tapvpwrvgnd_1
XFILLER_9_261 vssd1 vccd1 vssd1 vccd1 SS_sky130_ef_sc_hd__decap_40_12
XFILLER_20_249 vssd1 vccd1 vccd1 vssd1 SS_sky130_fd_sc_hd__fill_2
XTAP_TAPCELL_ROW_31_767 vccd1 vssd1 SS_sky130_fd_sc_hd__tapvpwrvgnd_1
X_0944_ vccd1 vssd1 vssd1 vccd1 hold792/X _0943_/X _0750_/X _1506_/Q _0944_/X _1473_/C1
+ SS_sky130_fd_sc_hd__o221a_2
X_0875_ vccd1 vssd1 vccd1 vssd1 _1527_/Q wire421/X _1687_/Q wire448/X _0875_/X SS_sky130_fd_sc_hd__a22o_2
Xclkload20 vssd1 vccd1 _1692_/CLK clkload20/X vccd1 vssd1 SS_sky130_fd_sc_hd__clkbuf_4
XFILLER_118_137 vssd1 vccd1 vccd1 vssd1 SS_sky130_fd_sc_hd__fill_2
XFILLER_114_321 vssd1 vccd1 vccd1 vssd1 SS_sky130_fd_sc_hd__fill_4
XFILLER_87_205 vssd1 vccd1 vssd1 vccd1 SS_sky130_ef_sc_hd__decap_40_12
XFILLER_114_365 vssd1 vccd1 vssd1 vccd1 SS_sky130_ef_sc_hd__decap_40_12
X_1427_ vssd1 vccd1 vccd1 vssd1 wire207/X wire495/X _1739_/D _1447_/C1 _1426_/X SS_sky130_fd_sc_hd__o211a_2
XFILLER_87_249 vssd1 vccd1 vssd1 vccd1 SS_sky130_ef_sc_hd__decap_40_12
XFILLER_28_305 vssd1 vccd1 vccd1 vssd1 SS_sky130_fd_sc_hd__fill_2
XFILLER_55_113 vssd1 vccd1 vssd1 vccd1 SS_sky130_ef_sc_hd__decap_40_12
X_1358_ vccd1 vssd1 vccd1 vssd1 _1358_/X _1358_/A _1404_/B SS_sky130_fd_sc_hd__or2_2
XFILLER_95_293 vssd1 vccd1 vccd1 vssd1 SS_sky130_fd_sc_hd__fill_8
XTAP_TAPCELL_ROW_39_878 vccd1 vssd1 SS_sky130_fd_sc_hd__tapvpwrvgnd_1
XFILLER_56_669 vssd1 vccd1 vssd1 vccd1 SS_sky130_ef_sc_hd__decap_40_12
XFILLER_71_617 vssd1 vccd1 vssd1 vccd1 SS_sky130_ef_sc_hd__decap_40_12
XFILLER_83_466 vssd1 vccd1 vssd1 vccd1 SS_sky130_ef_sc_hd__decap_40_12
X_1289_ vssd1 vccd1 vccd1 vssd1 _1339_/A2 input47/X _1289_/X _1439_/C1 _1288_/X SS_sky130_fd_sc_hd__o211a_2
XTAP_TAPCELL_ROW_39_889 vccd1 vssd1 SS_sky130_fd_sc_hd__tapvpwrvgnd_1
XTAP_TAPCELL_ROW_19_580 vccd1 vssd1 SS_sky130_fd_sc_hd__tapvpwrvgnd_1
XTAP_TAPCELL_ROW_19_591 vccd1 vssd1 SS_sky130_fd_sc_hd__tapvpwrvgnd_1
XFILLER_24_533 vssd1 vccd1 vssd1 vccd1 SS_sky130_ef_sc_hd__decap_40_12
XFILLER_34_15 vssd1 vccd1 vssd1 vccd1 SS_sky130_ef_sc_hd__decap_40_12
XFILLER_11_205 vssd1 vccd1 vssd1 vccd1 SS_sky130_ef_sc_hd__decap_40_12
XTAP_TAPCELL_ROW_61_1209 vccd1 vssd1 SS_sky130_fd_sc_hd__tapvpwrvgnd_1
XFILLER_51_385 vssd1 vccd1 vccd1 vssd1 SS_sky130_fd_sc_hd__fill_4
XFILLER_11_249 vssd1 vccd1 vssd1 vccd1 SS_sky130_ef_sc_hd__decap_40_12
Xclkload3 vssd1 vccd1 clkload3/A clkload3/X vccd1 vssd1 SS_sky130_fd_sc_hd__clkbuf_4
XFILLER_20_794 vccd1 vssd1 vccd1 vssd1 SS_sky130_fd_sc_hd__fill_1
XFILLER_126_6 vssd1 vccd1 vssd1 vccd1 SS_sky130_ef_sc_hd__decap_40_12
XFILLER_109_137 vssd1 vccd1 vssd1 vccd1 SS_sky130_ef_sc_hd__decap_40_12
XTAP_TAPCELL_ROW_76_1441 vccd1 vssd1 SS_sky130_fd_sc_hd__tapvpwrvgnd_1
XFILLER_133_630 vssd1 vccd1 vssd1 vccd1 SS_sky130_ef_sc_hd__decap_40_12
XFILLER_117_181 vssd1 vccd1 vssd1 vccd1 SS_sky130_ef_sc_hd__decap_40_12
XFILLER_105_332 vssd1 vccd1 vccd1 vssd1 SS_sky130_fd_sc_hd__fill_4
XFILLER_78_249 vssd1 vccd1 vccd1 vssd1 SS_sky130_fd_sc_hd__fill_2
XFILLER_132_195 vccd1 vssd1 vccd1 vssd1 SS_sky130_fd_sc_hd__fill_1
Xfanout240 vssd1 vccd1 vccd1 vssd1 _1079_/Y wire241/A SS_sky130_fd_sc_hd__clkdlybuf4s25_1
XFILLER_19_305 vssd1 vccd1 vssd1 vccd1 SS_sky130_ef_sc_hd__decap_40_12
XFILLER_47_614 vssd1 vccd1 vccd1 vssd1 SS_sky130_fd_sc_hd__fill_2
XFILLER_59_441 vssd1 vccd1 vccd1 vssd1 SS_sky130_fd_sc_hd__fill_4
XFILLER_87_783 vccd1 vssd1 vccd1 vssd1 SS_sky130_fd_sc_hd__fill_1
Xfanout251 vssd1 vccd1 vccd1 vssd1 _1012_/X _1076_/B SS_sky130_fd_sc_hd__clkdlybuf4s25_1
XFILLER_115_51 vssd1 vccd1 vccd1 vssd1 SS_sky130_fd_sc_hd__fill_4
XFILLER_74_433 vssd1 vccd1 vccd1 vssd1 SS_sky130_fd_sc_hd__fill_4
XFILLER_75_55 vccd1 vssd1 vccd1 vssd1 SS_sky130_fd_sc_hd__fill_1
XFILLER_19_349 vssd1 vccd1 vssd1 vccd1 SS_sky130_ef_sc_hd__decap_40_12
XFILLER_47_669 vssd1 vccd1 vccd1 vssd1 SS_sky130_fd_sc_hd__fill_2
XFILLER_74_444 vssd1 vccd1 vssd1 vccd1 SS_sky130_ef_sc_hd__decap_40_12
XFILLER_61_105 vssd1 vccd1 vccd1 vssd1 SS_sky130_fd_sc_hd__fill_4
XFILLER_74_477 vssd1 vccd1 vccd1 vssd1 SS_sky130_fd_sc_hd__fill_4
XFILLER_27_393 vssd1 vccd1 vssd1 vccd1 SS_sky130_ef_sc_hd__decap_40_12
XFILLER_61_149 vssd1 vccd1 vssd1 vccd1 SS_sky130_ef_sc_hd__decap_40_12
XFILLER_42_363 vccd1 vssd1 vccd1 vssd1 SS_sky130_fd_sc_hd__fill_1
XFILLER_70_661 vssd1 vccd1 vccd1 vssd1 SS_sky130_fd_sc_hd__fill_2
XFILLER_91_54 vssd1 vccd1 vccd1 vssd1 SS_sky130_fd_sc_hd__fill_2
XFILLER_30_525 vssd1 vccd1 vccd1 vssd1 SS_sky130_fd_sc_hd__fill_4
XFILLER_24_81 vssd1 vccd1 vccd1 vssd1 SS_sky130_fd_sc_hd__fill_2
XFILLER_30_569 vssd1 vccd1 vssd1 vccd1 SS_sky130_ef_sc_hd__decap_40_12
XFILLER_7_721 vssd1 vccd1 vccd1 vssd1 SS_sky130_fd_sc_hd__fill_4
XFILLER_11_783 vccd1 vssd1 vccd1 vssd1 SS_sky130_fd_sc_hd__fill_1
XFILLER_6_253 vssd1 vccd1 vssd1 vccd1 SS_sky130_ef_sc_hd__decap_40_12
XFILLER_7_765 vssd1 vccd1 vssd1 vccd1 SS_sky130_ef_sc_hd__decap_40_12
XFILLER_128_457 vssd1 vccd1 vssd1 vccd1 SS_sky130_ef_sc_hd__decap_40_12
XFILLER_41_6 vssd1 vccd1 vssd1 vccd1 SS_sky130_ef_sc_hd__decap_40_12
XFILLER_124_630 vssd1 vccd1 vssd1 vccd1 SS_sky130_ef_sc_hd__decap_40_12
XFILLER_69_205 vssd1 vccd1 vssd1 vccd1 SS_sky130_ef_sc_hd__decap_40_12
XFILLER_97_503 vccd1 vssd1 vccd1 vssd1 SS_sky130_fd_sc_hd__fill_1
XFILLER_69_249 vssd1 vccd1 vssd1 vccd1 SS_sky130_ef_sc_hd__decap_40_12
XFILLER_85_709 vssd1 vccd1 vssd1 vccd1 SS_sky130_ef_sc_hd__decap_40_12
XFILLER_111_335 vccd1 vssd1 vccd1 vssd1 SS_sky130_fd_sc_hd__fill_1
X_1212_ vccd1 vssd1 vccd1 vssd1 _1212_/X _1635_/Q _1272_/B SS_sky130_fd_sc_hd__or2_2
XFILLER_1_30 vssd1 vccd1 vssd1 vccd1 SS_sky130_ef_sc_hd__decap_40_12
XFILLER_37_113 vssd1 vccd1 vssd1 vccd1 SS_sky130_ef_sc_hd__decap_40_12
XFILLER_93_720 vssd1 vccd1 vccd1 vssd1 SS_sky130_fd_sc_hd__fill_2
XFILLER_38_669 vssd1 vccd1 vssd1 vccd1 SS_sky130_ef_sc_hd__decap_40_12
XFILLER_77_293 vssd1 vccd1 vssd1 vccd1 SS_sky130_ef_sc_hd__decap_40_12
X_1143_ vssd1 vccd1 vccd1 vssd1 _1079_/Y input44/X _1143_/X _1143_/C1 _1142_/X SS_sky130_fd_sc_hd__o211a_2
X_1074_ vccd1 vssd1 vccd1 vssd1 _1074_/X _1074_/A _1076_/B SS_sky130_fd_sc_hd__or2_2
XFILLER_93_797 vssd1 vccd1 vccd1 vssd1 SS_sky130_fd_sc_hd__fill_4
XTAP_TAPCELL_ROW_36_837 vccd1 vssd1 SS_sky130_fd_sc_hd__tapvpwrvgnd_1
XFILLER_80_447 vssd1 vccd1 vssd1 vccd1 SS_sky130_ef_sc_hd__decap_40_12
XFILLER_21_503 vccd1 vssd1 vccd1 vssd1 SS_sky130_fd_sc_hd__fill_1
XFILLER_33_385 vssd1 vccd1 vccd1 vssd1 SS_sky130_fd_sc_hd__fill_4
XFILLER_60_193 vssd1 vccd1 vccd1 vssd1 SS_sky130_fd_sc_hd__fill_2
XTAP_TAPCELL_ROW_134_2309 vccd1 vssd1 SS_sky130_fd_sc_hd__tapvpwrvgnd_1
X_0927_ vccd1 vssd1 vccd1 vssd1 _1664_/Q wire431/X _1632_/Q _0927_/A2 _0931_/B SS_sky130_fd_sc_hd__a22o_2
X_0858_ vccd1 vssd1 vccd1 vssd1 _1524_/Q wire421/A _1716_/Q wire454/A _0858_/X SS_sky130_fd_sc_hd__a22o_2
X_0789_ vccd1 vssd1 vccd1 vssd1 _1673_/Q wire448/X _1884_/A wire454/X _0789_/X SS_sky130_fd_sc_hd__a22o_2
XTAP_TAPCELL_ROW_58_1171 vccd1 vssd1 SS_sky130_fd_sc_hd__tapvpwrvgnd_1
XFILLER_134_449 vssd1 vccd1 vccd1 vssd1 SS_sky130_fd_sc_hd__fill_4
XFILLER_29_15 vssd1 vccd1 vssd1 vccd1 SS_sky130_ef_sc_hd__decap_40_12
XFILLER_114_195 vccd1 vssd1 vccd1 vssd1 SS_sky130_fd_sc_hd__fill_1
XTAP_TAPCELL_ROW_71_1360 vccd1 vssd1 SS_sky130_fd_sc_hd__tapvpwrvgnd_1
XTAP_TAPCELL_ROW_71_1371 vccd1 vssd1 SS_sky130_fd_sc_hd__tapvpwrvgnd_1
XFILLER_88_569 vssd1 vccd1 vccd1 vssd1 SS_sky130_fd_sc_hd__fill_2
XFILLER_102_357 vssd1 vccd1 vccd1 vssd1 SS_sky130_fd_sc_hd__fill_4
XFILLER_56_400 vssd1 vccd1 vssd1 vccd1 SS_sky130_ef_sc_hd__decap_40_12
XFILLER_69_783 vccd1 vssd1 vccd1 vssd1 SS_sky130_fd_sc_hd__fill_1
XFILLER_130_699 vccd1 vssd1 vccd1 vssd1 SS_sky130_fd_sc_hd__fill_1
XFILLER_56_433 vssd1 vccd1 vssd1 vccd1 SS_sky130_ef_sc_hd__decap_40_12
XFILLER_43_105 vssd1 vccd1 vccd1 vssd1 SS_sky130_fd_sc_hd__fill_4
XFILLER_56_477 vssd1 vccd1 vssd1 vccd1 SS_sky130_ef_sc_hd__decap_40_12
XFILLER_43_149 vssd1 vccd1 vssd1 vccd1 SS_sky130_ef_sc_hd__decap_40_12
XFILLER_45_69 vssd1 vccd1 vssd1 vccd1 SS_sky130_ef_sc_hd__decap_40_12
XTAP_TAPCELL_ROW_14_509 vccd1 vssd1 SS_sky130_fd_sc_hd__tapvpwrvgnd_1
XFILLER_24_363 vccd1 vssd1 vccd1 vssd1 SS_sky130_fd_sc_hd__fill_1
XFILLER_71_469 vssd1 vccd1 vssd1 vccd1 SS_sky130_ef_sc_hd__decap_40_12
XFILLER_101_42 vssd1 vccd1 vssd1 vccd1 SS_sky130_ef_sc_hd__decap_40_12
XFILLER_12_525 vssd1 vccd1 vccd1 vssd1 SS_sky130_fd_sc_hd__fill_4
XFILLER_12_569 vssd1 vccd1 vssd1 vccd1 SS_sky130_ef_sc_hd__decap_40_12
XFILLER_51_193 vssd1 vccd1 vssd1 vccd1 SS_sky130_ef_sc_hd__decap_40_12
XFILLER_61_57 vssd1 vccd1 vssd1 vccd1 SS_sky130_ef_sc_hd__decap_40_12
XFILLER_8_529 vssd1 vccd1 vccd1 vssd1 SS_sky130_fd_sc_hd__fill_2
XFILLER_138_755 vccd1 vssd1 vccd1 vssd1 SS_sky130_fd_sc_hd__fill_1
XFILLER_124_3 vssd1 vccd1 vssd1 vccd1 SS_sky130_ef_sc_hd__decap_40_12
XFILLER_4_713 vssd1 vccd1 vssd1 vccd1 SS_sky130_ef_sc_hd__decap_40_12
XFILLER_3_223 vccd1 vssd1 vccd1 vssd1 SS_sky130_fd_sc_hd__fill_1
XFILLER_4_757 vssd1 vccd1 vssd1 vccd1 SS_sky130_ef_sc_hd__decap_40_12
XFILLER_106_630 vssd1 vccd1 vssd1 vccd1 SS_sky130_ef_sc_hd__decap_40_12
XFILLER_79_503 vccd1 vssd1 vccd1 vssd1 SS_sky130_fd_sc_hd__fill_1
XFILLER_10_83 vccd1 vssd1 vccd1 vssd1 SS_sky130_fd_sc_hd__fill_1
XFILLER_120_121 vssd1 vccd1 vssd1 vccd1 SS_sky130_ef_sc_hd__decap_40_12
XFILLER_86_65 vssd1 vccd1 vssd1 vccd1 SS_sky130_ef_sc_hd__decap_40_12
XFILLER_126_83 vccd1 vssd1 vccd1 vssd1 SS_sky130_fd_sc_hd__fill_1
XFILLER_19_113 vssd1 vccd1 vssd1 vccd1 SS_sky130_ef_sc_hd__decap_40_12
XTAP_TAPCELL_ROW_89_1632 vccd1 vssd1 SS_sky130_fd_sc_hd__tapvpwrvgnd_1
XFILLER_120_165 vssd1 vccd1 vssd1 vccd1 SS_sky130_ef_sc_hd__decap_40_12
XFILLER_19_81 vssd1 vccd1 vssd1 vccd1 SS_sky130_ef_sc_hd__decap_40_12
XFILLER_59_293 vssd1 vccd1 vssd1 vccd1 SS_sky130_ef_sc_hd__decap_40_12
XFILLER_35_617 vssd1 vccd1 vssd1 vccd1 SS_sky130_ef_sc_hd__decap_40_12
XFILLER_75_797 vssd1 vccd1 vccd1 vssd1 SS_sky130_fd_sc_hd__fill_8
XFILLER_90_701 vccd1 vssd1 vccd1 vssd1 SS_sky130_fd_sc_hd__fill_1
XFILLER_62_425 vccd1 vssd1 vccd1 vssd1 SS_sky130_fd_sc_hd__fill_1
XFILLER_62_447 vccd1 vssd1 vccd1 vssd1 SS_sky130_fd_sc_hd__fill_1
XFILLER_15_385 vssd1 vccd1 vccd1 vssd1 SS_sky130_fd_sc_hd__fill_4
X_1830_ vccd1 vssd1 _1830_/X _1830_/A vccd1 vssd1 SS_sky130_fd_sc_hd__buf_2
XFILLER_30_333 vssd1 vccd1 vssd1 vccd1 SS_sky130_ef_sc_hd__decap_40_12
XFILLER_42_193 vssd1 vccd1 vccd1 vssd1 SS_sky130_fd_sc_hd__fill_2
XFILLER_129_711 vssd1 vccd1 vssd1 vccd1 SS_sky130_ef_sc_hd__decap_40_12
XFILLER_30_377 vssd1 vccd1 vssd1 vccd1 SS_sky130_ef_sc_hd__decap_40_12
XFILLER_128_221 vssd1 vccd1 vssd1 vccd1 SS_sky130_ef_sc_hd__decap_40_12
XFILLER_129_777 vssd1 vccd1 vccd1 vssd1 SS_sky130_fd_sc_hd__fill_4
X_1761_ _1761_/Q _1761_/CLK _1761_/D vccd1 vssd1 vccd1 vssd1 SS_sky130_fd_sc_hd__dfxtp_2
XTAP_TAPCELL_ROW_116_2039 vccd1 vssd1 SS_sky130_fd_sc_hd__tapvpwrvgnd_1
XFILLER_7_573 vssd1 vccd1 vssd1 vccd1 SS_sky130_ef_sc_hd__decap_40_12
XFILLER_128_265 vssd1 vccd1 vssd1 vccd1 SS_sky130_ef_sc_hd__decap_40_12
X_1692_ _1692_/Q _1692_/CLK _1692_/D vccd1 vssd1 vccd1 vssd1 SS_sky130_fd_sc_hd__dfxtp_2
XFILLER_116_438 vssd1 vccd1 vccd1 vssd1 SS_sky130_fd_sc_hd__fill_4
Xwire493 vccd1 vssd1 wire493/X wire493/A vccd1 vssd1 SS_sky130_fd_sc_hd__buf_4
XFILLER_116_449 vssd1 vccd1 vccd1 vssd1 SS_sky130_fd_sc_hd__fill_2
XFILLER_124_471 vssd1 vccd1 vccd1 vssd1 SS_sky130_fd_sc_hd__fill_4
XFILLER_124_493 vssd1 vccd1 vccd1 vssd1 SS_sky130_fd_sc_hd__fill_2
Xload_slew432 vssd1 vccd1 wire433/X _0815_/B1 vccd1 vssd1 SS_sky130_fd_sc_hd__clkbuf_4
XFILLER_58_709 vssd1 vccd1 vssd1 vccd1 SS_sky130_ef_sc_hd__decap_40_12
XFILLER_85_517 vssd1 vccd1 vccd1 vssd1 SS_sky130_fd_sc_hd__fill_8
XTAP_TAPCELL_ROW_111_1972 vccd1 vssd1 SS_sky130_fd_sc_hd__tapvpwrvgnd_1
XTAP_TAPCELL_ROW_111_1961 vccd1 vssd1 SS_sky130_fd_sc_hd__tapvpwrvgnd_1
XTAP_TAPCELL_ROW_53_1090 vccd1 vssd1 SS_sky130_fd_sc_hd__tapvpwrvgnd_1
XFILLER_66_731 vssd1 vccd1 vccd1 vssd1 SS_sky130_fd_sc_hd__fill_2
XFILLER_112_699 vccd1 vssd1 vccd1 vssd1 SS_sky130_fd_sc_hd__fill_1
XFILLER_111_165 vssd1 vccd1 vccd1 vssd1 SS_sky130_fd_sc_hd__fill_2
XFILLER_38_433 vssd1 vccd1 vssd1 vccd1 SS_sky130_ef_sc_hd__decap_40_12
Xclkbuf_leaf_10_wb_clk_i _1758_/CLK clkbuf_leaf_7_wb_clk_i/A vccd1 vssd1 vssd1 vccd1
+ SS_sky130_fd_sc_hd__clkbuf_8
XFILLER_25_105 vssd1 vccd1 vccd1 vssd1 SS_sky130_fd_sc_hd__fill_4
XFILLER_38_477 vssd1 vccd1 vssd1 vccd1 SS_sky130_ef_sc_hd__decap_40_12
X_1126_ vccd1 vssd1 vccd1 vssd1 _1126_/X _1126_/A _1126_/B SS_sky130_fd_sc_hd__or2_2
XFILLER_93_561 vssd1 vccd1 vccd1 vssd1 SS_sky130_fd_sc_hd__fill_8
XFILLER_25_149 vssd1 vccd1 vssd1 vccd1 SS_sky130_ef_sc_hd__decap_40_12
XFILLER_80_233 vssd1 vccd1 vssd1 vccd1 SS_sky130_ef_sc_hd__decap_40_12
XFILLER_15_39 vssd1 vccd1 vssd1 vccd1 SS_sky130_ef_sc_hd__decap_40_12
XFILLER_41_609 vssd1 vccd1 vccd1 vssd1 SS_sky130_fd_sc_hd__fill_4
X_1057_ vssd1 vccd1 vccd1 vssd1 _1077_/A2 input33/X _1560_/D _1451_/C1 _1056_/X SS_sky130_fd_sc_hd__o211a_2
XFILLER_80_277 vssd1 vccd1 vssd1 vccd1 SS_sky130_ef_sc_hd__decap_40_12
XFILLER_21_333 vssd1 vccd1 vccd1 vssd1 SS_sky130_fd_sc_hd__fill_2
XFILLER_33_193 vssd1 vccd1 vssd1 vccd1 SS_sky130_ef_sc_hd__decap_40_12
XFILLER_119_221 vssd1 vccd1 vccd1 vssd1 SS_sky130_fd_sc_hd__fill_2
XFILLER_135_747 vccd1 vssd1 vccd1 vssd1 SS_sky130_fd_sc_hd__fill_1
XFILLER_107_405 vssd1 vccd1 vssd1 vccd1 SS_sky130_ef_sc_hd__decap_40_12
XTAP_TAPCELL_ROW_73_1400 vccd1 vssd1 SS_sky130_fd_sc_hd__tapvpwrvgnd_1
XFILLER_107_449 vssd1 vccd1 vssd1 vccd1 SS_sky130_ef_sc_hd__decap_40_12
XFILLER_1_727 vccd1 vssd1 vccd1 vssd1 SS_sky130_fd_sc_hd__fill_1
XFILLER_122_419 vccd1 vssd1 vccd1 vssd1 SS_sky130_fd_sc_hd__fill_1
XFILLER_115_482 vccd1 vssd1 vccd1 vssd1 SS_sky130_fd_sc_hd__fill_1
XFILLER_88_344 vssd1 vccd1 vssd1 vccd1 SS_sky130_ef_sc_hd__decap_40_12
XFILLER_88_377 vssd1 vccd1 vssd1 vccd1 SS_sky130_ef_sc_hd__decap_40_12
XFILLER_102_121 vssd1 vccd1 vssd1 vccd1 SS_sky130_ef_sc_hd__decap_40_12
XFILLER_130_485 vssd1 vccd1 vccd1 vssd1 SS_sky130_fd_sc_hd__fill_2
XFILLER_102_165 vssd1 vccd1 vssd1 vccd1 SS_sky130_ef_sc_hd__decap_40_12
XFILLER_17_617 vssd1 vccd1 vssd1 vccd1 SS_sky130_ef_sc_hd__decap_40_12
XFILLER_72_701 vssd1 vccd1 vssd1 vccd1 SS_sky130_ef_sc_hd__decap_40_12
XFILLER_44_447 vssd1 vccd1 vssd1 vccd1 SS_sky130_ef_sc_hd__decap_40_12
XFILLER_112_41 vssd1 vccd1 vssd1 vccd1 SS_sky130_ef_sc_hd__decap_40_12
XTAP_TAPCELL_ROW_84_1562 vccd1 vssd1 SS_sky130_fd_sc_hd__tapvpwrvgnd_1
XFILLER_112_85 vssd1 vccd1 vssd1 vccd1 SS_sky130_ef_sc_hd__decap_40_12
XFILLER_71_277 vssd1 vccd1 vccd1 vssd1 SS_sky130_fd_sc_hd__fill_2
XFILLER_12_333 vssd1 vccd1 vssd1 vccd1 SS_sky130_ef_sc_hd__decap_40_12
XFILLER_24_193 vssd1 vccd1 vccd1 vssd1 SS_sky130_fd_sc_hd__fill_2
XFILLER_12_377 vssd1 vccd1 vssd1 vccd1 SS_sky130_ef_sc_hd__decap_40_12
XFILLER_138_585 vssd1 vccd1 vccd1 vssd1 SS_sky130_fd_sc_hd__fill_2
XFILLER_99_609 vssd1 vccd1 vccd1 vssd1 SS_sky130_fd_sc_hd__fill_4
XFILLER_21_93 vssd1 vccd1 vssd1 vccd1 SS_sky130_ef_sc_hd__decap_40_12
XFILLER_125_279 vccd1 vssd1 vccd1 vssd1 SS_sky130_fd_sc_hd__fill_1
XFILLER_4_587 vccd1 vssd1 vccd1 vssd1 SS_sky130_fd_sc_hd__fill_1
XFILLER_121_441 vssd1 vccd1 vccd1 vssd1 SS_sky130_fd_sc_hd__fill_4
XFILLER_67_517 vssd1 vccd1 vccd1 vssd1 SS_sky130_fd_sc_hd__fill_2
XFILLER_67_528 vssd1 vccd1 vccd1 vssd1 SS_sky130_fd_sc_hd__fill_2
XFILLER_121_485 vssd1 vccd1 vssd1 vccd1 SS_sky130_ef_sc_hd__decap_40_12
XFILLER_48_797 vssd1 vccd1 vssd1 vccd1 SS_sky130_ef_sc_hd__decap_40_12
XFILLER_75_561 vssd1 vccd1 vssd1 vccd1 SS_sky130_ef_sc_hd__decap_40_12
XFILLER_35_447 vccd1 vssd1 vccd1 vssd1 SS_sky130_fd_sc_hd__fill_1
XFILLER_62_233 vssd1 vccd1 vssd1 vccd1 SS_sky130_ef_sc_hd__decap_40_12
XFILLER_90_531 vccd1 vssd1 vccd1 vssd1 SS_sky130_fd_sc_hd__fill_1
XTAP_TAPCELL_ROW_126_2190 vccd1 vssd1 SS_sky130_fd_sc_hd__tapvpwrvgnd_1
XFILLER_23_609 vssd1 vccd1 vccd1 vssd1 SS_sky130_fd_sc_hd__fill_4
XFILLER_63_767 vssd1 vccd1 vccd1 vssd1 SS_sky130_fd_sc_hd__fill_4
XTAP_TAPCELL_ROW_46_987 vccd1 vssd1 SS_sky130_fd_sc_hd__tapvpwrvgnd_1
XFILLER_62_277 vssd1 vccd1 vssd1 vccd1 SS_sky130_ef_sc_hd__decap_40_12
XFILLER_15_193 vssd1 vccd1 vssd1 vccd1 SS_sky130_ef_sc_hd__decap_40_12
XFILLER_31_653 vssd1 vccd1 vccd1 vssd1 SS_sky130_fd_sc_hd__fill_8
XFILLER_30_141 vssd1 vccd1 vssd1 vccd1 SS_sky130_ef_sc_hd__decap_40_12
XFILLER_87_3 vssd1 vccd1 vssd1 vccd1 SS_sky130_ef_sc_hd__decap_40_12
XFILLER_129_541 vssd1 vccd1 vccd1 vssd1 SS_sky130_fd_sc_hd__fill_8
XFILLER_7_51 vssd1 vccd1 vccd1 vssd1 SS_sky130_fd_sc_hd__fill_4
X_1744_ _1908_/A clkload5/A _1744_/D vccd1 vssd1 vccd1 vssd1 SS_sky130_fd_sc_hd__dfxtp_2
Xwire290 vccd1 vssd1 vssd1 vccd1 wire290/A analog_ctrl[118] SS_sky130_fd_sc_hd__buf_12
X_1675_ _1675_/Q _1742_/CLK _1675_/D vccd1 vssd1 vccd1 vssd1 SS_sky130_fd_sc_hd__dfxtp_2
XFILLER_131_205 vssd1 vccd1 vssd1 vccd1 SS_sky130_ef_sc_hd__decap_40_12
XPHY_EDGE_ROW_15_Right_15 vccd1 vssd1 vccd1 vssd1 SS_sky130_fd_sc_hd__decap_3
XTAP_TAPCELL_ROW_55_1130 vccd1 vssd1 SS_sky130_fd_sc_hd__tapvpwrvgnd_1
XFILLER_131_249 vssd1 vccd1 vssd1 vccd1 SS_sky130_ef_sc_hd__decap_40_12
XFILLER_39_720 vssd1 vccd1 vccd1 vssd1 SS_sky130_fd_sc_hd__fill_8
XFILLER_133_18 vssd1 vccd1 vssd1 vccd1 SS_sky130_ef_sc_hd__decap_40_12
XFILLER_100_625 vssd1 vccd1 vccd1 vssd1 SS_sky130_fd_sc_hd__fill_4
XFILLER_39_753 vssd1 vccd1 vssd1 vccd1 SS_sky130_ef_sc_hd__decap_40_12
XFILLER_54_701 vssd1 vccd1 vssd1 vccd1 SS_sky130_ef_sc_hd__decap_40_12
XFILLER_85_369 vccd1 vssd1 vccd1 vssd1 SS_sky130_fd_sc_hd__fill_1
XPHY_EDGE_ROW_24_Right_24 vccd1 vssd1 vccd1 vssd1 SS_sky130_fd_sc_hd__decap_3
XFILLER_26_469 vssd1 vccd1 vccd1 vssd1 SS_sky130_fd_sc_hd__fill_4
XFILLER_81_553 vssd1 vccd1 vccd1 vssd1 SS_sky130_fd_sc_hd__fill_2
X_1109_ vssd1 vccd1 vccd1 vssd1 _1141_/A2 wire498/X _1585_/D _1439_/C1 _1108_/X SS_sky130_fd_sc_hd__o211a_2
XFILLER_41_417 vssd1 vccd1 vssd1 vccd1 SS_sky130_ef_sc_hd__decap_40_12
XFILLER_53_277 vssd1 vccd1 vccd1 vssd1 SS_sky130_fd_sc_hd__fill_2
XTAP_TAPCELL_ROW_24_659 vccd1 vssd1 SS_sky130_fd_sc_hd__tapvpwrvgnd_1
XFILLER_42_15 vssd1 vccd1 vssd1 vccd1 SS_sky130_ef_sc_hd__decap_40_12
XTAP_TAPCELL_ROW_66_1292 vccd1 vssd1 SS_sky130_fd_sc_hd__tapvpwrvgnd_1
XFILLER_22_697 vssd1 vccd1 vccd1 vssd1 SS_sky130_fd_sc_hd__fill_2
XFILLER_5_329 vssd1 vccd1 vccd1 vssd1 SS_sky130_fd_sc_hd__fill_4
XFILLER_108_769 vssd1 vccd1 vssd1 vccd1 SS_sky130_ef_sc_hd__decap_40_12
XFILLER_108_747 vccd1 vssd1 vccd1 vssd1 SS_sky130_fd_sc_hd__fill_1
XPHY_EDGE_ROW_33_Right_33 vccd1 vssd1 vccd1 vssd1 SS_sky130_fd_sc_hd__decap_3
XFILLER_107_279 vccd1 vssd1 vccd1 vssd1 SS_sky130_fd_sc_hd__fill_1
XFILLER_1_557 vssd1 vccd1 vccd1 vssd1 SS_sky130_fd_sc_hd__fill_2
XFILLER_77_815 vccd1 vssd1 vccd1 vssd1 SS_sky130_fd_sc_hd__fill_1
XFILLER_88_141 vssd1 vccd1 vssd1 vccd1 SS_sky130_ef_sc_hd__decap_40_12
XFILLER_89_664 vssd1 vccd1 vccd1 vssd1 SS_sky130_fd_sc_hd__fill_8
XFILLER_122_249 vssd1 vccd1 vccd1 vssd1 SS_sky130_fd_sc_hd__fill_2
XFILLER_49_517 vssd1 vccd1 vssd1 vccd1 SS_sky130_ef_sc_hd__decap_40_12
XFILLER_89_697 vssd1 vccd1 vssd1 vccd1 SS_sky130_ef_sc_hd__decap_40_12
XFILLER_131_783 vccd1 vssd1 vccd1 vssd1 SS_sky130_fd_sc_hd__fill_1
XFILLER_103_485 vssd1 vccd1 vssd1 vccd1 SS_sky130_ef_sc_hd__decap_40_12
XTAP_TAPCELL_ROW_4_362 vccd1 vssd1 SS_sky130_fd_sc_hd__tapvpwrvgnd_1
XFILLER_57_561 vssd1 vccd1 vssd1 vccd1 SS_sky130_ef_sc_hd__decap_40_12
XFILLER_91_317 vssd1 vccd1 vssd1 vccd1 SS_sky130_ef_sc_hd__decap_40_12
XPHY_EDGE_ROW_42_Right_42 vccd1 vssd1 vccd1 vssd1 SS_sky130_fd_sc_hd__decap_3
XFILLER_57_594 vssd1 vccd1 vccd1 vssd1 SS_sky130_fd_sc_hd__fill_4
XFILLER_17_447 vccd1 vssd1 vccd1 vssd1 SS_sky130_fd_sc_hd__fill_1
XFILLER_44_233 vssd1 vccd1 vssd1 vccd1 SS_sky130_ef_sc_hd__decap_40_12
XFILLER_32_417 vssd1 vccd1 vccd1 vssd1 SS_sky130_fd_sc_hd__fill_2
XFILLER_44_277 vssd1 vccd1 vssd1 vccd1 SS_sky130_ef_sc_hd__decap_40_12
XFILLER_13_653 vssd1 vccd1 vssd1 vccd1 SS_sky130_ef_sc_hd__decap_40_12
XTAP_TAPCELL_ROW_43_946 vccd1 vssd1 SS_sky130_fd_sc_hd__tapvpwrvgnd_1
XFILLER_60_759 vccd1 vssd1 vccd1 vssd1 SS_sky130_fd_sc_hd__fill_1
XFILLER_9_613 vssd1 vccd1 vccd1 vssd1 SS_sky130_fd_sc_hd__fill_2
XFILLER_12_141 vssd1 vccd1 vssd1 vccd1 SS_sky130_ef_sc_hd__decap_40_12
XFILLER_13_697 vssd1 vccd1 vssd1 vccd1 SS_sky130_ef_sc_hd__decap_40_12
XFILLER_32_81 vssd1 vccd1 vccd1 vssd1 SS_sky130_fd_sc_hd__fill_2
XPHY_EDGE_ROW_51_Right_51 vccd1 vssd1 vccd1 vssd1 SS_sky130_fd_sc_hd__decap_3
XFILLER_5_841 vccd1 vssd1 vccd1 vssd1 SS_sky130_fd_sc_hd__fill_1
XFILLER_8_189 vssd1 vccd1 vccd1 vssd1 SS_sky130_fd_sc_hd__fill_4
XFILLER_126_533 vssd1 vccd1 vssd1 vccd1 SS_sky130_ef_sc_hd__decap_40_12
XTAP_TAPCELL_ROW_97_1753 vccd1 vssd1 SS_sky130_fd_sc_hd__tapvpwrvgnd_1
XPHY_EDGE_ROW_136_Right_136 vccd1 vssd1 vccd1 vssd1 SS_sky130_fd_sc_hd__decap_3
XFILLER_126_577 vssd1 vccd1 vccd1 vssd1 SS_sky130_fd_sc_hd__fill_8
XFILLER_113_205 vssd1 vccd1 vssd1 vccd1 SS_sky130_ef_sc_hd__decap_40_12
XFILLER_99_417 vssd1 vccd1 vssd1 vccd1 SS_sky130_ef_sc_hd__decap_40_12
X_1460_ vccd1 vssd1 vccd1 vssd1 _1460_/X _1460_/A _1472_/B SS_sky130_fd_sc_hd__or2_2
XFILLER_68_815 vccd1 vssd1 vccd1 vssd1 SS_sky130_fd_sc_hd__fill_1
XFILLER_113_249 vssd1 vccd1 vssd1 vccd1 SS_sky130_ef_sc_hd__decap_40_12
X_1391_ vssd1 vccd1 vccd1 vssd1 _1391_/A2 input35/X _1722_/D _1459_/C1 _1390_/X SS_sky130_fd_sc_hd__o211a_2
XFILLER_121_293 vccd1 vssd1 vccd1 vssd1 SS_sky130_fd_sc_hd__fill_1
XFILLER_94_133 vssd1 vccd1 vccd1 vssd1 SS_sky130_fd_sc_hd__fill_4
XFILLER_36_701 vssd1 vccd1 vssd1 vccd1 SS_sky130_ef_sc_hd__decap_40_12
XPHY_EDGE_ROW_60_Right_60 vccd1 vssd1 vccd1 vssd1 SS_sky130_fd_sc_hd__decap_3
XFILLER_82_317 vssd1 vccd1 vssd1 vccd1 SS_sky130_ef_sc_hd__decap_40_12
XFILLER_94_177 vssd1 vccd1 vssd1 vccd1 SS_sky130_ef_sc_hd__decap_40_12
XFILLER_75_391 vccd1 vssd1 vccd1 vssd1 SS_sky130_fd_sc_hd__fill_1
XFILLER_63_553 vssd1 vccd1 vccd1 vssd1 SS_sky130_fd_sc_hd__fill_4
XFILLER_23_417 vssd1 vccd1 vssd1 vccd1 SS_sky130_ef_sc_hd__decap_40_12
XFILLER_35_277 vssd1 vccd1 vccd1 vssd1 SS_sky130_fd_sc_hd__fill_2
XTAP_TAPCELL_ROW_106_1893 vccd1 vssd1 SS_sky130_fd_sc_hd__tapvpwrvgnd_1
XTAP_TAPCELL_ROW_21_618 vccd1 vssd1 SS_sky130_fd_sc_hd__tapvpwrvgnd_1
XFILLER_31_461 vssd1 vccd1 vssd1 vccd1 SS_sky130_ef_sc_hd__decap_40_12
XFILLER_12_29 vssd1 vccd1 vssd1 vccd1 SS_sky130_ef_sc_hd__decap_40_12
XFILLER_128_18 vssd1 vccd1 vccd1 vssd1 SS_sky130_fd_sc_hd__fill_8
XFILLER_128_29 vssd1 vccd1 vssd1 vccd1 SS_sky130_ef_sc_hd__decap_40_12
XFILLER_129_393 vssd1 vccd1 vccd1 vssd1 SS_sky130_fd_sc_hd__fill_4
X_1727_ _1727_/Q _1727_/CLK _1727_/D vccd1 vssd1 vccd1 vssd1 SS_sky130_fd_sc_hd__dfxtp_2
XPHY_EDGE_ROW_103_Right_103 vccd1 vssd1 vccd1 vssd1 SS_sky130_fd_sc_hd__decap_3
X_1658_ _1658_/Q _1686_/CLK _1658_/D vccd1 vssd1 vccd1 vssd1 SS_sky130_fd_sc_hd__dfxtp_2
XFILLER_104_249 vssd1 vccd1 vccd1 vssd1 SS_sky130_fd_sc_hd__fill_2
X_1589_ _1863_/A clkload2/A _1589_/D vccd1 vssd1 vccd1 vssd1 SS_sky130_fd_sc_hd__dfxtp_2
XFILLER_86_601 vssd1 vccd1 vssd1 vccd1 SS_sky130_ef_sc_hd__decap_40_12
XPHY_EDGE_ROW_13_Left_152 vccd1 vssd1 vccd1 vssd1 SS_sky130_fd_sc_hd__decap_3
XFILLER_37_15 vssd1 vccd1 vssd1 vccd1 SS_sky130_ef_sc_hd__decap_40_12
XFILLER_85_111 vccd1 vssd1 vccd1 vssd1 SS_sky130_fd_sc_hd__fill_1
XFILLER_86_645 vssd1 vccd1 vssd1 vccd1 SS_sky130_ef_sc_hd__decap_40_12
Xafe_wb_536 afe_wb_536/LO analog_io_oeb[0] vccd1 vssd1 vssd1 vccd1 SS_sky130_fd_sc_hd__conb_1
XFILLER_39_561 vssd1 vccd1 vssd1 vccd1 SS_sky130_ef_sc_hd__decap_40_12
XFILLER_73_317 vssd1 vccd1 vccd1 vssd1 SS_sky130_fd_sc_hd__fill_8
Xafe_wb_514 analog_io_out[6] afe_wb_514/HI vccd1 vssd1 vssd1 vccd1 SS_sky130_fd_sc_hd__conb_1
Xafe_wb_525 analog_io_out[17] afe_wb_525/HI vccd1 vssd1 vssd1 vccd1 SS_sky130_fd_sc_hd__conb_1
Xafe_wb_503 analog_ctrl[99] afe_wb_503/HI vccd1 vssd1 vssd1 vccd1 SS_sky130_fd_sc_hd__conb_1
XFILLER_100_477 vssd1 vccd1 vccd1 vssd1 SS_sky130_fd_sc_hd__fill_2
XTAP_TAPCELL_ROW_1_310 vccd1 vssd1 SS_sky130_fd_sc_hd__tapvpwrvgnd_1
XTAP_TAPCELL_ROW_1_321 vccd1 vssd1 SS_sky130_fd_sc_hd__tapvpwrvgnd_1
Xafe_wb_547 afe_wb_547/LO analog_io_oeb[11] vccd1 vssd1 vssd1 vccd1 SS_sky130_fd_sc_hd__conb_1
XTAP_TAPCELL_ROW_29_729 vccd1 vssd1 SS_sky130_fd_sc_hd__tapvpwrvgnd_1
Xafe_wb_558 afe_wb_558/LO analog_io_oeb[22] vccd1 vssd1 vssd1 vccd1 SS_sky130_fd_sc_hd__conb_1
XTAP_TAPCELL_ROW_68_1321 vccd1 vssd1 SS_sky130_fd_sc_hd__tapvpwrvgnd_1
XFILLER_100_499 vssd1 vccd1 vssd1 vccd1 SS_sky130_ef_sc_hd__decap_40_12
XFILLER_26_233 vssd1 vccd1 vssd1 vccd1 SS_sky130_ef_sc_hd__decap_40_12
XFILLER_27_778 vssd1 vccd1 vccd1 vssd1 SS_sky130_fd_sc_hd__fill_4
XFILLER_14_417 vssd1 vccd1 vccd1 vssd1 SS_sky130_fd_sc_hd__fill_2
XFILLER_26_277 vssd1 vccd1 vssd1 vccd1 SS_sky130_ef_sc_hd__decap_40_12
XTAP_TAPCELL_ROW_81_1510 vccd1 vssd1 SS_sky130_fd_sc_hd__tapvpwrvgnd_1
XFILLER_81_361 vssd1 vccd1 vccd1 vssd1 SS_sky130_fd_sc_hd__fill_8
XFILLER_41_225 vssd1 vccd1 vssd1 vccd1 SS_sky130_ef_sc_hd__decap_40_12
XFILLER_42_759 vccd1 vssd1 vccd1 vssd1 SS_sky130_fd_sc_hd__fill_1
XFILLER_53_69 vssd1 vccd1 vssd1 vccd1 SS_sky130_ef_sc_hd__decap_40_12
XTAP_TAPCELL_ROW_81_1521 vccd1 vssd1 SS_sky130_fd_sc_hd__tapvpwrvgnd_1
XFILLER_10_601 vssd1 vccd1 vssd1 vccd1 SS_sky130_ef_sc_hd__decap_40_12
XPHY_EDGE_ROW_22_Left_161 vccd1 vssd1 vccd1 vssd1 SS_sky130_fd_sc_hd__decap_3
XTAP_TAPCELL_ROW_40_905 vccd1 vssd1 SS_sky130_fd_sc_hd__tapvpwrvgnd_1
XFILLER_10_645 vssd1 vccd1 vssd1 vccd1 SS_sky130_ef_sc_hd__decap_40_12
XFILLER_50_781 vssd1 vccd1 vssd1 vccd1 SS_sky130_ef_sc_hd__decap_40_12
XFILLER_127_308 vssd1 vccd1 vccd1 vssd1 SS_sky130_fd_sc_hd__fill_8
XFILLER_5_137 vssd1 vccd1 vssd1 vccd1 SS_sky130_ef_sc_hd__decap_40_12
XFILLER_108_533 vssd1 vccd1 vssd1 vccd1 SS_sky130_ef_sc_hd__decap_40_12
XFILLER_108_522 vssd1 vccd1 vccd1 vssd1 SS_sky130_fd_sc_hd__fill_8
XTAP_TAPCELL_ROW_79_1483 vccd1 vssd1 SS_sky130_fd_sc_hd__tapvpwrvgnd_1
XFILLER_123_503 vccd1 vssd1 vccd1 vssd1 SS_sky130_fd_sc_hd__fill_1
XFILLER_2_811 vccd1 vssd1 vccd1 vssd1 SS_sky130_fd_sc_hd__fill_1
XTAP_TAPCELL_ROW_9_432 vccd1 vssd1 SS_sky130_fd_sc_hd__tapvpwrvgnd_1
XFILLER_123_569 vssd1 vccd1 vccd1 vssd1 SS_sky130_fd_sc_hd__fill_2
Xhold690 _1396_/A _1725_/Q vccd1 vssd1 vssd1 vccd1 SS_sky130_fd_sc_hd__dlygate4sd3_1
XFILLER_111_709 vssd1 vccd1 vssd1 vccd1 SS_sky130_ef_sc_hd__decap_40_12
XPHY_EDGE_ROW_31_Left_170 vccd1 vssd1 vccd1 vssd1 SS_sky130_fd_sc_hd__decap_3
XFILLER_78_77 vssd1 vccd1 vccd1 vssd1 SS_sky130_fd_sc_hd__fill_4
XFILLER_89_461 vssd1 vccd1 vssd1 vccd1 SS_sky130_ef_sc_hd__decap_40_12
XTAP_TAPCELL_ROW_92_1683 vccd1 vssd1 SS_sky130_fd_sc_hd__tapvpwrvgnd_1
XFILLER_76_133 vssd1 vccd1 vccd1 vssd1 SS_sky130_fd_sc_hd__fill_4
XFILLER_103_293 vssd1 vccd1 vssd1 vccd1 SS_sky130_ef_sc_hd__decap_40_12
XFILLER_18_701 vssd1 vccd1 vssd1 vccd1 SS_sky130_ef_sc_hd__decap_40_12
XFILLER_76_177 vssd1 vccd1 vssd1 vccd1 SS_sky130_ef_sc_hd__decap_40_12
XFILLER_91_125 vssd1 vccd1 vssd1 vccd1 SS_sky130_ef_sc_hd__decap_40_12
XFILLER_94_65 vssd1 vccd1 vssd1 vccd1 SS_sky130_ef_sc_hd__decap_40_12
XFILLER_27_81 vssd1 vccd1 vssd1 vccd1 SS_sky130_ef_sc_hd__decap_40_12
XFILLER_91_169 vssd1 vccd1 vssd1 vccd1 SS_sky130_ef_sc_hd__decap_40_12
XFILLER_17_277 vssd1 vccd1 vccd1 vssd1 SS_sky130_fd_sc_hd__fill_2
XFILLER_13_461 vssd1 vccd1 vssd1 vccd1 SS_sky130_ef_sc_hd__decap_40_12
X_0960_ vccd1 vssd1 vccd1 vssd1 _0960_/X _1839_/A _0988_/B SS_sky130_fd_sc_hd__or2_2
XFILLER_41_781 vssd1 vccd1 vccd1 vssd1 SS_sky130_fd_sc_hd__fill_2
XFILLER_71_6 vssd1 vccd1 vssd1 vccd1 SS_sky130_ef_sc_hd__decap_40_12
X_0891_ vccd1 vssd1 vccd1 vssd1 _1690_/Q _0891_/B1 _1722_/Q _1343_/A _0895_/B SS_sky130_fd_sc_hd__a22o_2
XFILLER_126_330 vssd1 vccd1 vssd1 vccd1 SS_sky130_ef_sc_hd__decap_40_12
XFILLER_5_671 vccd1 vssd1 vccd1 vssd1 SS_sky130_fd_sc_hd__fill_1
X_1512_ _1838_/A _1573_/CLK _1512_/D vccd1 vssd1 vccd1 vssd1 SS_sky130_fd_sc_hd__dfxtp_2
XFILLER_99_225 vssd1 vccd1 vssd1 vccd1 SS_sky130_ef_sc_hd__decap_40_12
XFILLER_4_41 vssd1 vccd1 vssd1 vccd1 SS_sky130_ef_sc_hd__decap_40_12
XFILLER_114_569 vssd1 vccd1 vccd1 vssd1 SS_sky130_fd_sc_hd__fill_8
X_1443_ vssd1 vccd1 vccd1 vssd1 wire207/X input27/X _1747_/D _1459_/C1 _1442_/X SS_sky130_fd_sc_hd__o211a_2
XFILLER_4_85 vssd1 vccd1 vssd1 vccd1 SS_sky130_ef_sc_hd__decap_40_12
XFILLER_68_601 vssd1 vccd1 vssd1 vccd1 SS_sky130_ef_sc_hd__decap_40_12
XFILLER_67_111 vccd1 vssd1 vccd1 vssd1 SS_sky130_fd_sc_hd__fill_1
XFILLER_68_645 vssd1 vccd1 vssd1 vccd1 SS_sky130_ef_sc_hd__decap_40_12
X_1374_ vccd1 vssd1 vccd1 vssd1 _1374_/X _1374_/A _1396_/B SS_sky130_fd_sc_hd__or2_2
XFILLER_68_689 vssd1 vccd1 vccd1 vssd1 SS_sky130_fd_sc_hd__fill_2
XFILLER_83_615 vccd1 vssd1 vccd1 vssd1 SS_sky130_fd_sc_hd__fill_1
XFILLER_110_753 vssd1 vccd1 vccd1 vssd1 SS_sky130_fd_sc_hd__fill_2
XFILLER_55_317 vssd1 vccd1 vccd1 vssd1 SS_sky130_fd_sc_hd__fill_8
XFILLER_55_339 vccd1 vssd1 vccd1 vssd1 SS_sky130_fd_sc_hd__fill_1
XTAP_TAPCELL_ROW_108_1922 vccd1 vssd1 SS_sky130_fd_sc_hd__tapvpwrvgnd_1
XFILLER_95_497 vssd1 vccd1 vccd1 vssd1 SS_sky130_fd_sc_hd__fill_4
XFILLER_36_531 vccd1 vssd1 vccd1 vssd1 SS_sky130_fd_sc_hd__fill_1
XFILLER_36_553 vccd1 vssd1 vccd1 vssd1 SS_sky130_fd_sc_hd__fill_1
XFILLER_70_309 vssd1 vccd1 vssd1 vccd1 SS_sky130_ef_sc_hd__decap_40_12
XFILLER_24_737 vssd1 vccd1 vssd1 vccd1 SS_sky130_ef_sc_hd__decap_40_12
XFILLER_36_597 vssd1 vccd1 vssd1 vccd1 SS_sky130_ef_sc_hd__decap_40_12
XFILLER_51_501 vssd1 vccd1 vccd1 vssd1 SS_sky130_fd_sc_hd__fill_2
XFILLER_91_670 vssd1 vccd1 vccd1 vssd1 SS_sky130_fd_sc_hd__fill_2
XFILLER_23_225 vssd1 vccd1 vssd1 vccd1 SS_sky130_ef_sc_hd__decap_40_12
XTAP_TAPCELL_ROW_63_1240 vccd1 vssd1 SS_sky130_fd_sc_hd__tapvpwrvgnd_1
XTAP_TAPCELL_ROW_63_1251 vccd1 vssd1 SS_sky130_fd_sc_hd__tapvpwrvgnd_1
XFILLER_32_781 vssd1 vccd1 vssd1 vccd1 SS_sky130_ef_sc_hd__decap_40_12
XFILLER_137_617 vssd1 vccd1 vccd1 vssd1 SS_sky130_fd_sc_hd__fill_2
XFILLER_133_801 vssd1 vccd1 vccd1 vssd1 SS_sky130_fd_sc_hd__fill_2
XFILLER_105_503 vccd1 vssd1 vccd1 vssd1 SS_sky130_fd_sc_hd__fill_1
XFILLER_132_311 vccd1 vssd1 vccd1 vssd1 SS_sky130_fd_sc_hd__fill_1
XFILLER_133_823 vccd1 vssd1 vccd1 vssd1 SS_sky130_fd_sc_hd__fill_1
XFILLER_59_612 vssd1 vccd1 vccd1 vssd1 SS_sky130_fd_sc_hd__fill_4
XFILLER_58_133 vssd1 vccd1 vccd1 vssd1 SS_sky130_fd_sc_hd__fill_4
Xfanout466 vssd1 vccd1 vccd1 vssd1 wire493/X wire467/A SS_sky130_fd_sc_hd__clkdlybuf4s25_1
Xfanout444 vssd1 vccd1 vccd1 vssd1 _0741_/Y wire445/A SS_sky130_fd_sc_hd__clkdlybuf4s25_1
XFILLER_86_475 vccd1 vssd1 vccd1 vssd1 SS_sky130_fd_sc_hd__fill_1
XFILLER_101_753 vssd1 vccd1 vssd1 vccd1 SS_sky130_ef_sc_hd__decap_40_12
XFILLER_58_177 vssd1 vccd1 vssd1 vccd1 SS_sky130_ef_sc_hd__decap_40_12
XFILLER_73_125 vssd1 vccd1 vssd1 vccd1 SS_sky130_ef_sc_hd__decap_40_12
XFILLER_104_53 vssd1 vccd1 vssd1 vccd1 SS_sky130_ef_sc_hd__decap_40_12
XFILLER_27_553 vssd1 vccd1 vccd1 vssd1 SS_sky130_fd_sc_hd__fill_4
XFILLER_39_391 vccd1 vssd1 vccd1 vssd1 SS_sky130_fd_sc_hd__fill_1
XFILLER_104_97 vssd1 vccd1 vssd1 vccd1 SS_sky130_ef_sc_hd__decap_40_12
XFILLER_42_512 vssd1 vccd1 vssd1 vccd1 SS_sky130_ef_sc_hd__decap_40_12
XFILLER_70_810 vssd1 vccd1 vccd1 vssd1 SS_sky130_fd_sc_hd__fill_2
XFILLER_73_169 vssd1 vccd1 vssd1 vccd1 SS_sky130_ef_sc_hd__decap_40_12
XFILLER_27_597 vssd1 vccd1 vssd1 vccd1 SS_sky130_ef_sc_hd__decap_40_12
XFILLER_42_545 vssd1 vccd1 vccd1 vssd1 SS_sky130_fd_sc_hd__fill_2
XFILLER_120_41 vssd1 vccd1 vssd1 vccd1 SS_sky130_ef_sc_hd__decap_40_12
XFILLER_42_589 vssd1 vccd1 vssd1 vccd1 SS_sky130_ef_sc_hd__decap_40_12
XFILLER_23_781 vssd1 vccd1 vccd1 vssd1 SS_sky130_fd_sc_hd__fill_2
XFILLER_120_85 vssd1 vccd1 vssd1 vccd1 SS_sky130_ef_sc_hd__decap_40_12
XFILLER_128_628 vssd1 vccd1 vccd1 vssd1 SS_sky130_fd_sc_hd__fill_4
XFILLER_127_105 vssd1 vccd1 vccd1 vssd1 SS_sky130_fd_sc_hd__fill_4
XFILLER_6_413 vssd1 vccd1 vccd1 vssd1 SS_sky130_fd_sc_hd__fill_4
XFILLER_10_475 vccd1 vssd1 vccd1 vssd1 SS_sky130_fd_sc_hd__fill_1
XFILLER_6_457 vssd1 vccd1 vssd1 vccd1 SS_sky130_ef_sc_hd__decap_40_12
XFILLER_127_149 vssd1 vccd1 vssd1 vccd1 SS_sky130_ef_sc_hd__decap_40_12
XTAP_TAPCELL_ROW_94_1712 vccd1 vssd1 SS_sky130_fd_sc_hd__tapvpwrvgnd_1
XFILLER_123_311 vccd1 vssd1 vccd1 vssd1 SS_sky130_fd_sc_hd__fill_1
XFILLER_108_363 vccd1 vssd1 vccd1 vssd1 SS_sky130_fd_sc_hd__fill_1
XFILLER_2_641 vssd1 vccd1 vccd1 vssd1 SS_sky130_fd_sc_hd__fill_2
XFILLER_135_193 vssd1 vccd1 vssd1 vccd1 SS_sky130_ef_sc_hd__decap_40_12
XFILLER_97_707 vccd1 vssd1 vccd1 vssd1 SS_sky130_fd_sc_hd__fill_1
XFILLER_111_517 vssd1 vccd1 vssd1 vccd1 SS_sky130_ef_sc_hd__decap_40_12
XFILLER_97_729 vssd1 vccd1 vssd1 vccd1 SS_sky130_ef_sc_hd__decap_40_12
XFILLER_49_111 vccd1 vssd1 vccd1 vssd1 SS_sky130_fd_sc_hd__fill_1
XFILLER_37_317 vssd1 vccd1 vssd1 vccd1 SS_sky130_ef_sc_hd__decap_40_12
XFILLER_92_401 vssd1 vccd1 vssd1 vccd1 SS_sky130_ef_sc_hd__decap_40_12
XFILLER_18_531 vccd1 vssd1 vccd1 vssd1 SS_sky130_fd_sc_hd__fill_1
X_1090_ vccd1 vssd1 vccd1 vssd1 _1090_/X _1090_/A _1116_/B SS_sky130_fd_sc_hd__or2_2
XFILLER_80_607 vccd1 vssd1 vccd1 vssd1 SS_sky130_fd_sc_hd__fill_1
XTAP_TAPCELL_ROW_121_2108 vccd1 vssd1 SS_sky130_fd_sc_hd__tapvpwrvgnd_1
XFILLER_92_445 vssd1 vccd1 vccd1 vssd1 SS_sky130_fd_sc_hd__fill_4
XFILLER_33_501 vssd1 vccd1 vccd1 vssd1 SS_sky130_fd_sc_hd__fill_2
XFILLER_45_361 vssd1 vccd1 vssd1 vccd1 SS_sky130_ef_sc_hd__decap_40_12
XFILLER_52_309 vssd1 vccd1 vssd1 vccd1 SS_sky130_ef_sc_hd__decap_40_12
XTAP_TAPCELL_ROW_121_2119 vccd1 vssd1 SS_sky130_fd_sc_hd__tapvpwrvgnd_1
XFILLER_92_489 vssd1 vccd1 vssd1 vccd1 SS_sky130_ef_sc_hd__decap_40_12
XFILLER_21_729 vssd1 vccd1 vssd1 vccd1 SS_sky130_ef_sc_hd__decap_40_12
XTAP_TAPCELL_ROW_103_1852 vccd1 vssd1 SS_sky130_fd_sc_hd__tapvpwrvgnd_1
XTAP_TAPCELL_ROW_103_1841 vccd1 vssd1 SS_sky130_fd_sc_hd__tapvpwrvgnd_1
XFILLER_14_781 vssd1 vccd1 vssd1 vccd1 SS_sky130_ef_sc_hd__decap_40_12
XTAP_TAPCELL_ROW_31_768 vccd1 vssd1 SS_sky130_fd_sc_hd__tapvpwrvgnd_1
Xclkbuf_leaf_35_wb_clk_i clkload5/A clkload0/A vccd1 vssd1 vssd1 vccd1 SS_sky130_fd_sc_hd__clkbuf_8
X_0943_ vssd1 vccd1 vccd1 vssd1 _0943_/B _0943_/C _0943_/A _0943_/X SS_sky130_fd_sc_hd__or3_2
XFILLER_119_617 vssd1 vccd1 vssd1 vccd1 SS_sky130_ef_sc_hd__decap_40_12
XFILLER_9_273 vssd1 vccd1 vccd1 vssd1 SS_sky130_fd_sc_hd__fill_4
Xclkload10 vssd1 vccd1 _1608_/CLK clkload10/X vccd1 vssd1 SS_sky130_fd_sc_hd__clkbuf_4
X_0874_ vssd1 vccd1 vssd1 vccd1 _0874_/A2 _1450_/A _0873_/X _0874_/X SS_sky130_fd_sc_hd__a21o_2
XTAP_TAPCELL_ROW_136_2340 vccd1 vssd1 SS_sky130_fd_sc_hd__tapvpwrvgnd_1
XTAP_TAPCELL_ROW_11_470 vccd1 vssd1 SS_sky130_fd_sc_hd__tapvpwrvgnd_1
Xclkload21 vssd1 vccd1 _1751_/CLK clkload21/X vccd1 vssd1 SS_sky130_fd_sc_hd__clkbuf_4
XFILLER_126_193 vssd1 vccd1 vccd1 vssd1 SS_sky130_fd_sc_hd__fill_2
XFILLER_87_217 vssd1 vccd1 vccd1 vssd1 SS_sky130_fd_sc_hd__fill_4
XFILLER_114_377 vssd1 vccd1 vssd1 vccd1 SS_sky130_ef_sc_hd__decap_40_12
X_1426_ vccd1 vssd1 vccd1 vssd1 _1426_/X _1426_/A _1454_/B SS_sky130_fd_sc_hd__or2_2
X_1357_ vssd1 vccd1 vccd1 vssd1 _1369_/A2 wire497/X _1705_/D _1423_/C1 _1356_/X SS_sky130_fd_sc_hd__o211a_2
XFILLER_55_125 vssd1 vccd1 vssd1 vccd1 SS_sky130_ef_sc_hd__decap_40_12
XFILLER_68_475 vccd1 vssd1 vccd1 vssd1 SS_sky130_fd_sc_hd__fill_1
XFILLER_95_261 vssd1 vccd1 vssd1 vccd1 SS_sky130_ef_sc_hd__decap_40_12
X_1288_ vccd1 vssd1 vccd1 vssd1 _1288_/X _1890_/A _1338_/B SS_sky130_fd_sc_hd__or2_2
XFILLER_24_501 vssd1 vccd1 vssd1 vccd1 SS_sky130_ef_sc_hd__decap_40_12
XFILLER_36_361 vssd1 vccd1 vccd1 vssd1 SS_sky130_fd_sc_hd__fill_2
XTAP_TAPCELL_ROW_39_879 vccd1 vssd1 SS_sky130_fd_sc_hd__tapvpwrvgnd_1
XFILLER_55_169 vssd1 vccd1 vssd1 vccd1 SS_sky130_ef_sc_hd__decap_40_12
XFILLER_71_629 vssd1 vccd1 vccd1 vssd1 SS_sky130_fd_sc_hd__fill_2
XFILLER_83_478 vssd1 vccd1 vccd1 vssd1 SS_sky130_fd_sc_hd__fill_8
XTAP_TAPCELL_ROW_19_581 vccd1 vssd1 SS_sky130_fd_sc_hd__tapvpwrvgnd_1
XTAP_TAPCELL_ROW_19_592 vccd1 vssd1 SS_sky130_fd_sc_hd__tapvpwrvgnd_1
XFILLER_24_545 vssd1 vccd1 vssd1 vccd1 SS_sky130_ef_sc_hd__decap_40_12
XFILLER_34_27 vccd1 vssd1 vccd1 vssd1 SS_sky130_fd_sc_hd__fill_1
XFILLER_70_139 vccd1 vssd1 vccd1 vssd1 SS_sky130_fd_sc_hd__fill_1
XFILLER_11_217 vssd1 vccd1 vccd1 vssd1 SS_sky130_fd_sc_hd__fill_4
XFILLER_24_589 vssd1 vccd1 vssd1 vccd1 SS_sky130_ef_sc_hd__decap_40_12
XFILLER_20_751 vssd1 vccd1 vccd1 vssd1 SS_sky130_fd_sc_hd__fill_4
XFILLER_50_15 vssd1 vccd1 vssd1 vccd1 SS_sky130_ef_sc_hd__decap_40_12
Xclkload4 clkload4/X clkload4/A vccd1 vssd1 vssd1 vccd1 SS_sky130_fd_sc_hd__clkbuf_8
XFILLER_109_105 vssd1 vccd1 vccd1 vssd1 SS_sky130_fd_sc_hd__fill_4
XFILLER_137_447 vccd1 vssd1 vccd1 vssd1 SS_sky130_fd_sc_hd__fill_1
XFILLER_125_609 vssd1 vccd1 vccd1 vssd1 SS_sky130_fd_sc_hd__fill_4
XFILLER_109_149 vssd1 vccd1 vssd1 vccd1 SS_sky130_ef_sc_hd__decap_40_12
XFILLER_3_405 vssd1 vccd1 vssd1 vccd1 SS_sky130_ef_sc_hd__decap_40_12
XTAP_TAPCELL_ROW_76_1442 vccd1 vssd1 SS_sky130_fd_sc_hd__tapvpwrvgnd_1
XFILLER_105_311 vccd1 vssd1 vccd1 vssd1 SS_sky130_fd_sc_hd__fill_1
XFILLER_1_6 vssd1 vccd1 vssd1 vccd1 SS_sky130_ef_sc_hd__decap_40_12
XFILLER_3_449 vssd1 vccd1 vssd1 vccd1 SS_sky130_ef_sc_hd__decap_40_12
XFILLER_133_642 vssd1 vccd1 vssd1 vccd1 SS_sky130_ef_sc_hd__decap_40_12
XFILLER_117_193 vssd1 vccd1 vssd1 vccd1 SS_sky130_ef_sc_hd__decap_40_12
XFILLER_59_57 vssd1 vccd1 vssd1 vccd1 SS_sky130_ef_sc_hd__decap_40_12
XFILLER_79_729 vssd1 vccd1 vssd1 vccd1 SS_sky130_ef_sc_hd__decap_40_12
XFILLER_132_141 vssd1 vccd1 vssd1 vccd1 SS_sky130_ef_sc_hd__decap_40_12
XFILLER_120_314 vssd1 vccd1 vssd1 vccd1 SS_sky130_ef_sc_hd__decap_40_12
Xfanout230 vssd1 vccd1 vccd1 vssd1 _1264_/B _1272_/B SS_sky130_fd_sc_hd__clkdlybuf4s25_1
XFILLER_105_388 vssd1 vccd1 vccd1 vssd1 SS_sky130_fd_sc_hd__fill_4
Xfanout252 vssd1 vccd1 vccd1 vssd1 fanout254/X wire253/A SS_sky130_fd_sc_hd__clkdlybuf4s25_1
XFILLER_19_317 vssd1 vccd1 vssd1 vccd1 SS_sky130_ef_sc_hd__decap_40_12
XFILLER_101_561 vssd1 vccd1 vssd1 vccd1 SS_sky130_ef_sc_hd__decap_40_12
XFILLER_62_607 vssd1 vccd1 vssd1 vccd1 SS_sky130_ef_sc_hd__decap_40_12
XFILLER_74_456 vssd1 vccd1 vssd1 vccd1 SS_sky130_ef_sc_hd__decap_40_12
XFILLER_15_501 vssd1 vccd1 vccd1 vssd1 SS_sky130_fd_sc_hd__fill_2
XFILLER_27_361 vssd1 vccd1 vssd1 vccd1 SS_sky130_ef_sc_hd__decap_40_12
XFILLER_34_309 vssd1 vccd1 vssd1 vccd1 SS_sky130_ef_sc_hd__decap_40_12
XFILLER_55_670 vssd1 vccd1 vccd1 vssd1 SS_sky130_fd_sc_hd__fill_2
XFILLER_74_489 vssd1 vccd1 vccd1 vssd1 SS_sky130_fd_sc_hd__fill_2
XFILLER_11_751 vssd1 vccd1 vssd1 vccd1 SS_sky130_ef_sc_hd__decap_40_12
XFILLER_6_221 vssd1 vccd1 vssd1 vccd1 SS_sky130_ef_sc_hd__decap_40_12
XFILLER_7_777 vssd1 vccd1 vccd1 vssd1 SS_sky130_fd_sc_hd__fill_4
XFILLER_128_469 vssd1 vccd1 vccd1 vssd1 SS_sky130_fd_sc_hd__fill_4
XTAP_TAPCELL_ROW_118_2070 vccd1 vssd1 SS_sky130_fd_sc_hd__tapvpwrvgnd_1
XFILLER_6_265 vssd1 vccd1 vssd1 vccd1 SS_sky130_ef_sc_hd__decap_40_12
XFILLER_40_81 vssd1 vccd1 vccd1 vssd1 SS_sky130_fd_sc_hd__fill_2
XFILLER_124_642 vssd1 vccd1 vccd1 vssd1 SS_sky130_fd_sc_hd__fill_2
XFILLER_108_193 vssd1 vccd1 vccd1 vssd1 SS_sky130_fd_sc_hd__fill_2
XFILLER_69_217 vssd1 vccd1 vccd1 vssd1 SS_sky130_fd_sc_hd__fill_4
XTAP_TAPCELL_ROW_131_2270 vccd1 vssd1 SS_sky130_fd_sc_hd__tapvpwrvgnd_1
XFILLER_124_697 vssd1 vccd1 vccd1 vssd1 SS_sky130_fd_sc_hd__fill_2
XFILLER_111_325 vssd1 vccd1 vccd1 vssd1 SS_sky130_fd_sc_hd__fill_8
XFILLER_97_559 vccd1 vssd1 vccd1 vssd1 SS_sky130_fd_sc_hd__fill_1
XFILLER_84_209 vssd1 vccd1 vssd1 vccd1 SS_sky130_ef_sc_hd__decap_40_12
X_1211_ vccd1 vssd1 vssd1 vccd1 _1211_/Y _1211_/A _1409_/B SS_sky130_fd_sc_hd__nand2_2
XFILLER_77_261 vssd1 vccd1 vssd1 vccd1 SS_sky130_ef_sc_hd__decap_40_12
XFILLER_1_42 vssd1 vccd1 vssd1 vccd1 SS_sky130_ef_sc_hd__decap_40_12
XFILLER_37_125 vssd1 vccd1 vssd1 vccd1 SS_sky130_ef_sc_hd__decap_40_12
XFILLER_65_445 vssd1 vccd1 vccd1 vssd1 SS_sky130_fd_sc_hd__fill_2
X_1142_ vccd1 vssd1 vccd1 vssd1 _1142_/X _1602_/Q _1142_/B SS_sky130_fd_sc_hd__or2_2
XFILLER_18_361 vssd1 vccd1 vccd1 vssd1 SS_sky130_fd_sc_hd__fill_2
XFILLER_37_169 vssd1 vccd1 vssd1 vccd1 SS_sky130_ef_sc_hd__decap_40_12
XFILLER_53_607 vccd1 vssd1 vccd1 vssd1 SS_sky130_fd_sc_hd__fill_1
XFILLER_80_404 vssd1 vccd1 vssd1 vccd1 SS_sky130_ef_sc_hd__decap_40_12
X_1073_ vssd1 vccd1 vccd1 vssd1 _1077_/A2 input41/X _1568_/D _1403_/C1 _1072_/X SS_sky130_fd_sc_hd__o211a_2
XFILLER_92_253 vssd1 vccd1 vssd1 vccd1 SS_sky130_ef_sc_hd__decap_40_12
XTAP_TAPCELL_ROW_36_838 vccd1 vssd1 SS_sky130_fd_sc_hd__tapvpwrvgnd_1
XFILLER_46_681 vssd1 vccd1 vssd1 vccd1 SS_sky130_ef_sc_hd__decap_40_12
XTAP_TAPCELL_ROW_47_1010 vccd1 vssd1 SS_sky130_fd_sc_hd__tapvpwrvgnd_1
XFILLER_52_139 vccd1 vssd1 vccd1 vssd1 SS_sky130_fd_sc_hd__fill_1
XFILLER_80_437 vssd1 vccd1 vccd1 vssd1 SS_sky130_fd_sc_hd__fill_2
XFILLER_80_459 vssd1 vccd1 vssd1 vccd1 SS_sky130_ef_sc_hd__decap_40_12
XTAP_TAPCELL_ROW_16_540 vccd1 vssd1 SS_sky130_fd_sc_hd__tapvpwrvgnd_1
XFILLER_61_673 vssd1 vccd1 vssd1 vccd1 SS_sky130_ef_sc_hd__decap_40_12
XFILLER_21_559 vccd1 vssd1 vccd1 vssd1 SS_sky130_fd_sc_hd__fill_1
X_0926_ vccd1 vssd1 vssd1 vccd1 _0922_/X _0925_/X _0926_/A2 _1503_/Q _0926_/X _1473_/C1
+ SS_sky130_fd_sc_hd__o221a_2
XFILLER_119_447 vccd1 vssd1 vccd1 vssd1 SS_sky130_fd_sc_hd__fill_1
XFILLER_107_609 vssd1 vccd1 vccd1 vssd1 SS_sky130_fd_sc_hd__fill_4
XFILLER_20_29 vssd1 vccd1 vssd1 vccd1 SS_sky130_ef_sc_hd__decap_40_12
X_0857_ vccd1 vssd1 vccd1 vssd1 _1862_/A wire443/X _1684_/Q _0891_/B1 _0857_/X SS_sky130_fd_sc_hd__a22o_2
XFILLER_136_18 vssd1 vccd1 vccd1 vssd1 SS_sky130_fd_sc_hd__fill_8
XFILLER_115_642 vssd1 vccd1 vssd1 vccd1 SS_sky130_ef_sc_hd__decap_40_12
X_0788_ vccd1 vssd1 vssd1 vccd1 _0784_/X _0787_/X _0926_/A2 _1480_/Q _1480_/D _1431_/C1
+ SS_sky130_fd_sc_hd__o221a_2
XFILLER_0_419 vccd1 vssd1 vccd1 vssd1 SS_sky130_fd_sc_hd__fill_1
XTAP_TAPCELL_ROW_58_1172 vccd1 vssd1 SS_sky130_fd_sc_hd__tapvpwrvgnd_1
XFILLER_130_601 vssd1 vccd1 vssd1 vccd1 SS_sky130_ef_sc_hd__decap_40_12
XFILLER_114_141 vssd1 vccd1 vssd1 vccd1 SS_sky130_ef_sc_hd__decap_40_12
XFILLER_130_645 vssd1 vccd1 vssd1 vccd1 SS_sky130_ef_sc_hd__decap_40_12
XFILLER_29_27 vssd1 vccd1 vssd1 vccd1 SS_sky130_ef_sc_hd__decap_40_12
XTAP_TAPCELL_ROW_71_1361 vccd1 vssd1 SS_sky130_fd_sc_hd__tapvpwrvgnd_1
XTAP_TAPCELL_ROW_71_1372 vccd1 vssd1 SS_sky130_fd_sc_hd__tapvpwrvgnd_1
XPHY_EDGE_ROW_89_Right_89 vccd1 vssd1 vccd1 vssd1 SS_sky130_fd_sc_hd__decap_3
X_1409_ vccd1 vssd1 vssd1 vccd1 _1409_/Y _1409_/A _1409_/B SS_sky130_fd_sc_hd__nand2_2
XFILLER_29_615 vccd1 vssd1 vccd1 vssd1 SS_sky130_fd_sc_hd__fill_1
XFILLER_29_626 vssd1 vccd1 vssd1 vccd1 SS_sky130_ef_sc_hd__decap_40_12
XFILLER_56_412 vssd1 vccd1 vccd1 vssd1 SS_sky130_fd_sc_hd__fill_8
XFILLER_56_445 vssd1 vccd1 vssd1 vccd1 SS_sky130_ef_sc_hd__decap_40_12
XFILLER_84_765 vssd1 vccd1 vssd1 vccd1 SS_sky130_ef_sc_hd__decap_40_12
XFILLER_110_391 vssd1 vccd1 vssd1 vccd1 SS_sky130_ef_sc_hd__decap_40_12
XFILLER_16_309 vssd1 vccd1 vssd1 vccd1 SS_sky130_ef_sc_hd__decap_40_12
XFILLER_37_670 vssd1 vccd1 vccd1 vssd1 SS_sky130_fd_sc_hd__fill_2
XFILLER_45_15 vssd1 vccd1 vssd1 vccd1 SS_sky130_ef_sc_hd__decap_40_12
XFILLER_56_489 vssd1 vccd1 vssd1 vccd1 SS_sky130_ef_sc_hd__decap_40_12
XFILLER_84_787 vccd1 vssd1 vccd1 vssd1 SS_sky130_fd_sc_hd__fill_1
XFILLER_40_813 vccd1 vssd1 vccd1 vssd1 SS_sky130_fd_sc_hd__fill_1
XFILLER_51_161 vssd1 vccd1 vccd1 vssd1 SS_sky130_fd_sc_hd__fill_4
XFILLER_101_54 vssd1 vccd1 vccd1 vssd1 SS_sky130_fd_sc_hd__fill_2
XPHY_EDGE_ROW_98_Right_98 vccd1 vssd1 vccd1 vssd1 SS_sky130_fd_sc_hd__decap_3
XFILLER_61_69 vssd1 vccd1 vssd1 vccd1 SS_sky130_ef_sc_hd__decap_40_12
XFILLER_137_211 vssd1 vccd1 vccd1 vssd1 SS_sky130_fd_sc_hd__fill_2
XFILLER_137_200 vssd1 vccd1 vccd1 vssd1 SS_sky130_fd_sc_hd__fill_2
XFILLER_20_581 vssd1 vccd1 vccd1 vssd1 SS_sky130_fd_sc_hd__fill_4
XFILLER_4_725 vssd1 vccd1 vssd1 vccd1 SS_sky130_ef_sc_hd__decap_40_12
XFILLER_137_277 vssd1 vccd1 vccd1 vssd1 SS_sky130_fd_sc_hd__fill_2
XFILLER_137_266 vccd1 vssd1 vccd1 vssd1 SS_sky130_fd_sc_hd__fill_1
XFILLER_117_3 vssd1 vccd1 vssd1 vccd1 SS_sky130_ef_sc_hd__decap_40_12
XFILLER_106_642 vssd1 vccd1 vccd1 vssd1 SS_sky130_fd_sc_hd__fill_2
XFILLER_4_769 vssd1 vccd1 vssd1 vccd1 SS_sky130_ef_sc_hd__decap_40_12
XPHY_EDGE_ROW_5_Left_144 vccd1 vssd1 vccd1 vssd1 SS_sky130_fd_sc_hd__decap_3
XFILLER_121_601 vssd1 vccd1 vssd1 vccd1 SS_sky130_ef_sc_hd__decap_40_12
XFILLER_3_279 vccd1 vssd1 vccd1 vssd1 SS_sky130_fd_sc_hd__fill_1
XFILLER_121_634 vssd1 vccd1 vssd1 vccd1 SS_sky130_ef_sc_hd__decap_40_12
XFILLER_66_209 vssd1 vccd1 vssd1 vccd1 SS_sky130_ef_sc_hd__decap_40_12
XFILLER_120_133 vssd1 vccd1 vccd1 vssd1 SS_sky130_fd_sc_hd__fill_4
XFILLER_59_261 vssd1 vccd1 vssd1 vccd1 SS_sky130_ef_sc_hd__decap_40_12
XFILLER_86_77 vssd1 vccd1 vccd1 vssd1 SS_sky130_fd_sc_hd__fill_4
XFILLER_120_177 vssd1 vccd1 vssd1 vccd1 SS_sky130_ef_sc_hd__decap_40_12
XFILLER_94_529 vssd1 vccd1 vccd1 vssd1 SS_sky130_fd_sc_hd__fill_2
XFILLER_19_125 vssd1 vccd1 vssd1 vccd1 SS_sky130_ef_sc_hd__decap_40_12
XTAP_TAPCELL_ROW_89_1633 vccd1 vssd1 SS_sky130_fd_sc_hd__tapvpwrvgnd_1
XFILLER_101_391 vccd1 vssd1 vccd1 vssd1 SS_sky130_fd_sc_hd__fill_1
XFILLER_19_93 vssd1 vccd1 vssd1 vccd1 SS_sky130_ef_sc_hd__decap_40_12
XFILLER_19_169 vssd1 vccd1 vssd1 vccd1 SS_sky130_ef_sc_hd__decap_40_12
XFILLER_35_629 vssd1 vccd1 vssd1 vccd1 SS_sky130_ef_sc_hd__decap_40_12
XFILLER_74_253 vssd1 vccd1 vssd1 vccd1 SS_sky130_ef_sc_hd__decap_40_12
XFILLER_28_681 vssd1 vccd1 vssd1 vccd1 SS_sky130_ef_sc_hd__decap_40_12
XFILLER_34_139 vccd1 vssd1 vccd1 vssd1 SS_sky130_fd_sc_hd__fill_1
XFILLER_90_757 vssd1 vccd1 vssd1 vccd1 SS_sky130_ef_sc_hd__decap_40_12
XFILLER_30_301 vssd1 vccd1 vccd1 vssd1 SS_sky130_fd_sc_hd__fill_4
XFILLER_35_81 vssd1 vccd1 vssd1 vccd1 SS_sky130_ef_sc_hd__decap_40_12
XFILLER_43_673 vssd1 vccd1 vssd1 vccd1 SS_sky130_ef_sc_hd__decap_40_12
XTAP_TAPCELL_ROW_100_1800 vccd1 vssd1 SS_sky130_fd_sc_hd__tapvpwrvgnd_1
XFILLER_30_345 vssd1 vccd1 vssd1 vccd1 SS_sky130_ef_sc_hd__decap_40_12
XFILLER_129_701 vssd1 vccd1 vccd1 vssd1 SS_sky130_fd_sc_hd__fill_2
XFILLER_30_389 vssd1 vccd1 vssd1 vccd1 SS_sky130_ef_sc_hd__decap_40_12
XFILLER_129_723 vssd1 vccd1 vccd1 vssd1 SS_sky130_fd_sc_hd__fill_4
X_1760_ _1760_/Q _1760_/CLK _1760_/D vccd1 vssd1 vccd1 vssd1 SS_sky130_fd_sc_hd__dfxtp_2
XFILLER_7_541 vssd1 vccd1 vssd1 vccd1 SS_sky130_ef_sc_hd__decap_40_12
XFILLER_128_233 vssd1 vccd1 vssd1 vccd1 SS_sky130_ef_sc_hd__decap_40_12
XFILLER_7_585 vssd1 vccd1 vssd1 vccd1 SS_sky130_ef_sc_hd__decap_40_12
XFILLER_128_277 vssd1 vccd1 vssd1 vccd1 SS_sky130_ef_sc_hd__decap_40_12
X_1691_ _1691_/Q _1755_/CLK _1691_/D vccd1 vssd1 vccd1 vssd1 SS_sky130_fd_sc_hd__dfxtp_2
XFILLER_116_417 vssd1 vccd1 vccd1 vssd1 SS_sky130_fd_sc_hd__fill_2
Xwire494 vccd1 vssd1 wire494/X wire494/A vccd1 vssd1 SS_sky130_fd_sc_hd__buf_4
XFILLER_128_299 vccd1 vssd1 vccd1 vssd1 SS_sky130_fd_sc_hd__fill_1
Xmax_cap227 vccd1 vssd1 _1267_/A2 _1273_/A2 vccd1 vssd1 SS_sky130_fd_sc_hd__buf_6
XFILLER_98_813 vccd1 vssd1 vccd1 vssd1 SS_sky130_fd_sc_hd__fill_1
XFILLER_32_3 vssd1 vccd1 vssd1 vccd1 SS_sky130_ef_sc_hd__decap_40_12
XFILLER_111_111 vccd1 vssd1 vccd1 vssd1 SS_sky130_fd_sc_hd__fill_1
XFILLER_97_334 vssd1 vccd1 vccd1 vssd1 SS_sky130_fd_sc_hd__fill_2
XFILLER_112_645 vssd1 vccd1 vssd1 vccd1 SS_sky130_ef_sc_hd__decap_40_12
XTAP_TAPCELL_ROW_111_1962 vccd1 vssd1 SS_sky130_fd_sc_hd__tapvpwrvgnd_1
XFILLER_38_401 vssd1 vccd1 vssd1 vccd1 SS_sky130_ef_sc_hd__decap_40_12
XTAP_TAPCELL_ROW_53_1091 vccd1 vssd1 SS_sky130_fd_sc_hd__tapvpwrvgnd_1
Xload_slew488 vccd1 vssd1 _1401_/C1 _1403_/C1 vccd1 vssd1 SS_sky130_fd_sc_hd__buf_4
Xload_slew477 vccd1 vssd1 _1451_/C1 _1251_/C1 vccd1 vssd1 SS_sky130_fd_sc_hd__buf_4
XFILLER_38_445 vssd1 vccd1 vssd1 vccd1 SS_sky130_ef_sc_hd__decap_40_12
XFILLER_38_467 vccd1 vssd1 vccd1 vssd1 SS_sky130_fd_sc_hd__fill_1
XFILLER_38_489 vssd1 vccd1 vssd1 vccd1 SS_sky130_ef_sc_hd__decap_40_12
X_1125_ vssd1 vccd1 vccd1 vssd1 wire241/X input34/X _1593_/D _1457_/C1 _1124_/X SS_sky130_fd_sc_hd__o211a_2
XFILLER_19_692 vssd1 vccd1 vccd1 vssd1 SS_sky130_fd_sc_hd__fill_8
XFILLER_81_746 vssd1 vccd1 vccd1 vssd1 SS_sky130_fd_sc_hd__fill_2
XFILLER_81_757 vssd1 vccd1 vssd1 vccd1 SS_sky130_ef_sc_hd__decap_40_12
XFILLER_80_245 vssd1 vccd1 vccd1 vssd1 SS_sky130_fd_sc_hd__fill_4
X_1056_ vccd1 vssd1 vccd1 vssd1 _1056_/X _1056_/A _1076_/B SS_sky130_fd_sc_hd__or2_2
XFILLER_22_813 vccd1 vssd1 vccd1 vssd1 SS_sky130_fd_sc_hd__fill_1
XFILLER_33_161 vssd1 vccd1 vccd1 vssd1 SS_sky130_fd_sc_hd__fill_4
XFILLER_40_109 vssd1 vccd1 vssd1 vccd1 SS_sky130_ef_sc_hd__decap_40_12
XFILLER_61_481 vccd1 vssd1 vccd1 vssd1 SS_sky130_fd_sc_hd__fill_1
XFILLER_80_289 vssd1 vccd1 vssd1 vccd1 SS_sky130_ef_sc_hd__decap_40_12
XFILLER_21_389 vssd1 vccd1 vccd1 vssd1 SS_sky130_fd_sc_hd__fill_2
X_1889_ vccd1 vssd1 _1889_/X _1889_/A vccd1 vssd1 SS_sky130_fd_sc_hd__buf_2
X_0909_ vccd1 vssd1 vccd1 vssd1 _1565_/Q _1012_/A _1597_/Q wire445/A _0909_/X SS_sky130_fd_sc_hd__a22o_2
XFILLER_119_277 vssd1 vccd1 vccd1 vssd1 SS_sky130_fd_sc_hd__fill_2
XFILLER_107_417 vssd1 vccd1 vssd1 vccd1 SS_sky130_ef_sc_hd__decap_40_12
XTAP_TAPCELL_ROW_73_1401 vccd1 vssd1 SS_sky130_fd_sc_hd__tapvpwrvgnd_1
XFILLER_103_601 vssd1 vccd1 vccd1 vssd1 SS_sky130_fd_sc_hd__fill_2
XFILLER_88_301 vssd1 vccd1 vccd1 vssd1 SS_sky130_fd_sc_hd__fill_4
XFILLER_0_249 vssd1 vccd1 vccd1 vssd1 SS_sky130_fd_sc_hd__fill_2
XFILLER_88_356 vssd1 vccd1 vccd1 vssd1 SS_sky130_fd_sc_hd__fill_8
XFILLER_102_133 vssd1 vccd1 vccd1 vssd1 SS_sky130_fd_sc_hd__fill_4
XFILLER_48_209 vssd1 vccd1 vssd1 vccd1 SS_sky130_ef_sc_hd__decap_40_12
XFILLER_57_721 vssd1 vccd1 vccd1 vssd1 SS_sky130_fd_sc_hd__fill_2
XFILLER_76_529 vssd1 vccd1 vccd1 vssd1 SS_sky130_fd_sc_hd__fill_2
XFILLER_88_389 vssd1 vccd1 vssd1 vccd1 SS_sky130_ef_sc_hd__decap_40_12
XFILLER_130_475 vccd1 vssd1 vccd1 vssd1 SS_sky130_fd_sc_hd__fill_1
XFILLER_102_177 vssd1 vccd1 vssd1 vccd1 SS_sky130_ef_sc_hd__decap_40_12
XFILLER_29_445 vssd1 vccd1 vccd1 vssd1 SS_sky130_fd_sc_hd__fill_2
XFILLER_17_629 vssd1 vccd1 vssd1 vccd1 SS_sky130_ef_sc_hd__decap_40_12
XFILLER_56_253 vssd1 vccd1 vssd1 vccd1 SS_sky130_ef_sc_hd__decap_40_12
XFILLER_57_787 vccd1 vssd1 vccd1 vssd1 SS_sky130_fd_sc_hd__fill_1
XFILLER_72_713 vssd1 vccd1 vssd1 vccd1 SS_sky130_ef_sc_hd__decap_40_12
XFILLER_16_139 vccd1 vssd1 vccd1 vssd1 SS_sky130_fd_sc_hd__fill_1
XFILLER_71_223 vccd1 vssd1 vccd1 vssd1 SS_sky130_fd_sc_hd__fill_1
XFILLER_72_757 vssd1 vccd1 vccd1 vssd1 SS_sky130_fd_sc_hd__fill_4
XFILLER_25_662 vssd1 vccd1 vccd1 vssd1 SS_sky130_fd_sc_hd__fill_8
XFILLER_44_459 vssd1 vccd1 vssd1 vccd1 SS_sky130_ef_sc_hd__decap_40_12
XFILLER_112_53 vssd1 vccd1 vssd1 vccd1 SS_sky130_ef_sc_hd__decap_40_12
XFILLER_12_301 vssd1 vccd1 vccd1 vssd1 SS_sky130_fd_sc_hd__fill_4
XFILLER_25_673 vssd1 vccd1 vssd1 vccd1 SS_sky130_ef_sc_hd__decap_40_12
XFILLER_31_109 vssd1 vccd1 vccd1 vssd1 SS_sky130_fd_sc_hd__fill_2
XFILLER_52_470 vssd1 vccd1 vccd1 vssd1 SS_sky130_fd_sc_hd__fill_4
XTAP_TAPCELL_ROW_84_1563 vccd1 vssd1 SS_sky130_fd_sc_hd__tapvpwrvgnd_1
XFILLER_112_97 vssd1 vccd1 vssd1 vccd1 SS_sky130_ef_sc_hd__decap_40_12
XFILLER_9_817 vccd1 vssd1 vccd1 vssd1 SS_sky130_fd_sc_hd__fill_1
XFILLER_12_345 vssd1 vccd1 vssd1 vccd1 SS_sky130_ef_sc_hd__decap_40_12
XFILLER_40_643 vccd1 vssd1 vccd1 vssd1 SS_sky130_fd_sc_hd__fill_1
XFILLER_8_305 vssd1 vccd1 vccd1 vssd1 SS_sky130_fd_sc_hd__fill_2
XPHY_EDGE_ROW_117_Right_117 vccd1 vssd1 vccd1 vssd1 SS_sky130_fd_sc_hd__decap_3
XFILLER_12_389 vssd1 vccd1 vssd1 vccd1 SS_sky130_ef_sc_hd__decap_40_12
XFILLER_138_531 vccd1 vssd1 vccd1 vssd1 SS_sky130_fd_sc_hd__fill_1
XFILLER_4_533 vssd1 vccd1 vssd1 vccd1 SS_sky130_ef_sc_hd__decap_40_12
XFILLER_125_225 vssd1 vccd1 vssd1 vccd1 SS_sky130_ef_sc_hd__decap_40_12
XFILLER_98_109 vssd1 vccd1 vssd1 vccd1 SS_sky130_ef_sc_hd__decap_40_12
XFILLER_106_483 vssd1 vccd1 vssd1 vccd1 SS_sky130_ef_sc_hd__decap_40_12
XFILLER_79_345 vssd1 vccd1 vssd1 vccd1 SS_sky130_ef_sc_hd__decap_40_12
XFILLER_0_783 vccd1 vssd1 vccd1 vssd1 SS_sky130_fd_sc_hd__fill_1
XFILLER_121_497 vssd1 vccd1 vccd1 vssd1 SS_sky130_fd_sc_hd__fill_4
XFILLER_75_573 vssd1 vccd1 vssd1 vccd1 SS_sky130_ef_sc_hd__decap_40_12
XFILLER_90_521 vssd1 vccd1 vccd1 vssd1 SS_sky130_fd_sc_hd__fill_8
XTAP_TAPCELL_ROW_126_2191 vccd1 vssd1 SS_sky130_fd_sc_hd__tapvpwrvgnd_1
XFILLER_62_245 vssd1 vccd1 vccd1 vssd1 SS_sky130_fd_sc_hd__fill_4
XFILLER_63_757 vssd1 vccd1 vccd1 vssd1 SS_sky130_fd_sc_hd__fill_2
XFILLER_15_161 vssd1 vccd1 vccd1 vssd1 SS_sky130_fd_sc_hd__fill_4
XFILLER_16_684 vssd1 vccd1 vssd1 vccd1 SS_sky130_ef_sc_hd__decap_40_12
XFILLER_22_109 vssd1 vccd1 vssd1 vccd1 SS_sky130_ef_sc_hd__decap_40_12
XTAP_TAPCELL_ROW_46_988 vccd1 vssd1 SS_sky130_fd_sc_hd__tapvpwrvgnd_1
XFILLER_62_289 vssd1 vccd1 vssd1 vccd1 SS_sky130_ef_sc_hd__decap_40_12
XFILLER_90_587 vccd1 vssd1 vccd1 vssd1 SS_sky130_fd_sc_hd__fill_1
XTAP_TAPCELL_ROW_26_690 vccd1 vssd1 SS_sky130_fd_sc_hd__tapvpwrvgnd_1
XFILLER_71_790 vssd1 vccd1 vccd1 vssd1 SS_sky130_fd_sc_hd__fill_2
XFILLER_30_153 vssd1 vccd1 vssd1 vccd1 SS_sky130_ef_sc_hd__decap_40_12
XFILLER_30_197 vssd1 vccd1 vssd1 vccd1 SS_sky130_ef_sc_hd__decap_40_12
XPHY_EDGE_ROW_68_Left_207 vccd1 vssd1 vccd1 vssd1 SS_sky130_fd_sc_hd__decap_3
X_1743_ _1907_/A _1752_/CLK _1743_/D vccd1 vssd1 vccd1 vssd1 SS_sky130_fd_sc_hd__dfxtp_2
XFILLER_7_393 vssd1 vccd1 vssd1 vccd1 SS_sky130_ef_sc_hd__decap_40_12
Xwire280 vccd1 vssd1 vssd1 vccd1 wire280/A analog_ctrl[16] SS_sky130_fd_sc_hd__buf_12
X_1674_ _1674_/Q _1738_/CLK _1674_/D vccd1 vssd1 vccd1 vssd1 SS_sky130_fd_sc_hd__dfxtp_2
Xwire291 vccd1 vssd1 vssd1 vccd1 wire291/A analog_ctrl[117] SS_sky130_fd_sc_hd__buf_12
XFILLER_89_109 vssd1 vccd1 vccd1 vssd1 SS_sky130_fd_sc_hd__fill_2
XTAP_TAPCELL_ROW_55_1120 vccd1 vssd1 SS_sky130_fd_sc_hd__tapvpwrvgnd_1
XTAP_TAPCELL_ROW_55_1131 vccd1 vssd1 SS_sky130_fd_sc_hd__tapvpwrvgnd_1
XFILLER_131_217 vssd1 vccd1 vccd1 vssd1 SS_sky130_fd_sc_hd__fill_4
XFILLER_125_781 vssd1 vccd1 vccd1 vssd1 SS_sky130_fd_sc_hd__fill_2
XFILLER_98_643 vccd1 vssd1 vccd1 vssd1 SS_sky130_fd_sc_hd__fill_1
XFILLER_58_529 vssd1 vccd1 vccd1 vssd1 SS_sky130_fd_sc_hd__fill_2
XFILLER_112_475 vccd1 vssd1 vccd1 vssd1 SS_sky130_fd_sc_hd__fill_1
XFILLER_98_698 vssd1 vccd1 vccd1 vssd1 SS_sky130_fd_sc_hd__fill_2
XFILLER_85_337 vssd1 vccd1 vssd1 vccd1 SS_sky130_ef_sc_hd__decap_40_12
XFILLER_100_637 vssd1 vccd1 vccd1 vssd1 SS_sky130_fd_sc_hd__fill_4
XFILLER_38_253 vssd1 vccd1 vssd1 vccd1 SS_sky130_ef_sc_hd__decap_40_12
XFILLER_39_765 vssd1 vccd1 vssd1 vccd1 SS_sky130_ef_sc_hd__decap_40_12
XFILLER_54_713 vssd1 vccd1 vssd1 vccd1 SS_sky130_ef_sc_hd__decap_40_12
XFILLER_66_551 vssd1 vccd1 vssd1 vccd1 SS_sky130_ef_sc_hd__decap_40_12
XPHY_EDGE_ROW_77_Left_216 vccd1 vssd1 vccd1 vssd1 SS_sky130_fd_sc_hd__decap_3
XFILLER_53_223 vccd1 vssd1 vccd1 vssd1 SS_sky130_fd_sc_hd__fill_1
XFILLER_54_757 vssd1 vccd1 vssd1 vccd1 SS_sky130_ef_sc_hd__decap_40_12
X_1108_ vccd1 vssd1 vccd1 vssd1 _1108_/X _1859_/A _1140_/B SS_sky130_fd_sc_hd__or2_2
XFILLER_13_109 vssd1 vccd1 vccd1 vssd1 SS_sky130_fd_sc_hd__fill_2
XFILLER_41_429 vssd1 vccd1 vssd1 vccd1 SS_sky130_ef_sc_hd__decap_40_12
X_1039_ vssd1 vccd1 vccd1 vssd1 _1051_/A2 wire499/X _1551_/D _1425_/C1 _1038_/X SS_sky130_fd_sc_hd__o211a_2
XFILLER_22_643 vccd1 vssd1 vccd1 vssd1 SS_sky130_fd_sc_hd__fill_1
XTAP_TAPCELL_ROW_66_1293 vccd1 vssd1 SS_sky130_fd_sc_hd__tapvpwrvgnd_1
XFILLER_42_27 vccd1 vssd1 vccd1 vssd1 SS_sky130_fd_sc_hd__fill_1
XFILLER_6_809 vssd1 vccd1 vccd1 vssd1 SS_sky130_fd_sc_hd__fill_2
XPHY_EDGE_ROW_86_Left_225 vccd1 vssd1 vccd1 vssd1 SS_sky130_fd_sc_hd__decap_3
XFILLER_135_501 vssd1 vccd1 vccd1 vssd1 SS_sky130_fd_sc_hd__fill_2
XFILLER_107_225 vssd1 vccd1 vssd1 vccd1 SS_sky130_ef_sc_hd__decap_40_12
XFILLER_123_729 vssd1 vccd1 vssd1 vccd1 SS_sky130_ef_sc_hd__decap_40_12
XFILLER_123_707 vccd1 vssd1 vccd1 vssd1 SS_sky130_fd_sc_hd__fill_1
XFILLER_101_6 vssd1 vccd1 vssd1 vccd1 SS_sky130_ef_sc_hd__decap_40_12
XFILLER_1_503 vccd1 vssd1 vccd1 vssd1 SS_sky130_fd_sc_hd__fill_1
XFILLER_116_781 vssd1 vccd1 vccd1 vssd1 SS_sky130_fd_sc_hd__fill_4
XFILLER_77_805 vccd1 vssd1 vccd1 vssd1 SS_sky130_fd_sc_hd__fill_1
XFILLER_49_529 vssd1 vccd1 vssd1 vccd1 SS_sky130_ef_sc_hd__decap_40_12
XFILLER_67_57 vssd1 vccd1 vssd1 vccd1 SS_sky130_ef_sc_hd__decap_40_12
XFILLER_88_153 vssd1 vccd1 vssd1 vccd1 SS_sky130_ef_sc_hd__decap_40_12
XFILLER_88_197 vssd1 vccd1 vssd1 vccd1 SS_sky130_ef_sc_hd__decap_40_12
XFILLER_103_497 vssd1 vccd1 vccd1 vssd1 SS_sky130_fd_sc_hd__fill_4
XPHY_EDGE_ROW_95_Left_234 vccd1 vssd1 vccd1 vssd1 SS_sky130_fd_sc_hd__decap_3
XTAP_TAPCELL_ROW_4_363 vccd1 vssd1 SS_sky130_fd_sc_hd__tapvpwrvgnd_1
XFILLER_57_573 vssd1 vccd1 vssd1 vccd1 SS_sky130_ef_sc_hd__decap_40_12
XFILLER_123_30 vssd1 vccd1 vssd1 vccd1 SS_sky130_ef_sc_hd__decap_40_12
XFILLER_91_329 vssd1 vccd1 vccd1 vssd1 SS_sky130_fd_sc_hd__fill_4
XFILLER_44_245 vssd1 vccd1 vccd1 vssd1 SS_sky130_fd_sc_hd__fill_4
XFILLER_44_289 vssd1 vccd1 vssd1 vccd1 SS_sky130_ef_sc_hd__decap_40_12
XFILLER_16_83 vccd1 vssd1 vccd1 vssd1 SS_sky130_fd_sc_hd__fill_1
XTAP_TAPCELL_ROW_43_947 vccd1 vssd1 SS_sky130_fd_sc_hd__tapvpwrvgnd_1
XFILLER_12_153 vssd1 vccd1 vssd1 vccd1 SS_sky130_ef_sc_hd__decap_40_12
XFILLER_13_665 vssd1 vccd1 vccd1 vssd1 SS_sky130_fd_sc_hd__fill_4
XFILLER_9_669 vssd1 vccd1 vccd1 vssd1 SS_sky130_fd_sc_hd__fill_2
XFILLER_40_473 vssd1 vccd1 vccd1 vssd1 SS_sky130_fd_sc_hd__fill_2
XFILLER_12_197 vssd1 vccd1 vssd1 vccd1 SS_sky130_ef_sc_hd__decap_40_12
XFILLER_126_545 vssd1 vccd1 vssd1 vccd1 SS_sky130_ef_sc_hd__decap_40_12
XTAP_TAPCELL_ROW_97_1754 vccd1 vssd1 SS_sky130_fd_sc_hd__tapvpwrvgnd_1
XFILLER_4_363 vccd1 vssd1 vccd1 vssd1 SS_sky130_fd_sc_hd__fill_1
XFILLER_126_589 vssd1 vccd1 vssd1 vccd1 SS_sky130_ef_sc_hd__decap_40_12
XFILLER_113_217 vssd1 vccd1 vccd1 vssd1 SS_sky130_fd_sc_hd__fill_4
XFILLER_99_429 vssd1 vccd1 vssd1 vccd1 SS_sky130_ef_sc_hd__decap_40_12
XFILLER_68_805 vssd1 vccd1 vccd1 vssd1 SS_sky130_fd_sc_hd__fill_4
X_1390_ vccd1 vssd1 vccd1 vssd1 _1390_/X _1390_/A _1396_/B SS_sky130_fd_sc_hd__or2_2
XTAP_TAPCELL_ROW_128_2220 vccd1 vssd1 SS_sky130_fd_sc_hd__tapvpwrvgnd_1
XFILLER_121_261 vssd1 vccd1 vssd1 vccd1 SS_sky130_ef_sc_hd__decap_40_12
XFILLER_67_337 vssd1 vccd1 vccd1 vssd1 SS_sky130_fd_sc_hd__fill_4
XTAP_TAPCELL_ROW_50_1050 vccd1 vssd1 SS_sky130_fd_sc_hd__tapvpwrvgnd_1
XFILLER_82_307 vccd1 vssd1 vccd1 vssd1 SS_sky130_fd_sc_hd__fill_1
XFILLER_36_713 vssd1 vccd1 vssd1 vccd1 SS_sky130_ef_sc_hd__decap_40_12
XFILLER_82_329 vssd1 vccd1 vccd1 vssd1 SS_sky130_fd_sc_hd__fill_8
XFILLER_94_189 vssd1 vccd1 vccd1 vssd1 SS_sky130_fd_sc_hd__fill_4
XFILLER_35_223 vccd1 vssd1 vccd1 vssd1 SS_sky130_fd_sc_hd__fill_1
XFILLER_36_757 vssd1 vccd1 vssd1 vccd1 SS_sky130_ef_sc_hd__decap_40_12
XFILLER_91_841 vccd1 vssd1 vccd1 vssd1 SS_sky130_fd_sc_hd__fill_1
XFILLER_23_429 vssd1 vccd1 vssd1 vccd1 SS_sky130_ef_sc_hd__decap_40_12
XFILLER_51_727 vccd1 vssd1 vccd1 vssd1 SS_sky130_fd_sc_hd__fill_1
XTAP_TAPCELL_ROW_106_1894 vccd1 vssd1 SS_sky130_fd_sc_hd__tapvpwrvgnd_1
XTAP_TAPCELL_ROW_106_1883 vccd1 vssd1 SS_sky130_fd_sc_hd__tapvpwrvgnd_1
XTAP_TAPCELL_ROW_21_608 vccd1 vssd1 SS_sky130_fd_sc_hd__tapvpwrvgnd_1
XTAP_TAPCELL_ROW_21_619 vccd1 vssd1 SS_sky130_fd_sc_hd__tapvpwrvgnd_1
XFILLER_31_473 vssd1 vccd1 vssd1 vccd1 SS_sky130_ef_sc_hd__decap_40_12
XFILLER_136_309 vssd1 vccd1 vccd1 vssd1 SS_sky130_fd_sc_hd__fill_4
X_1726_ _1726_/Q _1758_/CLK _1726_/D vccd1 vssd1 vccd1 vssd1 SS_sky130_fd_sc_hd__dfxtp_2
X_1657_ _1657_/Q _1756_/CLK _1657_/D vccd1 vssd1 vccd1 vssd1 SS_sky130_fd_sc_hd__dfxtp_2
XFILLER_105_729 vssd1 vccd1 vssd1 vccd1 SS_sky130_ef_sc_hd__decap_40_12
X_1588_ _1862_/A clkload5/A _1588_/D vccd1 vssd1 vccd1 vssd1 SS_sky130_fd_sc_hd__dfxtp_2
XFILLER_86_613 vssd1 vccd1 vssd1 vccd1 SS_sky130_ef_sc_hd__decap_40_12
XFILLER_86_657 vssd1 vccd1 vssd1 vccd1 SS_sky130_ef_sc_hd__decap_40_12
XFILLER_98_495 vssd1 vccd1 vssd1 vccd1 SS_sky130_ef_sc_hd__decap_40_12
XFILLER_37_27 vssd1 vccd1 vssd1 vccd1 SS_sky130_ef_sc_hd__decap_40_12
XFILLER_85_167 vccd1 vssd1 vccd1 vssd1 SS_sky130_fd_sc_hd__fill_1
Xafe_wb_515 analog_io_out[7] afe_wb_515/HI vccd1 vssd1 vssd1 vccd1 SS_sky130_fd_sc_hd__conb_1
Xafe_wb_526 analog_io_out[18] afe_wb_526/HI vccd1 vssd1 vssd1 vccd1 SS_sky130_fd_sc_hd__conb_1
Xafe_wb_504 analog_ctrl[100] afe_wb_504/HI vccd1 vssd1 vssd1 vccd1 SS_sky130_fd_sc_hd__conb_1
XTAP_TAPCELL_ROW_1_311 vccd1 vssd1 SS_sky130_fd_sc_hd__tapvpwrvgnd_1
XTAP_TAPCELL_ROW_1_322 vccd1 vssd1 SS_sky130_fd_sc_hd__tapvpwrvgnd_1
Xafe_wb_537 afe_wb_537/LO analog_io_oeb[1] vccd1 vssd1 vssd1 vccd1 SS_sky130_fd_sc_hd__conb_1
Xafe_wb_548 afe_wb_548/LO analog_io_oeb[12] vccd1 vssd1 vssd1 vccd1 SS_sky130_fd_sc_hd__conb_1
XFILLER_39_573 vssd1 vccd1 vssd1 vccd1 SS_sky130_ef_sc_hd__decap_40_12
Xafe_wb_559 afe_wb_559/LO analog_io_oeb[23] vccd1 vssd1 vssd1 vccd1 SS_sky130_fd_sc_hd__conb_1
XTAP_TAPCELL_ROW_68_1322 vccd1 vssd1 SS_sky130_fd_sc_hd__tapvpwrvgnd_1
XFILLER_26_245 vssd1 vccd1 vccd1 vssd1 SS_sky130_fd_sc_hd__fill_4
XFILLER_27_757 vssd1 vccd1 vccd1 vssd1 SS_sky130_fd_sc_hd__fill_2
XFILLER_27_768 vssd1 vccd1 vccd1 vssd1 SS_sky130_fd_sc_hd__fill_2
XFILLER_42_705 vssd1 vccd1 vccd1 vssd1 SS_sky130_fd_sc_hd__fill_2
XFILLER_26_289 vssd1 vccd1 vssd1 vccd1 SS_sky130_ef_sc_hd__decap_40_12
XFILLER_54_565 vssd1 vccd1 vssd1 vccd1 SS_sky130_ef_sc_hd__decap_40_12
XFILLER_54_587 vccd1 vssd1 vccd1 vssd1 SS_sky130_fd_sc_hd__fill_1
XFILLER_41_237 vssd1 vccd1 vssd1 vccd1 SS_sky130_ef_sc_hd__decap_40_12
XTAP_TAPCELL_ROW_81_1511 vccd1 vssd1 SS_sky130_fd_sc_hd__tapvpwrvgnd_1
XTAP_TAPCELL_ROW_81_1522 vccd1 vssd1 SS_sky130_fd_sc_hd__tapvpwrvgnd_1
XTAP_TAPCELL_ROW_40_906 vccd1 vssd1 SS_sky130_fd_sc_hd__tapvpwrvgnd_1
XFILLER_10_613 vssd1 vccd1 vssd1 vccd1 SS_sky130_ef_sc_hd__decap_40_12
XFILLER_22_473 vssd1 vccd1 vccd1 vssd1 SS_sky130_fd_sc_hd__fill_2
XFILLER_50_793 vssd1 vccd1 vssd1 vccd1 SS_sky130_ef_sc_hd__decap_40_12
XFILLER_10_657 vssd1 vccd1 vssd1 vccd1 SS_sky130_ef_sc_hd__decap_40_12
XFILLER_5_105 vssd1 vccd1 vccd1 vssd1 SS_sky130_fd_sc_hd__fill_4
XFILLER_136_821 vssd1 vccd1 vssd1 vccd1 SS_sky130_ef_sc_hd__decap_40_12
XFILLER_5_149 vssd1 vccd1 vssd1 vccd1 SS_sky130_ef_sc_hd__decap_40_12
XTAP_TAPCELL_ROW_79_1484 vccd1 vssd1 SS_sky130_fd_sc_hd__tapvpwrvgnd_1
XFILLER_118_41 vssd1 vccd1 vssd1 vccd1 SS_sky130_ef_sc_hd__decap_40_12
XFILLER_108_545 vssd1 vccd1 vssd1 vccd1 SS_sky130_ef_sc_hd__decap_40_12
XTAP_TAPCELL_ROW_9_433 vccd1 vssd1 SS_sky130_fd_sc_hd__tapvpwrvgnd_1
XFILLER_135_364 vccd1 vssd1 vccd1 vssd1 SS_sky130_fd_sc_hd__fill_1
XFILLER_108_589 vssd1 vccd1 vssd1 vccd1 SS_sky130_ef_sc_hd__decap_40_12
XFILLER_1_333 vssd1 vccd1 vccd1 vssd1 SS_sky130_fd_sc_hd__fill_2
XFILLER_123_559 vccd1 vssd1 vccd1 vssd1 SS_sky130_fd_sc_hd__fill_1
XFILLER_118_85 vssd1 vccd1 vssd1 vccd1 SS_sky130_ef_sc_hd__decap_40_12
Xhold680 _1334_/A _1695_/Q vccd1 vssd1 vssd1 vccd1 SS_sky130_fd_sc_hd__dlygate4sd3_1
XTAP_TAPCELL_ROW_92_1673 vccd1 vssd1 SS_sky130_fd_sc_hd__tapvpwrvgnd_1
XFILLER_77_613 vssd1 vccd1 vccd1 vssd1 SS_sky130_fd_sc_hd__fill_2
XFILLER_89_473 vssd1 vccd1 vssd1 vccd1 SS_sky130_ef_sc_hd__decap_40_12
XFILLER_110_209 vssd1 vccd1 vssd1 vccd1 SS_sky130_ef_sc_hd__decap_40_12
XFILLER_103_261 vssd1 vccd1 vssd1 vccd1 SS_sky130_ef_sc_hd__decap_40_12
Xhold691 _1184_/A _1622_/Q vccd1 vssd1 vssd1 vccd1 SS_sky130_fd_sc_hd__dlygate4sd3_1
XTAP_TAPCELL_ROW_92_1684 vccd1 vssd1 SS_sky130_fd_sc_hd__tapvpwrvgnd_1
XFILLER_49_337 vssd1 vccd1 vssd1 vccd1 SS_sky130_ef_sc_hd__decap_40_12
XFILLER_64_307 vccd1 vssd1 vccd1 vssd1 SS_sky130_fd_sc_hd__fill_1
XFILLER_18_713 vssd1 vccd1 vccd1 vssd1 SS_sky130_fd_sc_hd__fill_8
XFILLER_76_189 vssd1 vccd1 vccd1 vssd1 SS_sky130_fd_sc_hd__fill_4
XFILLER_94_77 vssd1 vccd1 vccd1 vssd1 SS_sky130_fd_sc_hd__fill_4
XFILLER_17_223 vccd1 vssd1 vccd1 vssd1 SS_sky130_fd_sc_hd__fill_1
XFILLER_73_841 vccd1 vssd1 vccd1 vssd1 SS_sky130_fd_sc_hd__fill_1
XFILLER_91_137 vssd1 vccd1 vssd1 vccd1 SS_sky130_ef_sc_hd__decap_40_12
XTAP_TAPCELL_ROW_123_2150 vccd1 vssd1 SS_sky130_fd_sc_hd__tapvpwrvgnd_1
XFILLER_27_93 vssd1 vccd1 vssd1 vccd1 SS_sky130_ef_sc_hd__decap_40_12
XFILLER_72_362 vssd1 vccd1 vccd1 vssd1 SS_sky130_fd_sc_hd__fill_2
XFILLER_13_473 vssd1 vccd1 vssd1 vccd1 SS_sky130_ef_sc_hd__decap_40_12
XFILLER_43_81 vssd1 vccd1 vssd1 vccd1 SS_sky130_ef_sc_hd__decap_40_12
X_0890_ vccd1 vssd1 vssd1 vccd1 _0887_/X _0889_/X _0753_/A hold811/X _1497_/D _1327_/C1
+ SS_sky130_fd_sc_hd__o221a_2
XFILLER_126_342 vssd1 vccd1 vccd1 vssd1 SS_sky130_fd_sc_hd__fill_8
X_1511_ _1840_/A clkload9/A _1511_/D vccd1 vssd1 vccd1 vssd1 SS_sky130_fd_sc_hd__dfxtp_2
XFILLER_4_193 vssd1 vccd1 vccd1 vssd1 SS_sky130_fd_sc_hd__fill_2
XFILLER_99_237 vssd1 vccd1 vssd1 vccd1 SS_sky130_ef_sc_hd__decap_40_12
X_1442_ vccd1 vssd1 vccd1 vssd1 _1442_/X _1442_/A _1454_/B SS_sky130_fd_sc_hd__or2_2
XFILLER_4_53 vssd1 vccd1 vssd1 vccd1 SS_sky130_ef_sc_hd__decap_40_12
XFILLER_68_613 vssd1 vccd1 vssd1 vccd1 SS_sky130_ef_sc_hd__decap_40_12
XFILLER_4_97 vssd1 vccd1 vssd1 vccd1 SS_sky130_ef_sc_hd__decap_40_12
XFILLER_68_657 vssd1 vccd1 vssd1 vccd1 SS_sky130_ef_sc_hd__decap_40_12
X_1373_ vssd1 vccd1 vccd1 vssd1 _1385_/A2 wire498/X _1713_/D _1459_/C1 _1372_/X SS_sky130_fd_sc_hd__o211a_2
XFILLER_122_570 vccd1 vssd1 vccd1 vssd1 SS_sky130_fd_sc_hd__fill_1
XFILLER_95_432 vssd1 vccd1 vssd1 vccd1 SS_sky130_ef_sc_hd__decap_40_12
XFILLER_67_167 vccd1 vssd1 vccd1 vssd1 SS_sky130_fd_sc_hd__fill_1
XTAP_TAPCELL_ROW_108_1923 vccd1 vssd1 SS_sky130_fd_sc_hd__tapvpwrvgnd_1
XFILLER_48_392 vccd1 vssd1 vccd1 vssd1 SS_sky130_fd_sc_hd__fill_1
XFILLER_82_137 vssd1 vccd1 vccd1 vssd1 SS_sky130_fd_sc_hd__fill_2
XFILLER_23_237 vssd1 vccd1 vssd1 vccd1 SS_sky130_ef_sc_hd__decap_40_12
XFILLER_24_749 vssd1 vccd1 vccd1 vssd1 SS_sky130_fd_sc_hd__fill_2
XFILLER_23_18 vssd1 vccd1 vssd1 vccd1 SS_sky130_ef_sc_hd__decap_40_12
XTAP_TAPCELL_ROW_63_1241 vccd1 vssd1 SS_sky130_fd_sc_hd__tapvpwrvgnd_1
XTAP_TAPCELL_ROW_63_1252 vccd1 vssd1 SS_sky130_fd_sc_hd__tapvpwrvgnd_1
XFILLER_32_793 vssd1 vccd1 vssd1 vccd1 SS_sky130_ef_sc_hd__decap_40_12
XFILLER_31_281 vssd1 vccd1 vssd1 vccd1 SS_sky130_ef_sc_hd__decap_40_12
XFILLER_118_810 vssd1 vccd1 vccd1 vssd1 SS_sky130_fd_sc_hd__fill_2
XFILLER_136_139 vccd1 vssd1 vccd1 vssd1 SS_sky130_fd_sc_hd__fill_1
XFILLER_3_609 vssd1 vccd1 vccd1 vssd1 SS_sky130_fd_sc_hd__fill_4
X_1709_ _1888_/A clkload8/A _1709_/D vccd1 vssd1 vccd1 vssd1 SS_sky130_fd_sc_hd__dfxtp_2
XFILLER_132_301 vssd1 vccd1 vccd1 vssd1 SS_sky130_fd_sc_hd__fill_4
XFILLER_105_526 vccd1 vssd1 vccd1 vssd1 SS_sky130_fd_sc_hd__fill_1
XFILLER_105_515 vccd1 vssd1 vccd1 vssd1 SS_sky130_fd_sc_hd__fill_1
Xfanout423 vssd1 vccd1 vccd1 vssd1 _0754_/X wire424/A SS_sky130_fd_sc_hd__clkdlybuf4s25_1
XFILLER_120_529 vssd1 vccd1 vccd1 vssd1 SS_sky130_fd_sc_hd__fill_2
XFILLER_99_782 vssd1 vccd1 vccd1 vssd1 SS_sky130_fd_sc_hd__fill_2
XFILLER_48_26 vssd1 vccd1 vccd1 vssd1 SS_sky130_fd_sc_hd__fill_2
XFILLER_86_421 vssd1 vccd1 vccd1 vssd1 SS_sky130_fd_sc_hd__fill_4
Xfanout434 vssd1 vccd1 vccd1 vssd1 _0745_/X wire435/A SS_sky130_fd_sc_hd__clkdlybuf4s25_1
Xfanout456 vssd1 vccd1 vccd1 vssd1 _1459_/C1 _1441_/C1 SS_sky130_fd_sc_hd__clkdlybuf4s25_1
XFILLER_101_710 vccd1 vssd1 vccd1 vssd1 SS_sky130_fd_sc_hd__fill_1
XFILLER_46_307 vccd1 vssd1 vccd1 vssd1 SS_sky130_fd_sc_hd__fill_1
Xfanout489 vssd1 vccd1 vccd1 vssd1 _1471_/C1 _1143_/C1 SS_sky130_fd_sc_hd__clkdlybuf4s25_1
Xfanout478 vssd1 vccd1 vccd1 vssd1 wire493/X _1259_/C1 SS_sky130_fd_sc_hd__clkdlybuf4s25_1
XFILLER_101_765 vssd1 vccd1 vssd1 vccd1 SS_sky130_ef_sc_hd__decap_40_12
XFILLER_100_253 vssd1 vccd1 vssd1 vccd1 SS_sky130_ef_sc_hd__decap_40_12
XFILLER_58_189 vssd1 vccd1 vccd1 vssd1 SS_sky130_fd_sc_hd__fill_4
XFILLER_74_627 vssd1 vccd1 vssd1 vccd1 SS_sky130_ef_sc_hd__decap_40_12
Xclkbuf_leaf_5_wb_clk_i _1717_/CLK clkbuf_leaf_9_wb_clk_i/A vccd1 vssd1 vssd1 vccd1
+ SS_sky130_fd_sc_hd__clkbuf_8
XFILLER_55_841 vccd1 vssd1 vccd1 vssd1 SS_sky130_fd_sc_hd__fill_1
XFILLER_67_690 vssd1 vccd1 vccd1 vssd1 SS_sky130_fd_sc_hd__fill_4
XFILLER_73_137 vssd1 vccd1 vssd1 vccd1 SS_sky130_ef_sc_hd__decap_40_12
XFILLER_104_65 vssd1 vccd1 vssd1 vccd1 SS_sky130_ef_sc_hd__decap_40_12
XFILLER_15_716 vssd1 vccd1 vssd1 vccd1 SS_sky130_ef_sc_hd__decap_40_12
XFILLER_42_524 vssd1 vccd1 vccd1 vssd1 SS_sky130_fd_sc_hd__fill_8
XFILLER_81_181 vssd1 vccd1 vssd1 vccd1 SS_sky130_ef_sc_hd__decap_40_12
XFILLER_120_53 vssd1 vccd1 vssd1 vccd1 SS_sky130_ef_sc_hd__decap_40_12
XFILLER_120_97 vssd1 vccd1 vssd1 vccd1 SS_sky130_ef_sc_hd__decap_40_12
XFILLER_10_421 vssd1 vccd1 vssd1 vccd1 SS_sky130_ef_sc_hd__decap_40_12
XFILLER_129_51 vssd1 vccd1 vccd1 vssd1 SS_sky130_fd_sc_hd__fill_4
XFILLER_6_469 vssd1 vccd1 vccd1 vssd1 SS_sky130_fd_sc_hd__fill_4
XTAP_TAPCELL_ROW_94_1713 vccd1 vssd1 SS_sky130_fd_sc_hd__tapvpwrvgnd_1
XFILLER_89_55 vccd1 vssd1 vccd1 vssd1 SS_sky130_fd_sc_hd__fill_1
XFILLER_135_161 vssd1 vccd1 vccd1 vssd1 SS_sky130_fd_sc_hd__fill_4
XFILLER_136_673 vssd1 vccd1 vccd1 vssd1 SS_sky130_fd_sc_hd__fill_2
XFILLER_124_824 vssd1 vccd1 vccd1 vssd1 SS_sky130_fd_sc_hd__fill_2
XFILLER_124_813 vssd1 vccd1 vccd1 vssd1 SS_sky130_fd_sc_hd__fill_4
XFILLER_123_334 vssd1 vccd1 vccd1 vssd1 SS_sky130_fd_sc_hd__fill_2
XFILLER_123_378 vssd1 vccd1 vccd1 vssd1 SS_sky130_fd_sc_hd__fill_2
XFILLER_111_529 vssd1 vccd1 vssd1 vccd1 SS_sky130_ef_sc_hd__decap_40_12
XFILLER_2_697 vssd1 vccd1 vccd1 vssd1 SS_sky130_fd_sc_hd__fill_2
XFILLER_89_281 vssd1 vccd1 vssd1 vccd1 SS_sky130_ef_sc_hd__decap_40_12
XFILLER_77_443 vssd1 vccd1 vccd1 vssd1 SS_sky130_fd_sc_hd__fill_4
XFILLER_37_329 vssd1 vccd1 vccd1 vssd1 SS_sky130_fd_sc_hd__fill_4
XFILLER_38_81 vssd1 vccd1 vccd1 vssd1 SS_sky130_fd_sc_hd__fill_2
XFILLER_49_167 vccd1 vssd1 vccd1 vssd1 SS_sky130_fd_sc_hd__fill_1
XFILLER_92_413 vssd1 vccd1 vccd1 vssd1 SS_sky130_fd_sc_hd__fill_4
XFILLER_64_137 vssd1 vccd1 vccd1 vssd1 SS_sky130_fd_sc_hd__fill_2
XTAP_TAPCELL_ROW_121_2109 vccd1 vssd1 SS_sky130_fd_sc_hd__tapvpwrvgnd_1
XFILLER_18_587 vccd1 vssd1 vccd1 vssd1 SS_sky130_fd_sc_hd__fill_1
XFILLER_73_671 vccd1 vssd1 vccd1 vssd1 SS_sky130_fd_sc_hd__fill_1
XFILLER_45_373 vssd1 vccd1 vssd1 vccd1 SS_sky130_ef_sc_hd__decap_40_12
XFILLER_60_321 vssd1 vccd1 vssd1 vccd1 SS_sky130_ef_sc_hd__decap_40_12
XFILLER_33_557 vssd1 vccd1 vccd1 vssd1 SS_sky130_fd_sc_hd__fill_2
XFILLER_60_365 vssd1 vccd1 vssd1 vccd1 SS_sky130_ef_sc_hd__decap_40_12
XTAP_TAPCELL_ROW_103_1842 vccd1 vssd1 SS_sky130_fd_sc_hd__tapvpwrvgnd_1
XFILLER_14_793 vssd1 vccd1 vssd1 vccd1 SS_sky130_ef_sc_hd__decap_40_12
XFILLER_13_281 vssd1 vccd1 vssd1 vccd1 SS_sky130_ef_sc_hd__decap_40_12
XTAP_TAPCELL_ROW_31_758 vccd1 vssd1 SS_sky130_fd_sc_hd__tapvpwrvgnd_1
XTAP_TAPCELL_ROW_31_769 vccd1 vssd1 SS_sky130_fd_sc_hd__tapvpwrvgnd_1
XFILLER_119_629 vssd1 vccd1 vssd1 vccd1 SS_sky130_ef_sc_hd__decap_40_12
X_0942_ vccd1 vssd1 vccd1 vssd1 _1666_/Q wire431/X _1730_/Q wire455/X _0943_/C SS_sky130_fd_sc_hd__a22o_2
X_0873_ vccd1 vssd1 vccd1 vssd1 _1559_/Q _1013_/A _1655_/Q _0894_/B1 _0873_/X SS_sky130_fd_sc_hd__a22o_2
XTAP_TAPCELL_ROW_136_2341 vccd1 vssd1 SS_sky130_fd_sc_hd__tapvpwrvgnd_1
XFILLER_118_139 vccd1 vssd1 vccd1 vssd1 SS_sky130_fd_sc_hd__fill_1
XTAP_TAPCELL_ROW_11_460 vccd1 vssd1 SS_sky130_fd_sc_hd__tapvpwrvgnd_1
XTAP_TAPCELL_ROW_11_471 vccd1 vssd1 SS_sky130_fd_sc_hd__tapvpwrvgnd_1
Xclkload11 vssd1 vccd1 _1573_/CLK clkload11/X vccd1 vssd1 SS_sky130_fd_sc_hd__clkbuf_4
XFILLER_62_3 vssd1 vccd1 vssd1 vccd1 SS_sky130_ef_sc_hd__decap_40_12
XFILLER_115_802 vssd1 vccd1 vssd1 vccd1 SS_sky130_ef_sc_hd__decap_40_12
Xclkload22 clkload22/X _1724_/CLK vccd1 vssd1 vssd1 vccd1 SS_sky130_fd_sc_hd__clkbuf_8
XFILLER_133_109 vssd1 vccd1 vccd1 vssd1 SS_sky130_fd_sc_hd__fill_2
XFILLER_127_673 vssd1 vccd1 vssd1 vccd1 SS_sky130_ef_sc_hd__decap_40_12
XFILLER_130_805 vssd1 vccd1 vccd1 vssd1 SS_sky130_fd_sc_hd__fill_4
X_1425_ vssd1 vccd1 vccd1 vssd1 _1463_/A2 wire496/X _1738_/D _1425_/C1 _1424_/X SS_sky130_fd_sc_hd__o211a_2
XFILLER_68_421 vssd1 vccd1 vssd1 vccd1 SS_sky130_ef_sc_hd__decap_40_12
XFILLER_114_389 vssd1 vccd1 vssd1 vccd1 SS_sky130_ef_sc_hd__decap_40_12
X_1356_ vccd1 vssd1 vccd1 vssd1 _1356_/X _1884_/A _1404_/B SS_sky130_fd_sc_hd__or2_2
XFILLER_18_18 vssd1 vccd1 vccd1 vssd1 SS_sky130_fd_sc_hd__fill_8
XFILLER_18_29 vssd1 vccd1 vssd1 vccd1 SS_sky130_ef_sc_hd__decap_40_12
XFILLER_28_307 vccd1 vssd1 vccd1 vssd1 SS_sky130_fd_sc_hd__fill_1
XFILLER_95_273 vssd1 vccd1 vccd1 vssd1 SS_sky130_fd_sc_hd__fill_4
XFILLER_37_841 vccd1 vssd1 vccd1 vssd1 SS_sky130_fd_sc_hd__fill_1
X_1287_ vssd1 vccd1 vccd1 vssd1 _1337_/A2 input46/X _1287_/X _1417_/C1 _1286_/X SS_sky130_fd_sc_hd__o211a_2
XPHY_EDGE_ROW_50_Left_189 vccd1 vssd1 vccd1 vssd1 SS_sky130_fd_sc_hd__decap_3
XFILLER_55_137 vssd1 vccd1 vssd1 vccd1 SS_sky130_ef_sc_hd__decap_40_12
XFILLER_83_446 vssd1 vccd1 vccd1 vssd1 SS_sky130_fd_sc_hd__fill_2
XFILLER_83_457 vccd1 vssd1 vccd1 vssd1 SS_sky130_fd_sc_hd__fill_1
XFILLER_52_811 vccd1 vssd1 vccd1 vssd1 SS_sky130_fd_sc_hd__fill_1
XTAP_TAPCELL_ROW_19_582 vccd1 vssd1 SS_sky130_fd_sc_hd__tapvpwrvgnd_1
XFILLER_24_513 vssd1 vccd1 vssd1 vccd1 SS_sky130_ef_sc_hd__decap_40_12
XFILLER_63_181 vssd1 vccd1 vssd1 vccd1 SS_sky130_ef_sc_hd__decap_40_12
XFILLER_24_557 vssd1 vccd1 vssd1 vccd1 SS_sky130_ef_sc_hd__decap_40_12
Xclkload5 clkload5/X clkload5/A vccd1 vssd1 vssd1 vccd1 SS_sky130_fd_sc_hd__clkbuf_8
XFILLER_50_27 vccd1 vssd1 vccd1 vssd1 SS_sky130_fd_sc_hd__fill_1
XFILLER_3_417 vssd1 vccd1 vssd1 vccd1 SS_sky130_ef_sc_hd__decap_40_12
XTAP_TAPCELL_ROW_76_1443 vccd1 vssd1 SS_sky130_fd_sc_hd__tapvpwrvgnd_1
XFILLER_124_109 vssd1 vccd1 vssd1 vccd1 SS_sky130_ef_sc_hd__decap_40_12
XFILLER_118_684 vssd1 vccd1 vssd1 vccd1 SS_sky130_ef_sc_hd__decap_40_12
XFILLER_118_673 vssd1 vccd1 vccd1 vssd1 SS_sky130_fd_sc_hd__fill_2
XFILLER_117_161 vssd1 vccd1 vccd1 vssd1 SS_sky130_fd_sc_hd__fill_4
XFILLER_106_813 vccd1 vssd1 vccd1 vssd1 SS_sky130_fd_sc_hd__fill_1
XFILLER_133_654 vccd1 vssd1 vccd1 vssd1 SS_sky130_fd_sc_hd__fill_1
XFILLER_132_153 vssd1 vccd1 vssd1 vccd1 SS_sky130_ef_sc_hd__decap_40_12
XFILLER_59_69 vssd1 vccd1 vssd1 vccd1 SS_sky130_ef_sc_hd__decap_40_12
XFILLER_132_197 vssd1 vccd1 vssd1 vccd1 SS_sky130_ef_sc_hd__decap_40_12
XFILLER_120_326 vssd1 vccd1 vssd1 vccd1 SS_sky130_ef_sc_hd__decap_40_12
Xfanout231 vssd1 vccd1 vccd1 vssd1 _1274_/B _1264_/B SS_sky130_fd_sc_hd__clkdlybuf4s25_1
Xfanout220 vssd1 vccd1 vccd1 vssd1 _1277_/Y _1331_/A2 SS_sky130_fd_sc_hd__clkdlybuf4s25_1
XFILLER_47_605 vccd1 vssd1 vccd1 vssd1 SS_sky130_fd_sc_hd__fill_1
XFILLER_87_741 vssd1 vccd1 vssd1 vccd1 SS_sky130_ef_sc_hd__decap_40_12
XFILLER_120_359 vssd1 vccd1 vccd1 vssd1 SS_sky130_fd_sc_hd__fill_4
XFILLER_19_329 vssd1 vccd1 vccd1 vssd1 SS_sky130_fd_sc_hd__fill_4
XFILLER_86_251 vccd1 vssd1 vccd1 vssd1 SS_sky130_fd_sc_hd__fill_1
XFILLER_87_785 vssd1 vccd1 vssd1 vccd1 SS_sky130_ef_sc_hd__decap_40_12
XFILLER_101_573 vssd1 vccd1 vssd1 vccd1 SS_sky130_ef_sc_hd__decap_40_12
XFILLER_46_137 vssd1 vccd1 vccd1 vssd1 SS_sky130_fd_sc_hd__fill_2
XFILLER_75_57 vssd1 vccd1 vssd1 vccd1 SS_sky130_ef_sc_hd__decap_40_12
XFILLER_62_619 vssd1 vccd1 vssd1 vccd1 SS_sky130_ef_sc_hd__decap_40_12
XFILLER_74_468 vssd1 vccd1 vccd1 vssd1 SS_sky130_fd_sc_hd__fill_8
XFILLER_131_30 vssd1 vccd1 vssd1 vccd1 SS_sky130_ef_sc_hd__decap_40_12
XFILLER_27_373 vssd1 vccd1 vssd1 vccd1 SS_sky130_ef_sc_hd__decap_40_12
XFILLER_42_321 vssd1 vccd1 vssd1 vccd1 SS_sky130_ef_sc_hd__decap_40_12
XFILLER_15_557 vssd1 vccd1 vccd1 vssd1 SS_sky130_fd_sc_hd__fill_2
XFILLER_42_365 vssd1 vccd1 vssd1 vccd1 SS_sky130_ef_sc_hd__decap_40_12
XFILLER_11_741 vssd1 vccd1 vccd1 vssd1 SS_sky130_fd_sc_hd__fill_4
XFILLER_24_83 vccd1 vssd1 vccd1 vssd1 SS_sky130_fd_sc_hd__fill_1
XFILLER_10_251 vccd1 vssd1 vccd1 vssd1 SS_sky130_fd_sc_hd__fill_1
XFILLER_11_763 vssd1 vccd1 vssd1 vccd1 SS_sky130_ef_sc_hd__decap_40_12
XFILLER_11_785 vssd1 vccd1 vssd1 vccd1 SS_sky130_ef_sc_hd__decap_40_12
XFILLER_6_233 vssd1 vccd1 vssd1 vccd1 SS_sky130_ef_sc_hd__decap_40_12
XTAP_TAPCELL_ROW_118_2071 vccd1 vssd1 SS_sky130_fd_sc_hd__tapvpwrvgnd_1
XFILLER_6_277 vssd1 vccd1 vssd1 vccd1 SS_sky130_ef_sc_hd__decap_40_12
XFILLER_115_109 vssd1 vccd1 vccd1 vssd1 SS_sky130_fd_sc_hd__fill_2
XFILLER_109_684 vssd1 vccd1 vssd1 vccd1 SS_sky130_ef_sc_hd__decap_40_12
XFILLER_109_673 vssd1 vccd1 vccd1 vssd1 SS_sky130_fd_sc_hd__fill_2
XTAP_TAPCELL_ROW_131_2260 vccd1 vssd1 SS_sky130_fd_sc_hd__tapvpwrvgnd_1
XFILLER_124_621 vccd1 vssd1 vccd1 vssd1 SS_sky130_fd_sc_hd__fill_1
XTAP_TAPCELL_ROW_131_2271 vccd1 vssd1 SS_sky130_fd_sc_hd__tapvpwrvgnd_1
XFILLER_124_665 vssd1 vccd1 vssd1 vccd1 SS_sky130_ef_sc_hd__decap_40_12
XFILLER_112_805 vssd1 vccd1 vccd1 vssd1 SS_sky130_fd_sc_hd__fill_4
XFILLER_97_505 vssd1 vccd1 vssd1 vccd1 SS_sky130_ef_sc_hd__decap_40_12
XFILLER_111_337 vssd1 vccd1 vssd1 vccd1 SS_sky130_ef_sc_hd__decap_40_12
XFILLER_97_549 vssd1 vccd1 vccd1 vssd1 SS_sky130_fd_sc_hd__fill_2
X_1210_ vccd1 vssd1 _1211_/A _1274_/B _1409_/B vccd1 vssd1 SS_sky130_fd_sc_hd__and2_2
XFILLER_77_273 vssd1 vccd1 vccd1 vssd1 SS_sky130_fd_sc_hd__fill_4
X_1141_ vssd1 vccd1 vccd1 vssd1 _1141_/A2 input43/X _1601_/D _1401_/C1 _1140_/X SS_sky130_fd_sc_hd__o211a_2
XFILLER_93_733 vssd1 vccd1 vccd1 vssd1 SS_sky130_fd_sc_hd__fill_2
XFILLER_93_722 vccd1 vssd1 vccd1 vssd1 SS_sky130_fd_sc_hd__fill_1
XFILLER_1_54 vssd1 vccd1 vccd1 vssd1 SS_sky130_fd_sc_hd__fill_2
XFILLER_19_841 vccd1 vssd1 vccd1 vssd1 SS_sky130_fd_sc_hd__fill_1
XFILLER_37_137 vssd1 vccd1 vssd1 vccd1 SS_sky130_ef_sc_hd__decap_40_12
XFILLER_92_221 vssd1 vccd1 vssd1 vccd1 SS_sky130_ef_sc_hd__decap_40_12
XFILLER_80_416 vssd1 vccd1 vccd1 vssd1 SS_sky130_fd_sc_hd__fill_4
X_1072_ vccd1 vssd1 vccd1 vssd1 _1072_/X _1072_/A _1076_/B SS_sky130_fd_sc_hd__or2_2
XFILLER_92_265 vssd1 vccd1 vssd1 vccd1 SS_sky130_ef_sc_hd__decap_40_12
XTAP_TAPCELL_ROW_36_839 vccd1 vssd1 SS_sky130_fd_sc_hd__tapvpwrvgnd_1
XFILLER_45_181 vssd1 vccd1 vssd1 vccd1 SS_sky130_ef_sc_hd__decap_40_12
XTAP_TAPCELL_ROW_47_1000 vccd1 vssd1 SS_sky130_fd_sc_hd__tapvpwrvgnd_1
XFILLER_46_693 vssd1 vccd1 vccd1 vssd1 SS_sky130_fd_sc_hd__fill_4
XTAP_TAPCELL_ROW_47_1011 vccd1 vssd1 SS_sky130_fd_sc_hd__tapvpwrvgnd_1
XTAP_TAPCELL_ROW_16_541 vccd1 vssd1 SS_sky130_fd_sc_hd__tapvpwrvgnd_1
XFILLER_21_505 vssd1 vccd1 vssd1 vccd1 SS_sky130_ef_sc_hd__decap_40_12
XTAP_TAPCELL_ROW_60_1200 vccd1 vssd1 SS_sky130_fd_sc_hd__tapvpwrvgnd_1
XFILLER_61_685 vssd1 vccd1 vssd1 vccd1 SS_sky130_ef_sc_hd__decap_40_12
XFILLER_60_195 vccd1 vssd1 vccd1 vssd1 SS_sky130_fd_sc_hd__fill_1
X_0925_ vssd1 vccd1 vssd1 vccd1 _0930_/B1 _1535_/Q _0923_/X _0924_/X _0925_/X _0751_/X
+ SS_sky130_fd_sc_hd__a2111o_2
X_0856_ vssd1 vccd1 vssd1 vccd1 wire424/A _1048_/A _0855_/X _0856_/X SS_sky130_fd_sc_hd__a21o_2
XFILLER_106_109 vssd1 vccd1 vssd1 vccd1 SS_sky130_ef_sc_hd__decap_40_12
XFILLER_115_632 vssd1 vccd1 vccd1 vssd1 SS_sky130_fd_sc_hd__fill_2
XFILLER_115_621 vssd1 vccd1 vccd1 vssd1 SS_sky130_fd_sc_hd__fill_2
X_0787_ vssd1 vccd1 vssd1 vccd1 wire435/X _1900_/A _0865_/B1 _0785_/X _0787_/X _0786_/X
+ SS_sky130_fd_sc_hd__a2111o_2
XTAP_TAPCELL_ROW_58_1173 vccd1 vssd1 SS_sky130_fd_sc_hd__tapvpwrvgnd_1
XFILLER_115_654 vssd1 vccd1 vssd1 vccd1 SS_sky130_ef_sc_hd__decap_40_12
XFILLER_114_153 vssd1 vccd1 vssd1 vccd1 SS_sky130_ef_sc_hd__decap_40_12
XFILLER_103_805 vssd1 vccd1 vccd1 vssd1 SS_sky130_fd_sc_hd__fill_2
XFILLER_130_613 vssd1 vccd1 vssd1 vccd1 SS_sky130_ef_sc_hd__decap_40_12
XFILLER_102_337 vssd1 vccd1 vccd1 vssd1 SS_sky130_fd_sc_hd__fill_2
XFILLER_29_39 vssd1 vccd1 vssd1 vccd1 SS_sky130_ef_sc_hd__decap_40_12
XFILLER_69_741 vssd1 vccd1 vssd1 vccd1 SS_sky130_ef_sc_hd__decap_40_12
XTAP_TAPCELL_ROW_71_1362 vccd1 vssd1 SS_sky130_fd_sc_hd__tapvpwrvgnd_1
XFILLER_130_657 vssd1 vccd1 vssd1 vccd1 SS_sky130_ef_sc_hd__decap_40_12
X_1408_ vccd1 vssd1 _1409_/A _1468_/B _1409_/B vccd1 vssd1 SS_sky130_fd_sc_hd__and2_2
XFILLER_114_197 vssd1 vccd1 vssd1 vccd1 SS_sky130_ef_sc_hd__decap_40_12
XFILLER_29_638 vssd1 vccd1 vssd1 vccd1 SS_sky130_ef_sc_hd__decap_40_12
XFILLER_68_251 vccd1 vssd1 vccd1 vssd1 SS_sky130_fd_sc_hd__fill_1
XFILLER_69_785 vssd1 vccd1 vssd1 vccd1 SS_sky130_ef_sc_hd__decap_40_12
XFILLER_28_137 vssd1 vccd1 vccd1 vssd1 SS_sky130_fd_sc_hd__fill_2
XFILLER_56_457 vssd1 vccd1 vssd1 vccd1 SS_sky130_ef_sc_hd__decap_40_12
XFILLER_83_221 vssd1 vccd1 vccd1 vssd1 SS_sky130_fd_sc_hd__fill_2
XFILLER_84_755 vccd1 vssd1 vccd1 vssd1 SS_sky130_fd_sc_hd__fill_1
X_1339_ vssd1 vccd1 vccd1 vssd1 _1339_/A2 input43/X _1697_/D _1471_/C1 _1338_/X SS_sky130_fd_sc_hd__o211a_2
XFILLER_45_27 vssd1 vccd1 vssd1 vccd1 SS_sky130_ef_sc_hd__decap_40_12
XFILLER_84_777 vssd1 vccd1 vccd1 vssd1 SS_sky130_fd_sc_hd__fill_8
XFILLER_24_321 vssd1 vccd1 vssd1 vccd1 SS_sky130_ef_sc_hd__decap_40_12
XFILLER_24_365 vssd1 vccd1 vssd1 vccd1 SS_sky130_ef_sc_hd__decap_40_12
XFILLER_131_6 vssd1 vccd1 vssd1 vccd1 SS_sky130_ef_sc_hd__decap_40_12
XFILLER_138_757 vssd1 vccd1 vccd1 vssd1 SS_sky130_fd_sc_hd__fill_2
XFILLER_3_225 vssd1 vccd1 vssd1 vccd1 SS_sky130_ef_sc_hd__decap_40_12
XFILLER_4_737 vssd1 vccd1 vssd1 vccd1 SS_sky130_ef_sc_hd__decap_40_12
XFILLER_10_41 vssd1 vccd1 vssd1 vccd1 SS_sky130_ef_sc_hd__decap_40_12
XFILLER_79_505 vssd1 vccd1 vccd1 vssd1 SS_sky130_fd_sc_hd__fill_2
XFILLER_10_85 vssd1 vccd1 vssd1 vccd1 SS_sky130_ef_sc_hd__decap_40_12
XFILLER_79_549 vssd1 vccd1 vccd1 vssd1 SS_sky130_fd_sc_hd__fill_2
XFILLER_126_41 vssd1 vccd1 vssd1 vccd1 SS_sky130_ef_sc_hd__decap_40_12
XFILLER_121_613 vssd1 vccd1 vccd1 vssd1 SS_sky130_fd_sc_hd__fill_2
XFILLER_126_85 vssd1 vccd1 vssd1 vccd1 SS_sky130_ef_sc_hd__decap_40_12
XFILLER_121_646 vssd1 vccd1 vccd1 vssd1 SS_sky130_fd_sc_hd__fill_8
XFILLER_59_273 vssd1 vccd1 vccd1 vssd1 SS_sky130_fd_sc_hd__fill_4
XFILLER_120_189 vssd1 vccd1 vccd1 vssd1 SS_sky130_fd_sc_hd__fill_4
XFILLER_19_137 vssd1 vccd1 vssd1 vccd1 SS_sky130_ef_sc_hd__decap_40_12
XFILLER_74_221 vssd1 vccd1 vssd1 vccd1 SS_sky130_ef_sc_hd__decap_40_12
XFILLER_75_733 vccd1 vssd1 vccd1 vssd1 SS_sky130_fd_sc_hd__fill_1
XTAP_TAPCELL_ROW_89_1634 vccd1 vssd1 SS_sky130_fd_sc_hd__tapvpwrvgnd_1
XFILLER_74_265 vssd1 vccd1 vssd1 vccd1 SS_sky130_ef_sc_hd__decap_40_12
XFILLER_16_811 vccd1 vssd1 vccd1 vssd1 SS_sky130_fd_sc_hd__fill_1
XFILLER_28_693 vssd1 vccd1 vccd1 vssd1 SS_sky130_fd_sc_hd__fill_4
XFILLER_27_181 vssd1 vccd1 vssd1 vccd1 SS_sky130_ef_sc_hd__decap_40_12
XFILLER_90_769 vssd1 vccd1 vssd1 vccd1 SS_sky130_ef_sc_hd__decap_40_12
XTAP_TAPCELL_ROW_13_500 vccd1 vssd1 SS_sky130_fd_sc_hd__tapvpwrvgnd_1
XFILLER_35_93 vssd1 vccd1 vssd1 vccd1 SS_sky130_ef_sc_hd__decap_40_12
XFILLER_43_685 vssd1 vccd1 vssd1 vccd1 SS_sky130_ef_sc_hd__decap_40_12
XPHY_EDGE_ROW_106_Left_245 vccd1 vssd1 vccd1 vssd1 SS_sky130_fd_sc_hd__decap_3
XTAP_TAPCELL_ROW_100_1801 vccd1 vssd1 SS_sky130_fd_sc_hd__tapvpwrvgnd_1
XFILLER_42_195 vccd1 vssd1 vccd1 vssd1 SS_sky130_fd_sc_hd__fill_1
XFILLER_30_357 vssd1 vccd1 vccd1 vssd1 SS_sky130_fd_sc_hd__fill_4
XFILLER_51_81 vssd1 vccd1 vssd1 vccd1 SS_sky130_ef_sc_hd__decap_40_12
XFILLER_128_245 vssd1 vccd1 vccd1 vssd1 SS_sky130_fd_sc_hd__fill_4
XTAP_TAPCELL_ROW_133_2300 vccd1 vssd1 SS_sky130_fd_sc_hd__tapvpwrvgnd_1
XFILLER_7_553 vssd1 vccd1 vccd1 vssd1 SS_sky130_fd_sc_hd__fill_4
XFILLER_128_289 vssd1 vccd1 vccd1 vssd1 SS_sky130_fd_sc_hd__fill_8
XFILLER_116_429 vccd1 vssd1 vccd1 vssd1 SS_sky130_fd_sc_hd__fill_1
X_1690_ _1690_/Q _1753_/CLK _1690_/D vccd1 vssd1 vccd1 vssd1 SS_sky130_fd_sc_hd__dfxtp_2
XFILLER_7_597 vssd1 vccd1 vssd1 vccd1 SS_sky130_ef_sc_hd__decap_40_12
Xwire495 vccd1 vssd1 wire495/X wire495/A vccd1 vssd1 SS_sky130_fd_sc_hd__buf_4
XFILLER_109_481 vssd1 vccd1 vccd1 vssd1 SS_sky130_fd_sc_hd__fill_4
XPHY_EDGE_ROW_115_Left_254 vccd1 vssd1 vccd1 vssd1 SS_sky130_fd_sc_hd__decap_3
XFILLER_3_781 vssd1 vccd1 vccd1 vssd1 SS_sky130_fd_sc_hd__fill_2
XFILLER_124_495 vccd1 vssd1 vccd1 vssd1 SS_sky130_fd_sc_hd__fill_1
XFILLER_112_657 vssd1 vccd1 vssd1 vccd1 SS_sky130_ef_sc_hd__decap_40_12
XTAP_TAPCELL_ROW_111_1963 vccd1 vssd1 SS_sky130_fd_sc_hd__tapvpwrvgnd_1
XFILLER_25_3 vssd1 vccd1 vssd1 vccd1 SS_sky130_ef_sc_hd__decap_40_12
XFILLER_38_413 vssd1 vccd1 vccd1 vssd1 SS_sky130_fd_sc_hd__fill_4
XTAP_TAPCELL_ROW_53_1092 vccd1 vssd1 SS_sky130_fd_sc_hd__tapvpwrvgnd_1
XFILLER_66_711 vssd1 vccd1 vssd1 vccd1 SS_sky130_ef_sc_hd__decap_40_12
XFILLER_111_167 vccd1 vssd1 vccd1 vssd1 SS_sky130_fd_sc_hd__fill_1
XFILLER_65_221 vssd1 vccd1 vccd1 vssd1 SS_sky130_fd_sc_hd__fill_2
XFILLER_66_733 vccd1 vssd1 vccd1 vssd1 SS_sky130_fd_sc_hd__fill_1
XFILLER_66_755 vccd1 vssd1 vccd1 vssd1 SS_sky130_fd_sc_hd__fill_1
XFILLER_93_541 vssd1 vccd1 vssd1 vccd1 SS_sky130_ef_sc_hd__decap_40_12
XFILLER_38_457 vssd1 vccd1 vccd1 vssd1 SS_sky130_fd_sc_hd__fill_8
XFILLER_53_405 vssd1 vccd1 vccd1 vssd1 SS_sky130_fd_sc_hd__fill_2
X_1124_ vccd1 vssd1 vccd1 vssd1 _1124_/X _1124_/A _1126_/B SS_sky130_fd_sc_hd__or2_2
XFILLER_19_671 vccd1 vssd1 vccd1 vssd1 SS_sky130_fd_sc_hd__fill_1
XFILLER_53_416 vssd1 vccd1 vccd1 vssd1 SS_sky130_fd_sc_hd__fill_4
X_1055_ vssd1 vccd1 vccd1 vssd1 _1077_/A2 input32/X _1559_/D _1451_/C1 _1054_/X SS_sky130_fd_sc_hd__o211a_2
XFILLER_34_641 vssd1 vccd1 vccd1 vssd1 SS_sky130_fd_sc_hd__fill_2
XFILLER_81_769 vssd1 vccd1 vssd1 vccd1 SS_sky130_ef_sc_hd__decap_40_12
XPHY_EDGE_ROW_124_Left_263 vccd1 vssd1 vccd1 vssd1 SS_sky130_fd_sc_hd__decap_3
XFILLER_21_335 vccd1 vssd1 vccd1 vssd1 SS_sky130_fd_sc_hd__fill_1
XFILLER_31_18 vssd1 vccd1 vssd1 vccd1 SS_sky130_ef_sc_hd__decap_40_12
XFILLER_119_223 vccd1 vssd1 vccd1 vssd1 SS_sky130_fd_sc_hd__fill_1
X_1888_ vccd1 vssd1 _1888_/X _1888_/A vccd1 vssd1 SS_sky130_fd_sc_hd__buf_2
XFILLER_135_705 vccd1 vssd1 vccd1 vssd1 SS_sky130_fd_sc_hd__fill_1
XFILLER_135_727 vccd1 vssd1 vccd1 vssd1 SS_sky130_fd_sc_hd__fill_1
X_0908_ vccd1 vssd1 vssd1 vccd1 _0904_/X _0907_/X _0932_/A2 hold802/X _1500_/D _1329_/C1
+ SS_sky130_fd_sc_hd__o221a_2
XFILLER_107_429 vssd1 vccd1 vssd1 vccd1 SS_sky130_ef_sc_hd__decap_40_12
X_0839_ vccd1 vssd1 vccd1 vssd1 _1649_/Q _0894_/B1 _1859_/A wire445/A _0839_/X SS_sky130_fd_sc_hd__a22o_2
XPHY_EDGE_ROW_133_Left_272 vccd1 vssd1 vccd1 vssd1 SS_sky130_fd_sc_hd__decap_3
XTAP_TAPCELL_ROW_73_1402 vccd1 vssd1 SS_sky130_fd_sc_hd__tapvpwrvgnd_1
XFILLER_1_729 vssd1 vccd1 vssd1 vccd1 SS_sky130_ef_sc_hd__decap_40_12
XFILLER_88_313 vccd1 vssd1 vccd1 vssd1 SS_sky130_fd_sc_hd__fill_1
XFILLER_103_613 vssd1 vccd1 vccd1 vssd1 SS_sky130_fd_sc_hd__fill_2
XFILLER_130_421 vssd1 vccd1 vssd1 vccd1 SS_sky130_ef_sc_hd__decap_40_12
XFILLER_130_487 vccd1 vssd1 vccd1 vssd1 SS_sky130_fd_sc_hd__fill_1
XFILLER_56_26 vssd1 vccd1 vccd1 vssd1 SS_sky130_fd_sc_hd__fill_2
XFILLER_56_221 vssd1 vccd1 vssd1 vccd1 SS_sky130_ef_sc_hd__decap_40_12
XFILLER_57_755 vssd1 vccd1 vssd1 vccd1 SS_sky130_ef_sc_hd__decap_40_12
XFILLER_102_189 vssd1 vccd1 vccd1 vssd1 SS_sky130_fd_sc_hd__fill_4
XFILLER_56_265 vssd1 vccd1 vssd1 vccd1 SS_sky130_ef_sc_hd__decap_40_12
XFILLER_72_725 vssd1 vccd1 vssd1 vccd1 SS_sky130_ef_sc_hd__decap_40_12
XFILLER_84_585 vssd1 vccd1 vccd1 vssd1 SS_sky130_fd_sc_hd__fill_2
XTAP_TAPCELL_ROW_84_1553 vccd1 vssd1 SS_sky130_fd_sc_hd__tapvpwrvgnd_1
XFILLER_112_65 vssd1 vccd1 vssd1 vccd1 SS_sky130_ef_sc_hd__decap_40_12
XFILLER_25_685 vssd1 vccd1 vssd1 vccd1 SS_sky130_ef_sc_hd__decap_40_12
XFILLER_40_611 vssd1 vccd1 vssd1 vccd1 SS_sky130_ef_sc_hd__decap_40_12
XFILLER_71_279 vccd1 vssd1 vccd1 vssd1 SS_sky130_fd_sc_hd__fill_1
XTAP_TAPCELL_ROW_84_1564 vccd1 vssd1 SS_sky130_fd_sc_hd__tapvpwrvgnd_1
XFILLER_24_195 vccd1 vssd1 vccd1 vssd1 SS_sky130_fd_sc_hd__fill_1
XFILLER_52_493 vssd1 vccd1 vccd1 vssd1 SS_sky130_fd_sc_hd__fill_2
XFILLER_12_357 vssd1 vccd1 vccd1 vssd1 SS_sky130_fd_sc_hd__fill_4
XFILLER_40_699 vccd1 vssd1 vccd1 vssd1 SS_sky130_fd_sc_hd__fill_1
XFILLER_4_501 vssd1 vccd1 vssd1 vccd1 SS_sky130_ef_sc_hd__decap_40_12
XFILLER_138_587 vccd1 vssd1 vccd1 vssd1 SS_sky130_fd_sc_hd__fill_1
XFILLER_126_716 vssd1 vccd1 vssd1 vccd1 SS_sky130_ef_sc_hd__decap_40_12
XTAP_TAPCELL_ROW_115_2030 vccd1 vssd1 SS_sky130_fd_sc_hd__tapvpwrvgnd_1
XFILLER_125_237 vssd1 vccd1 vssd1 vccd1 SS_sky130_ef_sc_hd__decap_40_12
XFILLER_4_545 vssd1 vccd1 vssd1 vccd1 SS_sky130_ef_sc_hd__decap_40_12
XFILLER_137_73 vssd1 vccd1 vssd1 vccd1 SS_sky130_ef_sc_hd__decap_40_12
XFILLER_4_589 vssd1 vccd1 vssd1 vccd1 SS_sky130_ef_sc_hd__decap_40_12
XFILLER_137_95 vssd1 vccd1 vccd1 vssd1 SS_sky130_fd_sc_hd__fill_4
XFILLER_97_55 vccd1 vssd1 vccd1 vssd1 SS_sky130_fd_sc_hd__fill_1
XFILLER_79_335 vccd1 vssd1 vccd1 vssd1 SS_sky130_fd_sc_hd__fill_1
XFILLER_79_357 vssd1 vccd1 vccd1 vssd1 SS_sky130_fd_sc_hd__fill_8
XFILLER_133_281 vssd1 vccd1 vssd1 vccd1 SS_sky130_ef_sc_hd__decap_40_12
XFILLER_106_495 vssd1 vccd1 vssd1 vccd1 SS_sky130_ef_sc_hd__decap_40_12
XFILLER_67_519 vccd1 vssd1 vccd1 vssd1 SS_sky130_fd_sc_hd__fill_1
XFILLER_94_305 vssd1 vccd1 vccd1 vssd1 SS_sky130_fd_sc_hd__fill_2
XFILLER_47_221 vssd1 vccd1 vccd1 vssd1 SS_sky130_fd_sc_hd__fill_2
XFILLER_48_755 vccd1 vssd1 vccd1 vssd1 SS_sky130_fd_sc_hd__fill_1
XFILLER_35_405 vssd1 vccd1 vssd1 vccd1 SS_sky130_ef_sc_hd__decap_40_12
XFILLER_75_541 vssd1 vccd1 vssd1 vccd1 SS_sky130_ef_sc_hd__decap_40_12
XFILLER_63_725 vssd1 vccd1 vccd1 vssd1 SS_sky130_fd_sc_hd__fill_2
XFILLER_75_585 vssd1 vccd1 vssd1 vccd1 SS_sky130_ef_sc_hd__decap_40_12
XFILLER_90_533 vssd1 vccd1 vssd1 vccd1 SS_sky130_ef_sc_hd__decap_40_12
XTAP_TAPCELL_ROW_126_2192 vccd1 vssd1 SS_sky130_fd_sc_hd__tapvpwrvgnd_1
XFILLER_16_641 vssd1 vccd1 vccd1 vssd1 SS_sky130_fd_sc_hd__fill_2
XFILLER_35_449 vssd1 vccd1 vssd1 vccd1 SS_sky130_ef_sc_hd__decap_40_12
XFILLER_46_81 vssd1 vccd1 vccd1 vssd1 SS_sky130_fd_sc_hd__fill_2
XTAP_TAPCELL_ROW_46_989 vccd1 vssd1 SS_sky130_fd_sc_hd__tapvpwrvgnd_1
XFILLER_50_419 vccd1 vssd1 vccd1 vssd1 SS_sky130_fd_sc_hd__fill_1
XFILLER_16_696 vssd1 vccd1 vccd1 vssd1 SS_sky130_fd_sc_hd__fill_4
XTAP_TAPCELL_ROW_26_691 vccd1 vssd1 SS_sky130_fd_sc_hd__tapvpwrvgnd_1
XFILLER_30_121 vssd1 vccd1 vssd1 vccd1 SS_sky130_ef_sc_hd__decap_40_12
XFILLER_30_165 vssd1 vccd1 vssd1 vccd1 SS_sky130_ef_sc_hd__decap_40_12
XFILLER_31_688 vssd1 vccd1 vssd1 vccd1 SS_sky130_ef_sc_hd__decap_40_12
X_1742_ _1906_/A _1742_/CLK _1742_/D vccd1 vssd1 vccd1 vssd1 SS_sky130_fd_sc_hd__dfxtp_2
XFILLER_129_565 vccd1 vssd1 vccd1 vssd1 SS_sky130_fd_sc_hd__fill_1
XFILLER_117_727 vccd1 vssd1 vccd1 vssd1 SS_sky130_fd_sc_hd__fill_1
XFILLER_7_361 vssd1 vccd1 vssd1 vccd1 SS_sky130_ef_sc_hd__decap_40_12
Xwire281 vccd1 vssd1 vssd1 vccd1 wire281/A analog_ctrl[15] SS_sky130_fd_sc_hd__buf_12
Xwire270 vccd1 vssd1 vssd1 vccd1 wire270/A analog_ctrl[25] SS_sky130_fd_sc_hd__buf_12
X_1673_ _1673_/Q clkload9/A _1673_/D vccd1 vssd1 vccd1 vssd1 SS_sky130_fd_sc_hd__dfxtp_2
XFILLER_129_598 vssd1 vccd1 vssd1 vccd1 SS_sky130_ef_sc_hd__decap_40_12
Xwire292 vccd1 vssd1 vssd1 vccd1 wire292/A analog_ctrl[116] SS_sky130_fd_sc_hd__buf_12
XTAP_TAPCELL_ROW_55_1121 vccd1 vssd1 SS_sky130_fd_sc_hd__tapvpwrvgnd_1
XTAP_TAPCELL_ROW_55_1132 vccd1 vssd1 SS_sky130_fd_sc_hd__tapvpwrvgnd_1
XFILLER_112_410 vssd1 vccd1 vccd1 vssd1 SS_sky130_fd_sc_hd__fill_8
XFILLER_112_421 vssd1 vccd1 vssd1 vccd1 SS_sky130_ef_sc_hd__decap_40_12
XFILLER_85_305 vssd1 vccd1 vssd1 vccd1 SS_sky130_ef_sc_hd__decap_40_12
Xload_slew242 vccd1 vssd1 _1141_/A2 wire241/A vccd1 vssd1 SS_sky130_fd_sc_hd__buf_4
XFILLER_97_165 vssd1 vccd1 vccd1 vssd1 SS_sky130_fd_sc_hd__fill_2
XFILLER_38_221 vssd1 vccd1 vssd1 vccd1 SS_sky130_ef_sc_hd__decap_40_12
XFILLER_85_349 vssd1 vccd1 vssd1 vccd1 SS_sky130_ef_sc_hd__decap_40_12
XFILLER_39_777 vssd1 vccd1 vccd1 vssd1 SS_sky130_fd_sc_hd__fill_4
XFILLER_66_563 vssd1 vccd1 vssd1 vccd1 SS_sky130_ef_sc_hd__decap_40_12
XFILLER_26_18 vssd1 vccd1 vccd1 vssd1 SS_sky130_fd_sc_hd__fill_8
XFILLER_26_29 vssd1 vccd1 vssd1 vccd1 SS_sky130_ef_sc_hd__decap_40_12
XFILLER_38_265 vssd1 vccd1 vssd1 vccd1 SS_sky130_ef_sc_hd__decap_40_12
XFILLER_54_725 vssd1 vccd1 vssd1 vccd1 SS_sky130_ef_sc_hd__decap_40_12
XPHY_EDGE_ROW_5_Right_5 vccd1 vssd1 vccd1 vssd1 SS_sky130_fd_sc_hd__decap_3
XFILLER_54_769 vssd1 vccd1 vssd1 vccd1 SS_sky130_ef_sc_hd__decap_40_12
X_1107_ vssd1 vccd1 vccd1 vssd1 wire239/A input24/X _1584_/D _1445_/C1 _1106_/X SS_sky130_fd_sc_hd__o211a_2
XFILLER_93_393 vssd1 vccd1 vssd1 vccd1 SS_sky130_ef_sc_hd__decap_40_12
XFILLER_53_279 vccd1 vssd1 vccd1 vssd1 SS_sky130_fd_sc_hd__fill_1
X_1038_ vccd1 vssd1 vccd1 vssd1 _1038_/X _1038_/A _1050_/B SS_sky130_fd_sc_hd__or2_2
XTAP_TAPCELL_ROW_66_1283 vccd1 vssd1 SS_sky130_fd_sc_hd__tapvpwrvgnd_1
XTAP_TAPCELL_ROW_66_1294 vccd1 vssd1 SS_sky130_fd_sc_hd__tapvpwrvgnd_1
XFILLER_10_806 vssd1 vccd1 vccd1 vssd1 SS_sky130_fd_sc_hd__fill_4
XFILLER_10_817 vssd1 vccd1 vccd1 vssd1 SS_sky130_fd_sc_hd__fill_2
XFILLER_21_165 vssd1 vccd1 vccd1 vssd1 SS_sky130_fd_sc_hd__fill_2
XFILLER_22_699 vccd1 vssd1 vccd1 vssd1 SS_sky130_fd_sc_hd__fill_1
XFILLER_107_237 vssd1 vccd1 vssd1 vccd1 SS_sky130_ef_sc_hd__decap_40_12
XFILLER_1_559 vccd1 vssd1 vccd1 vssd1 SS_sky130_fd_sc_hd__fill_1
XFILLER_88_121 vssd1 vccd1 vssd1 vccd1 SS_sky130_ef_sc_hd__decap_40_12
XFILLER_131_741 vssd1 vccd1 vssd1 vccd1 SS_sky130_ef_sc_hd__decap_40_12
XFILLER_115_281 vssd1 vccd1 vssd1 vccd1 SS_sky130_ef_sc_hd__decap_40_12
XFILLER_76_305 vssd1 vccd1 vccd1 vssd1 SS_sky130_fd_sc_hd__fill_2
XFILLER_88_165 vssd1 vccd1 vssd1 vccd1 SS_sky130_ef_sc_hd__decap_40_12
XFILLER_130_251 vccd1 vssd1 vccd1 vssd1 SS_sky130_fd_sc_hd__fill_1
XFILLER_131_785 vssd1 vccd1 vssd1 vccd1 SS_sky130_ef_sc_hd__decap_40_12
XFILLER_29_221 vssd1 vccd1 vccd1 vssd1 SS_sky130_fd_sc_hd__fill_2
XFILLER_67_69 vssd1 vccd1 vssd1 vccd1 SS_sky130_ef_sc_hd__decap_40_12
XTAP_TAPCELL_ROW_4_353 vccd1 vssd1 SS_sky130_fd_sc_hd__tapvpwrvgnd_1
XTAP_TAPCELL_ROW_4_364 vccd1 vssd1 SS_sky130_fd_sc_hd__tapvpwrvgnd_1
XFILLER_57_541 vssd1 vccd1 vssd1 vccd1 SS_sky130_ef_sc_hd__decap_40_12
XFILLER_123_42 vssd1 vccd1 vssd1 vccd1 SS_sky130_ef_sc_hd__decap_40_12
XFILLER_17_405 vssd1 vccd1 vssd1 vccd1 SS_sky130_ef_sc_hd__decap_40_12
XFILLER_57_585 vssd1 vccd1 vccd1 vssd1 SS_sky130_fd_sc_hd__fill_4
XFILLER_17_449 vssd1 vccd1 vssd1 vccd1 SS_sky130_ef_sc_hd__decap_40_12
XFILLER_83_57 vssd1 vccd1 vssd1 vccd1 SS_sky130_ef_sc_hd__decap_40_12
XFILLER_32_419 vccd1 vssd1 vccd1 vssd1 SS_sky130_fd_sc_hd__fill_1
XFILLER_72_566 vssd1 vccd1 vccd1 vssd1 SS_sky130_fd_sc_hd__fill_4
XTAP_TAPCELL_ROW_43_948 vccd1 vssd1 SS_sky130_fd_sc_hd__tapvpwrvgnd_1
XFILLER_9_615 vccd1 vssd1 vccd1 vssd1 SS_sky130_fd_sc_hd__fill_1
XFILLER_12_121 vssd1 vccd1 vssd1 vccd1 SS_sky130_ef_sc_hd__decap_40_12
XTAP_TAPCELL_ROW_23_650 vccd1 vssd1 SS_sky130_fd_sc_hd__tapvpwrvgnd_1
XFILLER_12_165 vssd1 vccd1 vssd1 vccd1 SS_sky130_ef_sc_hd__decap_40_12
XFILLER_32_83 vccd1 vssd1 vccd1 vssd1 SS_sky130_fd_sc_hd__fill_1
XFILLER_5_821 vssd1 vccd1 vssd1 vccd1 SS_sky130_ef_sc_hd__decap_40_12
XFILLER_126_524 vssd1 vccd1 vccd1 vssd1 SS_sky130_fd_sc_hd__fill_2
XTAP_TAPCELL_ROW_97_1755 vccd1 vssd1 SS_sky130_fd_sc_hd__tapvpwrvgnd_1
XFILLER_67_305 vssd1 vccd1 vssd1 vccd1 SS_sky130_ef_sc_hd__decap_40_12
XFILLER_79_165 vssd1 vccd1 vccd1 vssd1 SS_sky130_fd_sc_hd__fill_2
XTAP_TAPCELL_ROW_128_2221 vccd1 vssd1 SS_sky130_fd_sc_hd__tapvpwrvgnd_1
XFILLER_121_273 vssd1 vccd1 vccd1 vssd1 SS_sky130_fd_sc_hd__fill_4
XTAP_TAPCELL_ROW_50_1051 vccd1 vssd1 SS_sky130_fd_sc_hd__tapvpwrvgnd_1
XFILLER_83_809 vssd1 vccd1 vccd1 vssd1 SS_sky130_fd_sc_hd__fill_2
XFILLER_95_669 vssd1 vccd1 vccd1 vssd1 SS_sky130_fd_sc_hd__fill_2
Xclkbuf_leaf_29_wb_clk_i _1576_/CLK clkload1/A vccd1 vssd1 vssd1 vccd1 SS_sky130_fd_sc_hd__clkbuf_8
XFILLER_36_725 vssd1 vccd1 vssd1 vccd1 SS_sky130_ef_sc_hd__decap_40_12
XFILLER_36_769 vssd1 vccd1 vssd1 vccd1 SS_sky130_ef_sc_hd__decap_40_12
XFILLER_75_393 vssd1 vccd1 vccd1 vssd1 SS_sky130_fd_sc_hd__fill_2
XFILLER_35_279 vccd1 vssd1 vccd1 vssd1 SS_sky130_fd_sc_hd__fill_1
XFILLER_90_363 vccd1 vssd1 vccd1 vssd1 SS_sky130_fd_sc_hd__fill_1
XFILLER_50_249 vssd1 vccd1 vccd1 vssd1 SS_sky130_fd_sc_hd__fill_2
XTAP_TAPCELL_ROW_106_1895 vccd1 vssd1 SS_sky130_fd_sc_hd__tapvpwrvgnd_1
XTAP_TAPCELL_ROW_106_1884 vccd1 vssd1 SS_sky130_fd_sc_hd__tapvpwrvgnd_1
XTAP_TAPCELL_ROW_21_609 vccd1 vssd1 SS_sky130_fd_sc_hd__tapvpwrvgnd_1
XFILLER_31_441 vssd1 vccd1 vccd1 vssd1 SS_sky130_fd_sc_hd__fill_4
XFILLER_92_3 vssd1 vccd1 vssd1 vccd1 SS_sky130_ef_sc_hd__decap_40_12
XFILLER_31_485 vssd1 vccd1 vssd1 vccd1 SS_sky130_ef_sc_hd__decap_40_12
XFILLER_129_351 vssd1 vccd1 vssd1 vccd1 SS_sky130_ef_sc_hd__decap_40_12
XFILLER_8_681 vssd1 vccd1 vssd1 vccd1 SS_sky130_ef_sc_hd__decap_40_12
X_1725_ _1725_/Q _1758_/CLK _1725_/D vccd1 vssd1 vccd1 vssd1 SS_sky130_fd_sc_hd__dfxtp_2
XFILLER_117_557 vssd1 vccd1 vccd1 vssd1 SS_sky130_fd_sc_hd__fill_2
XFILLER_132_538 vssd1 vccd1 vccd1 vssd1 SS_sky130_fd_sc_hd__fill_4
X_1656_ _1656_/Q _1741_/CLK _1656_/D vccd1 vssd1 vccd1 vssd1 SS_sky130_fd_sc_hd__dfxtp_2
X_1587_ _1861_/A _1686_/CLK _1587_/D vccd1 vssd1 vccd1 vssd1 SS_sky130_fd_sc_hd__dfxtp_2
XFILLER_58_305 vssd1 vccd1 vccd1 vssd1 SS_sky130_fd_sc_hd__fill_2
XFILLER_113_785 vssd1 vccd1 vssd1 vccd1 SS_sky130_ef_sc_hd__decap_40_12
XFILLER_112_251 vccd1 vssd1 vccd1 vssd1 SS_sky130_fd_sc_hd__fill_1
XFILLER_85_113 vssd1 vccd1 vssd1 vccd1 SS_sky130_ef_sc_hd__decap_40_12
XFILLER_86_625 vssd1 vccd1 vssd1 vccd1 SS_sky130_ef_sc_hd__decap_40_12
XFILLER_100_435 vssd1 vccd1 vssd1 vccd1 SS_sky130_ef_sc_hd__decap_40_12
XFILLER_98_485 vssd1 vccd1 vccd1 vssd1 SS_sky130_fd_sc_hd__fill_4
XFILLER_37_39 vssd1 vccd1 vssd1 vccd1 SS_sky130_ef_sc_hd__decap_40_12
XFILLER_74_809 vssd1 vccd1 vccd1 vssd1 SS_sky130_fd_sc_hd__fill_2
XFILLER_86_669 vssd1 vccd1 vssd1 vccd1 SS_sky130_ef_sc_hd__decap_40_12
Xafe_wb_516 analog_io_out[8] afe_wb_516/HI vccd1 vssd1 vssd1 vccd1 SS_sky130_fd_sc_hd__conb_1
Xafe_wb_527 analog_io_out[19] afe_wb_527/HI vccd1 vssd1 vssd1 vccd1 SS_sky130_fd_sc_hd__conb_1
Xafe_wb_505 analog_ctrl[101] afe_wb_505/HI vccd1 vssd1 vssd1 vccd1 SS_sky130_fd_sc_hd__conb_1
XTAP_TAPCELL_ROW_1_312 vccd1 vssd1 SS_sky130_fd_sc_hd__tapvpwrvgnd_1
Xafe_wb_538 afe_wb_538/LO analog_io_oeb[2] vccd1 vssd1 vssd1 vccd1 SS_sky130_fd_sc_hd__conb_1
Xafe_wb_549 afe_wb_549/LO analog_io_oeb[13] vccd1 vssd1 vssd1 vccd1 SS_sky130_fd_sc_hd__conb_1
XFILLER_39_585 vssd1 vccd1 vssd1 vccd1 SS_sky130_ef_sc_hd__decap_40_12
XTAP_TAPCELL_ROW_68_1323 vccd1 vssd1 SS_sky130_fd_sc_hd__tapvpwrvgnd_1
XFILLER_54_533 vssd1 vccd1 vssd1 vccd1 SS_sky130_ef_sc_hd__decap_40_12
XFILLER_14_419 vccd1 vssd1 vccd1 vssd1 SS_sky130_fd_sc_hd__fill_1
XFILLER_41_205 vssd1 vccd1 vssd1 vccd1 SS_sky130_ef_sc_hd__decap_40_12
XFILLER_54_577 vssd1 vccd1 vccd1 vssd1 SS_sky130_fd_sc_hd__fill_8
XTAP_TAPCELL_ROW_81_1512 vccd1 vssd1 SS_sky130_fd_sc_hd__tapvpwrvgnd_1
XTAP_TAPCELL_ROW_40_907 vccd1 vssd1 SS_sky130_fd_sc_hd__tapvpwrvgnd_1
XFILLER_41_249 vssd1 vccd1 vssd1 vccd1 SS_sky130_ef_sc_hd__decap_40_12
XFILLER_10_625 vssd1 vccd1 vssd1 vccd1 SS_sky130_ef_sc_hd__decap_40_12
XFILLER_10_669 vssd1 vccd1 vssd1 vccd1 SS_sky130_ef_sc_hd__decap_40_12
XFILLER_136_800 vssd1 vccd1 vssd1 vccd1 SS_sky130_ef_sc_hd__decap_40_12
XFILLER_136_833 vccd1 vssd1 vccd1 vssd1 SS_sky130_fd_sc_hd__fill_1
XTAP_TAPCELL_ROW_79_1485 vccd1 vssd1 SS_sky130_fd_sc_hd__tapvpwrvgnd_1
XFILLER_2_813 vssd1 vccd1 vssd1 vccd1 SS_sky130_ef_sc_hd__decap_40_12
XTAP_TAPCELL_ROW_9_434 vccd1 vssd1 SS_sky130_fd_sc_hd__tapvpwrvgnd_1
XFILLER_123_505 vssd1 vccd1 vssd1 vccd1 SS_sky130_ef_sc_hd__decap_40_12
XFILLER_118_53 vssd1 vccd1 vssd1 vccd1 SS_sky130_ef_sc_hd__decap_40_12
XFILLER_118_97 vssd1 vccd1 vssd1 vccd1 SS_sky130_ef_sc_hd__decap_40_12
Xhold681 _1188_/A _1624_/Q vccd1 vssd1 vssd1 vccd1 SS_sky130_fd_sc_hd__dlygate4sd3_1
Xhold670 _0990_/A _1528_/Q vccd1 vssd1 vssd1 vccd1 SS_sky130_fd_sc_hd__dlygate4sd3_1
XFILLER_49_305 vssd1 vccd1 vssd1 vccd1 SS_sky130_ef_sc_hd__decap_40_12
Xhold692 _1330_/A _1693_/Q vccd1 vssd1 vssd1 vccd1 SS_sky130_fd_sc_hd__dlygate4sd3_1
XFILLER_104_774 vssd1 vccd1 vssd1 vccd1 SS_sky130_ef_sc_hd__decap_40_12
XTAP_TAPCELL_ROW_92_1685 vccd1 vssd1 SS_sky130_fd_sc_hd__tapvpwrvgnd_1
XTAP_TAPCELL_ROW_92_1674 vccd1 vssd1 SS_sky130_fd_sc_hd__tapvpwrvgnd_1
XFILLER_1_389 vssd1 vccd1 vccd1 vssd1 SS_sky130_fd_sc_hd__fill_2
XFILLER_89_485 vssd1 vccd1 vssd1 vccd1 SS_sky130_ef_sc_hd__decap_40_12
XFILLER_131_582 vssd1 vccd1 vssd1 vccd1 SS_sky130_ef_sc_hd__decap_40_12
XFILLER_103_273 vssd1 vccd1 vccd1 vssd1 SS_sky130_fd_sc_hd__fill_4
XFILLER_49_349 vssd1 vccd1 vssd1 vccd1 SS_sky130_ef_sc_hd__decap_40_12
XFILLER_134_85 vssd1 vccd1 vssd1 vccd1 SS_sky130_ef_sc_hd__decap_40_12
XFILLER_91_105 vssd1 vccd1 vccd1 vssd1 SS_sky130_fd_sc_hd__fill_4
XTAP_TAPCELL_ROW_28_720 vccd1 vssd1 SS_sky130_fd_sc_hd__tapvpwrvgnd_1
XFILLER_57_393 vssd1 vccd1 vssd1 vccd1 SS_sky130_ef_sc_hd__decap_40_12
XFILLER_91_149 vssd1 vccd1 vssd1 vccd1 SS_sky130_ef_sc_hd__decap_40_12
XTAP_TAPCELL_ROW_123_2140 vccd1 vssd1 SS_sky130_fd_sc_hd__tapvpwrvgnd_1
XFILLER_17_279 vccd1 vssd1 vccd1 vssd1 SS_sky130_fd_sc_hd__fill_1
XTAP_TAPCELL_ROW_123_2151 vccd1 vssd1 SS_sky130_fd_sc_hd__tapvpwrvgnd_1
XFILLER_13_441 vssd1 vccd1 vccd1 vssd1 SS_sky130_fd_sc_hd__fill_4
XFILLER_32_249 vssd1 vccd1 vccd1 vssd1 SS_sky130_fd_sc_hd__fill_2
XFILLER_13_485 vssd1 vccd1 vssd1 vccd1 SS_sky130_ef_sc_hd__decap_40_12
XFILLER_41_783 vccd1 vssd1 vccd1 vssd1 SS_sky130_fd_sc_hd__fill_1
XFILLER_43_93 vssd1 vccd1 vssd1 vccd1 SS_sky130_ef_sc_hd__decap_40_12
XFILLER_9_445 vssd1 vccd1 vccd1 vssd1 SS_sky130_fd_sc_hd__fill_2
XFILLER_126_321 vssd1 vccd1 vccd1 vssd1 SS_sky130_fd_sc_hd__fill_2
XFILLER_5_673 vssd1 vccd1 vssd1 vccd1 SS_sky130_ef_sc_hd__decap_40_12
X_1510_ _1834_/A _1573_/CLK _1510_/D vccd1 vssd1 vccd1 vssd1 SS_sky130_fd_sc_hd__dfxtp_2
XFILLER_126_365 vssd1 vccd1 vssd1 vccd1 SS_sky130_ef_sc_hd__decap_40_12
XFILLER_99_205 vssd1 vccd1 vssd1 vccd1 SS_sky130_ef_sc_hd__decap_40_12
X_1441_ vssd1 vccd1 vccd1 vssd1 wire207/X input26/X _1746_/D _1441_/C1 _1440_/X SS_sky130_fd_sc_hd__o211a_2
XFILLER_99_249 vssd1 vccd1 vssd1 vccd1 SS_sky130_ef_sc_hd__decap_40_12
XFILLER_4_65 vssd1 vccd1 vssd1 vccd1 SS_sky130_ef_sc_hd__decap_40_12
XFILLER_67_113 vssd1 vccd1 vssd1 vccd1 SS_sky130_ef_sc_hd__decap_40_12
XFILLER_68_625 vssd1 vccd1 vssd1 vccd1 SS_sky130_ef_sc_hd__decap_40_12
X_1372_ vccd1 vssd1 vccd1 vssd1 _1372_/X _1372_/A _1396_/B SS_sky130_fd_sc_hd__or2_2
XFILLER_68_669 vssd1 vccd1 vssd1 vccd1 SS_sky130_ef_sc_hd__decap_40_12
XFILLER_110_755 vccd1 vssd1 vccd1 vssd1 SS_sky130_fd_sc_hd__fill_1
XFILLER_95_444 vssd1 vccd1 vccd1 vssd1 SS_sky130_fd_sc_hd__fill_4
XTAP_TAPCELL_ROW_108_1924 vccd1 vssd1 SS_sky130_fd_sc_hd__tapvpwrvgnd_1
XTAP_TAPCELL_ROW_108_1913 vccd1 vssd1 SS_sky130_fd_sc_hd__tapvpwrvgnd_1
XFILLER_36_533 vssd1 vccd1 vssd1 vccd1 SS_sky130_ef_sc_hd__decap_40_12
XFILLER_23_205 vssd1 vccd1 vssd1 vccd1 SS_sky130_ef_sc_hd__decap_40_12
XFILLER_51_503 vccd1 vssd1 vccd1 vssd1 SS_sky130_fd_sc_hd__fill_1
XFILLER_91_661 vccd1 vssd1 vccd1 vssd1 SS_sky130_fd_sc_hd__fill_1
XFILLER_23_249 vssd1 vccd1 vssd1 vccd1 SS_sky130_ef_sc_hd__decap_40_12
XFILLER_51_569 vssd1 vccd1 vssd1 vccd1 SS_sky130_ef_sc_hd__decap_40_12
XTAP_TAPCELL_ROW_63_1242 vccd1 vssd1 SS_sky130_fd_sc_hd__tapvpwrvgnd_1
XFILLER_90_193 vssd1 vccd1 vccd1 vssd1 SS_sky130_fd_sc_hd__fill_2
XFILLER_31_293 vssd1 vccd1 vssd1 vccd1 SS_sky130_ef_sc_hd__decap_40_12
XFILLER_129_181 vssd1 vccd1 vssd1 vccd1 SS_sky130_ef_sc_hd__decap_40_12
XFILLER_133_803 vccd1 vssd1 vccd1 vssd1 SS_sky130_fd_sc_hd__fill_1
XFILLER_2_109 vssd1 vccd1 vssd1 vccd1 SS_sky130_ef_sc_hd__decap_40_12
X_1708_ _1887_/A clkload7/A _1708_/D vccd1 vssd1 vccd1 vssd1 SS_sky130_fd_sc_hd__dfxtp_2
XFILLER_105_505 vssd1 vccd1 vccd1 vssd1 SS_sky130_fd_sc_hd__fill_8
X_1639_ _1639_/Q clkload8/A _1639_/D vccd1 vssd1 vccd1 vssd1 SS_sky130_fd_sc_hd__dfxtp_2
Xfanout468 vssd1 vccd1 vccd1 vssd1 _1165_/C1 _1151_/C1 SS_sky130_fd_sc_hd__clkdlybuf4s25_1
XFILLER_47_809 vssd1 vccd1 vccd1 vssd1 SS_sky130_fd_sc_hd__fill_2
XFILLER_100_221 vssd1 vccd1 vssd1 vccd1 SS_sky130_ef_sc_hd__decap_40_12
XFILLER_73_105 vssd1 vccd1 vccd1 vssd1 SS_sky130_fd_sc_hd__fill_4
XFILLER_74_639 vssd1 vccd1 vccd1 vssd1 SS_sky130_fd_sc_hd__fill_4
XFILLER_86_477 vssd1 vccd1 vssd1 vccd1 SS_sky130_ef_sc_hd__decap_40_12
XFILLER_101_777 vssd1 vccd1 vccd1 vssd1 SS_sky130_fd_sc_hd__fill_4
XFILLER_100_265 vssd1 vccd1 vssd1 vccd1 SS_sky130_ef_sc_hd__decap_40_12
XFILLER_39_393 vssd1 vccd1 vssd1 vccd1 SS_sky130_ef_sc_hd__decap_40_12
XFILLER_64_15 vssd1 vccd1 vssd1 vccd1 SS_sky130_ef_sc_hd__decap_40_12
XFILLER_73_149 vssd1 vccd1 vssd1 vccd1 SS_sky130_ef_sc_hd__decap_40_12
XFILLER_104_77 vssd1 vccd1 vccd1 vssd1 SS_sky130_fd_sc_hd__fill_4
XFILLER_54_352 vssd1 vccd1 vssd1 vccd1 SS_sky130_ef_sc_hd__decap_40_12
XFILLER_14_249 vssd1 vccd1 vccd1 vssd1 SS_sky130_fd_sc_hd__fill_2
XFILLER_81_193 vssd1 vccd1 vssd1 vccd1 SS_sky130_ef_sc_hd__decap_40_12
XFILLER_120_65 vssd1 vccd1 vssd1 vccd1 SS_sky130_ef_sc_hd__decap_40_12
XFILLER_23_783 vccd1 vssd1 vccd1 vssd1 SS_sky130_fd_sc_hd__fill_1
XFILLER_10_433 vssd1 vccd1 vssd1 vccd1 SS_sky130_ef_sc_hd__decap_40_12
XFILLER_13_30 vssd1 vccd1 vssd1 vccd1 SS_sky130_ef_sc_hd__decap_40_12
XFILLER_10_477 vssd1 vccd1 vssd1 vccd1 SS_sky130_ef_sc_hd__decap_40_12
XFILLER_136_641 vssd1 vccd1 vccd1 vssd1 SS_sky130_fd_sc_hd__fill_2
XFILLER_108_321 vssd1 vccd1 vssd1 vccd1 SS_sky130_ef_sc_hd__decap_40_12
XTAP_TAPCELL_ROW_94_1714 vccd1 vssd1 SS_sky130_fd_sc_hd__tapvpwrvgnd_1
XTAP_TAPCELL_ROW_94_1703 vccd1 vssd1 SS_sky130_fd_sc_hd__tapvpwrvgnd_1
XFILLER_108_365 vssd1 vccd1 vssd1 vccd1 SS_sky130_ef_sc_hd__decap_40_12
XFILLER_2_643 vccd1 vssd1 vccd1 vssd1 SS_sky130_fd_sc_hd__fill_1
XFILLER_49_113 vssd1 vccd1 vssd1 vccd1 SS_sky130_ef_sc_hd__decap_40_12
XFILLER_77_433 vssd1 vccd1 vccd1 vssd1 SS_sky130_fd_sc_hd__fill_2
XFILLER_89_293 vssd1 vccd1 vssd1 vccd1 SS_sky130_ef_sc_hd__decap_40_12
XFILLER_65_617 vssd1 vccd1 vssd1 vccd1 SS_sky130_ef_sc_hd__decap_40_12
XFILLER_18_533 vssd1 vccd1 vssd1 vccd1 SS_sky130_ef_sc_hd__decap_40_12
XFILLER_33_503 vccd1 vssd1 vccd1 vssd1 SS_sky130_fd_sc_hd__fill_1
XFILLER_45_385 vssd1 vccd1 vccd1 vssd1 SS_sky130_fd_sc_hd__fill_4
XFILLER_54_81 vssd1 vccd1 vccd1 vssd1 SS_sky130_fd_sc_hd__fill_2
XFILLER_60_333 vssd1 vccd1 vssd1 vccd1 SS_sky130_ef_sc_hd__decap_40_12
XFILLER_72_193 vssd1 vccd1 vccd1 vssd1 SS_sky130_fd_sc_hd__fill_2
XTAP_TAPCELL_ROW_103_1843 vccd1 vssd1 SS_sky130_fd_sc_hd__tapvpwrvgnd_1
XFILLER_60_377 vssd1 vccd1 vssd1 vccd1 SS_sky130_ef_sc_hd__decap_40_12
X_0941_ vccd1 vssd1 vccd1 vssd1 _1538_/Q _0941_/B1 _1762_/Q _0745_/X _0943_/B SS_sky130_fd_sc_hd__a22o_2
XFILLER_13_293 vssd1 vccd1 vssd1 vccd1 SS_sky130_ef_sc_hd__decap_40_12
XTAP_TAPCELL_ROW_31_759 vccd1 vssd1 SS_sky130_fd_sc_hd__tapvpwrvgnd_1
XTAP_TAPCELL_ROW_136_2342 vccd1 vssd1 SS_sky130_fd_sc_hd__tapvpwrvgnd_1
X_0872_ vccd1 vssd1 vssd1 vccd1 _0868_/X _0871_/X _0926_/A2 hold800/X _1494_/D _1251_/C1
+ SS_sky130_fd_sc_hd__o221a_2
XTAP_TAPCELL_ROW_11_461 vccd1 vssd1 SS_sky130_fd_sc_hd__tapvpwrvgnd_1
XTAP_TAPCELL_ROW_11_472 vccd1 vssd1 SS_sky130_fd_sc_hd__tapvpwrvgnd_1
Xclkload12 vssd1 vccd1 _1576_/CLK clkload12/X vccd1 vssd1 SS_sky130_fd_sc_hd__clkbuf_4
Xclkload23 vssd1 vccd1 _1758_/CLK clkload23/X vccd1 vssd1 SS_sky130_fd_sc_hd__clkbuf_4
XFILLER_127_630 vssd1 vccd1 vssd1 vccd1 SS_sky130_ef_sc_hd__decap_40_12
XFILLER_55_3 vssd1 vccd1 vssd1 vccd1 SS_sky130_ef_sc_hd__decap_40_12
XFILLER_127_685 vssd1 vccd1 vssd1 vccd1 SS_sky130_ef_sc_hd__decap_40_12
XFILLER_115_814 vssd1 vccd1 vccd1 vssd1 SS_sky130_fd_sc_hd__fill_4
XFILLER_126_195 vccd1 vssd1 vccd1 vssd1 SS_sky130_fd_sc_hd__fill_1
XFILLER_130_817 vccd1 vssd1 vccd1 vssd1 SS_sky130_fd_sc_hd__fill_1
X_1424_ vccd1 vssd1 vccd1 vssd1 _1424_/X _1424_/A _1466_/B SS_sky130_fd_sc_hd__or2_2
XFILLER_29_809 vssd1 vccd1 vccd1 vssd1 SS_sky130_fd_sc_hd__fill_4
XFILLER_56_606 vssd1 vccd1 vssd1 vccd1 SS_sky130_ef_sc_hd__decap_40_12
XFILLER_68_433 vssd1 vccd1 vssd1 vccd1 SS_sky130_ef_sc_hd__decap_40_12
XFILLER_110_530 vssd1 vccd1 vccd1 vssd1 SS_sky130_fd_sc_hd__fill_2
XFILLER_96_753 vssd1 vccd1 vccd1 vssd1 SS_sky130_fd_sc_hd__fill_2
X_1355_ vssd1 vccd1 vccd1 vssd1 _1405_/A2 input47/X _1704_/D _1439_/C1 _1354_/X SS_sky130_fd_sc_hd__o211a_2
XFILLER_55_105 vssd1 vccd1 vccd1 vssd1 SS_sky130_fd_sc_hd__fill_4
XFILLER_68_477 vssd1 vccd1 vssd1 vccd1 SS_sky130_ef_sc_hd__decap_40_12
XFILLER_110_585 vssd1 vccd1 vccd1 vssd1 SS_sky130_fd_sc_hd__fill_2
X_1286_ vccd1 vssd1 vccd1 vssd1 _1286_/X _1889_/A _1338_/B SS_sky130_fd_sc_hd__or2_2
XFILLER_55_149 vssd1 vccd1 vssd1 vccd1 SS_sky130_ef_sc_hd__decap_40_12
XFILLER_36_363 vccd1 vssd1 vccd1 vssd1 SS_sky130_fd_sc_hd__fill_1
XTAP_TAPCELL_ROW_19_583 vccd1 vssd1 SS_sky130_fd_sc_hd__tapvpwrvgnd_1
XFILLER_24_525 vssd1 vccd1 vccd1 vssd1 SS_sky130_fd_sc_hd__fill_4
XFILLER_91_480 vssd1 vccd1 vssd1 vccd1 SS_sky130_ef_sc_hd__decap_40_12
XFILLER_24_569 vssd1 vccd1 vssd1 vccd1 SS_sky130_ef_sc_hd__decap_40_12
XFILLER_34_29 vssd1 vccd1 vssd1 vccd1 SS_sky130_ef_sc_hd__decap_40_12
XFILLER_51_333 vssd1 vccd1 vccd1 vssd1 SS_sky130_fd_sc_hd__fill_2
XFILLER_63_193 vssd1 vccd1 vssd1 vccd1 SS_sky130_ef_sc_hd__decap_40_12
XFILLER_20_720 vssd1 vccd1 vccd1 vssd1 SS_sky130_fd_sc_hd__fill_2
XFILLER_20_764 vssd1 vccd1 vssd1 vccd1 SS_sky130_ef_sc_hd__decap_40_12
Xclkload6 vssd1 vccd1 clkload6/A clkload6/X vccd1 vssd1 SS_sky130_fd_sc_hd__clkbuf_4
XFILLER_137_449 vssd1 vccd1 vccd1 vssd1 SS_sky130_fd_sc_hd__fill_2
XFILLER_118_641 vssd1 vccd1 vccd1 vssd1 SS_sky130_fd_sc_hd__fill_2
XTAP_TAPCELL_ROW_76_1433 vccd1 vssd1 SS_sky130_fd_sc_hd__tapvpwrvgnd_1
XFILLER_3_429 vssd1 vccd1 vssd1 vccd1 SS_sky130_ef_sc_hd__decap_40_12
XFILLER_59_15 vssd1 vccd1 vssd1 vccd1 SS_sky130_ef_sc_hd__decap_40_12
XTAP_TAPCELL_ROW_76_1444 vccd1 vssd1 SS_sky130_fd_sc_hd__tapvpwrvgnd_1
XFILLER_132_121 vssd1 vccd1 vssd1 vccd1 SS_sky130_ef_sc_hd__decap_40_12
XFILLER_118_696 vssd1 vccd1 vccd1 vssd1 SS_sky130_fd_sc_hd__fill_4
XFILLER_79_709 vssd1 vccd1 vssd1 vccd1 SS_sky130_ef_sc_hd__decap_40_12
Xfanout232 vssd1 vccd1 vccd1 vssd1 _1145_/Y wire233/A SS_sky130_fd_sc_hd__clkdlybuf4s25_1
XFILLER_132_165 vssd1 vccd1 vssd1 vccd1 SS_sky130_ef_sc_hd__decap_40_12
XFILLER_120_338 vssd1 vccd1 vccd1 vssd1 SS_sky130_fd_sc_hd__fill_8
Xfanout243 vssd1 vccd1 vccd1 vssd1 _1126_/B _1116_/B SS_sky130_fd_sc_hd__clkdlybuf4s25_1
XFILLER_87_753 vssd1 vccd1 vssd1 vccd1 SS_sky130_ef_sc_hd__decap_40_12
Xfanout254 vssd1 vccd1 vccd1 vssd1 _0947_/Y fanout254/X SS_sky130_fd_sc_hd__clkdlybuf4s25_1
XFILLER_101_541 vssd1 vccd1 vssd1 vccd1 SS_sky130_ef_sc_hd__decap_40_12
XFILLER_47_617 vssd1 vccd1 vssd1 vccd1 SS_sky130_ef_sc_hd__decap_40_12
XFILLER_87_797 vssd1 vccd1 vccd1 vssd1 SS_sky130_fd_sc_hd__fill_2
XFILLER_101_585 vssd1 vccd1 vssd1 vccd1 SS_sky130_ef_sc_hd__decap_40_12
XFILLER_75_69 vssd1 vccd1 vssd1 vccd1 SS_sky130_ef_sc_hd__decap_40_12
XFILLER_15_503 vccd1 vssd1 vccd1 vssd1 SS_sky130_fd_sc_hd__fill_1
XFILLER_43_801 vssd1 vccd1 vccd1 vssd1 SS_sky130_fd_sc_hd__fill_2
XFILLER_55_650 vssd1 vccd1 vssd1 vccd1 SS_sky130_ef_sc_hd__decap_40_12
XFILLER_131_42 vssd1 vccd1 vssd1 vccd1 SS_sky130_ef_sc_hd__decap_40_12
XFILLER_27_385 vssd1 vccd1 vccd1 vssd1 SS_sky130_fd_sc_hd__fill_4
XTAP_TAPCELL_ROW_38_870 vccd1 vssd1 SS_sky130_fd_sc_hd__tapvpwrvgnd_1
XFILLER_42_333 vssd1 vccd1 vssd1 vccd1 SS_sky130_ef_sc_hd__decap_40_12
XFILLER_54_193 vssd1 vccd1 vccd1 vssd1 SS_sky130_fd_sc_hd__fill_2
XFILLER_91_57 vssd1 vccd1 vssd1 vccd1 SS_sky130_ef_sc_hd__decap_40_12
XFILLER_42_377 vssd1 vccd1 vssd1 vccd1 SS_sky130_ef_sc_hd__decap_40_12
XFILLER_11_775 vssd1 vccd1 vccd1 vssd1 SS_sky130_fd_sc_hd__fill_8
XFILLER_11_797 vssd1 vccd1 vssd1 vccd1 SS_sky130_ef_sc_hd__decap_40_12
XTAP_TAPCELL_ROW_118_2072 vccd1 vssd1 SS_sky130_fd_sc_hd__tapvpwrvgnd_1
XFILLER_109_641 vssd1 vccd1 vccd1 vssd1 SS_sky130_fd_sc_hd__fill_2
XFILLER_6_245 vssd1 vccd1 vccd1 vssd1 SS_sky130_fd_sc_hd__fill_4
XFILLER_109_663 vccd1 vssd1 vccd1 vssd1 SS_sky130_fd_sc_hd__fill_1
XFILLER_6_289 vssd1 vccd1 vssd1 vccd1 SS_sky130_ef_sc_hd__decap_40_12
XFILLER_40_83 vccd1 vssd1 vccd1 vssd1 SS_sky130_fd_sc_hd__fill_1
XFILLER_109_696 vssd1 vccd1 vccd1 vssd1 SS_sky130_fd_sc_hd__fill_4
XFILLER_108_195 vccd1 vssd1 vccd1 vssd1 SS_sky130_fd_sc_hd__fill_1
XTAP_TAPCELL_ROW_131_2261 vccd1 vssd1 SS_sky130_fd_sc_hd__tapvpwrvgnd_1
XTAP_TAPCELL_ROW_131_2272 vccd1 vssd1 SS_sky130_fd_sc_hd__tapvpwrvgnd_1
XFILLER_124_677 vssd1 vccd1 vssd1 vccd1 SS_sky130_ef_sc_hd__decap_40_12
XFILLER_97_517 vssd1 vccd1 vssd1 vccd1 SS_sky130_ef_sc_hd__decap_40_12
XFILLER_2_473 vssd1 vccd1 vccd1 vssd1 SS_sky130_fd_sc_hd__fill_2
XFILLER_124_699 vccd1 vssd1 vccd1 vssd1 SS_sky130_fd_sc_hd__fill_1
XFILLER_123_165 vssd1 vccd1 vccd1 vssd1 SS_sky130_fd_sc_hd__fill_2
XFILLER_111_305 vssd1 vccd1 vssd1 vccd1 SS_sky130_ef_sc_hd__decap_40_12
XFILLER_49_81 vssd1 vccd1 vssd1 vccd1 SS_sky130_ef_sc_hd__decap_40_12
XFILLER_78_753 vssd1 vccd1 vccd1 vssd1 SS_sky130_fd_sc_hd__fill_2
XFILLER_111_349 vssd1 vccd1 vssd1 vccd1 SS_sky130_ef_sc_hd__decap_40_12
XFILLER_37_105 vssd1 vccd1 vccd1 vssd1 SS_sky130_fd_sc_hd__fill_4
X_1140_ vccd1 vssd1 vccd1 vssd1 _1140_/X _1140_/A _1140_/B SS_sky130_fd_sc_hd__or2_2
XFILLER_65_447 vccd1 vssd1 vccd1 vssd1 SS_sky130_fd_sc_hd__fill_1
XFILLER_93_756 vssd1 vccd1 vssd1 vccd1 SS_sky130_ef_sc_hd__decap_40_12
XFILLER_92_233 vssd1 vccd1 vssd1 vccd1 SS_sky130_ef_sc_hd__decap_40_12
XFILLER_34_801 vssd1 vccd1 vccd1 vssd1 SS_sky130_fd_sc_hd__fill_2
XFILLER_37_149 vssd1 vccd1 vssd1 vccd1 SS_sky130_ef_sc_hd__decap_40_12
X_1071_ vssd1 vccd1 vccd1 vssd1 _1077_/A2 input40/X _1071_/X _1401_/C1 _1070_/X SS_sky130_fd_sc_hd__o211a_2
XFILLER_18_363 vccd1 vssd1 vccd1 vssd1 SS_sky130_fd_sc_hd__fill_1
XTAP_TAPCELL_ROW_47_1001 vccd1 vssd1 SS_sky130_fd_sc_hd__tapvpwrvgnd_1
XTAP_TAPCELL_ROW_47_1012 vccd1 vssd1 SS_sky130_fd_sc_hd__tapvpwrvgnd_1
XFILLER_92_277 vssd1 vccd1 vssd1 vccd1 SS_sky130_ef_sc_hd__decap_40_12
XTAP_TAPCELL_ROW_16_542 vccd1 vssd1 SS_sky130_fd_sc_hd__tapvpwrvgnd_1
XFILLER_33_333 vssd1 vccd1 vccd1 vssd1 SS_sky130_fd_sc_hd__fill_2
XFILLER_45_193 vssd1 vccd1 vssd1 vccd1 SS_sky130_ef_sc_hd__decap_40_12
XFILLER_21_517 vssd1 vccd1 vssd1 vccd1 SS_sky130_ef_sc_hd__decap_40_12
XFILLER_60_141 vssd1 vccd1 vssd1 vccd1 SS_sky130_ef_sc_hd__decap_40_12
XTAP_TAPCELL_ROW_60_1201 vccd1 vssd1 SS_sky130_fd_sc_hd__tapvpwrvgnd_1
XFILLER_61_697 vssd1 vccd1 vssd1 vccd1 SS_sky130_ef_sc_hd__decap_40_12
XFILLER_119_427 vssd1 vccd1 vccd1 vssd1 SS_sky130_fd_sc_hd__fill_2
X_0924_ vccd1 vssd1 vccd1 vssd1 _1695_/Q wire448/A _1727_/Q wire452/X _0924_/X SS_sky130_fd_sc_hd__a22o_2
X_0855_ vccd1 vssd1 vccd1 vssd1 _1652_/Q wire431/X _1620_/Q _0876_/B1 _0855_/X SS_sky130_fd_sc_hd__a22o_2
XFILLER_119_449 vssd1 vccd1 vssd1 vccd1 SS_sky130_ef_sc_hd__decap_40_12
X_0786_ vccd1 vssd1 vccd1 vssd1 _1838_/A wire421/X _1868_/A _0828_/B1 _0786_/X SS_sky130_fd_sc_hd__a22o_2
XTAP_TAPCELL_ROW_58_1163 vccd1 vssd1 SS_sky130_fd_sc_hd__tapvpwrvgnd_1
XTAP_TAPCELL_ROW_58_1174 vccd1 vssd1 SS_sky130_fd_sc_hd__tapvpwrvgnd_1
XFILLER_115_677 vssd1 vccd1 vccd1 vssd1 SS_sky130_fd_sc_hd__fill_2
XFILLER_115_666 vssd1 vccd1 vccd1 vssd1 SS_sky130_fd_sc_hd__fill_4
XFILLER_114_121 vssd1 vccd1 vssd1 vccd1 SS_sky130_ef_sc_hd__decap_40_12
XFILLER_69_720 vccd1 vssd1 vccd1 vssd1 SS_sky130_fd_sc_hd__fill_1
XFILLER_88_528 vssd1 vccd1 vccd1 vssd1 SS_sky130_fd_sc_hd__fill_4
XFILLER_130_625 vssd1 vccd1 vssd1 vccd1 SS_sky130_ef_sc_hd__decap_40_12
XFILLER_115_699 vssd1 vccd1 vccd1 vssd1 SS_sky130_fd_sc_hd__fill_2
XFILLER_115_688 vssd1 vccd1 vccd1 vssd1 SS_sky130_fd_sc_hd__fill_2
XFILLER_114_165 vssd1 vccd1 vssd1 vccd1 SS_sky130_ef_sc_hd__decap_40_12
XFILLER_102_305 vssd1 vccd1 vccd1 vssd1 SS_sky130_fd_sc_hd__fill_2
XFILLER_69_753 vssd1 vccd1 vssd1 vccd1 SS_sky130_ef_sc_hd__decap_40_12
XTAP_TAPCELL_ROW_71_1363 vccd1 vssd1 SS_sky130_fd_sc_hd__tapvpwrvgnd_1
XFILLER_130_669 vssd1 vccd1 vssd1 vccd1 SS_sky130_ef_sc_hd__decap_40_12
X_1407_ vssd1 vccd1 vccd1 vssd1 _1343_/Y input44/X _1730_/D _1473_/C1 _1406_/X SS_sky130_fd_sc_hd__o211a_2
XFILLER_29_617 vccd1 vssd1 vccd1 vssd1 SS_sky130_fd_sc_hd__fill_1
XFILLER_69_797 vssd1 vccd1 vssd1 vccd1 SS_sky130_ef_sc_hd__decap_40_12
XFILLER_84_701 vssd1 vccd1 vssd1 vccd1 SS_sky130_ef_sc_hd__decap_40_12
X_1338_ vccd1 vssd1 vccd1 vssd1 _1338_/X _1338_/A _1338_/B SS_sky130_fd_sc_hd__or2_2
XFILLER_56_469 vssd1 vccd1 vccd1 vssd1 SS_sky130_fd_sc_hd__fill_4
X_1269_ vssd1 vccd1 vccd1 vssd1 _1273_/A2 input40/X _1663_/D _1439_/C1 _1268_/X SS_sky130_fd_sc_hd__o211a_2
XFILLER_25_823 vccd1 vssd1 vccd1 vssd1 SS_sky130_fd_sc_hd__fill_1
XFILLER_45_39 vssd1 vccd1 vssd1 vccd1 SS_sky130_ef_sc_hd__decap_40_12
XFILLER_83_277 vssd1 vccd1 vccd1 vssd1 SS_sky130_fd_sc_hd__fill_2
XFILLER_24_333 vssd1 vccd1 vssd1 vccd1 SS_sky130_ef_sc_hd__decap_40_12
XFILLER_36_193 vssd1 vccd1 vccd1 vssd1 SS_sky130_fd_sc_hd__fill_2
XFILLER_24_377 vssd1 vccd1 vssd1 vccd1 SS_sky130_ef_sc_hd__decap_40_12
XFILLER_138_725 vssd1 vccd1 vccd1 vssd1 SS_sky130_fd_sc_hd__fill_2
XFILLER_137_202 vccd1 vssd1 vccd1 vssd1 SS_sky130_fd_sc_hd__fill_1
XFILLER_137_279 vccd1 vssd1 vccd1 vssd1 SS_sky130_fd_sc_hd__fill_1
XFILLER_4_749 vssd1 vccd1 vccd1 vssd1 SS_sky130_fd_sc_hd__fill_4
XFILLER_3_237 vssd1 vccd1 vssd1 vccd1 SS_sky130_ef_sc_hd__decap_40_12
XFILLER_10_53 vssd1 vccd1 vssd1 vccd1 SS_sky130_ef_sc_hd__decap_40_12
XFILLER_10_97 vssd1 vccd1 vssd1 vccd1 SS_sky130_ef_sc_hd__decap_40_12
XFILLER_133_496 vssd1 vccd1 vccd1 vssd1 SS_sky130_fd_sc_hd__fill_8
XFILLER_126_53 vssd1 vccd1 vssd1 vccd1 SS_sky130_ef_sc_hd__decap_40_12
XFILLER_106_699 vccd1 vssd1 vccd1 vssd1 SS_sky130_fd_sc_hd__fill_1
XFILLER_105_165 vssd1 vccd1 vccd1 vssd1 SS_sky130_fd_sc_hd__fill_2
XFILLER_126_97 vssd1 vccd1 vssd1 vccd1 SS_sky130_ef_sc_hd__decap_40_12
XFILLER_19_105 vssd1 vccd1 vccd1 vssd1 SS_sky130_fd_sc_hd__fill_4
XFILLER_87_561 vssd1 vccd1 vccd1 vssd1 SS_sky130_fd_sc_hd__fill_2
XFILLER_19_51 vssd1 vccd1 vccd1 vssd1 SS_sky130_fd_sc_hd__fill_4
XFILLER_47_447 vccd1 vssd1 vccd1 vssd1 SS_sky130_fd_sc_hd__fill_1
XTAP_TAPCELL_ROW_89_1635 vccd1 vssd1 SS_sky130_fd_sc_hd__tapvpwrvgnd_1
XFILLER_19_149 vssd1 vccd1 vssd1 vccd1 SS_sky130_ef_sc_hd__decap_40_12
XFILLER_74_233 vssd1 vccd1 vssd1 vccd1 SS_sky130_ef_sc_hd__decap_40_12
XFILLER_62_417 vssd1 vccd1 vccd1 vssd1 SS_sky130_fd_sc_hd__fill_2
XFILLER_74_277 vssd1 vccd1 vssd1 vccd1 SS_sky130_ef_sc_hd__decap_40_12
XFILLER_15_333 vssd1 vccd1 vccd1 vssd1 SS_sky130_fd_sc_hd__fill_2
XFILLER_27_193 vssd1 vccd1 vssd1 vccd1 SS_sky130_ef_sc_hd__decap_40_12
XFILLER_43_631 vccd1 vssd1 vccd1 vssd1 SS_sky130_fd_sc_hd__fill_1
XFILLER_42_141 vssd1 vccd1 vssd1 vccd1 SS_sky130_ef_sc_hd__decap_40_12
XTAP_TAPCELL_ROW_100_1802 vccd1 vssd1 SS_sky130_fd_sc_hd__tapvpwrvgnd_1
XTAP_TAPCELL_ROW_13_501 vccd1 vssd1 SS_sky130_fd_sc_hd__tapvpwrvgnd_1
XFILLER_43_697 vssd1 vccd1 vssd1 vccd1 SS_sky130_ef_sc_hd__decap_40_12
XFILLER_11_561 vssd1 vccd1 vssd1 vccd1 SS_sky130_ef_sc_hd__decap_40_12
Xwire430 vccd1 vssd1 wire430/X wire431/X vccd1 vssd1 SS_sky130_fd_sc_hd__buf_4
XTAP_TAPCELL_ROW_133_2301 vccd1 vssd1 SS_sky130_fd_sc_hd__tapvpwrvgnd_1
XFILLER_51_93 vssd1 vccd1 vssd1 vccd1 SS_sky130_ef_sc_hd__decap_40_12
Xwire452 vccd1 vssd1 wire452/X _1343_/A vccd1 vssd1 SS_sky130_fd_sc_hd__buf_4
XFILLER_116_419 vccd1 vssd1 vccd1 vssd1 SS_sky130_fd_sc_hd__fill_1
Xmax_cap229 vccd1 vssd1 _1261_/A2 _1265_/A2 vccd1 vssd1 SS_sky130_fd_sc_hd__buf_6
XFILLER_109_493 vssd1 vccd1 vccd1 vssd1 SS_sky130_fd_sc_hd__fill_8
Xwire496 vccd1 vssd1 wire496/X wire496/A vccd1 vssd1 SS_sky130_fd_sc_hd__buf_4
XFILLER_124_441 vccd1 vssd1 vccd1 vssd1 SS_sky130_fd_sc_hd__fill_1
XFILLER_112_669 vssd1 vccd1 vssd1 vccd1 SS_sky130_ef_sc_hd__decap_40_12
XTAP_TAPCELL_ROW_111_1964 vccd1 vssd1 SS_sky130_fd_sc_hd__tapvpwrvgnd_1
XFILLER_111_113 vssd1 vccd1 vssd1 vccd1 SS_sky130_ef_sc_hd__decap_40_12
XFILLER_66_701 vccd1 vssd1 vccd1 vssd1 SS_sky130_fd_sc_hd__fill_1
Xload_slew457 vccd1 vssd1 _1309_/C1 _1441_/C1 vccd1 vssd1 SS_sky130_fd_sc_hd__buf_4
Xload_slew479 vccd1 vssd1 _1381_/C1 _1259_/C1 vccd1 vssd1 SS_sky130_fd_sc_hd__buf_4
XTAP_TAPCELL_ROW_53_1093 vccd1 vssd1 SS_sky130_fd_sc_hd__tapvpwrvgnd_1
XFILLER_66_723 vssd1 vccd1 vccd1 vssd1 SS_sky130_fd_sc_hd__fill_8
X_1123_ vssd1 vccd1 vccd1 vssd1 wire241/X input33/X _1592_/D _1387_/C1 _1122_/X SS_sky130_fd_sc_hd__o211a_2
XFILLER_93_553 vssd1 vccd1 vccd1 vssd1 SS_sky130_fd_sc_hd__fill_4
XFILLER_65_277 vssd1 vccd1 vccd1 vssd1 SS_sky130_fd_sc_hd__fill_2
XFILLER_81_748 vccd1 vssd1 vccd1 vssd1 SS_sky130_fd_sc_hd__fill_1
X_1054_ vccd1 vssd1 vccd1 vssd1 _1054_/X _1054_/A _1076_/B SS_sky130_fd_sc_hd__or2_2
XFILLER_18_193 vssd1 vccd1 vccd1 vssd1 SS_sky130_fd_sc_hd__fill_2
XFILLER_34_697 vssd1 vccd1 vccd1 vssd1 SS_sky130_fd_sc_hd__fill_2
X_0907_ vssd1 vccd1 vccd1 vssd1 _0907_/B _0907_/C _0943_/A _0907_/X SS_sky130_fd_sc_hd__or3_2
X_1887_ vccd1 vssd1 _1887_/X _1887_/A vccd1 vssd1 SS_sky130_fd_sc_hd__buf_2
XFILLER_119_279 vccd1 vssd1 vccd1 vssd1 SS_sky130_fd_sc_hd__fill_1
X_0838_ vssd1 vccd1 vssd1 vccd1 _0891_/B1 _1306_/A _0837_/X _0838_/X SS_sky130_fd_sc_hd__a21o_2
X_0769_ vssd1 vccd1 vssd1 vccd1 wire454/X _1880_/A _0865_/B1 _0767_/X _0769_/X _0768_/X
+ SS_sky130_fd_sc_hd__a2111o_2
XPHY_EDGE_ROW_131_Right_131 vccd1 vssd1 vccd1 vssd1 SS_sky130_fd_sc_hd__decap_3
XFILLER_134_249 vssd1 vccd1 vccd1 vssd1 SS_sky130_fd_sc_hd__fill_2
XFILLER_115_441 vssd1 vccd1 vccd1 vssd1 SS_sky130_fd_sc_hd__fill_4
XFILLER_130_433 vssd1 vccd1 vssd1 vccd1 SS_sky130_ef_sc_hd__decap_40_12
XFILLER_115_496 vssd1 vccd1 vccd1 vssd1 SS_sky130_fd_sc_hd__fill_8
XFILLER_103_669 vssd1 vccd1 vccd1 vssd1 SS_sky130_fd_sc_hd__fill_2
XFILLER_69_561 vssd1 vccd1 vssd1 vccd1 SS_sky130_ef_sc_hd__decap_40_12
XFILLER_130_477 vssd1 vccd1 vccd1 vssd1 SS_sky130_fd_sc_hd__fill_8
XFILLER_57_723 vccd1 vssd1 vccd1 vssd1 SS_sky130_fd_sc_hd__fill_1
XFILLER_17_609 vssd1 vccd1 vccd1 vssd1 SS_sky130_fd_sc_hd__fill_4
XFILLER_29_447 vccd1 vssd1 vccd1 vssd1 SS_sky130_fd_sc_hd__fill_1
XFILLER_56_233 vssd1 vccd1 vssd1 vccd1 SS_sky130_ef_sc_hd__decap_40_12
XFILLER_57_767 vssd1 vccd1 vssd1 vccd1 SS_sky130_ef_sc_hd__decap_40_12
XFILLER_44_417 vssd1 vccd1 vccd1 vssd1 SS_sky130_fd_sc_hd__fill_2
XFILLER_56_277 vssd1 vccd1 vssd1 vccd1 SS_sky130_ef_sc_hd__decap_40_12
XFILLER_72_737 vssd1 vccd1 vccd1 vssd1 SS_sky130_fd_sc_hd__fill_2
XFILLER_71_225 vssd1 vccd1 vssd1 vccd1 SS_sky130_ef_sc_hd__decap_40_12
XFILLER_72_15 vssd1 vccd1 vssd1 vccd1 SS_sky130_ef_sc_hd__decap_40_12
XFILLER_112_77 vssd1 vccd1 vccd1 vssd1 SS_sky130_fd_sc_hd__fill_4
XFILLER_24_141 vssd1 vccd1 vssd1 vccd1 SS_sky130_ef_sc_hd__decap_40_12
XFILLER_40_601 vssd1 vccd1 vccd1 vssd1 SS_sky130_fd_sc_hd__fill_2
XTAP_TAPCELL_ROW_84_1554 vccd1 vssd1 SS_sky130_fd_sc_hd__tapvpwrvgnd_1
XTAP_TAPCELL_ROW_84_1565 vccd1 vssd1 SS_sky130_fd_sc_hd__tapvpwrvgnd_1
XFILLER_25_697 vssd1 vccd1 vssd1 vccd1 SS_sky130_ef_sc_hd__decap_40_12
XFILLER_40_623 vssd1 vccd1 vssd1 vccd1 SS_sky130_ef_sc_hd__decap_40_12
XFILLER_40_645 vssd1 vccd1 vssd1 vccd1 SS_sky130_ef_sc_hd__decap_40_12
XFILLER_80_781 vssd1 vccd1 vssd1 vccd1 SS_sky130_ef_sc_hd__decap_40_12
XFILLER_8_307 vccd1 vssd1 vccd1 vssd1 SS_sky130_fd_sc_hd__fill_1
XFILLER_40_689 vccd1 vssd1 vccd1 vssd1 SS_sky130_fd_sc_hd__fill_1
XFILLER_21_30 vssd1 vccd1 vssd1 vccd1 SS_sky130_ef_sc_hd__decap_40_12
XFILLER_126_728 vssd1 vccd1 vccd1 vssd1 SS_sky130_fd_sc_hd__fill_8
XFILLER_122_3 vssd1 vccd1 vssd1 vccd1 SS_sky130_ef_sc_hd__decap_40_12
XTAP_TAPCELL_ROW_115_2020 vccd1 vssd1 SS_sky130_fd_sc_hd__tapvpwrvgnd_1
XFILLER_4_513 vssd1 vccd1 vssd1 vccd1 SS_sky130_ef_sc_hd__decap_40_12
XFILLER_125_205 vssd1 vccd1 vssd1 vccd1 SS_sky130_ef_sc_hd__decap_40_12
XTAP_TAPCELL_ROW_115_2031 vccd1 vssd1 SS_sky130_fd_sc_hd__tapvpwrvgnd_1
XFILLER_4_557 vssd1 vccd1 vssd1 vccd1 SS_sky130_ef_sc_hd__decap_40_12
XFILLER_134_750 vccd1 vssd1 vccd1 vssd1 SS_sky130_fd_sc_hd__fill_1
XFILLER_137_63 vssd1 vccd1 vccd1 vssd1 SS_sky130_fd_sc_hd__fill_4
XFILLER_125_249 vssd1 vccd1 vssd1 vccd1 SS_sky130_ef_sc_hd__decap_40_12
XFILLER_137_85 vssd1 vccd1 vccd1 vssd1 SS_sky130_fd_sc_hd__fill_4
XFILLER_106_474 vssd1 vccd1 vccd1 vssd1 SS_sky130_fd_sc_hd__fill_2
XFILLER_0_741 vssd1 vccd1 vssd1 vccd1 SS_sky130_ef_sc_hd__decap_40_12
XFILLER_133_293 vssd1 vccd1 vssd1 vccd1 SS_sky130_ef_sc_hd__decap_40_12
XFILLER_48_701 vssd1 vccd1 vssd1 vccd1 SS_sky130_ef_sc_hd__decap_40_12
XFILLER_0_785 vssd1 vccd1 vssd1 vccd1 SS_sky130_ef_sc_hd__decap_40_12
XFILLER_48_745 vccd1 vssd1 vccd1 vssd1 SS_sky130_fd_sc_hd__fill_1
XFILLER_87_391 vccd1 vssd1 vccd1 vssd1 SS_sky130_fd_sc_hd__fill_1
XFILLER_75_553 vssd1 vccd1 vccd1 vssd1 SS_sky130_fd_sc_hd__fill_4
XFILLER_35_417 vssd1 vccd1 vssd1 vccd1 SS_sky130_ef_sc_hd__decap_40_12
XFILLER_47_277 vssd1 vccd1 vccd1 vssd1 SS_sky130_fd_sc_hd__fill_2
XFILLER_75_597 vssd1 vccd1 vccd1 vssd1 SS_sky130_fd_sc_hd__fill_8
XTAP_TAPCELL_ROW_126_2193 vccd1 vssd1 SS_sky130_fd_sc_hd__tapvpwrvgnd_1
XFILLER_63_759 vccd1 vssd1 vccd1 vssd1 SS_sky130_fd_sc_hd__fill_1
XFILLER_90_545 vssd1 vccd1 vssd1 vccd1 SS_sky130_ef_sc_hd__decap_40_12
XFILLER_43_461 vssd1 vccd1 vssd1 vccd1 SS_sky130_ef_sc_hd__decap_40_12
XFILLER_90_589 vssd1 vccd1 vssd1 vccd1 SS_sky130_ef_sc_hd__decap_40_12
XTAP_TAPCELL_ROW_26_692 vccd1 vssd1 SS_sky130_fd_sc_hd__tapvpwrvgnd_1
XFILLER_30_133 vssd1 vccd1 vccd1 vssd1 SS_sky130_fd_sc_hd__fill_4
XFILLER_31_678 vssd1 vccd1 vccd1 vssd1 SS_sky130_fd_sc_hd__fill_2
XFILLER_62_81 vssd1 vccd1 vccd1 vssd1 SS_sky130_fd_sc_hd__fill_2
XFILLER_30_177 vssd1 vccd1 vssd1 vccd1 SS_sky130_ef_sc_hd__decap_40_12
XFILLER_11_391 vccd1 vssd1 vccd1 vssd1 SS_sky130_fd_sc_hd__fill_1
X_1741_ _1905_/A _1741_/CLK _1741_/D vccd1 vssd1 vccd1 vssd1 SS_sky130_fd_sc_hd__dfxtp_2
XFILLER_7_373 vssd1 vccd1 vssd1 vccd1 SS_sky130_ef_sc_hd__decap_40_12
Xwire282 vccd1 vssd1 vssd1 vccd1 wire282/A analog_ctrl[14] SS_sky130_fd_sc_hd__buf_12
Xwire271 vccd1 vssd1 vssd1 vccd1 wire271/A analog_ctrl[24] SS_sky130_fd_sc_hd__buf_12
Xwire293 vccd1 vssd1 vssd1 vccd1 wire293/A analog_ctrl[115] SS_sky130_fd_sc_hd__buf_12
X_1672_ _1890_/A _1745_/CLK _1672_/D vccd1 vssd1 vccd1 vssd1 SS_sky130_fd_sc_hd__dfxtp_2
XFILLER_132_709 vssd1 vccd1 vccd1 vssd1 SS_sky130_fd_sc_hd__fill_2
XFILLER_116_249 vssd1 vccd1 vccd1 vssd1 SS_sky130_fd_sc_hd__fill_2
XTAP_TAPCELL_ROW_55_1122 vccd1 vssd1 SS_sky130_fd_sc_hd__tapvpwrvgnd_1
XFILLER_125_783 vccd1 vssd1 vccd1 vssd1 SS_sky130_fd_sc_hd__fill_1
XFILLER_98_601 vssd1 vccd1 vssd1 vccd1 SS_sky130_ef_sc_hd__decap_40_12
XFILLER_124_293 vssd1 vccd1 vccd1 vssd1 SS_sky130_fd_sc_hd__fill_2
XFILLER_112_433 vssd1 vccd1 vssd1 vccd1 SS_sky130_ef_sc_hd__decap_40_12
XFILLER_98_645 vssd1 vccd1 vssd1 vccd1 SS_sky130_ef_sc_hd__decap_40_12
Xload_slew221 vccd1 vssd1 _1319_/A2 _1325_/A2 vccd1 vssd1 SS_sky130_fd_sc_hd__buf_6
XFILLER_97_111 vccd1 vssd1 vccd1 vssd1 SS_sky130_fd_sc_hd__fill_1
XFILLER_85_317 vssd1 vccd1 vssd1 vccd1 SS_sky130_ef_sc_hd__decap_40_12
XFILLER_112_477 vssd1 vccd1 vssd1 vccd1 SS_sky130_ef_sc_hd__decap_40_12
XFILLER_38_233 vssd1 vccd1 vssd1 vccd1 SS_sky130_ef_sc_hd__decap_40_12
XFILLER_26_417 vssd1 vccd1 vccd1 vssd1 SS_sky130_fd_sc_hd__fill_2
XFILLER_38_277 vssd1 vccd1 vssd1 vccd1 SS_sky130_ef_sc_hd__decap_40_12
XFILLER_39_789 vccd1 vssd1 vccd1 vssd1 SS_sky130_fd_sc_hd__fill_1
XFILLER_54_737 vssd1 vccd1 vssd1 vccd1 SS_sky130_ef_sc_hd__decap_40_12
X_1106_ vccd1 vssd1 vccd1 vssd1 _1106_/X _1858_/A _1116_/B SS_sky130_fd_sc_hd__or2_2
XFILLER_66_575 vssd1 vccd1 vssd1 vccd1 SS_sky130_ef_sc_hd__decap_40_12
XFILLER_81_501 vssd1 vccd1 vccd1 vssd1 SS_sky130_fd_sc_hd__fill_2
XFILLER_93_350 vssd1 vccd1 vssd1 vccd1 SS_sky130_ef_sc_hd__decap_40_12
XFILLER_53_225 vssd1 vccd1 vssd1 vccd1 SS_sky130_ef_sc_hd__decap_40_12
XFILLER_22_601 vssd1 vccd1 vccd1 vssd1 SS_sky130_fd_sc_hd__fill_8
X_1037_ vssd1 vccd1 vccd1 vssd1 _1051_/A2 wire500/X _1550_/D _1445_/C1 _1036_/X SS_sky130_fd_sc_hd__o211a_2
XFILLER_21_111 vccd1 vssd1 vccd1 vssd1 SS_sky130_fd_sc_hd__fill_1
XFILLER_62_781 vssd1 vccd1 vssd1 vccd1 SS_sky130_ef_sc_hd__decap_40_12
XTAP_TAPCELL_ROW_66_1284 vccd1 vssd1 SS_sky130_fd_sc_hd__tapvpwrvgnd_1
XTAP_TAPCELL_ROW_66_1295 vccd1 vssd1 SS_sky130_fd_sc_hd__tapvpwrvgnd_1
XFILLER_22_645 vssd1 vccd1 vssd1 vccd1 SS_sky130_ef_sc_hd__decap_40_12
XFILLER_42_29 vssd1 vccd1 vssd1 vccd1 SS_sky130_ef_sc_hd__decap_40_12
XFILLER_135_503 vccd1 vssd1 vccd1 vssd1 SS_sky130_fd_sc_hd__fill_1
XFILLER_107_205 vssd1 vccd1 vssd1 vccd1 SS_sky130_ef_sc_hd__decap_40_12
XFILLER_107_249 vssd1 vccd1 vssd1 vccd1 SS_sky130_ef_sc_hd__decap_40_12
XFILLER_1_505 vssd1 vccd1 vssd1 vccd1 SS_sky130_ef_sc_hd__decap_40_12
XFILLER_88_133 vssd1 vccd1 vccd1 vssd1 SS_sky130_fd_sc_hd__fill_4
XFILLER_89_645 vssd1 vccd1 vccd1 vssd1 SS_sky130_fd_sc_hd__fill_2
XFILLER_115_293 vssd1 vccd1 vccd1 vssd1 SS_sky130_fd_sc_hd__fill_8
XFILLER_107_55 vccd1 vssd1 vccd1 vssd1 SS_sky130_fd_sc_hd__fill_1
XFILLER_67_15 vssd1 vccd1 vssd1 vccd1 SS_sky130_ef_sc_hd__decap_40_12
XFILLER_131_753 vssd1 vccd1 vssd1 vccd1 SS_sky130_ef_sc_hd__decap_40_12
XFILLER_88_177 vssd1 vccd1 vssd1 vccd1 SS_sky130_ef_sc_hd__decap_40_12
XFILLER_131_797 vssd1 vccd1 vccd1 vssd1 SS_sky130_fd_sc_hd__fill_8
XTAP_TAPCELL_ROW_4_354 vccd1 vssd1 SS_sky130_fd_sc_hd__tapvpwrvgnd_1
XTAP_TAPCELL_ROW_4_365 vccd1 vssd1 SS_sky130_fd_sc_hd__tapvpwrvgnd_1
XFILLER_57_553 vssd1 vccd1 vccd1 vssd1 SS_sky130_fd_sc_hd__fill_4
XFILLER_69_391 vccd1 vssd1 vccd1 vssd1 SS_sky130_fd_sc_hd__fill_1
XFILLER_17_417 vssd1 vccd1 vssd1 vccd1 SS_sky130_ef_sc_hd__decap_40_12
XFILLER_29_277 vssd1 vccd1 vccd1 vssd1 SS_sky130_fd_sc_hd__fill_2
XFILLER_45_726 vssd1 vccd1 vccd1 vssd1 SS_sky130_fd_sc_hd__fill_2
XFILLER_72_512 vssd1 vccd1 vccd1 vssd1 SS_sky130_fd_sc_hd__fill_4
XFILLER_123_54 vssd1 vccd1 vccd1 vssd1 SS_sky130_fd_sc_hd__fill_2
XFILLER_83_69 vssd1 vccd1 vssd1 vccd1 SS_sky130_ef_sc_hd__decap_40_12
XFILLER_16_41 vssd1 vccd1 vssd1 vccd1 SS_sky130_ef_sc_hd__decap_40_12
XFILLER_25_461 vssd1 vccd1 vssd1 vccd1 SS_sky130_ef_sc_hd__decap_40_12
XPHY_EDGE_ROW_11_Right_11 vccd1 vssd1 vccd1 vssd1 SS_sky130_fd_sc_hd__decap_3
XFILLER_16_85 vssd1 vccd1 vssd1 vccd1 SS_sky130_ef_sc_hd__decap_40_12
XTAP_TAPCELL_ROW_43_938 vccd1 vssd1 SS_sky130_fd_sc_hd__tapvpwrvgnd_1
XTAP_TAPCELL_ROW_43_949 vccd1 vssd1 SS_sky130_fd_sc_hd__tapvpwrvgnd_1
XFILLER_12_133 vssd1 vccd1 vccd1 vssd1 SS_sky130_fd_sc_hd__fill_4
XTAP_TAPCELL_ROW_23_640 vccd1 vssd1 SS_sky130_fd_sc_hd__tapvpwrvgnd_1
XFILLER_12_177 vssd1 vccd1 vssd1 vccd1 SS_sky130_ef_sc_hd__decap_40_12
XTAP_TAPCELL_ROW_23_651 vccd1 vssd1 SS_sky130_fd_sc_hd__tapvpwrvgnd_1
XFILLER_40_475 vccd1 vssd1 vccd1 vssd1 SS_sky130_fd_sc_hd__fill_1
XFILLER_8_137 vssd1 vccd1 vccd1 vssd1 SS_sky130_fd_sc_hd__fill_2
XFILLER_5_833 vssd1 vccd1 vccd1 vssd1 SS_sky130_fd_sc_hd__fill_4
XFILLER_138_363 vccd1 vssd1 vccd1 vssd1 SS_sky130_fd_sc_hd__fill_1
XTAP_TAPCELL_ROW_97_1756 vccd1 vssd1 SS_sky130_fd_sc_hd__tapvpwrvgnd_1
XFILLER_4_321 vssd1 vccd1 vssd1 vccd1 SS_sky130_ef_sc_hd__decap_40_12
XFILLER_4_365 vssd1 vccd1 vssd1 vccd1 SS_sky130_ef_sc_hd__decap_40_12
XFILLER_107_783 vccd1 vssd1 vccd1 vssd1 SS_sky130_fd_sc_hd__fill_1
XPHY_EDGE_ROW_20_Right_20 vccd1 vssd1 vccd1 vssd1 SS_sky130_fd_sc_hd__decap_3
XFILLER_79_111 vccd1 vssd1 vccd1 vssd1 SS_sky130_fd_sc_hd__fill_1
XFILLER_67_317 vssd1 vccd1 vssd1 vccd1 SS_sky130_ef_sc_hd__decap_40_12
XTAP_TAPCELL_ROW_128_2222 vccd1 vssd1 SS_sky130_fd_sc_hd__tapvpwrvgnd_1
XFILLER_48_531 vccd1 vssd1 vccd1 vssd1 SS_sky130_fd_sc_hd__fill_1
XTAP_TAPCELL_ROW_50_1052 vccd1 vssd1 SS_sky130_fd_sc_hd__tapvpwrvgnd_1
XFILLER_36_737 vssd1 vccd1 vssd1 vccd1 SS_sky130_ef_sc_hd__decap_40_12
XFILLER_57_81 vssd1 vccd1 vssd1 vccd1 SS_sky130_ef_sc_hd__decap_40_12
XFILLER_63_501 vssd1 vccd1 vccd1 vssd1 SS_sky130_fd_sc_hd__fill_2
XFILLER_35_225 vssd1 vccd1 vssd1 vccd1 SS_sky130_ef_sc_hd__decap_40_12
XFILLER_51_707 vssd1 vccd1 vssd1 vccd1 SS_sky130_ef_sc_hd__decap_40_12
XFILLER_51_729 vssd1 vccd1 vssd1 vccd1 SS_sky130_ef_sc_hd__decap_40_12
XFILLER_44_781 vssd1 vccd1 vssd1 vccd1 SS_sky130_ef_sc_hd__decap_40_12
XTAP_TAPCELL_ROW_106_1896 vccd1 vssd1 SS_sky130_fd_sc_hd__tapvpwrvgnd_1
XTAP_TAPCELL_ROW_106_1885 vccd1 vssd1 SS_sky130_fd_sc_hd__tapvpwrvgnd_1
XFILLER_85_3 vssd1 vccd1 vssd1 vccd1 SS_sky130_ef_sc_hd__decap_40_12
XFILLER_31_497 vssd1 vccd1 vccd1 vssd1 SS_sky130_fd_sc_hd__fill_4
XFILLER_129_363 vssd1 vccd1 vssd1 vccd1 SS_sky130_ef_sc_hd__decap_40_12
X_1724_ _1724_/Q _1724_/CLK _1724_/D vccd1 vssd1 vccd1 vssd1 SS_sky130_fd_sc_hd__dfxtp_2
XFILLER_7_181 vssd1 vccd1 vssd1 vccd1 SS_sky130_ef_sc_hd__decap_40_12
XFILLER_8_693 vssd1 vccd1 vccd1 vssd1 SS_sky130_fd_sc_hd__fill_4
XFILLER_105_709 vssd1 vccd1 vssd1 vccd1 SS_sky130_ef_sc_hd__decap_40_12
X_1655_ _1655_/Q _1752_/CLK _1655_/D vccd1 vssd1 vccd1 vssd1 SS_sky130_fd_sc_hd__dfxtp_2
X_1586_ _1860_/A _1746_/CLK _1586_/D vccd1 vssd1 vccd1 vssd1 SS_sky130_fd_sc_hd__dfxtp_2
XFILLER_98_475 vccd1 vssd1 vccd1 vssd1 SS_sky130_fd_sc_hd__fill_1
XFILLER_85_125 vssd1 vccd1 vssd1 vccd1 SS_sky130_ef_sc_hd__decap_40_12
XFILLER_86_637 vssd1 vccd1 vccd1 vssd1 SS_sky130_fd_sc_hd__fill_4
XFILLER_113_797 vssd1 vccd1 vssd1 vccd1 SS_sky130_ef_sc_hd__decap_40_12
XFILLER_100_425 vssd1 vccd1 vccd1 vssd1 SS_sky130_fd_sc_hd__fill_2
XFILLER_39_531 vssd1 vccd1 vssd1 vccd1 SS_sky130_ef_sc_hd__decap_40_12
Xafe_wb_506 analog_ctrl[102] afe_wb_506/HI vccd1 vssd1 vssd1 vccd1 SS_sky130_fd_sc_hd__conb_1
XFILLER_100_447 vssd1 vccd1 vssd1 vccd1 SS_sky130_ef_sc_hd__decap_40_12
Xafe_wb_517 analog_io_out[9] afe_wb_517/HI vccd1 vssd1 vssd1 vccd1 SS_sky130_fd_sc_hd__conb_1
XTAP_TAPCELL_ROW_1_313 vccd1 vssd1 SS_sky130_fd_sc_hd__tapvpwrvgnd_1
Xafe_wb_539 afe_wb_539/LO analog_io_oeb[3] vccd1 vssd1 vssd1 vccd1 SS_sky130_fd_sc_hd__conb_1
XFILLER_27_704 vssd1 vccd1 vssd1 vccd1 SS_sky130_ef_sc_hd__decap_40_12
XTAP_TAPCELL_ROW_68_1313 vccd1 vssd1 SS_sky130_fd_sc_hd__tapvpwrvgnd_1
XFILLER_82_810 vssd1 vccd1 vccd1 vssd1 SS_sky130_fd_sc_hd__fill_2
XFILLER_85_169 vssd1 vccd1 vssd1 vccd1 SS_sky130_ef_sc_hd__decap_40_12
Xafe_wb_528 analog_io_out[20] afe_wb_528/HI vccd1 vssd1 vssd1 vccd1 SS_sky130_fd_sc_hd__conb_1
XFILLER_27_759 vccd1 vssd1 vccd1 vssd1 SS_sky130_fd_sc_hd__fill_1
XFILLER_39_597 vssd1 vccd1 vccd1 vssd1 SS_sky130_fd_sc_hd__fill_8
XFILLER_54_545 vssd1 vccd1 vccd1 vssd1 SS_sky130_fd_sc_hd__fill_4
XTAP_TAPCELL_ROW_68_1324 vccd1 vssd1 SS_sky130_fd_sc_hd__tapvpwrvgnd_1
XFILLER_54_589 vssd1 vccd1 vssd1 vccd1 SS_sky130_ef_sc_hd__decap_40_12
XFILLER_41_217 vssd1 vccd1 vccd1 vssd1 SS_sky130_fd_sc_hd__fill_4
XTAP_TAPCELL_ROW_81_1513 vccd1 vssd1 SS_sky130_fd_sc_hd__tapvpwrvgnd_1
XFILLER_22_475 vccd1 vssd1 vccd1 vssd1 SS_sky130_fd_sc_hd__fill_1
XFILLER_10_637 vssd1 vccd1 vccd1 vssd1 SS_sky130_fd_sc_hd__fill_4
XFILLER_108_514 vccd1 vssd1 vccd1 vssd1 SS_sky130_fd_sc_hd__fill_1
XTAP_TAPCELL_ROW_79_1486 vccd1 vssd1 SS_sky130_fd_sc_hd__tapvpwrvgnd_1
XFILLER_2_825 vssd1 vccd1 vssd1 vccd1 SS_sky130_ef_sc_hd__decap_40_12
XFILLER_123_517 vssd1 vccd1 vssd1 vccd1 SS_sky130_ef_sc_hd__decap_40_12
XFILLER_118_65 vssd1 vccd1 vssd1 vccd1 SS_sky130_ef_sc_hd__decap_40_12
XTAP_TAPCELL_ROW_9_435 vccd1 vssd1 SS_sky130_fd_sc_hd__tapvpwrvgnd_1
Xhold660 input39/A wbs_dat_i[27] vccd1 vssd1 vssd1 vccd1 SS_sky130_fd_sc_hd__dlygate4sd3_1
XFILLER_123_539 vssd1 vccd1 vccd1 vssd1 SS_sky130_fd_sc_hd__fill_4
Xhold671 _1056_/A _1560_/Q vccd1 vssd1 vssd1 vccd1 SS_sky130_fd_sc_hd__dlygate4sd3_1
XFILLER_1_335 vccd1 vssd1 vccd1 vssd1 SS_sky130_fd_sc_hd__fill_1
XFILLER_77_615 vccd1 vssd1 vccd1 vssd1 SS_sky130_fd_sc_hd__fill_1
XFILLER_131_561 vssd1 vccd1 vccd1 vssd1 SS_sky130_fd_sc_hd__fill_4
Xhold682 _1004_/A _1535_/Q vccd1 vssd1 vssd1 vccd1 SS_sky130_fd_sc_hd__dlygate4sd3_1
Xhold693 _1052_/A _1558_/Q vccd1 vssd1 vssd1 vccd1 SS_sky130_fd_sc_hd__dlygate4sd3_1
XTAP_TAPCELL_ROW_92_1686 vccd1 vssd1 SS_sky130_fd_sc_hd__tapvpwrvgnd_1
XTAP_TAPCELL_ROW_92_1675 vccd1 vssd1 SS_sky130_fd_sc_hd__tapvpwrvgnd_1
XFILLER_49_317 vssd1 vccd1 vssd1 vccd1 SS_sky130_ef_sc_hd__decap_40_12
XFILLER_131_594 vssd1 vccd1 vssd1 vccd1 SS_sky130_ef_sc_hd__decap_40_12
XFILLER_104_786 vssd1 vccd1 vssd1 vccd1 SS_sky130_ef_sc_hd__decap_40_12
XFILLER_64_309 vssd1 vccd1 vssd1 vccd1 SS_sky130_ef_sc_hd__decap_40_12
XFILLER_73_821 vssd1 vccd1 vccd1 vssd1 SS_sky130_fd_sc_hd__fill_2
XFILLER_134_97 vssd1 vccd1 vssd1 vccd1 SS_sky130_ef_sc_hd__decap_40_12
XFILLER_17_225 vssd1 vccd1 vssd1 vccd1 SS_sky130_ef_sc_hd__decap_40_12
XFILLER_27_51 vssd1 vccd1 vccd1 vssd1 SS_sky130_fd_sc_hd__fill_4
XTAP_TAPCELL_ROW_28_721 vccd1 vssd1 SS_sky130_fd_sc_hd__tapvpwrvgnd_1
XFILLER_72_331 vccd1 vssd1 vccd1 vssd1 SS_sky130_fd_sc_hd__fill_1
XTAP_TAPCELL_ROW_123_2141 vccd1 vssd1 SS_sky130_fd_sc_hd__tapvpwrvgnd_1
XFILLER_33_729 vssd1 vccd1 vssd1 vccd1 SS_sky130_ef_sc_hd__decap_40_12
XTAP_TAPCELL_ROW_123_2152 vccd1 vssd1 SS_sky130_fd_sc_hd__tapvpwrvgnd_1
XFILLER_26_781 vssd1 vccd1 vssd1 vccd1 SS_sky130_ef_sc_hd__decap_40_12
XFILLER_60_537 vssd1 vccd1 vccd1 vssd1 SS_sky130_fd_sc_hd__fill_2
XFILLER_13_497 vssd1 vccd1 vccd1 vssd1 SS_sky130_fd_sc_hd__fill_4
XFILLER_5_641 vssd1 vccd1 vssd1 vccd1 SS_sky130_ef_sc_hd__decap_40_12
XFILLER_126_377 vssd1 vccd1 vssd1 vccd1 SS_sky130_ef_sc_hd__decap_40_12
XFILLER_99_217 vssd1 vccd1 vccd1 vssd1 SS_sky130_fd_sc_hd__fill_4
XFILLER_5_685 vssd1 vccd1 vssd1 vccd1 SS_sky130_ef_sc_hd__decap_40_12
X_1440_ vccd1 vssd1 vccd1 vssd1 _1440_/X _1440_/A _1454_/B SS_sky130_fd_sc_hd__or2_2
XFILLER_4_77 vssd1 vccd1 vccd1 vssd1 SS_sky130_fd_sc_hd__fill_4
XFILLER_4_195 vccd1 vssd1 vccd1 vssd1 SS_sky130_fd_sc_hd__fill_1
X_1371_ vssd1 vccd1 vccd1 vssd1 _1385_/A2 input24/X _1712_/D _1445_/C1 _1370_/X SS_sky130_fd_sc_hd__o211a_2
XFILLER_110_701 vssd1 vccd1 vssd1 vccd1 SS_sky130_ef_sc_hd__decap_40_12
XFILLER_68_637 vssd1 vccd1 vccd1 vssd1 SS_sky130_fd_sc_hd__fill_4
XFILLER_67_125 vssd1 vccd1 vssd1 vccd1 SS_sky130_ef_sc_hd__decap_40_12
XFILLER_36_501 vssd1 vccd1 vssd1 vccd1 SS_sky130_ef_sc_hd__decap_40_12
XFILLER_48_361 vssd1 vccd1 vccd1 vssd1 SS_sky130_fd_sc_hd__fill_2
XFILLER_67_169 vssd1 vccd1 vssd1 vccd1 SS_sky130_ef_sc_hd__decap_40_12
XTAP_TAPCELL_ROW_108_1914 vccd1 vssd1 SS_sky130_fd_sc_hd__tapvpwrvgnd_1
XFILLER_36_545 vccd1 vssd1 vccd1 vssd1 SS_sky130_fd_sc_hd__fill_1
XFILLER_82_139 vccd1 vssd1 vccd1 vssd1 SS_sky130_fd_sc_hd__fill_1
XTAP_TAPCELL_ROW_108_1925 vccd1 vssd1 SS_sky130_fd_sc_hd__tapvpwrvgnd_1
XFILLER_36_578 vssd1 vccd1 vccd1 vssd1 SS_sky130_fd_sc_hd__fill_2
XFILLER_91_673 vssd1 vccd1 vccd1 vssd1 SS_sky130_fd_sc_hd__fill_2
XFILLER_23_217 vssd1 vccd1 vccd1 vssd1 SS_sky130_fd_sc_hd__fill_4
XFILLER_63_397 vccd1 vssd1 vccd1 vssd1 SS_sky130_fd_sc_hd__fill_1
XTAP_TAPCELL_ROW_63_1243 vccd1 vssd1 SS_sky130_fd_sc_hd__tapvpwrvgnd_1
XFILLER_31_261 vssd1 vccd1 vssd1 vccd1 SS_sky130_ef_sc_hd__decap_40_12
XFILLER_137_609 vssd1 vccd1 vccd1 vssd1 SS_sky130_fd_sc_hd__fill_4
XFILLER_129_193 vssd1 vccd1 vssd1 vccd1 SS_sky130_ef_sc_hd__decap_40_12
XFILLER_117_333 vssd1 vccd1 vccd1 vssd1 SS_sky130_fd_sc_hd__fill_2
X_1707_ _1886_/A _1742_/CLK _1707_/D vccd1 vssd1 vccd1 vssd1 SS_sky130_fd_sc_hd__dfxtp_2
X_1638_ _1638_/Q clkload8/A _1638_/D vccd1 vssd1 vccd1 vssd1 SS_sky130_fd_sc_hd__dfxtp_2
XFILLER_99_762 vssd1 vccd1 vssd1 vccd1 SS_sky130_ef_sc_hd__decap_40_12
Xfanout436 vssd1 vccd1 vccd1 vssd1 _0745_/X _1409_/A SS_sky130_fd_sc_hd__clkdlybuf4s25_1
Xfanout425 vssd1 vccd1 vccd1 vssd1 _0754_/X _1012_/A SS_sky130_fd_sc_hd__clkdlybuf4s25_1
X_1569_ _1569_/Q _1634_/CLK _1569_/D vccd1 vssd1 vccd1 vssd1 SS_sky130_fd_sc_hd__dfxtp_2
Xfanout447 vssd1 vccd1 vccd1 vssd1 _0740_/X wire448/A SS_sky130_fd_sc_hd__clkdlybuf4s25_1
XFILLER_113_561 vssd1 vccd1 vssd1 vccd1 SS_sky130_ef_sc_hd__decap_40_12
XFILLER_101_701 vccd1 vssd1 vccd1 vssd1 SS_sky130_fd_sc_hd__fill_1
XFILLER_74_607 vssd1 vccd1 vccd1 vssd1 SS_sky130_fd_sc_hd__fill_2
Xfanout458 vssd1 vccd1 vccd1 vssd1 _1459_/C1 _1327_/C1 SS_sky130_fd_sc_hd__clkdlybuf4s25_1
XFILLER_100_233 vssd1 vccd1 vssd1 vccd1 SS_sky130_ef_sc_hd__decap_40_12
XFILLER_27_501 vssd1 vccd1 vccd1 vssd1 SS_sky130_fd_sc_hd__fill_2
XFILLER_39_361 vssd1 vccd1 vssd1 vccd1 SS_sky130_ef_sc_hd__decap_40_12
XFILLER_46_309 vssd1 vccd1 vssd1 vccd1 SS_sky130_ef_sc_hd__decap_40_12
XFILLER_86_489 vssd1 vccd1 vssd1 vccd1 SS_sky130_ef_sc_hd__decap_40_12
XFILLER_100_277 vssd1 vccd1 vssd1 vccd1 SS_sky130_ef_sc_hd__decap_40_12
XFILLER_64_27 vccd1 vssd1 vccd1 vssd1 SS_sky130_fd_sc_hd__fill_1
XFILLER_70_802 vssd1 vccd1 vccd1 vssd1 SS_sky130_fd_sc_hd__fill_8
XFILLER_70_813 vccd1 vssd1 vccd1 vssd1 SS_sky130_fd_sc_hd__fill_1
XFILLER_15_729 vssd1 vccd1 vssd1 vccd1 SS_sky130_ef_sc_hd__decap_40_12
XFILLER_81_161 vssd1 vccd1 vccd1 vssd1 SS_sky130_fd_sc_hd__fill_4
XFILLER_10_401 vssd1 vccd1 vssd1 vccd1 SS_sky130_ef_sc_hd__decap_40_12
XFILLER_80_15 vssd1 vccd1 vssd1 vccd1 SS_sky130_ef_sc_hd__decap_40_12
XFILLER_120_77 vssd1 vccd1 vccd1 vssd1 SS_sky130_fd_sc_hd__fill_4
XFILLER_13_42 vssd1 vccd1 vssd1 vccd1 SS_sky130_ef_sc_hd__decap_40_12
XTAP_TAPCELL_ROW_33_790 vccd1 vssd1 SS_sky130_fd_sc_hd__tapvpwrvgnd_1
XFILLER_50_581 vssd1 vccd1 vccd1 vssd1 SS_sky130_fd_sc_hd__fill_4
XFILLER_10_445 vssd1 vccd1 vssd1 vccd1 SS_sky130_ef_sc_hd__decap_40_12
XFILLER_10_489 vssd1 vccd1 vssd1 vccd1 SS_sky130_ef_sc_hd__decap_40_12
XFILLER_136_653 vssd1 vccd1 vccd1 vssd1 SS_sky130_fd_sc_hd__fill_4
XFILLER_108_333 vssd1 vccd1 vssd1 vccd1 SS_sky130_ef_sc_hd__decap_40_12
XTAP_TAPCELL_ROW_94_1715 vccd1 vssd1 SS_sky130_fd_sc_hd__tapvpwrvgnd_1
XTAP_TAPCELL_ROW_94_1704 vccd1 vssd1 SS_sky130_fd_sc_hd__tapvpwrvgnd_1
XFILLER_89_57 vssd1 vccd1 vssd1 vccd1 SS_sky130_ef_sc_hd__decap_40_12
XFILLER_108_377 vssd1 vccd1 vssd1 vccd1 SS_sky130_ef_sc_hd__decap_40_12
XFILLER_136_697 vssd1 vccd1 vccd1 vssd1 SS_sky130_fd_sc_hd__fill_2
XFILLER_96_209 vssd1 vccd1 vssd1 vccd1 SS_sky130_ef_sc_hd__decap_40_12
XFILLER_1_165 vssd1 vccd1 vccd1 vssd1 SS_sky130_fd_sc_hd__fill_2
XFILLER_2_699 vccd1 vssd1 vccd1 vssd1 SS_sky130_fd_sc_hd__fill_1
XFILLER_89_261 vssd1 vccd1 vssd1 vccd1 SS_sky130_ef_sc_hd__decap_40_12
XFILLER_49_125 vssd1 vccd1 vssd1 vccd1 SS_sky130_ef_sc_hd__decap_40_12
XFILLER_131_391 vccd1 vssd1 vccd1 vssd1 SS_sky130_fd_sc_hd__fill_1
XFILLER_18_501 vssd1 vccd1 vssd1 vccd1 SS_sky130_ef_sc_hd__decap_40_12
XFILLER_49_169 vssd1 vccd1 vssd1 vccd1 SS_sky130_ef_sc_hd__decap_40_12
XFILLER_65_629 vssd1 vccd1 vssd1 vccd1 SS_sky130_ef_sc_hd__decap_40_12
XFILLER_38_83 vccd1 vssd1 vccd1 vssd1 SS_sky130_fd_sc_hd__fill_1
XFILLER_58_681 vccd1 vssd1 vccd1 vssd1 SS_sky130_fd_sc_hd__fill_1
XFILLER_64_139 vccd1 vssd1 vccd1 vssd1 SS_sky130_fd_sc_hd__fill_1
XFILLER_18_545 vssd1 vccd1 vssd1 vccd1 SS_sky130_ef_sc_hd__decap_40_12
XFILLER_18_589 vssd1 vccd1 vssd1 vccd1 SS_sky130_ef_sc_hd__decap_40_12
XFILLER_60_301 vssd1 vccd1 vccd1 vssd1 SS_sky130_fd_sc_hd__fill_4
XFILLER_73_673 vssd1 vccd1 vssd1 vccd1 SS_sky130_ef_sc_hd__decap_40_12
XFILLER_33_559 vccd1 vssd1 vccd1 vssd1 SS_sky130_fd_sc_hd__fill_1
XFILLER_60_345 vssd1 vccd1 vssd1 vccd1 SS_sky130_ef_sc_hd__decap_40_12
XTAP_TAPCELL_ROW_103_1844 vccd1 vssd1 SS_sky130_fd_sc_hd__tapvpwrvgnd_1
XFILLER_13_261 vssd1 vccd1 vssd1 vccd1 SS_sky130_ef_sc_hd__decap_40_12
XFILLER_20_209 vssd1 vccd1 vssd1 vccd1 SS_sky130_ef_sc_hd__decap_40_12
XFILLER_60_389 vssd1 vccd1 vssd1 vccd1 SS_sky130_ef_sc_hd__decap_40_12
X_0940_ vccd1 vssd1 vccd1 vssd1 _0939_/X _1208_/A hold791/X _1698_/Q hold787/X _0940_/X
+ SS_sky130_fd_sc_hd__a221o_2
XFILLER_9_221 vssd1 vccd1 vccd1 vssd1 SS_sky130_fd_sc_hd__fill_2
XFILLER_119_609 vssd1 vccd1 vccd1 vssd1 SS_sky130_fd_sc_hd__fill_4
XTAP_TAPCELL_ROW_136_2343 vccd1 vssd1 SS_sky130_fd_sc_hd__tapvpwrvgnd_1
X_0871_ vssd1 vccd1 vssd1 vccd1 wire445/X _1864_/A _0751_/X _0869_/X _0871_/X _0870_/X
+ SS_sky130_fd_sc_hd__a2111o_2
XTAP_TAPCELL_ROW_11_462 vccd1 vssd1 SS_sky130_fd_sc_hd__tapvpwrvgnd_1
Xclkload13 vssd1 vccd1 vccd1 vssd1 _1610_/CLK clkload13/Y SS_sky130_fd_sc_hd__clkinv_2
XFILLER_70_81 vssd1 vccd1 vccd1 vssd1 SS_sky130_fd_sc_hd__fill_2
XFILLER_127_642 vssd1 vccd1 vssd1 vccd1 SS_sky130_ef_sc_hd__decap_40_12
Xclkload24 clkload24/X _1761_/CLK vccd1 vssd1 vssd1 vccd1 SS_sky130_fd_sc_hd__clkbuf_8
XFILLER_126_141 vssd1 vccd1 vssd1 vccd1 SS_sky130_ef_sc_hd__decap_40_12
XFILLER_127_697 vssd1 vccd1 vssd1 vccd1 SS_sky130_ef_sc_hd__decap_40_12
XFILLER_114_336 vccd1 vssd1 vccd1 vssd1 SS_sky130_fd_sc_hd__fill_1
XFILLER_114_325 vssd1 vccd1 vccd1 vssd1 SS_sky130_fd_sc_hd__fill_2
X_1423_ vssd1 vccd1 vccd1 vssd1 _1463_/A2 wire497/X _1737_/D _1423_/C1 _1422_/X SS_sky130_fd_sc_hd__o211a_2
XFILLER_68_445 vssd1 vccd1 vssd1 vccd1 SS_sky130_ef_sc_hd__decap_40_12
X_1354_ vccd1 vssd1 vccd1 vssd1 _1354_/X _1354_/A _1404_/B SS_sky130_fd_sc_hd__or2_2
XFILLER_28_309 vssd1 vccd1 vssd1 vccd1 SS_sky130_ef_sc_hd__decap_40_12
XFILLER_56_618 vssd1 vccd1 vssd1 vccd1 SS_sky130_ef_sc_hd__decap_40_12
XFILLER_68_489 vssd1 vccd1 vssd1 vccd1 SS_sky130_ef_sc_hd__decap_40_12
X_1285_ vssd1 vccd1 vccd1 vssd1 _1339_/A2 input45/X _1670_/D _1473_/C1 _1284_/X SS_sky130_fd_sc_hd__o211a_2
Xclkbuf_leaf_13_wb_clk_i _1761_/CLK clkbuf_leaf_7_wb_clk_i/A vccd1 vssd1 vssd1 vccd1
+ SS_sky130_fd_sc_hd__clkbuf_8
XTAP_TAPCELL_ROW_19_584 vccd1 vssd1 SS_sky130_fd_sc_hd__tapvpwrvgnd_1
XFILLER_52_813 vssd1 vccd1 vccd1 vssd1 SS_sky130_fd_sc_hd__fill_2
XFILLER_63_161 vssd1 vccd1 vccd1 vssd1 SS_sky130_fd_sc_hd__fill_4
XFILLER_70_109 vssd1 vccd1 vssd1 vccd1 SS_sky130_ef_sc_hd__decap_40_12
XFILLER_91_492 vssd1 vccd1 vssd1 vccd1 SS_sky130_ef_sc_hd__decap_40_12
XFILLER_51_389 vssd1 vccd1 vccd1 vssd1 SS_sky130_fd_sc_hd__fill_2
XFILLER_20_776 vssd1 vccd1 vssd1 vccd1 SS_sky130_ef_sc_hd__decap_40_12
XFILLER_50_29 vssd1 vccd1 vssd1 vccd1 SS_sky130_ef_sc_hd__decap_40_12
Xclkload7 vssd1 vccd1 clkload7/A clkload7/X vccd1 vssd1 SS_sky130_fd_sc_hd__clkbuf_4
XTAP_TAPCELL_ROW_76_1434 vccd1 vssd1 SS_sky130_fd_sc_hd__tapvpwrvgnd_1
XFILLER_118_675 vccd1 vssd1 vccd1 vssd1 SS_sky130_fd_sc_hd__fill_1
XFILLER_106_804 vssd1 vccd1 vccd1 vssd1 SS_sky130_fd_sc_hd__fill_8
XTAP_TAPCELL_ROW_76_1445 vccd1 vssd1 SS_sky130_fd_sc_hd__tapvpwrvgnd_1
XFILLER_59_27 vssd1 vccd1 vssd1 vccd1 SS_sky130_ef_sc_hd__decap_40_12
XFILLER_78_209 vssd1 vccd1 vssd1 vccd1 SS_sky130_ef_sc_hd__decap_40_12
XFILLER_132_133 vssd1 vccd1 vccd1 vssd1 SS_sky130_fd_sc_hd__fill_4
XFILLER_87_721 vssd1 vccd1 vccd1 vssd1 SS_sky130_fd_sc_hd__fill_4
XFILLER_132_177 vssd1 vccd1 vssd1 vccd1 SS_sky130_ef_sc_hd__decap_40_12
Xfanout211 vssd1 vccd1 vccd1 vssd1 _1397_/A2 _1405_/A2 SS_sky130_fd_sc_hd__clkdlybuf4s25_1
XFILLER_59_445 vssd1 vccd1 vccd1 vssd1 SS_sky130_fd_sc_hd__fill_2
XFILLER_87_765 vssd1 vccd1 vssd1 vccd1 SS_sky130_ef_sc_hd__decap_40_12
Xfanout244 vssd1 vccd1 vccd1 vssd1 _1142_/B _1140_/B SS_sky130_fd_sc_hd__clkdlybuf4s25_1
XFILLER_115_55 vccd1 vssd1 vccd1 vssd1 SS_sky130_fd_sc_hd__fill_1
XFILLER_113_391 vccd1 vssd1 vccd1 vssd1 SS_sky130_fd_sc_hd__fill_1
XFILLER_47_629 vssd1 vccd1 vssd1 vccd1 SS_sky130_ef_sc_hd__decap_40_12
XFILLER_75_15 vssd1 vccd1 vssd1 vccd1 SS_sky130_ef_sc_hd__decap_40_12
XFILLER_86_253 vssd1 vccd1 vssd1 vccd1 SS_sky130_ef_sc_hd__decap_40_12
XFILLER_101_553 vssd1 vccd1 vccd1 vssd1 SS_sky130_fd_sc_hd__fill_4
XFILLER_46_139 vccd1 vssd1 vccd1 vssd1 SS_sky130_fd_sc_hd__fill_1
XFILLER_101_597 vssd1 vccd1 vssd1 vccd1 SS_sky130_ef_sc_hd__decap_40_12
XFILLER_55_662 vssd1 vccd1 vccd1 vssd1 SS_sky130_fd_sc_hd__fill_8
XTAP_TAPCELL_ROW_38_871 vccd1 vssd1 SS_sky130_fd_sc_hd__tapvpwrvgnd_1
XFILLER_42_301 vssd1 vccd1 vccd1 vssd1 SS_sky130_fd_sc_hd__fill_4
XFILLER_61_109 vssd1 vccd1 vccd1 vssd1 SS_sky130_fd_sc_hd__fill_2
XFILLER_131_54 vssd1 vccd1 vccd1 vssd1 SS_sky130_fd_sc_hd__fill_2
XTAP_TAPCELL_ROW_120_2100 vccd1 vssd1 SS_sky130_fd_sc_hd__tapvpwrvgnd_1
XFILLER_15_559 vccd1 vssd1 vccd1 vssd1 SS_sky130_fd_sc_hd__fill_1
XFILLER_42_345 vssd1 vccd1 vssd1 vccd1 SS_sky130_ef_sc_hd__decap_40_12
XFILLER_24_41 vssd1 vccd1 vssd1 vccd1 SS_sky130_ef_sc_hd__decap_40_12
XFILLER_30_529 vssd1 vccd1 vccd1 vssd1 SS_sky130_fd_sc_hd__fill_2
XFILLER_42_389 vssd1 vccd1 vssd1 vccd1 SS_sky130_ef_sc_hd__decap_40_12
XFILLER_91_69 vssd1 vccd1 vssd1 vccd1 SS_sky130_ef_sc_hd__decap_40_12
XFILLER_11_721 vssd1 vccd1 vccd1 vssd1 SS_sky130_fd_sc_hd__fill_4
XFILLER_24_85 vssd1 vccd1 vssd1 vccd1 SS_sky130_ef_sc_hd__decap_40_12
XFILLER_7_725 vssd1 vccd1 vccd1 vssd1 SS_sky130_fd_sc_hd__fill_2
XFILLER_10_253 vssd1 vccd1 vssd1 vccd1 SS_sky130_ef_sc_hd__decap_40_12
XFILLER_128_417 vssd1 vccd1 vccd1 vssd1 SS_sky130_fd_sc_hd__fill_2
XTAP_TAPCELL_ROW_118_2073 vccd1 vssd1 SS_sky130_fd_sc_hd__tapvpwrvgnd_1
XFILLER_124_601 vssd1 vccd1 vssd1 vccd1 SS_sky130_ef_sc_hd__decap_40_12
XFILLER_109_675 vccd1 vssd1 vccd1 vssd1 SS_sky130_fd_sc_hd__fill_1
XFILLER_108_141 vssd1 vccd1 vssd1 vccd1 SS_sky130_ef_sc_hd__decap_40_12
XFILLER_123_111 vccd1 vssd1 vccd1 vssd1 SS_sky130_fd_sc_hd__fill_1
XTAP_TAPCELL_ROW_131_2262 vccd1 vssd1 SS_sky130_fd_sc_hd__tapvpwrvgnd_1
XFILLER_124_645 vssd1 vccd1 vssd1 vccd1 SS_sky130_ef_sc_hd__decap_40_12
XFILLER_124_689 vssd1 vccd1 vccd1 vssd1 SS_sky130_fd_sc_hd__fill_8
XFILLER_97_529 vssd1 vccd1 vssd1 vccd1 SS_sky130_ef_sc_hd__decap_40_12
XFILLER_49_93 vssd1 vccd1 vssd1 vccd1 SS_sky130_ef_sc_hd__decap_40_12
XFILLER_93_735 vccd1 vssd1 vccd1 vssd1 SS_sky130_fd_sc_hd__fill_1
XFILLER_65_459 vssd1 vccd1 vccd1 vssd1 SS_sky130_fd_sc_hd__fill_2
X_1070_ vccd1 vssd1 vccd1 vssd1 _1070_/X _1567_/Q _1076_/B SS_sky130_fd_sc_hd__or2_2
XFILLER_93_768 vssd1 vccd1 vssd1 vccd1 SS_sky130_ef_sc_hd__decap_40_12
XFILLER_92_245 vssd1 vccd1 vccd1 vssd1 SS_sky130_fd_sc_hd__fill_4
XFILLER_45_161 vssd1 vccd1 vccd1 vssd1 SS_sky130_fd_sc_hd__fill_4
XTAP_TAPCELL_ROW_47_1002 vccd1 vssd1 SS_sky130_fd_sc_hd__tapvpwrvgnd_1
XFILLER_52_109 vssd1 vccd1 vssd1 vccd1 SS_sky130_ef_sc_hd__decap_40_12
XFILLER_65_81 vssd1 vccd1 vssd1 vccd1 SS_sky130_ef_sc_hd__decap_40_12
XFILLER_73_481 vssd1 vccd1 vccd1 vssd1 SS_sky130_fd_sc_hd__fill_2
XFILLER_92_289 vssd1 vccd1 vssd1 vccd1 SS_sky130_ef_sc_hd__decap_40_12
XTAP_TAPCELL_ROW_16_543 vccd1 vssd1 SS_sky130_fd_sc_hd__tapvpwrvgnd_1
XFILLER_60_153 vssd1 vccd1 vssd1 vccd1 SS_sky130_ef_sc_hd__decap_40_12
XFILLER_14_581 vssd1 vccd1 vccd1 vssd1 SS_sky130_fd_sc_hd__fill_4
XFILLER_21_529 vssd1 vccd1 vssd1 vccd1 SS_sky130_ef_sc_hd__decap_40_12
XFILLER_33_389 vssd1 vccd1 vccd1 vssd1 SS_sky130_fd_sc_hd__fill_2
XFILLER_60_197 vssd1 vccd1 vssd1 vccd1 SS_sky130_ef_sc_hd__decap_40_12
XTAP_TAPCELL_ROW_60_1202 vccd1 vssd1 SS_sky130_fd_sc_hd__tapvpwrvgnd_1
X_0923_ vccd1 vssd1 vccd1 vssd1 _1567_/Q _1012_/A _1631_/Q _0927_/A2 _0923_/X SS_sky130_fd_sc_hd__a22o_2
XPHY_EDGE_ROW_112_Right_112 vccd1 vssd1 vccd1 vssd1 SS_sky130_fd_sc_hd__decap_3
X_0854_ vccd1 vssd1 vssd1 vccd1 _0850_/X _0853_/X _0753_/A hold805/X _1491_/D _1309_/C1
+ SS_sky130_fd_sc_hd__o221a_2
XFILLER_127_461 vssd1 vccd1 vssd1 vccd1 SS_sky130_ef_sc_hd__decap_40_12
XPHY_EDGE_ROW_49_Right_49 vccd1 vssd1 vccd1 vssd1 SS_sky130_fd_sc_hd__decap_3
XFILLER_115_623 vccd1 vssd1 vccd1 vssd1 SS_sky130_fd_sc_hd__fill_1
X_0785_ vccd1 vssd1 vccd1 vssd1 _1890_/A wire448/A _1883_/A wire452/X _0785_/X SS_sky130_fd_sc_hd__a22o_2
XTAP_TAPCELL_ROW_58_1164 vccd1 vssd1 SS_sky130_fd_sc_hd__tapvpwrvgnd_1
XTAP_TAPCELL_ROW_58_1175 vccd1 vssd1 SS_sky130_fd_sc_hd__tapvpwrvgnd_1
XFILLER_114_133 vssd1 vccd1 vccd1 vssd1 SS_sky130_fd_sc_hd__fill_4
XFILLER_114_177 vssd1 vccd1 vssd1 vccd1 SS_sky130_ef_sc_hd__decap_40_12
XTAP_TAPCELL_ROW_71_1364 vccd1 vssd1 SS_sky130_fd_sc_hd__tapvpwrvgnd_1
XFILLER_130_637 vssd1 vccd1 vccd1 vssd1 SS_sky130_fd_sc_hd__fill_4
X_1406_ vccd1 vssd1 vccd1 vssd1 _1406_/X _1406_/A _1406_/B SS_sky130_fd_sc_hd__or2_2
XFILLER_68_253 vssd1 vccd1 vssd1 vccd1 SS_sky130_ef_sc_hd__decap_40_12
XFILLER_69_765 vssd1 vccd1 vssd1 vccd1 SS_sky130_ef_sc_hd__decap_40_12
XFILLER_84_713 vssd1 vccd1 vssd1 vccd1 SS_sky130_ef_sc_hd__decap_40_12
X_1337_ vssd1 vccd1 vccd1 vssd1 _1337_/A2 input41/X _1696_/D _1431_/C1 _1336_/X SS_sky130_fd_sc_hd__o211a_2
XFILLER_28_139 vccd1 vssd1 vccd1 vssd1 SS_sky130_fd_sc_hd__fill_1
XFILLER_83_223 vccd1 vssd1 vccd1 vssd1 SS_sky130_fd_sc_hd__fill_1
XFILLER_96_584 vssd1 vccd1 vccd1 vssd1 SS_sky130_fd_sc_hd__fill_4
XFILLER_37_640 vssd1 vccd1 vccd1 vssd1 SS_sky130_fd_sc_hd__fill_8
XPHY_EDGE_ROW_58_Right_58 vccd1 vssd1 vccd1 vssd1 SS_sky130_fd_sc_hd__decap_3
X_1268_ vccd1 vssd1 vccd1 vssd1 _1268_/X _1663_/Q _1272_/B SS_sky130_fd_sc_hd__or2_2
XFILLER_24_301 vssd1 vccd1 vccd1 vssd1 SS_sky130_fd_sc_hd__fill_4
XFILLER_37_673 vssd1 vccd1 vssd1 vccd1 SS_sky130_ef_sc_hd__decap_40_12
XFILLER_43_109 vssd1 vccd1 vccd1 vssd1 SS_sky130_fd_sc_hd__fill_2
XFILLER_64_470 vssd1 vccd1 vccd1 vssd1 SS_sky130_fd_sc_hd__fill_4
X_1199_ vssd1 vccd1 vccd1 vssd1 _1209_/A2 input38/X _1629_/D _1465_/C1 _1198_/X SS_sky130_fd_sc_hd__o211a_2
XFILLER_24_345 vssd1 vccd1 vssd1 vccd1 SS_sky130_ef_sc_hd__decap_40_12
XTAP_TAPCELL_ROW_35_830 vccd1 vssd1 SS_sky130_fd_sc_hd__tapvpwrvgnd_1
XFILLER_101_57 vssd1 vccd1 vssd1 vccd1 SS_sky130_ef_sc_hd__decap_40_12
XFILLER_12_529 vssd1 vccd1 vccd1 vssd1 SS_sky130_fd_sc_hd__fill_2
XFILLER_24_389 vssd1 vccd1 vssd1 vccd1 SS_sky130_ef_sc_hd__decap_40_12
XFILLER_138_759 vccd1 vssd1 vccd1 vssd1 SS_sky130_fd_sc_hd__fill_1
XFILLER_137_225 vssd1 vccd1 vccd1 vssd1 SS_sky130_fd_sc_hd__fill_4
XPHY_EDGE_ROW_67_Right_67 vccd1 vssd1 vccd1 vssd1 SS_sky130_fd_sc_hd__decap_3
XFILLER_106_601 vssd1 vccd1 vccd1 vssd1 SS_sky130_fd_sc_hd__fill_8
XFILLER_3_205 vssd1 vccd1 vssd1 vccd1 SS_sky130_ef_sc_hd__decap_40_12
XFILLER_3_249 vssd1 vccd1 vssd1 vccd1 SS_sky130_ef_sc_hd__decap_40_12
XFILLER_106_645 vssd1 vccd1 vssd1 vccd1 SS_sky130_ef_sc_hd__decap_40_12
XFILLER_105_111 vccd1 vssd1 vccd1 vssd1 SS_sky130_fd_sc_hd__fill_1
XFILLER_10_65 vssd1 vccd1 vssd1 vccd1 SS_sky130_ef_sc_hd__decap_40_12
XFILLER_79_529 vssd1 vccd1 vssd1 vccd1 SS_sky130_ef_sc_hd__decap_40_12
XFILLER_121_615 vccd1 vssd1 vccd1 vssd1 SS_sky130_fd_sc_hd__fill_1
XFILLER_126_65 vssd1 vccd1 vssd1 vccd1 SS_sky130_ef_sc_hd__decap_40_12
XPHY_EDGE_ROW_76_Right_76 vccd1 vssd1 vccd1 vssd1 SS_sky130_fd_sc_hd__decap_3
XTAP_TAPCELL_ROW_89_1636 vccd1 vssd1 SS_sky130_fd_sc_hd__tapvpwrvgnd_1
XFILLER_101_361 vssd1 vccd1 vssd1 vccd1 SS_sky130_ef_sc_hd__decap_40_12
XFILLER_74_245 vssd1 vccd1 vccd1 vssd1 SS_sky130_fd_sc_hd__fill_4
XFILLER_75_757 vssd1 vccd1 vssd1 vccd1 SS_sky130_ef_sc_hd__decap_40_12
XFILLER_16_813 vssd1 vccd1 vccd1 vssd1 SS_sky130_fd_sc_hd__fill_2
XFILLER_27_161 vssd1 vccd1 vccd1 vssd1 SS_sky130_fd_sc_hd__fill_4
XFILLER_34_109 vssd1 vccd1 vssd1 vccd1 SS_sky130_ef_sc_hd__decap_40_12
XFILLER_55_470 vssd1 vccd1 vssd1 vccd1 SS_sky130_ef_sc_hd__decap_40_12
XFILLER_74_289 vssd1 vccd1 vssd1 vccd1 SS_sky130_ef_sc_hd__decap_40_12
XFILLER_35_51 vssd1 vccd1 vccd1 vssd1 SS_sky130_fd_sc_hd__fill_4
XFILLER_31_805 vccd1 vssd1 vccd1 vssd1 SS_sky130_fd_sc_hd__fill_1
XFILLER_42_153 vssd1 vccd1 vssd1 vccd1 SS_sky130_ef_sc_hd__decap_40_12
XFILLER_43_665 vssd1 vccd1 vccd1 vssd1 SS_sky130_fd_sc_hd__fill_4
XTAP_TAPCELL_ROW_13_502 vccd1 vssd1 SS_sky130_fd_sc_hd__tapvpwrvgnd_1
XFILLER_15_389 vssd1 vccd1 vccd1 vssd1 SS_sky130_fd_sc_hd__fill_2
XFILLER_42_197 vssd1 vccd1 vssd1 vccd1 SS_sky130_ef_sc_hd__decap_40_12
XTAP_TAPCELL_ROW_100_1803 vccd1 vssd1 SS_sky130_fd_sc_hd__tapvpwrvgnd_1
XFILLER_11_573 vssd1 vccd1 vssd1 vccd1 SS_sky130_ef_sc_hd__decap_40_12
XPHY_EDGE_ROW_85_Right_85 vccd1 vssd1 vccd1 vssd1 SS_sky130_fd_sc_hd__decap_3
XTAP_TAPCELL_ROW_133_2302 vccd1 vssd1 SS_sky130_fd_sc_hd__tapvpwrvgnd_1
Xwire431 vccd1 vssd1 wire431/X wire431/A vccd1 vssd1 SS_sky130_fd_sc_hd__buf_4
XFILLER_109_461 vssd1 vccd1 vssd1 vccd1 SS_sky130_ef_sc_hd__decap_40_12
Xwire497 vccd1 vssd1 wire497/X wire497/A vccd1 vssd1 SS_sky130_fd_sc_hd__buf_4
XFILLER_124_475 vccd1 vssd1 vccd1 vssd1 SS_sky130_fd_sc_hd__fill_1
XFILLER_3_783 vccd1 vssd1 vccd1 vssd1 SS_sky130_fd_sc_hd__fill_1
XTAP_TAPCELL_ROW_111_1965 vccd1 vssd1 SS_sky130_fd_sc_hd__tapvpwrvgnd_1
XFILLER_111_125 vssd1 vccd1 vssd1 vccd1 SS_sky130_ef_sc_hd__decap_40_12
XFILLER_97_337 vssd1 vccd1 vssd1 vccd1 SS_sky130_ef_sc_hd__decap_40_12
XFILLER_97_326 vssd1 vccd1 vccd1 vssd1 SS_sky130_fd_sc_hd__fill_8
XPHY_EDGE_ROW_29_Left_168 vccd1 vssd1 vccd1 vssd1 SS_sky130_fd_sc_hd__decap_3
Xload_slew469 vccd1 vssd1 _1149_/C1 _1151_/C1 vccd1 vssd1 SS_sky130_fd_sc_hd__buf_4
XFILLER_111_169 vssd1 vccd1 vssd1 vccd1 SS_sky130_ef_sc_hd__decap_40_12
XPHY_EDGE_ROW_94_Right_94 vccd1 vssd1 vccd1 vssd1 SS_sky130_fd_sc_hd__decap_3
XTAP_TAPCELL_ROW_53_1094 vccd1 vssd1 SS_sky130_fd_sc_hd__tapvpwrvgnd_1
XFILLER_65_223 vccd1 vssd1 vccd1 vssd1 SS_sky130_fd_sc_hd__fill_1
XFILLER_78_584 vssd1 vccd1 vccd1 vssd1 SS_sky130_fd_sc_hd__fill_4
XFILLER_66_757 vssd1 vccd1 vssd1 vccd1 SS_sky130_ef_sc_hd__decap_40_12
X_1122_ vccd1 vssd1 vccd1 vssd1 _1122_/X _1122_/A _1126_/B SS_sky130_fd_sc_hd__or2_2
XFILLER_19_673 vssd1 vccd1 vssd1 vccd1 SS_sky130_ef_sc_hd__decap_40_12
XFILLER_25_109 vssd1 vccd1 vccd1 vssd1 SS_sky130_fd_sc_hd__fill_2
XFILLER_53_407 vccd1 vssd1 vccd1 vssd1 SS_sky130_fd_sc_hd__fill_1
XFILLER_81_727 vccd1 vssd1 vccd1 vssd1 SS_sky130_fd_sc_hd__fill_1
XFILLER_81_738 vssd1 vccd1 vccd1 vssd1 SS_sky130_fd_sc_hd__fill_8
X_1053_ vssd1 vccd1 vccd1 vssd1 _1077_/A2 input30/X _1558_/D _1259_/C1 _1052_/X SS_sky130_fd_sc_hd__o211a_2
XFILLER_34_643 vccd1 vssd1 vccd1 vssd1 SS_sky130_fd_sc_hd__fill_1
XPHY_EDGE_ROW_1_Left_140 vccd1 vssd1 vccd1 vssd1 SS_sky130_fd_sc_hd__decap_3
XFILLER_21_337 vssd1 vccd1 vssd1 vccd1 SS_sky130_ef_sc_hd__decap_40_12
XPHY_EDGE_ROW_38_Left_177 vccd1 vssd1 vccd1 vssd1 SS_sky130_fd_sc_hd__decap_3
XFILLER_61_473 vssd1 vccd1 vccd1 vssd1 SS_sky130_fd_sc_hd__fill_8
XFILLER_119_225 vssd1 vccd1 vssd1 vccd1 SS_sky130_ef_sc_hd__decap_40_12
X_0906_ vccd1 vssd1 vccd1 vssd1 _1660_/Q _1211_/A _1724_/Q wire452/X _0907_/C SS_sky130_fd_sc_hd__a22o_2
X_1886_ vccd1 vssd1 _1886_/X _1886_/A vccd1 vssd1 SS_sky130_fd_sc_hd__buf_2
X_0837_ vccd1 vssd1 vccd1 vssd1 _1553_/Q wire424/A _1713_/Q wire454/A _0837_/X SS_sky130_fd_sc_hd__a22o_2
XFILLER_128_781 vssd1 vccd1 vssd1 vccd1 SS_sky130_ef_sc_hd__decap_40_12
XFILLER_135_729 vssd1 vccd1 vssd1 vccd1 SS_sky130_ef_sc_hd__decap_40_12
XFILLER_1_709 vssd1 vccd1 vssd1 vccd1 SS_sky130_ef_sc_hd__decap_40_12
X_0768_ vccd1 vssd1 vccd1 vssd1 input5/X _0815_/B1 _1893_/A wire448/X _0768_/X SS_sky130_fd_sc_hd__a22o_2
XFILLER_130_401 vssd1 vccd1 vssd1 vccd1 SS_sky130_ef_sc_hd__decap_40_12
XFILLER_103_615 vccd1 vssd1 vccd1 vssd1 SS_sky130_fd_sc_hd__fill_1
XPHY_EDGE_ROW_47_Left_186 vccd1 vssd1 vccd1 vssd1 SS_sky130_fd_sc_hd__decap_3
XFILLER_130_445 vssd1 vccd1 vssd1 vccd1 SS_sky130_ef_sc_hd__decap_40_12
XFILLER_103_637 vssd1 vccd1 vssd1 vccd1 SS_sky130_ef_sc_hd__decap_40_12
XFILLER_69_573 vssd1 vccd1 vssd1 vccd1 SS_sky130_ef_sc_hd__decap_40_12
XFILLER_56_245 vssd1 vccd1 vccd1 vssd1 SS_sky130_fd_sc_hd__fill_4
XFILLER_57_779 vssd1 vccd1 vccd1 vssd1 SS_sky130_fd_sc_hd__fill_4
XFILLER_16_109 vssd1 vccd1 vssd1 vccd1 SS_sky130_ef_sc_hd__decap_40_12
XFILLER_56_289 vssd1 vccd1 vssd1 vccd1 SS_sky130_ef_sc_hd__decap_40_12
XFILLER_84_587 vccd1 vssd1 vccd1 vssd1 SS_sky130_fd_sc_hd__fill_1
XFILLER_71_237 vssd1 vccd1 vssd1 vccd1 SS_sky130_ef_sc_hd__decap_40_12
XFILLER_13_805 vssd1 vccd1 vssd1 vccd1 SS_sky130_ef_sc_hd__decap_40_12
XFILLER_24_153 vssd1 vccd1 vssd1 vccd1 SS_sky130_ef_sc_hd__decap_40_12
XPHY_EDGE_ROW_56_Left_195 vccd1 vssd1 vccd1 vssd1 SS_sky130_fd_sc_hd__decap_3
XFILLER_72_27 vccd1 vssd1 vccd1 vssd1 SS_sky130_fd_sc_hd__fill_1
XTAP_TAPCELL_ROW_84_1555 vccd1 vssd1 SS_sky130_fd_sc_hd__tapvpwrvgnd_1
XTAP_TAPCELL_ROW_84_1566 vccd1 vssd1 SS_sky130_fd_sc_hd__tapvpwrvgnd_1
XFILLER_9_809 vssd1 vccd1 vccd1 vssd1 SS_sky130_fd_sc_hd__fill_8
XFILLER_40_635 vssd1 vccd1 vccd1 vssd1 SS_sky130_fd_sc_hd__fill_8
XFILLER_52_495 vccd1 vssd1 vccd1 vssd1 SS_sky130_fd_sc_hd__fill_1
XFILLER_80_793 vssd1 vccd1 vssd1 vccd1 SS_sky130_ef_sc_hd__decap_40_12
XFILLER_24_197 vssd1 vccd1 vssd1 vccd1 SS_sky130_ef_sc_hd__decap_40_12
XFILLER_40_657 vssd1 vccd1 vssd1 vccd1 SS_sky130_ef_sc_hd__decap_40_12
XFILLER_126_707 vccd1 vssd1 vccd1 vssd1 SS_sky130_fd_sc_hd__fill_1
XTAP_TAPCELL_ROW_115_2021 vccd1 vssd1 SS_sky130_fd_sc_hd__tapvpwrvgnd_1
XFILLER_4_525 vssd1 vccd1 vccd1 vssd1 SS_sky130_fd_sc_hd__fill_4
XFILLER_21_42 vssd1 vccd1 vssd1 vccd1 SS_sky130_ef_sc_hd__decap_40_12
XFILLER_138_589 vssd1 vccd1 vccd1 vssd1 SS_sky130_fd_sc_hd__fill_2
XFILLER_125_217 vssd1 vccd1 vccd1 vssd1 SS_sky130_fd_sc_hd__fill_4
XTAP_TAPCELL_ROW_115_2032 vccd1 vssd1 SS_sky130_fd_sc_hd__tapvpwrvgnd_1
XFILLER_115_3 vssd1 vccd1 vssd1 vccd1 SS_sky130_ef_sc_hd__decap_40_12
XFILLER_4_569 vssd1 vccd1 vssd1 vccd1 SS_sky130_ef_sc_hd__decap_40_12
XFILLER_133_261 vssd1 vccd1 vssd1 vccd1 SS_sky130_ef_sc_hd__decap_40_12
XFILLER_97_57 vssd1 vccd1 vssd1 vccd1 SS_sky130_ef_sc_hd__decap_40_12
XFILLER_0_753 vssd1 vccd1 vccd1 vssd1 SS_sky130_fd_sc_hd__fill_2
XFILLER_121_445 vssd1 vccd1 vccd1 vssd1 SS_sky130_fd_sc_hd__fill_2
XFILLER_94_307 vccd1 vssd1 vccd1 vssd1 SS_sky130_fd_sc_hd__fill_1
XFILLER_0_797 vssd1 vccd1 vssd1 vccd1 SS_sky130_ef_sc_hd__decap_40_12
XFILLER_48_713 vssd1 vccd1 vssd1 vccd1 SS_sky130_ef_sc_hd__decap_40_12
XFILLER_47_223 vccd1 vssd1 vccd1 vssd1 SS_sky130_fd_sc_hd__fill_1
XFILLER_48_757 vssd1 vccd1 vssd1 vccd1 SS_sky130_ef_sc_hd__decap_40_12
XFILLER_35_429 vssd1 vccd1 vssd1 vccd1 SS_sky130_ef_sc_hd__decap_40_12
XFILLER_63_727 vccd1 vssd1 vccd1 vssd1 SS_sky130_fd_sc_hd__fill_1
XTAP_TAPCELL_ROW_126_2183 vccd1 vssd1 SS_sky130_fd_sc_hd__tapvpwrvgnd_1
XFILLER_16_643 vccd1 vssd1 vccd1 vssd1 SS_sky130_fd_sc_hd__fill_1
XFILLER_46_83 vccd1 vssd1 vccd1 vssd1 SS_sky130_fd_sc_hd__fill_1
XFILLER_90_557 vssd1 vccd1 vssd1 vccd1 SS_sky130_ef_sc_hd__decap_40_12
XTAP_TAPCELL_ROW_126_2194 vccd1 vssd1 SS_sky130_fd_sc_hd__tapvpwrvgnd_1
XFILLER_71_760 vccd1 vssd1 vccd1 vssd1 SS_sky130_fd_sc_hd__fill_1
XFILLER_43_473 vssd1 vccd1 vssd1 vccd1 SS_sky130_ef_sc_hd__decap_40_12
XTAP_TAPCELL_ROW_26_693 vccd1 vssd1 SS_sky130_fd_sc_hd__tapvpwrvgnd_1
XFILLER_129_501 vssd1 vccd1 vccd1 vssd1 SS_sky130_fd_sc_hd__fill_2
XFILLER_7_55 vccd1 vssd1 vccd1 vssd1 SS_sky130_fd_sc_hd__fill_1
XFILLER_30_189 vssd1 vccd1 vccd1 vssd1 SS_sky130_fd_sc_hd__fill_4
X_1740_ _1904_/A _1741_/CLK _1740_/D vccd1 vssd1 vccd1 vssd1 SS_sky130_fd_sc_hd__dfxtp_2
Xwire283 vccd1 vssd1 vssd1 vccd1 wire283/A analog_ctrl[13] SS_sky130_fd_sc_hd__buf_12
Xwire272 vccd1 vssd1 vssd1 vccd1 wire272/A analog_ctrl[23] SS_sky130_fd_sc_hd__buf_12
Xwire261 vccd1 vssd1 vssd1 vccd1 wire261/A analog_ctrl[33] SS_sky130_fd_sc_hd__buf_12
X_1671_ _1889_/A _1731_/CLK _1671_/D vccd1 vssd1 vccd1 vssd1 SS_sky130_fd_sc_hd__dfxtp_2
XFILLER_117_729 vssd1 vccd1 vssd1 vccd1 SS_sky130_ef_sc_hd__decap_40_12
XFILLER_7_385 vssd1 vccd1 vccd1 vssd1 SS_sky130_fd_sc_hd__fill_4
Xwire294 vccd1 vssd1 vssd1 vccd1 wire294/A analog_ctrl[114] SS_sky130_fd_sc_hd__buf_12
XTAP_TAPCELL_ROW_55_1123 vccd1 vssd1 SS_sky130_fd_sc_hd__tapvpwrvgnd_1
XFILLER_98_613 vssd1 vccd1 vssd1 vccd1 SS_sky130_ef_sc_hd__decap_40_12
Xload_slew222 vccd1 vssd1 _1325_/A2 _1331_/A2 vccd1 vssd1 SS_sky130_fd_sc_hd__buf_4
XFILLER_98_657 vssd1 vccd1 vssd1 vccd1 SS_sky130_ef_sc_hd__decap_40_12
XFILLER_30_3 vssd1 vccd1 vssd1 vccd1 SS_sky130_ef_sc_hd__decap_40_12
Xload_slew255 vccd1 vssd1 _0989_/A2 _0985_/A2 vccd1 vssd1 SS_sky130_fd_sc_hd__buf_4
XFILLER_112_445 vssd1 vccd1 vssd1 vccd1 SS_sky130_ef_sc_hd__decap_40_12
XFILLER_98_679 vssd1 vccd1 vccd1 vssd1 SS_sky130_fd_sc_hd__fill_2
XFILLER_97_167 vccd1 vssd1 vccd1 vssd1 SS_sky130_fd_sc_hd__fill_1
XFILLER_85_329 vssd1 vccd1 vccd1 vssd1 SS_sky130_fd_sc_hd__fill_4
XFILLER_112_489 vssd1 vccd1 vssd1 vccd1 SS_sky130_ef_sc_hd__decap_40_12
XFILLER_100_629 vssd1 vccd1 vccd1 vssd1 SS_sky130_fd_sc_hd__fill_2
XFILLER_38_245 vssd1 vccd1 vccd1 vssd1 SS_sky130_fd_sc_hd__fill_4
XFILLER_38_289 vssd1 vccd1 vssd1 vccd1 SS_sky130_ef_sc_hd__decap_40_12
X_1105_ vssd1 vccd1 vccd1 vssd1 wire241/X wire499/X _1583_/D wire467/X _1104_/X SS_sky130_fd_sc_hd__o211a_2
XFILLER_66_587 vccd1 vssd1 vccd1 vssd1 SS_sky130_fd_sc_hd__fill_1
XFILLER_93_362 vssd1 vccd1 vssd1 vccd1 SS_sky130_ef_sc_hd__decap_40_12
XFILLER_53_237 vssd1 vccd1 vssd1 vccd1 SS_sky130_ef_sc_hd__decap_40_12
XFILLER_54_749 vssd1 vccd1 vccd1 vssd1 SS_sky130_fd_sc_hd__fill_4
X_1036_ vccd1 vssd1 vccd1 vssd1 _1036_/X _1036_/A _1050_/B SS_sky130_fd_sc_hd__or2_2
XFILLER_34_473 vssd1 vccd1 vccd1 vssd1 SS_sky130_fd_sc_hd__fill_2
XTAP_TAPCELL_ROW_45_980 vccd1 vssd1 SS_sky130_fd_sc_hd__tapvpwrvgnd_1
XFILLER_62_793 vssd1 vccd1 vssd1 vccd1 SS_sky130_ef_sc_hd__decap_40_12
XTAP_TAPCELL_ROW_66_1285 vccd1 vssd1 SS_sky130_fd_sc_hd__tapvpwrvgnd_1
XTAP_TAPCELL_ROW_66_1296 vccd1 vssd1 SS_sky130_fd_sc_hd__tapvpwrvgnd_1
XFILLER_22_657 vssd1 vccd1 vssd1 vccd1 SS_sky130_ef_sc_hd__decap_40_12
XFILLER_61_281 vssd1 vccd1 vssd1 vccd1 SS_sky130_ef_sc_hd__decap_40_12
XFILLER_10_819 vccd1 vssd1 vccd1 vssd1 SS_sky130_fd_sc_hd__fill_1
XFILLER_21_167 vccd1 vssd1 vccd1 vssd1 SS_sky130_fd_sc_hd__fill_1
X_1869_ vccd1 vssd1 _1869_/X _1869_/A vccd1 vssd1 SS_sky130_fd_sc_hd__buf_2
XFILLER_107_217 vssd1 vccd1 vccd1 vssd1 SS_sky130_fd_sc_hd__fill_4
XFILLER_1_517 vssd1 vccd1 vssd1 vccd1 SS_sky130_ef_sc_hd__decap_40_12
XFILLER_122_209 vssd1 vccd1 vssd1 vccd1 SS_sky130_ef_sc_hd__decap_40_12
XFILLER_131_721 vssd1 vccd1 vccd1 vssd1 SS_sky130_fd_sc_hd__fill_4
XFILLER_115_261 vssd1 vccd1 vssd1 vccd1 SS_sky130_ef_sc_hd__decap_40_12
XFILLER_67_27 vssd1 vccd1 vssd1 vccd1 SS_sky130_ef_sc_hd__decap_40_12
XFILLER_76_307 vccd1 vssd1 vccd1 vssd1 SS_sky130_fd_sc_hd__fill_1
XFILLER_130_253 vssd1 vccd1 vssd1 vccd1 SS_sky130_ef_sc_hd__decap_40_12
XFILLER_131_765 vssd1 vccd1 vssd1 vccd1 SS_sky130_ef_sc_hd__decap_40_12
XFILLER_88_189 vssd1 vccd1 vccd1 vssd1 SS_sky130_fd_sc_hd__fill_4
XTAP_TAPCELL_ROW_4_355 vccd1 vssd1 SS_sky130_fd_sc_hd__tapvpwrvgnd_1
XTAP_TAPCELL_ROW_4_366 vccd1 vssd1 SS_sky130_fd_sc_hd__tapvpwrvgnd_1
XFILLER_29_223 vccd1 vssd1 vccd1 vssd1 SS_sky130_fd_sc_hd__fill_1
XFILLER_85_841 vccd1 vssd1 vccd1 vssd1 SS_sky130_fd_sc_hd__fill_1
XFILLER_84_351 vssd1 vccd1 vssd1 vccd1 SS_sky130_ef_sc_hd__decap_40_12
XFILLER_17_429 vssd1 vccd1 vssd1 vccd1 SS_sky130_ef_sc_hd__decap_40_12
XPHY_EDGE_ROW_64_Left_203 vccd1 vssd1 vccd1 vssd1 SS_sky130_fd_sc_hd__decap_3
XFILLER_16_53 vssd1 vccd1 vssd1 vccd1 SS_sky130_ef_sc_hd__decap_40_12
XFILLER_13_613 vssd1 vccd1 vccd1 vssd1 SS_sky130_fd_sc_hd__fill_2
XFILLER_25_473 vssd1 vccd1 vssd1 vccd1 SS_sky130_ef_sc_hd__decap_40_12
XTAP_TAPCELL_ROW_43_939 vccd1 vssd1 SS_sky130_fd_sc_hd__tapvpwrvgnd_1
XFILLER_53_782 vssd1 vccd1 vccd1 vssd1 SS_sky130_fd_sc_hd__fill_2
XFILLER_9_617 vssd1 vccd1 vssd1 vccd1 SS_sky130_ef_sc_hd__decap_40_12
XFILLER_16_97 vssd1 vccd1 vssd1 vccd1 SS_sky130_ef_sc_hd__decap_40_12
XTAP_TAPCELL_ROW_23_641 vccd1 vssd1 SS_sky130_fd_sc_hd__tapvpwrvgnd_1
XFILLER_40_421 vssd1 vccd1 vssd1 vccd1 SS_sky130_ef_sc_hd__decap_40_12
XTAP_TAPCELL_ROW_23_652 vccd1 vssd1 SS_sky130_fd_sc_hd__tapvpwrvgnd_1
XFILLER_12_189 vssd1 vccd1 vccd1 vssd1 SS_sky130_fd_sc_hd__fill_4
XFILLER_32_41 vssd1 vccd1 vssd1 vccd1 SS_sky130_ef_sc_hd__decap_40_12
XFILLER_32_85 vssd1 vccd1 vssd1 vccd1 SS_sky130_ef_sc_hd__decap_40_12
XPHY_EDGE_ROW_73_Left_212 vccd1 vssd1 vccd1 vssd1 SS_sky130_fd_sc_hd__decap_3
XTAP_TAPCELL_ROW_97_1757 vccd1 vssd1 SS_sky130_fd_sc_hd__tapvpwrvgnd_1
XFILLER_4_333 vssd1 vccd1 vssd1 vccd1 SS_sky130_ef_sc_hd__decap_40_12
XFILLER_4_377 vssd1 vccd1 vssd1 vccd1 SS_sky130_ef_sc_hd__decap_40_12
XFILLER_134_570 vssd1 vccd1 vccd1 vssd1 SS_sky130_fd_sc_hd__fill_4
XFILLER_122_754 vssd1 vccd1 vccd1 vssd1 SS_sky130_fd_sc_hd__fill_2
XFILLER_0_561 vssd1 vccd1 vssd1 vccd1 SS_sky130_ef_sc_hd__decap_40_12
XFILLER_67_329 vssd1 vccd1 vccd1 vssd1 SS_sky130_fd_sc_hd__fill_4
XFILLER_79_167 vccd1 vssd1 vccd1 vssd1 SS_sky130_fd_sc_hd__fill_1
XTAP_TAPCELL_ROW_128_2223 vccd1 vssd1 SS_sky130_fd_sc_hd__tapvpwrvgnd_1
XTAP_TAPCELL_ROW_50_1053 vccd1 vssd1 SS_sky130_fd_sc_hd__tapvpwrvgnd_1
XFILLER_94_137 vssd1 vccd1 vccd1 vssd1 SS_sky130_fd_sc_hd__fill_2
XFILLER_48_565 vccd1 vssd1 vccd1 vssd1 SS_sky130_fd_sc_hd__fill_1
XFILLER_48_576 vssd1 vccd1 vssd1 vccd1 SS_sky130_ef_sc_hd__decap_40_12
XFILLER_57_93 vssd1 vccd1 vssd1 vccd1 SS_sky130_ef_sc_hd__decap_40_12
XPHY_EDGE_ROW_82_Left_221 vccd1 vssd1 vccd1 vssd1 SS_sky130_fd_sc_hd__decap_3
XFILLER_35_237 vssd1 vccd1 vssd1 vccd1 SS_sky130_ef_sc_hd__decap_40_12
XFILLER_36_749 vssd1 vccd1 vccd1 vssd1 SS_sky130_fd_sc_hd__fill_4
XFILLER_75_395 vccd1 vssd1 vccd1 vssd1 SS_sky130_fd_sc_hd__fill_1
XFILLER_90_321 vssd1 vccd1 vccd1 vssd1 SS_sky130_fd_sc_hd__fill_8
XFILLER_51_719 vssd1 vccd1 vccd1 vssd1 SS_sky130_fd_sc_hd__fill_8
XFILLER_63_557 vssd1 vccd1 vccd1 vssd1 SS_sky130_fd_sc_hd__fill_2
XFILLER_90_365 vccd1 vssd1 vccd1 vssd1 SS_sky130_fd_sc_hd__fill_1
XFILLER_16_473 vssd1 vccd1 vccd1 vssd1 SS_sky130_fd_sc_hd__fill_2
XFILLER_44_793 vssd1 vccd1 vssd1 vccd1 SS_sky130_ef_sc_hd__decap_40_12
XFILLER_73_81 vssd1 vccd1 vssd1 vccd1 SS_sky130_ef_sc_hd__decap_40_12
XTAP_TAPCELL_ROW_106_1897 vccd1 vssd1 SS_sky130_fd_sc_hd__tapvpwrvgnd_1
XTAP_TAPCELL_ROW_106_1886 vccd1 vssd1 SS_sky130_fd_sc_hd__tapvpwrvgnd_1
XFILLER_43_281 vssd1 vccd1 vssd1 vccd1 SS_sky130_ef_sc_hd__decap_40_12
XPHY_EDGE_ROW_91_Left_230 vccd1 vssd1 vccd1 vssd1 SS_sky130_fd_sc_hd__decap_3
XFILLER_129_375 vssd1 vccd1 vssd1 vccd1 SS_sky130_ef_sc_hd__decap_40_12
X_1723_ _1723_/Q _1756_/CLK _1723_/D vccd1 vssd1 vccd1 vssd1 SS_sky130_fd_sc_hd__dfxtp_2
XFILLER_7_193 vssd1 vccd1 vssd1 vccd1 SS_sky130_ef_sc_hd__decap_40_12
XFILLER_129_397 vssd1 vccd1 vccd1 vssd1 SS_sky130_fd_sc_hd__fill_2
XFILLER_117_559 vccd1 vssd1 vccd1 vssd1 SS_sky130_fd_sc_hd__fill_1
XFILLER_132_507 vssd1 vccd1 vssd1 vccd1 SS_sky130_ef_sc_hd__decap_40_12
XFILLER_104_209 vssd1 vccd1 vssd1 vccd1 SS_sky130_ef_sc_hd__decap_40_12
X_1654_ _1654_/Q _1686_/CLK _1654_/D vccd1 vssd1 vccd1 vssd1 SS_sky130_fd_sc_hd__dfxtp_2
X_1585_ _1859_/A clkload6/A _1585_/D vccd1 vssd1 vccd1 vssd1 SS_sky130_fd_sc_hd__dfxtp_2
XFILLER_113_721 vssd1 vccd1 vccd1 vssd1 SS_sky130_fd_sc_hd__fill_4
XFILLER_98_421 vssd1 vccd1 vssd1 vccd1 SS_sky130_ef_sc_hd__decap_40_12
XFILLER_58_307 vccd1 vssd1 vccd1 vssd1 SS_sky130_fd_sc_hd__fill_1
XFILLER_112_253 vssd1 vccd1 vssd1 vccd1 SS_sky130_ef_sc_hd__decap_40_12
XFILLER_100_404 vssd1 vccd1 vccd1 vssd1 SS_sky130_fd_sc_hd__fill_4
XFILLER_39_543 vssd1 vccd1 vssd1 vccd1 SS_sky130_ef_sc_hd__decap_40_12
XFILLER_67_841 vccd1 vssd1 vccd1 vssd1 SS_sky130_fd_sc_hd__fill_1
XFILLER_85_137 vssd1 vccd1 vssd1 vccd1 SS_sky130_ef_sc_hd__decap_40_12
XFILLER_112_297 vccd1 vssd1 vccd1 vssd1 SS_sky130_fd_sc_hd__fill_1
Xafe_wb_507 analog_ctrl[103] afe_wb_507/HI vccd1 vssd1 vssd1 vccd1 SS_sky130_fd_sc_hd__conb_1
Xafe_wb_518 analog_io_out[10] afe_wb_518/HI vccd1 vssd1 vssd1 vccd1 SS_sky130_fd_sc_hd__conb_1
XTAP_TAPCELL_ROW_1_314 vccd1 vssd1 SS_sky130_fd_sc_hd__tapvpwrvgnd_1
XFILLER_27_716 vssd1 vccd1 vccd1 vssd1 SS_sky130_fd_sc_hd__fill_2
XFILLER_27_727 vccd1 vssd1 vccd1 vssd1 SS_sky130_fd_sc_hd__fill_1
XFILLER_66_351 vssd1 vccd1 vccd1 vssd1 SS_sky130_fd_sc_hd__fill_2
XTAP_TAPCELL_ROW_68_1314 vccd1 vssd1 SS_sky130_fd_sc_hd__tapvpwrvgnd_1
Xafe_wb_529 analog_io_out[21] afe_wb_529/HI vccd1 vssd1 vssd1 vccd1 SS_sky130_fd_sc_hd__conb_1
XFILLER_54_524 vssd1 vccd1 vccd1 vssd1 SS_sky130_fd_sc_hd__fill_8
XTAP_TAPCELL_ROW_68_1325 vccd1 vssd1 SS_sky130_fd_sc_hd__tapvpwrvgnd_1
XFILLER_93_181 vssd1 vccd1 vssd1 vccd1 SS_sky130_ef_sc_hd__decap_40_12
XFILLER_53_18 vssd1 vccd1 vssd1 vccd1 SS_sky130_ef_sc_hd__decap_40_12
X_1019_ vssd1 vccd1 vccd1 vssd1 _1033_/A2 input42/X _1541_/D _1149_/C1 _1018_/X SS_sky130_fd_sc_hd__o211a_2
XFILLER_35_771 vssd1 vccd1 vssd1 vccd1 SS_sky130_ef_sc_hd__decap_40_12
XFILLER_35_793 vssd1 vccd1 vccd1 vssd1 SS_sky130_fd_sc_hd__fill_2
XTAP_TAPCELL_ROW_81_1514 vccd1 vssd1 SS_sky130_fd_sc_hd__tapvpwrvgnd_1
XFILLER_22_421 vssd1 vccd1 vssd1 vccd1 SS_sky130_ef_sc_hd__decap_40_12
XTAP_TAPCELL_ROW_20_600 vccd1 vssd1 SS_sky130_fd_sc_hd__tapvpwrvgnd_1
XTAP_TAPCELL_ROW_79_1487 vccd1 vssd1 SS_sky130_fd_sc_hd__tapvpwrvgnd_1
XFILLER_2_837 vssd1 vccd1 vccd1 vssd1 SS_sky130_fd_sc_hd__fill_4
XTAP_TAPCELL_ROW_9_436 vccd1 vssd1 SS_sky130_fd_sc_hd__tapvpwrvgnd_1
XFILLER_78_26 vssd1 vccd1 vccd1 vssd1 SS_sky130_fd_sc_hd__fill_2
Xhold661 _1068_/A _1566_/Q vccd1 vssd1 vssd1 vccd1 SS_sky130_fd_sc_hd__dlygate4sd3_1
Xhold650 _1076_/A _1570_/Q vccd1 vssd1 vssd1 vccd1 SS_sky130_fd_sc_hd__dlygate4sd3_1
XFILLER_123_529 vssd1 vccd1 vccd1 vssd1 SS_sky130_fd_sc_hd__fill_4
XFILLER_118_77 vssd1 vccd1 vccd1 vssd1 SS_sky130_fd_sc_hd__fill_4
XFILLER_116_581 vssd1 vccd1 vccd1 vssd1 SS_sky130_fd_sc_hd__fill_4
Xhold672 _1386_/A _1720_/Q vccd1 vssd1 vssd1 vccd1 SS_sky130_fd_sc_hd__dlygate4sd3_1
Xhold694 _1198_/A _1629_/Q vccd1 vssd1 vssd1 vccd1 SS_sky130_fd_sc_hd__dlygate4sd3_1
Xhold683 _1400_/A _1727_/Q vccd1 vssd1 vssd1 vccd1 SS_sky130_fd_sc_hd__dlygate4sd3_1
XTAP_TAPCELL_ROW_92_1687 vccd1 vssd1 SS_sky130_fd_sc_hd__tapvpwrvgnd_1
XTAP_TAPCELL_ROW_92_1676 vccd1 vssd1 SS_sky130_fd_sc_hd__tapvpwrvgnd_1
XFILLER_49_329 vssd1 vccd1 vccd1 vssd1 SS_sky130_fd_sc_hd__fill_4
XFILLER_104_798 vssd1 vccd1 vssd1 vccd1 SS_sky130_ef_sc_hd__decap_40_12
XFILLER_76_137 vssd1 vccd1 vccd1 vssd1 SS_sky130_fd_sc_hd__fill_2
XFILLER_85_671 vccd1 vssd1 vccd1 vssd1 SS_sky130_fd_sc_hd__fill_1
XFILLER_17_237 vssd1 vccd1 vssd1 vccd1 SS_sky130_ef_sc_hd__decap_40_12
XFILLER_18_738 vssd1 vccd1 vssd1 vccd1 SS_sky130_ef_sc_hd__decap_40_12
XTAP_TAPCELL_ROW_28_722 vccd1 vssd1 SS_sky130_fd_sc_hd__tapvpwrvgnd_1
XFILLER_72_321 vssd1 vccd1 vccd1 vssd1 SS_sky130_fd_sc_hd__fill_8
XFILLER_33_719 vccd1 vssd1 vccd1 vssd1 SS_sky130_fd_sc_hd__fill_1
XFILLER_72_354 vssd1 vccd1 vccd1 vssd1 SS_sky130_fd_sc_hd__fill_8
XFILLER_72_365 vssd1 vccd1 vssd1 vccd1 SS_sky130_ef_sc_hd__decap_40_12
XTAP_TAPCELL_ROW_123_2142 vccd1 vssd1 SS_sky130_fd_sc_hd__tapvpwrvgnd_1
XFILLER_26_793 vccd1 vssd1 vccd1 vssd1 SS_sky130_fd_sc_hd__fill_1
XFILLER_25_281 vssd1 vccd1 vssd1 vccd1 SS_sky130_ef_sc_hd__decap_40_12
XFILLER_40_251 vccd1 vssd1 vccd1 vssd1 SS_sky130_fd_sc_hd__fill_1
XFILLER_41_785 vssd1 vccd1 vssd1 vccd1 SS_sky130_ef_sc_hd__decap_40_12
XFILLER_9_447 vccd1 vssd1 vccd1 vssd1 SS_sky130_fd_sc_hd__fill_1
XFILLER_126_301 vssd1 vccd1 vccd1 vssd1 SS_sky130_fd_sc_hd__fill_2
XFILLER_126_323 vccd1 vssd1 vccd1 vssd1 SS_sky130_fd_sc_hd__fill_1
XFILLER_4_141 vssd1 vccd1 vssd1 vccd1 SS_sky130_ef_sc_hd__decap_40_12
XFILLER_5_653 vssd1 vccd1 vssd1 vccd1 SS_sky130_ef_sc_hd__decap_40_12
XFILLER_5_697 vssd1 vccd1 vssd1 vccd1 SS_sky130_ef_sc_hd__decap_40_12
XFILLER_126_389 vssd1 vccd1 vccd1 vssd1 SS_sky130_fd_sc_hd__fill_4
X_1370_ vccd1 vssd1 vccd1 vssd1 _1370_/X _1370_/A _1396_/B SS_sky130_fd_sc_hd__or2_2
XFILLER_68_81 vssd1 vccd1 vccd1 vssd1 SS_sky130_fd_sc_hd__fill_2
XFILLER_110_713 vssd1 vccd1 vssd1 vccd1 SS_sky130_ef_sc_hd__decap_40_12
XFILLER_0_391 vccd1 vssd1 vccd1 vssd1 SS_sky130_fd_sc_hd__fill_1
XFILLER_49_841 vccd1 vssd1 vccd1 vssd1 SS_sky130_fd_sc_hd__fill_1
XFILLER_67_137 vssd1 vccd1 vssd1 vccd1 SS_sky130_ef_sc_hd__decap_40_12
XFILLER_110_757 vssd1 vccd1 vccd1 vssd1 SS_sky130_fd_sc_hd__fill_2
XTAP_TAPCELL_ROW_108_1915 vccd1 vssd1 SS_sky130_fd_sc_hd__tapvpwrvgnd_1
XFILLER_36_513 vssd1 vccd1 vssd1 vccd1 SS_sky130_ef_sc_hd__decap_40_12
XFILLER_75_181 vssd1 vccd1 vssd1 vccd1 SS_sky130_ef_sc_hd__decap_40_12
XTAP_TAPCELL_ROW_108_1926 vccd1 vssd1 SS_sky130_fd_sc_hd__tapvpwrvgnd_1
XFILLER_51_505 vssd1 vccd1 vssd1 vccd1 SS_sky130_ef_sc_hd__decap_40_12
XFILLER_32_730 vssd1 vccd1 vssd1 vccd1 SS_sky130_ef_sc_hd__decap_40_12
XTAP_TAPCELL_ROW_63_1244 vccd1 vssd1 SS_sky130_fd_sc_hd__tapvpwrvgnd_1
XFILLER_90_195 vccd1 vssd1 vccd1 vssd1 SS_sky130_fd_sc_hd__fill_1
XFILLER_31_273 vssd1 vccd1 vccd1 vssd1 SS_sky130_fd_sc_hd__fill_4
XFILLER_129_161 vssd1 vccd1 vccd1 vssd1 SS_sky130_fd_sc_hd__fill_4
XFILLER_136_109 vssd1 vccd1 vssd1 vccd1 SS_sky130_ef_sc_hd__decap_40_12
XFILLER_118_813 vccd1 vssd1 vccd1 vssd1 SS_sky130_fd_sc_hd__fill_1
XFILLER_118_802 vssd1 vccd1 vccd1 vssd1 SS_sky130_fd_sc_hd__fill_8
X_1706_ _1885_/A _1738_/CLK _1706_/D vccd1 vssd1 vccd1 vssd1 SS_sky130_fd_sc_hd__dfxtp_2
X_1637_ _1637_/Q clkload8/A _1637_/D vccd1 vssd1 vccd1 vssd1 SS_sky130_fd_sc_hd__dfxtp_2
XFILLER_99_741 vssd1 vccd1 vssd1 vccd1 SS_sky130_ef_sc_hd__decap_40_12
XFILLER_48_18 vssd1 vccd1 vccd1 vssd1 SS_sky130_fd_sc_hd__fill_8
XFILLER_48_29 vssd1 vccd1 vssd1 vccd1 SS_sky130_ef_sc_hd__decap_40_12
X_1568_ _1568_/Q _1634_/CLK _1568_/D vccd1 vssd1 vccd1 vssd1 SS_sky130_fd_sc_hd__dfxtp_2
XFILLER_99_785 vssd1 vccd1 vssd1 vccd1 SS_sky130_ef_sc_hd__decap_40_12
XFILLER_99_774 vssd1 vccd1 vccd1 vssd1 SS_sky130_fd_sc_hd__fill_8
XFILLER_98_251 vccd1 vssd1 vccd1 vssd1 SS_sky130_fd_sc_hd__fill_1
XFILLER_58_137 vssd1 vccd1 vccd1 vssd1 SS_sky130_fd_sc_hd__fill_2
X_1499_ _1499_/Q _1692_/CLK _1499_/D vccd1 vssd1 vccd1 vssd1 SS_sky130_fd_sc_hd__dfxtp_2
XFILLER_67_660 vssd1 vccd1 vssd1 vccd1 SS_sky130_ef_sc_hd__decap_40_12
XFILLER_100_245 vssd1 vccd1 vccd1 vssd1 SS_sky130_fd_sc_hd__fill_4
XFILLER_39_373 vssd1 vccd1 vssd1 vccd1 SS_sky130_ef_sc_hd__decap_40_12
XFILLER_54_321 vssd1 vccd1 vssd1 vccd1 SS_sky130_ef_sc_hd__decap_40_12
XFILLER_100_289 vssd1 vccd1 vssd1 vccd1 SS_sky130_ef_sc_hd__decap_40_12
XFILLER_27_557 vssd1 vccd1 vccd1 vssd1 SS_sky130_fd_sc_hd__fill_2
XFILLER_82_641 vssd1 vccd1 vccd1 vssd1 SS_sky130_fd_sc_hd__fill_2
XPHY_EDGE_ROW_126_Right_126 vccd1 vssd1 vccd1 vssd1 SS_sky130_fd_sc_hd__decap_3
XFILLER_54_365 vssd1 vccd1 vssd1 vccd1 SS_sky130_ef_sc_hd__decap_40_12
XFILLER_23_741 vssd1 vccd1 vssd1 vccd1 SS_sky130_ef_sc_hd__decap_40_12
XFILLER_22_251 vccd1 vssd1 vccd1 vssd1 SS_sky130_fd_sc_hd__fill_1
XFILLER_23_785 vssd1 vccd1 vssd1 vccd1 SS_sky130_ef_sc_hd__decap_40_12
XFILLER_50_560 vccd1 vssd1 vccd1 vssd1 SS_sky130_fd_sc_hd__fill_1
XFILLER_80_27 vccd1 vssd1 vccd1 vssd1 SS_sky130_fd_sc_hd__fill_1
XFILLER_10_413 vssd1 vccd1 vccd1 vssd1 SS_sky130_fd_sc_hd__fill_4
XTAP_TAPCELL_ROW_33_791 vccd1 vssd1 SS_sky130_fd_sc_hd__tapvpwrvgnd_1
XFILLER_50_593 vssd1 vccd1 vccd1 vssd1 SS_sky130_fd_sc_hd__fill_2
XFILLER_6_417 vssd1 vccd1 vccd1 vssd1 SS_sky130_fd_sc_hd__fill_2
XFILLER_10_457 vssd1 vccd1 vssd1 vccd1 SS_sky130_ef_sc_hd__decap_40_12
XFILLER_13_54 vssd1 vccd1 vccd1 vssd1 SS_sky130_fd_sc_hd__fill_2
XFILLER_127_109 vssd1 vccd1 vccd1 vssd1 SS_sky130_fd_sc_hd__fill_2
XFILLER_108_301 vssd1 vccd1 vccd1 vssd1 SS_sky130_fd_sc_hd__fill_4
XFILLER_136_643 vccd1 vssd1 vccd1 vssd1 SS_sky130_fd_sc_hd__fill_1
XTAP_TAPCELL_ROW_94_1705 vccd1 vssd1 SS_sky130_fd_sc_hd__tapvpwrvgnd_1
XFILLER_124_805 vssd1 vccd1 vccd1 vssd1 SS_sky130_fd_sc_hd__fill_4
XFILLER_108_345 vssd1 vccd1 vssd1 vccd1 SS_sky130_ef_sc_hd__decap_40_12
XTAP_TAPCELL_ROW_94_1716 vccd1 vssd1 SS_sky130_fd_sc_hd__tapvpwrvgnd_1
XFILLER_2_601 vssd1 vccd1 vssd1 vccd1 SS_sky130_ef_sc_hd__decap_40_12
XFILLER_89_69 vssd1 vccd1 vssd1 vccd1 SS_sky130_ef_sc_hd__decap_40_12
XFILLER_123_337 vssd1 vccd1 vssd1 vccd1 SS_sky130_ef_sc_hd__decap_40_12
XFILLER_108_389 vssd1 vccd1 vssd1 vccd1 SS_sky130_ef_sc_hd__decap_40_12
XFILLER_1_111 vccd1 vssd1 vccd1 vssd1 SS_sky130_fd_sc_hd__fill_1
XFILLER_2_645 vssd1 vccd1 vssd1 vccd1 SS_sky130_ef_sc_hd__decap_40_12
XFILLER_89_273 vssd1 vccd1 vccd1 vssd1 SS_sky130_fd_sc_hd__fill_4
XFILLER_49_137 vssd1 vccd1 vssd1 vccd1 SS_sky130_ef_sc_hd__decap_40_12
XFILLER_65_608 vssd1 vccd1 vccd1 vssd1 SS_sky130_fd_sc_hd__fill_8
XFILLER_18_513 vssd1 vccd1 vssd1 vccd1 SS_sky130_ef_sc_hd__decap_40_12
XFILLER_92_449 vccd1 vssd1 vccd1 vssd1 SS_sky130_fd_sc_hd__fill_1
XFILLER_18_557 vssd1 vccd1 vssd1 vccd1 SS_sky130_ef_sc_hd__decap_40_12
XFILLER_57_181 vssd1 vccd1 vssd1 vccd1 SS_sky130_ef_sc_hd__decap_40_12
XFILLER_73_641 vssd1 vccd1 vssd1 vccd1 SS_sky130_ef_sc_hd__decap_40_12
XFILLER_33_505 vssd1 vccd1 vssd1 vccd1 SS_sky130_ef_sc_hd__decap_40_12
XFILLER_73_685 vssd1 vccd1 vssd1 vccd1 SS_sky130_ef_sc_hd__decap_40_12
XFILLER_54_83 vccd1 vssd1 vccd1 vssd1 SS_sky130_fd_sc_hd__fill_1
XFILLER_72_195 vccd1 vssd1 vccd1 vssd1 SS_sky130_fd_sc_hd__fill_1
XTAP_TAPCELL_ROW_103_1845 vccd1 vssd1 SS_sky130_fd_sc_hd__tapvpwrvgnd_1
XFILLER_60_357 vssd1 vccd1 vccd1 vssd1 SS_sky130_fd_sc_hd__fill_4
XFILLER_13_273 vssd1 vccd1 vccd1 vssd1 SS_sky130_fd_sc_hd__fill_4
XFILLER_9_277 vssd1 vccd1 vccd1 vssd1 SS_sky130_fd_sc_hd__fill_2
XTAP_TAPCELL_ROW_136_2333 vccd1 vssd1 SS_sky130_fd_sc_hd__tapvpwrvgnd_1
XTAP_TAPCELL_ROW_136_2344 vccd1 vssd1 SS_sky130_fd_sc_hd__tapvpwrvgnd_1
XFILLER_118_109 vssd1 vccd1 vssd1 vccd1 SS_sky130_ef_sc_hd__decap_40_12
X_0870_ vccd1 vssd1 vccd1 vssd1 _1654_/Q _0894_/B1 _1686_/Q _1277_/A _0870_/X SS_sky130_fd_sc_hd__a22o_2
XTAP_TAPCELL_ROW_11_463 vccd1 vssd1 SS_sky130_fd_sc_hd__tapvpwrvgnd_1
Xclkload14 clkload14/X _1746_/CLK vccd1 vssd1 vssd1 vccd1 SS_sky130_fd_sc_hd__clkbuf_8
Xclkload25 clkload25/X _1762_/CLK vccd1 vssd1 vssd1 vccd1 SS_sky130_fd_sc_hd__clkbuf_8
XFILLER_127_654 vssd1 vccd1 vssd1 vccd1 SS_sky130_ef_sc_hd__decap_40_12
XFILLER_126_153 vssd1 vccd1 vssd1 vccd1 SS_sky130_ef_sc_hd__decap_40_12
XFILLER_5_461 vssd1 vccd1 vssd1 vccd1 SS_sky130_ef_sc_hd__decap_40_12
X_1422_ vccd1 vssd1 vccd1 vssd1 _1422_/X _1901_/A _1466_/B SS_sky130_fd_sc_hd__or2_2
XFILLER_126_197 vssd1 vccd1 vssd1 vccd1 SS_sky130_ef_sc_hd__decap_40_12
XFILLER_114_359 vssd1 vccd1 vccd1 vssd1 SS_sky130_fd_sc_hd__fill_4
XPHY_EDGE_ROW_10_Left_149 vccd1 vssd1 vccd1 vssd1 SS_sky130_fd_sc_hd__decap_3
X_1353_ vssd1 vccd1 vccd1 vssd1 _1369_/A2 input46/X _1703_/D _1417_/C1 _1352_/X SS_sky130_fd_sc_hd__o211a_2
XFILLER_96_755 vccd1 vssd1 vccd1 vssd1 SS_sky130_fd_sc_hd__fill_1
XFILLER_95_221 vssd1 vccd1 vccd1 vssd1 SS_sky130_fd_sc_hd__fill_2
XFILLER_68_457 vssd1 vccd1 vssd1 vccd1 SS_sky130_ef_sc_hd__decap_40_12
XFILLER_83_405 vssd1 vccd1 vssd1 vccd1 SS_sky130_ef_sc_hd__decap_40_12
X_1284_ vccd1 vssd1 vccd1 vssd1 _1284_/X _1894_/A _1338_/B SS_sky130_fd_sc_hd__or2_2
XFILLER_83_449 vssd1 vccd1 vccd1 vssd1 SS_sky130_fd_sc_hd__fill_8
XFILLER_110_587 vccd1 vssd1 vccd1 vssd1 SS_sky130_fd_sc_hd__fill_1
XFILLER_36_321 vssd1 vccd1 vssd1 vccd1 SS_sky130_ef_sc_hd__decap_40_12
XFILLER_64_630 vssd1 vccd1 vssd1 vccd1 SS_sky130_ef_sc_hd__decap_40_12
XFILLER_36_365 vssd1 vccd1 vssd1 vccd1 SS_sky130_ef_sc_hd__decap_40_12
XTAP_TAPCELL_ROW_19_585 vccd1 vssd1 SS_sky130_fd_sc_hd__tapvpwrvgnd_1
XFILLER_51_335 vccd1 vssd1 vccd1 vssd1 SS_sky130_fd_sc_hd__fill_1
XFILLER_20_755 vccd1 vssd1 vccd1 vssd1 SS_sky130_fd_sc_hd__fill_1
Xclkload8 vssd1 vccd1 clkload8/A clkload8/X vccd1 vssd1 SS_sky130_fd_sc_hd__clkbuf_4
XFILLER_109_109 vssd1 vccd1 vccd1 vssd1 SS_sky130_fd_sc_hd__fill_2
XFILLER_20_788 vssd1 vccd1 vccd1 vssd1 SS_sky130_fd_sc_hd__fill_4
XTAP_TAPCELL_ROW_30_750 vccd1 vssd1 SS_sky130_fd_sc_hd__tapvpwrvgnd_1
XFILLER_118_643 vccd1 vssd1 vccd1 vssd1 SS_sky130_fd_sc_hd__fill_1
X_0999_ vssd1 vccd1 vccd1 vssd1 wire253/X input37/X _1532_/D _1461_/C1 _0998_/X SS_sky130_fd_sc_hd__o211a_2
XTAP_TAPCELL_ROW_76_1435 vccd1 vssd1 SS_sky130_fd_sc_hd__tapvpwrvgnd_1
XTAP_TAPCELL_ROW_76_1446 vccd1 vssd1 SS_sky130_fd_sc_hd__tapvpwrvgnd_1
XFILLER_133_613 vssd1 vccd1 vccd1 vssd1 SS_sky130_fd_sc_hd__fill_2
XFILLER_59_39 vssd1 vccd1 vssd1 vccd1 SS_sky130_ef_sc_hd__decap_40_12
XFILLER_105_337 vssd1 vccd1 vccd1 vssd1 SS_sky130_fd_sc_hd__fill_4
Xfanout223 vssd1 vccd1 vccd1 vssd1 _1330_/B _1338_/B SS_sky130_fd_sc_hd__clkdlybuf4s25_1
XFILLER_86_221 vssd1 vccd1 vssd1 vccd1 SS_sky130_ef_sc_hd__decap_40_12
XFILLER_132_189 vssd1 vccd1 vccd1 vssd1 SS_sky130_fd_sc_hd__fill_4
Xfanout234 vssd1 vccd1 vccd1 vssd1 _1145_/Y _1195_/A2 SS_sky130_fd_sc_hd__clkdlybuf4s25_1
XFILLER_75_27 vssd1 vccd1 vssd1 vccd1 SS_sky130_ef_sc_hd__decap_40_12
XFILLER_86_265 vssd1 vccd1 vssd1 vccd1 SS_sky130_ef_sc_hd__decap_40_12
XFILLER_87_777 vssd1 vccd1 vccd1 vssd1 SS_sky130_fd_sc_hd__fill_4
XFILLER_28_811 vccd1 vssd1 vccd1 vssd1 SS_sky130_fd_sc_hd__fill_1
XFILLER_87_799 vccd1 vssd1 vccd1 vssd1 SS_sky130_fd_sc_hd__fill_1
XFILLER_39_181 vssd1 vccd1 vssd1 vccd1 SS_sky130_ef_sc_hd__decap_40_12
XFILLER_15_505 vssd1 vccd1 vssd1 vccd1 SS_sky130_ef_sc_hd__decap_40_12
XTAP_TAPCELL_ROW_38_872 vccd1 vssd1 SS_sky130_fd_sc_hd__tapvpwrvgnd_1
XTAP_TAPCELL_ROW_120_2101 vccd1 vssd1 SS_sky130_fd_sc_hd__tapvpwrvgnd_1
XFILLER_54_195 vccd1 vssd1 vccd1 vssd1 SS_sky130_fd_sc_hd__fill_1
XFILLER_70_633 vssd1 vccd1 vccd1 vssd1 SS_sky130_fd_sc_hd__fill_2
XFILLER_42_357 vssd1 vccd1 vccd1 vssd1 SS_sky130_fd_sc_hd__fill_4
XFILLER_24_53 vssd1 vccd1 vssd1 vccd1 SS_sky130_ef_sc_hd__decap_40_12
XFILLER_10_221 vssd1 vccd1 vssd1 vccd1 SS_sky130_ef_sc_hd__decap_40_12
XFILLER_24_97 vssd1 vccd1 vssd1 vccd1 SS_sky130_ef_sc_hd__decap_40_12
XFILLER_10_265 vssd1 vccd1 vssd1 vccd1 SS_sky130_ef_sc_hd__decap_40_12
XTAP_TAPCELL_ROW_118_2074 vccd1 vssd1 SS_sky130_fd_sc_hd__tapvpwrvgnd_1
XTAP_TAPCELL_ROW_118_2063 vccd1 vssd1 SS_sky130_fd_sc_hd__tapvpwrvgnd_1
XFILLER_109_610 vssd1 vccd1 vccd1 vssd1 SS_sky130_fd_sc_hd__fill_4
XFILLER_40_41 vssd1 vccd1 vssd1 vccd1 SS_sky130_ef_sc_hd__decap_40_12
XFILLER_136_451 vssd1 vccd1 vssd1 vccd1 SS_sky130_ef_sc_hd__decap_40_12
XFILLER_40_85 vssd1 vccd1 vssd1 vccd1 SS_sky130_ef_sc_hd__decap_40_12
XFILLER_124_613 vssd1 vccd1 vccd1 vssd1 SS_sky130_fd_sc_hd__fill_8
XFILLER_108_153 vssd1 vccd1 vssd1 vccd1 SS_sky130_ef_sc_hd__decap_40_12
XTAP_TAPCELL_ROW_131_2263 vccd1 vssd1 SS_sky130_fd_sc_hd__tapvpwrvgnd_1
XFILLER_108_197 vssd1 vccd1 vssd1 vccd1 SS_sky130_ef_sc_hd__decap_40_12
XFILLER_2_475 vccd1 vssd1 vccd1 vssd1 SS_sky130_fd_sc_hd__fill_1
XFILLER_123_167 vccd1 vssd1 vccd1 vssd1 SS_sky130_fd_sc_hd__fill_1
XFILLER_77_221 vssd1 vccd1 vccd1 vssd1 SS_sky130_fd_sc_hd__fill_2
XFILLER_78_755 vccd1 vssd1 vccd1 vssd1 SS_sky130_fd_sc_hd__fill_1
XFILLER_65_405 vssd1 vccd1 vssd1 vccd1 SS_sky130_ef_sc_hd__decap_40_12
XFILLER_1_57 vssd1 vccd1 vssd1 vccd1 SS_sky130_ef_sc_hd__decap_40_12
XFILLER_18_321 vssd1 vccd1 vssd1 vccd1 SS_sky130_ef_sc_hd__decap_40_12
XFILLER_65_449 vssd1 vccd1 vccd1 vssd1 SS_sky130_fd_sc_hd__fill_2
XFILLER_18_365 vssd1 vccd1 vssd1 vccd1 SS_sky130_ef_sc_hd__decap_40_12
XFILLER_34_803 vccd1 vssd1 vccd1 vssd1 SS_sky130_fd_sc_hd__fill_1
XTAP_TAPCELL_ROW_47_1003 vccd1 vssd1 SS_sky130_fd_sc_hd__tapvpwrvgnd_1
XFILLER_65_93 vssd1 vccd1 vssd1 vccd1 SS_sky130_ef_sc_hd__decap_40_12
XTAP_TAPCELL_ROW_16_533 vccd1 vssd1 SS_sky130_fd_sc_hd__tapvpwrvgnd_1
XFILLER_33_335 vccd1 vssd1 vccd1 vssd1 SS_sky130_fd_sc_hd__fill_1
XFILLER_60_121 vssd1 vccd1 vssd1 vccd1 SS_sky130_ef_sc_hd__decap_40_12
XTAP_TAPCELL_ROW_16_544 vccd1 vssd1 SS_sky130_fd_sc_hd__tapvpwrvgnd_1
XFILLER_60_165 vssd1 vccd1 vssd1 vccd1 SS_sky130_ef_sc_hd__decap_40_12
XTAP_TAPCELL_ROW_60_1203 vccd1 vssd1 SS_sky130_fd_sc_hd__tapvpwrvgnd_1
XFILLER_81_81 vssd1 vccd1 vssd1 vccd1 SS_sky130_ef_sc_hd__decap_40_12
X_0922_ vssd1 vccd1 vssd1 vccd1 wire435/X _1466_/A _0921_/X _0922_/X SS_sky130_fd_sc_hd__a21o_2
X_0853_ vssd1 vccd1 vssd1 vccd1 _1013_/A _1555_/Q _0851_/X _0852_/X _0853_/X _0751_/X
+ SS_sky130_fd_sc_hd__a2111o_2
XFILLER_60_3 vssd1 vccd1 vssd1 vccd1 SS_sky130_ef_sc_hd__decap_40_12
XFILLER_6_781 vssd1 vccd1 vssd1 vccd1 SS_sky130_ef_sc_hd__decap_40_12
X_0784_ vccd1 vssd1 vccd1 vssd1 _0783_/X _1831_/A wire424/X _1640_/Q wire430/X _0784_/X
+ SS_sky130_fd_sc_hd__a221o_2
XFILLER_127_473 vssd1 vccd1 vccd1 vssd1 SS_sky130_fd_sc_hd__fill_4
XTAP_TAPCELL_ROW_58_1165 vccd1 vssd1 SS_sky130_fd_sc_hd__tapvpwrvgnd_1
XTAP_TAPCELL_ROW_58_1176 vccd1 vssd1 SS_sky130_fd_sc_hd__tapvpwrvgnd_1
XFILLER_102_307 vccd1 vssd1 vccd1 vssd1 SS_sky130_fd_sc_hd__fill_1
XFILLER_68_221 vssd1 vccd1 vssd1 vccd1 SS_sky130_ef_sc_hd__decap_40_12
X_1405_ vssd1 vccd1 vccd1 vssd1 _1405_/A2 input43/X _1405_/X _1471_/C1 _1404_/X SS_sky130_fd_sc_hd__o211a_2
XFILLER_114_189 vssd1 vccd1 vccd1 vssd1 SS_sky130_fd_sc_hd__fill_4
XFILLER_111_841 vccd1 vssd1 vccd1 vssd1 SS_sky130_fd_sc_hd__fill_1
XFILLER_111_830 vccd1 vssd1 vccd1 vssd1 SS_sky130_fd_sc_hd__fill_1
XFILLER_96_530 vssd1 vccd1 vccd1 vssd1 SS_sky130_fd_sc_hd__fill_2
XFILLER_68_265 vssd1 vccd1 vssd1 vccd1 SS_sky130_ef_sc_hd__decap_40_12
XFILLER_69_777 vssd1 vccd1 vccd1 vssd1 SS_sky130_fd_sc_hd__fill_4
XTAP_TAPCELL_ROW_71_1365 vccd1 vssd1 SS_sky130_fd_sc_hd__tapvpwrvgnd_1
X_1336_ vccd1 vssd1 vccd1 vssd1 _1336_/X _1336_/A _1338_/B SS_sky130_fd_sc_hd__or2_2
Xinput1 vssd1 vccd1 vccd1 vssd1 adc_data[0] input1/X SS_sky130_fd_sc_hd__clkdlybuf4s25_1
XFILLER_84_725 vssd1 vccd1 vssd1 vccd1 SS_sky130_ef_sc_hd__decap_40_12
XFILLER_110_362 vssd1 vccd1 vccd1 vssd1 SS_sky130_fd_sc_hd__fill_2
X_1267_ vssd1 vccd1 vccd1 vssd1 _1267_/A2 input39/X _1662_/D _1403_/C1 _1266_/X SS_sky130_fd_sc_hd__o211a_2
XFILLER_37_685 vssd1 vccd1 vssd1 vccd1 SS_sky130_ef_sc_hd__decap_40_12
XFILLER_83_279 vccd1 vssd1 vccd1 vssd1 SS_sky130_fd_sc_hd__fill_1
X_1198_ vccd1 vssd1 vccd1 vssd1 _1198_/X _1198_/A _1208_/B SS_sky130_fd_sc_hd__or2_2
XTAP_TAPCELL_ROW_35_820 vccd1 vssd1 SS_sky130_fd_sc_hd__tapvpwrvgnd_1
XTAP_TAPCELL_ROW_35_831 vccd1 vssd1 SS_sky130_fd_sc_hd__tapvpwrvgnd_1
XFILLER_36_195 vccd1 vssd1 vccd1 vssd1 SS_sky130_fd_sc_hd__fill_1
XFILLER_64_493 vssd1 vccd1 vccd1 vssd1 SS_sky130_fd_sc_hd__fill_2
XFILLER_24_357 vssd1 vccd1 vccd1 vssd1 SS_sky130_fd_sc_hd__fill_4
XFILLER_51_165 vssd1 vccd1 vccd1 vssd1 SS_sky130_fd_sc_hd__fill_2
XFILLER_61_18 vssd1 vccd1 vssd1 vccd1 SS_sky130_ef_sc_hd__decap_40_12
XFILLER_101_69 vssd1 vccd1 vssd1 vccd1 SS_sky130_ef_sc_hd__decap_40_12
XFILLER_138_727 vccd1 vssd1 vccd1 vssd1 SS_sky130_fd_sc_hd__fill_1
XFILLER_20_585 vssd1 vccd1 vccd1 vssd1 SS_sky130_fd_sc_hd__fill_2
XFILLER_3_217 vssd1 vccd1 vccd1 vssd1 SS_sky130_fd_sc_hd__fill_4
XFILLER_133_443 vssd1 vccd1 vccd1 vssd1 SS_sky130_fd_sc_hd__fill_4
XFILLER_106_657 vssd1 vccd1 vccd1 vssd1 SS_sky130_fd_sc_hd__fill_4
XFILLER_10_77 vssd1 vccd1 vccd1 vssd1 SS_sky130_fd_sc_hd__fill_4
XFILLER_106_679 vssd1 vccd1 vssd1 vccd1 SS_sky130_ef_sc_hd__decap_40_12
XFILLER_105_167 vccd1 vssd1 vccd1 vssd1 SS_sky130_fd_sc_hd__fill_1
XFILLER_59_221 vssd1 vccd1 vccd1 vssd1 SS_sky130_fd_sc_hd__fill_2
XFILLER_86_26 vssd1 vccd1 vccd1 vssd1 SS_sky130_fd_sc_hd__fill_2
XFILLER_126_77 vssd1 vccd1 vccd1 vssd1 SS_sky130_fd_sc_hd__fill_4
XFILLER_120_137 vssd1 vccd1 vccd1 vssd1 SS_sky130_fd_sc_hd__fill_2
XFILLER_87_563 vccd1 vssd1 vccd1 vssd1 SS_sky130_fd_sc_hd__fill_1
XTAP_TAPCELL_ROW_89_1637 vccd1 vssd1 SS_sky130_fd_sc_hd__tapvpwrvgnd_1
XFILLER_101_373 vssd1 vccd1 vssd1 vccd1 SS_sky130_ef_sc_hd__decap_40_12
XFILLER_28_641 vssd1 vccd1 vccd1 vssd1 SS_sky130_fd_sc_hd__fill_2
XFILLER_75_769 vssd1 vccd1 vssd1 vccd1 SS_sky130_ef_sc_hd__decap_40_12
XFILLER_62_419 vccd1 vssd1 vccd1 vssd1 SS_sky130_fd_sc_hd__fill_1
XFILLER_15_335 vccd1 vssd1 vccd1 vssd1 SS_sky130_fd_sc_hd__fill_1
XFILLER_42_121 vssd1 vccd1 vssd1 vccd1 SS_sky130_ef_sc_hd__decap_40_12
XFILLER_55_482 vssd1 vccd1 vccd1 vssd1 SS_sky130_fd_sc_hd__fill_8
XFILLER_30_305 vssd1 vccd1 vccd1 vssd1 SS_sky130_fd_sc_hd__fill_2
XFILLER_42_165 vssd1 vccd1 vssd1 vccd1 SS_sky130_ef_sc_hd__decap_40_12
XTAP_TAPCELL_ROW_100_1804 vccd1 vssd1 SS_sky130_fd_sc_hd__tapvpwrvgnd_1
XFILLER_11_541 vssd1 vccd1 vssd1 vccd1 SS_sky130_ef_sc_hd__decap_40_12
XFILLER_129_727 vccd1 vssd1 vccd1 vssd1 SS_sky130_fd_sc_hd__fill_1
XFILLER_7_501 vssd1 vccd1 vccd1 vssd1 SS_sky130_fd_sc_hd__fill_2
XFILLER_11_585 vssd1 vccd1 vssd1 vccd1 SS_sky130_ef_sc_hd__decap_40_12
Xwire421 vccd1 vssd1 wire421/X wire421/A vccd1 vssd1 SS_sky130_fd_sc_hd__buf_4
Xwire410 vccd1 vssd1 vssd1 vccd1 wire410/A analog_ctrl[71] SS_sky130_fd_sc_hd__buf_12
Xwire443 vccd1 vssd1 wire443/X wire443/A vccd1 vssd1 SS_sky130_fd_sc_hd__buf_4
Xwire454 vccd1 vssd1 wire454/X wire454/A vccd1 vssd1 SS_sky130_fd_sc_hd__buf_4
Xwire498 vccd1 vssd1 wire498/X wire498/A vccd1 vssd1 SS_sky130_fd_sc_hd__buf_4
XFILLER_124_421 vssd1 vccd1 vssd1 vccd1 SS_sky130_ef_sc_hd__decap_40_12
Xload_slew437 vccd1 vssd1 _0874_/A2 _1409_/A vccd1 vssd1 SS_sky130_fd_sc_hd__buf_4
XFILLER_97_349 vssd1 vccd1 vccd1 vssd1 SS_sky130_fd_sc_hd__fill_8
Xload_slew459 vccd1 vssd1 _1457_/C1 _1327_/C1 vccd1 vssd1 SS_sky130_fd_sc_hd__buf_4
XTAP_TAPCELL_ROW_111_1966 vccd1 vssd1 SS_sky130_fd_sc_hd__tapvpwrvgnd_1
XFILLER_111_137 vssd1 vccd1 vssd1 vccd1 SS_sky130_ef_sc_hd__decap_40_12
XTAP_TAPCELL_ROW_53_1095 vccd1 vssd1 SS_sky130_fd_sc_hd__tapvpwrvgnd_1
XFILLER_19_641 vssd1 vccd1 vssd1 vccd1 SS_sky130_ef_sc_hd__decap_40_12
X_1121_ vssd1 vccd1 vccd1 vssd1 wire241/X input32/X _1591_/D wire467/X _1120_/X SS_sky130_fd_sc_hd__o211a_2
XFILLER_66_769 vssd1 vccd1 vssd1 vccd1 SS_sky130_ef_sc_hd__decap_40_12
XFILLER_76_81 vssd1 vccd1 vccd1 vssd1 SS_sky130_fd_sc_hd__fill_2
XFILLER_19_685 vssd1 vccd1 vccd1 vssd1 SS_sky130_fd_sc_hd__fill_2
XFILLER_65_279 vccd1 vssd1 vccd1 vssd1 SS_sky130_fd_sc_hd__fill_1
X_1052_ vccd1 vssd1 vccd1 vssd1 _1052_/X _1052_/A _1076_/B SS_sky130_fd_sc_hd__or2_2
XFILLER_18_195 vccd1 vssd1 vccd1 vssd1 SS_sky130_fd_sc_hd__fill_1
XFILLER_46_493 vssd1 vccd1 vccd1 vssd1 SS_sky130_fd_sc_hd__fill_2
XFILLER_80_249 vssd1 vccd1 vccd1 vssd1 SS_sky130_fd_sc_hd__fill_2
XFILLER_21_305 vssd1 vccd1 vssd1 vccd1 SS_sky130_ef_sc_hd__decap_40_12
XFILLER_33_165 vssd1 vccd1 vccd1 vssd1 SS_sky130_fd_sc_hd__fill_2
XFILLER_34_699 vccd1 vssd1 vccd1 vssd1 SS_sky130_fd_sc_hd__fill_1
XFILLER_21_349 vssd1 vccd1 vssd1 vccd1 SS_sky130_ef_sc_hd__decap_40_12
X_0905_ vccd1 vssd1 vccd1 vssd1 _1532_/Q _0930_/B1 _1756_/Q _1409_/A _0907_/B SS_sky130_fd_sc_hd__a22o_2
XFILLER_119_237 vssd1 vccd1 vssd1 vccd1 SS_sky130_ef_sc_hd__decap_40_12
X_1885_ vccd1 vssd1 _1885_/X _1885_/A vccd1 vssd1 SS_sky130_fd_sc_hd__buf_2
X_0836_ vccd1 vssd1 vssd1 vccd1 _0833_/X _0835_/X _0860_/A2 hold812/X _1488_/D _1445_/C1
+ SS_sky130_fd_sc_hd__o221a_2
XFILLER_128_793 vssd1 vccd1 vccd1 vssd1 SS_sky130_fd_sc_hd__fill_2
X_0767_ vccd1 vssd1 vccd1 vssd1 _1833_/A wire421/X _1637_/Q wire430/X _0767_/X SS_sky130_fd_sc_hd__a22o_2
XFILLER_127_281 vssd1 vccd1 vssd1 vccd1 SS_sky130_ef_sc_hd__decap_40_12
XFILLER_0_209 vssd1 vccd1 vssd1 vccd1 SS_sky130_ef_sc_hd__decap_40_12
XFILLER_88_305 vssd1 vccd1 vccd1 vssd1 SS_sky130_fd_sc_hd__fill_2
XFILLER_89_817 vccd1 vssd1 vccd1 vssd1 SS_sky130_fd_sc_hd__fill_1
XFILLER_115_465 vssd1 vccd1 vccd1 vssd1 SS_sky130_fd_sc_hd__fill_2
XFILLER_130_413 vssd1 vccd1 vccd1 vssd1 SS_sky130_fd_sc_hd__fill_4
XFILLER_103_649 vssd1 vccd1 vssd1 vccd1 SS_sky130_ef_sc_hd__decap_40_12
XPHY_EDGE_ROW_102_Left_241 vccd1 vssd1 vccd1 vssd1 SS_sky130_fd_sc_hd__decap_3
XFILLER_69_541 vssd1 vccd1 vssd1 vccd1 SS_sky130_ef_sc_hd__decap_40_12
XFILLER_130_457 vssd1 vccd1 vssd1 vccd1 SS_sky130_ef_sc_hd__decap_40_12
XFILLER_102_137 vssd1 vccd1 vccd1 vssd1 SS_sky130_fd_sc_hd__fill_2
XFILLER_29_405 vssd1 vccd1 vssd1 vccd1 SS_sky130_ef_sc_hd__decap_40_12
XFILLER_56_18 vssd1 vccd1 vccd1 vssd1 SS_sky130_fd_sc_hd__fill_8
XFILLER_56_29 vssd1 vccd1 vssd1 vccd1 SS_sky130_ef_sc_hd__decap_40_12
XFILLER_69_585 vssd1 vccd1 vssd1 vccd1 SS_sky130_ef_sc_hd__decap_40_12
XFILLER_111_671 vccd1 vssd1 vccd1 vssd1 SS_sky130_fd_sc_hd__fill_1
XFILLER_29_449 vssd1 vccd1 vssd1 vccd1 SS_sky130_ef_sc_hd__decap_40_12
X_1319_ vssd1 vccd1 vccd1 vssd1 _1319_/A2 input32/X _1687_/D wire467/X _1318_/X SS_sky130_fd_sc_hd__o211a_2
XFILLER_84_533 vssd1 vccd1 vssd1 vccd1 SS_sky130_ef_sc_hd__decap_40_12
XFILLER_44_419 vccd1 vssd1 vccd1 vssd1 SS_sky130_fd_sc_hd__fill_1
XFILLER_71_205 vssd1 vccd1 vssd1 vccd1 SS_sky130_ef_sc_hd__decap_40_12
XFILLER_37_493 vssd1 vccd1 vccd1 vssd1 SS_sky130_fd_sc_hd__fill_8
XFILLER_71_249 vssd1 vccd1 vssd1 vccd1 SS_sky130_ef_sc_hd__decap_40_12
XFILLER_13_817 vccd1 vssd1 vccd1 vssd1 SS_sky130_fd_sc_hd__fill_1
XFILLER_24_121 vssd1 vccd1 vssd1 vccd1 SS_sky130_ef_sc_hd__decap_40_12
XFILLER_25_655 vssd1 vccd1 vccd1 vssd1 SS_sky130_fd_sc_hd__fill_2
XFILLER_52_441 vssd1 vccd1 vccd1 vssd1 SS_sky130_fd_sc_hd__fill_8
XTAP_TAPCELL_ROW_84_1556 vccd1 vssd1 SS_sky130_fd_sc_hd__tapvpwrvgnd_1
XTAP_TAPCELL_ROW_84_1567 vccd1 vssd1 SS_sky130_fd_sc_hd__tapvpwrvgnd_1
XFILLER_12_305 vssd1 vccd1 vccd1 vssd1 SS_sky130_fd_sc_hd__fill_2
XFILLER_24_165 vssd1 vccd1 vssd1 vccd1 SS_sky130_ef_sc_hd__decap_40_12
XFILLER_52_474 vssd1 vccd1 vccd1 vssd1 SS_sky130_fd_sc_hd__fill_2
XPHY_EDGE_ROW_111_Left_250 vccd1 vssd1 vccd1 vssd1 SS_sky130_fd_sc_hd__decap_3
XFILLER_8_309 vssd1 vccd1 vssd1 vccd1 SS_sky130_ef_sc_hd__decap_40_12
XFILLER_40_669 vssd1 vccd1 vssd1 vccd1 SS_sky130_ef_sc_hd__decap_40_12
XFILLER_138_557 vssd1 vccd1 vccd1 vssd1 SS_sky130_fd_sc_hd__fill_2
XFILLER_21_54 vssd1 vccd1 vccd1 vssd1 SS_sky130_fd_sc_hd__fill_2
XFILLER_119_771 vssd1 vccd1 vssd1 vccd1 SS_sky130_ef_sc_hd__decap_40_12
XTAP_TAPCELL_ROW_115_2022 vccd1 vssd1 SS_sky130_fd_sc_hd__tapvpwrvgnd_1
XFILLER_106_421 vssd1 vccd1 vssd1 vccd1 SS_sky130_ef_sc_hd__decap_40_12
XFILLER_79_305 vssd1 vccd1 vssd1 vccd1 SS_sky130_ef_sc_hd__decap_40_12
XFILLER_106_454 vssd1 vccd1 vssd1 vccd1 SS_sky130_ef_sc_hd__decap_40_12
XFILLER_133_273 vssd1 vccd1 vccd1 vssd1 SS_sky130_fd_sc_hd__fill_4
XFILLER_134_796 vssd1 vccd1 vccd1 vssd1 SS_sky130_fd_sc_hd__fill_2
XFILLER_97_69 vssd1 vccd1 vssd1 vccd1 SS_sky130_ef_sc_hd__decap_40_12
XFILLER_0_765 vssd1 vccd1 vssd1 vccd1 SS_sky130_ef_sc_hd__decap_40_12
Xoutput190 vccd1 vssd1 wire365/A _1502_/Q vccd1 vssd1 SS_sky130_fd_sc_hd__buf_4
XFILLER_48_725 vssd1 vccd1 vssd1 vccd1 SS_sky130_ef_sc_hd__decap_40_12
XFILLER_87_371 vccd1 vssd1 vccd1 vssd1 SS_sky130_fd_sc_hd__fill_1
XFILLER_102_682 vssd1 vccd1 vssd1 vccd1 SS_sky130_ef_sc_hd__decap_40_12
XFILLER_48_769 vssd1 vccd1 vssd1 vccd1 SS_sky130_ef_sc_hd__decap_40_12
XFILLER_87_393 vssd1 vccd1 vssd1 vccd1 SS_sky130_ef_sc_hd__decap_40_12
XFILLER_101_181 vssd1 vccd1 vssd1 vccd1 SS_sky130_ef_sc_hd__decap_40_12
XFILLER_47_279 vccd1 vssd1 vccd1 vssd1 SS_sky130_fd_sc_hd__fill_1
XTAP_TAPCELL_ROW_126_2184 vccd1 vssd1 SS_sky130_fd_sc_hd__tapvpwrvgnd_1
XTAP_TAPCELL_ROW_126_2195 vccd1 vssd1 SS_sky130_fd_sc_hd__tapvpwrvgnd_1
XFILLER_16_677 vssd1 vccd1 vccd1 vssd1 SS_sky130_fd_sc_hd__fill_2
XFILLER_62_249 vssd1 vccd1 vccd1 vssd1 SS_sky130_fd_sc_hd__fill_2
XFILLER_90_569 vssd1 vccd1 vssd1 vccd1 SS_sky130_ef_sc_hd__decap_40_12
XFILLER_15_165 vssd1 vccd1 vccd1 vssd1 SS_sky130_fd_sc_hd__fill_2
XTAP_TAPCELL_ROW_26_683 vccd1 vssd1 SS_sky130_fd_sc_hd__tapvpwrvgnd_1
XFILLER_31_603 vssd1 vccd1 vssd1 vccd1 SS_sky130_ef_sc_hd__decap_40_12
XFILLER_43_485 vssd1 vccd1 vssd1 vccd1 SS_sky130_ef_sc_hd__decap_40_12
XTAP_TAPCELL_ROW_26_694 vccd1 vssd1 SS_sky130_fd_sc_hd__tapvpwrvgnd_1
XFILLER_62_83 vccd1 vssd1 vccd1 vssd1 SS_sky130_fd_sc_hd__fill_1
XFILLER_11_393 vssd1 vccd1 vssd1 vccd1 SS_sky130_ef_sc_hd__decap_40_12
Xwire284 vccd1 vssd1 vssd1 vccd1 wire284/A analog_ctrl[12] SS_sky130_fd_sc_hd__buf_12
Xwire273 vccd1 vssd1 vssd1 vccd1 wire273/A analog_ctrl[22] SS_sky130_fd_sc_hd__buf_12
Xwire262 vccd1 vssd1 vssd1 vccd1 wire262/A analog_ctrl[32] SS_sky130_fd_sc_hd__buf_12
X_1670_ _1894_/A _1762_/CLK _1670_/D vccd1 vssd1 vccd1 vssd1 SS_sky130_fd_sc_hd__dfxtp_2
Xwire295 vccd1 vssd1 vssd1 vccd1 wire295/A analog_ctrl[113] SS_sky130_fd_sc_hd__buf_12
XFILLER_109_281 vssd1 vccd1 vssd1 vccd1 SS_sky130_ef_sc_hd__decap_40_12
XTAP_TAPCELL_ROW_55_1124 vccd1 vssd1 SS_sky130_fd_sc_hd__tapvpwrvgnd_1
XFILLER_125_785 vssd1 vccd1 vssd1 vccd1 SS_sky130_ef_sc_hd__decap_40_12
XFILLER_124_251 vccd1 vssd1 vccd1 vssd1 SS_sky130_fd_sc_hd__fill_1
XFILLER_124_295 vccd1 vssd1 vccd1 vssd1 SS_sky130_fd_sc_hd__fill_1
XFILLER_98_625 vssd1 vccd1 vssd1 vccd1 SS_sky130_ef_sc_hd__decap_40_12
XFILLER_97_113 vssd1 vccd1 vssd1 vccd1 SS_sky130_ef_sc_hd__decap_40_12
Xload_slew212 vccd1 vssd1 _1369_/A2 _1405_/A2 vccd1 vssd1 SS_sky130_fd_sc_hd__buf_4
XFILLER_86_809 vssd1 vccd1 vccd1 vssd1 SS_sky130_fd_sc_hd__fill_2
XFILLER_112_457 vssd1 vccd1 vssd1 vccd1 SS_sky130_ef_sc_hd__decap_40_12
XFILLER_98_669 vssd1 vccd1 vccd1 vssd1 SS_sky130_fd_sc_hd__fill_4
Xload_slew256 vccd1 vssd1 _0985_/A2 fanout254/X vccd1 vssd1 SS_sky130_fd_sc_hd__buf_4
XFILLER_66_533 vccd1 vssd1 vccd1 vssd1 SS_sky130_fd_sc_hd__fill_1
XFILLER_26_419 vccd1 vssd1 vccd1 vssd1 SS_sky130_fd_sc_hd__fill_1
X_1104_ vccd1 vssd1 vccd1 vssd1 _1104_/X _1104_/A _1126_/B SS_sky130_fd_sc_hd__or2_2
XFILLER_53_205 vssd1 vccd1 vssd1 vccd1 SS_sky130_ef_sc_hd__decap_40_12
XFILLER_81_503 vccd1 vssd1 vccd1 vssd1 SS_sky130_fd_sc_hd__fill_1
XFILLER_93_374 vssd1 vccd1 vssd1 vccd1 SS_sky130_ef_sc_hd__decap_40_12
XFILLER_53_249 vssd1 vccd1 vssd1 vccd1 SS_sky130_ef_sc_hd__decap_40_12
X_1035_ vssd1 vccd1 vccd1 vssd1 _1051_/A2 wire501/X _1549_/D _1423_/C1 _1034_/X SS_sky130_fd_sc_hd__o211a_2
XTAP_TAPCELL_ROW_45_970 vccd1 vssd1 SS_sky130_fd_sc_hd__tapvpwrvgnd_1
XTAP_TAPCELL_ROW_45_981 vccd1 vssd1 SS_sky130_fd_sc_hd__tapvpwrvgnd_1
XTAP_TAPCELL_ROW_66_1286 vccd1 vssd1 SS_sky130_fd_sc_hd__tapvpwrvgnd_1
XTAP_TAPCELL_ROW_66_1297 vccd1 vssd1 SS_sky130_fd_sc_hd__tapvpwrvgnd_1
XFILLER_21_113 vssd1 vccd1 vssd1 vccd1 SS_sky130_ef_sc_hd__decap_40_12
XFILLER_22_669 vssd1 vccd1 vssd1 vccd1 SS_sky130_ef_sc_hd__decap_40_12
XFILLER_61_293 vssd1 vccd1 vssd1 vccd1 SS_sky130_ef_sc_hd__decap_40_12
X_1868_ vccd1 vssd1 _1868_/X _1868_/A vccd1 vssd1 SS_sky130_fd_sc_hd__buf_2
XFILLER_135_505 vssd1 vccd1 vssd1 vccd1 SS_sky130_ef_sc_hd__decap_40_12
X_0819_ vccd1 vssd1 vccd1 vssd1 _1550_/Q wire424/A _1710_/Q wire454/A _0819_/X SS_sky130_fd_sc_hd__a22o_2
Xhold810 _1490_/D _0848_/X vccd1 vssd1 vssd1 vccd1 SS_sky130_fd_sc_hd__dlygate4sd3_1
XFILLER_89_603 vssd1 vccd1 vssd1 vccd1 SS_sky130_ef_sc_hd__decap_40_12
XFILLER_1_529 vssd1 vccd1 vssd1 vccd1 SS_sky130_ef_sc_hd__decap_40_12
XFILLER_115_273 vssd1 vccd1 vccd1 vssd1 SS_sky130_fd_sc_hd__fill_4
XFILLER_107_57 vssd1 vccd1 vssd1 vccd1 SS_sky130_ef_sc_hd__decap_40_12
XFILLER_67_39 vssd1 vccd1 vssd1 vccd1 SS_sky130_ef_sc_hd__decap_40_12
XFILLER_130_221 vssd1 vccd1 vssd1 vccd1 SS_sky130_ef_sc_hd__decap_40_12
XFILLER_131_777 vssd1 vccd1 vccd1 vssd1 SS_sky130_fd_sc_hd__fill_4
XFILLER_103_446 vssd1 vccd1 vccd1 vssd1 SS_sky130_fd_sc_hd__fill_2
XFILLER_130_265 vssd1 vccd1 vssd1 vccd1 SS_sky130_ef_sc_hd__decap_40_12
XTAP_TAPCELL_ROW_4_356 vccd1 vssd1 SS_sky130_fd_sc_hd__tapvpwrvgnd_1
XTAP_TAPCELL_ROW_4_367 vccd1 vssd1 SS_sky130_fd_sc_hd__tapvpwrvgnd_1
XFILLER_69_393 vssd1 vccd1 vssd1 vccd1 SS_sky130_ef_sc_hd__decap_40_12
XFILLER_29_279 vccd1 vssd1 vccd1 vssd1 SS_sky130_fd_sc_hd__fill_1
XFILLER_45_706 vssd1 vccd1 vssd1 vccd1 SS_sky130_ef_sc_hd__decap_40_12
XFILLER_84_363 vccd1 vssd1 vccd1 vssd1 SS_sky130_fd_sc_hd__fill_1
XFILLER_72_547 vssd1 vccd1 vccd1 vssd1 SS_sky130_fd_sc_hd__fill_2
Xclkbuf_leaf_8_wb_clk_i _1756_/CLK clkbuf_leaf_9_wb_clk_i/A vccd1 vssd1 vssd1 vccd1
+ SS_sky130_fd_sc_hd__clkbuf_8
XFILLER_25_441 vssd1 vccd1 vccd1 vssd1 SS_sky130_fd_sc_hd__fill_4
XFILLER_44_249 vssd1 vccd1 vccd1 vssd1 SS_sky130_fd_sc_hd__fill_2
XFILLER_60_709 vssd1 vccd1 vccd1 vssd1 SS_sky130_fd_sc_hd__fill_2
XFILLER_16_65 vssd1 vccd1 vssd1 vccd1 SS_sky130_ef_sc_hd__decap_40_12
XFILLER_25_485 vssd1 vccd1 vssd1 vccd1 SS_sky130_ef_sc_hd__decap_40_12
XFILLER_40_433 vssd1 vccd1 vssd1 vccd1 SS_sky130_ef_sc_hd__decap_40_12
XFILLER_9_629 vssd1 vccd1 vssd1 vccd1 SS_sky130_ef_sc_hd__decap_40_12
XFILLER_13_669 vssd1 vccd1 vccd1 vssd1 SS_sky130_fd_sc_hd__fill_2
XTAP_TAPCELL_ROW_23_642 vccd1 vssd1 SS_sky130_fd_sc_hd__tapvpwrvgnd_1
XFILLER_40_477 vssd1 vccd1 vssd1 vccd1 SS_sky130_ef_sc_hd__decap_40_12
XFILLER_8_139 vccd1 vssd1 vccd1 vssd1 SS_sky130_fd_sc_hd__fill_1
XFILLER_32_53 vssd1 vccd1 vssd1 vccd1 SS_sky130_ef_sc_hd__decap_40_12
XFILLER_32_97 vssd1 vccd1 vssd1 vccd1 SS_sky130_ef_sc_hd__decap_40_12
XTAP_TAPCELL_ROW_97_1758 vccd1 vssd1 SS_sky130_fd_sc_hd__tapvpwrvgnd_1
XFILLER_4_301 vssd1 vccd1 vccd1 vssd1 SS_sky130_fd_sc_hd__fill_4
XFILLER_4_345 vssd1 vccd1 vssd1 vccd1 SS_sky130_ef_sc_hd__decap_40_12
XFILLER_106_251 vccd1 vssd1 vccd1 vssd1 SS_sky130_fd_sc_hd__fill_1
XFILLER_4_389 vssd1 vccd1 vssd1 vccd1 SS_sky130_ef_sc_hd__decap_40_12
XFILLER_79_113 vssd1 vccd1 vssd1 vccd1 SS_sky130_ef_sc_hd__decap_40_12
XFILLER_122_722 vssd1 vccd1 vssd1 vccd1 SS_sky130_ef_sc_hd__decap_40_12
XFILLER_107_785 vccd1 vssd1 vccd1 vssd1 SS_sky130_fd_sc_hd__fill_1
XFILLER_68_809 vssd1 vccd1 vccd1 vssd1 SS_sky130_fd_sc_hd__fill_2
XFILLER_121_221 vssd1 vccd1 vccd1 vssd1 SS_sky130_fd_sc_hd__fill_2
XFILLER_0_551 vccd1 vssd1 vccd1 vssd1 SS_sky130_fd_sc_hd__fill_1
XFILLER_0_573 vssd1 vccd1 vssd1 vccd1 SS_sky130_ef_sc_hd__decap_40_12
XTAP_TAPCELL_ROW_128_2213 vccd1 vssd1 SS_sky130_fd_sc_hd__tapvpwrvgnd_1
XTAP_TAPCELL_ROW_128_2224 vccd1 vssd1 SS_sky130_fd_sc_hd__tapvpwrvgnd_1
XFILLER_95_617 vssd1 vccd1 vssd1 vccd1 SS_sky130_ef_sc_hd__decap_40_12
XFILLER_48_533 vssd1 vccd1 vssd1 vccd1 SS_sky130_ef_sc_hd__decap_40_12
XTAP_TAPCELL_ROW_50_1043 vccd1 vssd1 SS_sky130_fd_sc_hd__tapvpwrvgnd_1
XTAP_TAPCELL_ROW_50_1054 vccd1 vssd1 SS_sky130_fd_sc_hd__tapvpwrvgnd_1
XFILLER_63_503 vccd1 vssd1 vccd1 vssd1 SS_sky130_fd_sc_hd__fill_1
XFILLER_35_205 vssd1 vccd1 vssd1 vccd1 SS_sky130_ef_sc_hd__decap_40_12
XFILLER_35_249 vssd1 vccd1 vssd1 vccd1 SS_sky130_ef_sc_hd__decap_40_12
XFILLER_90_355 vssd1 vccd1 vccd1 vssd1 SS_sky130_fd_sc_hd__fill_8
XTAP_TAPCELL_ROW_106_1887 vccd1 vssd1 SS_sky130_fd_sc_hd__tapvpwrvgnd_1
XFILLER_43_293 vssd1 vccd1 vssd1 vccd1 SS_sky130_ef_sc_hd__decap_40_12
XFILLER_73_93 vssd1 vccd1 vssd1 vccd1 SS_sky130_ef_sc_hd__decap_40_12
XFILLER_129_387 vssd1 vccd1 vccd1 vssd1 SS_sky130_fd_sc_hd__fill_4
XFILLER_117_505 vssd1 vccd1 vssd1 vccd1 SS_sky130_ef_sc_hd__decap_40_12
X_1722_ _1722_/Q _1753_/CLK _1722_/D vccd1 vssd1 vccd1 vssd1 SS_sky130_fd_sc_hd__dfxtp_2
XFILLER_7_161 vssd1 vccd1 vccd1 vssd1 SS_sky130_fd_sc_hd__fill_4
X_1653_ _1653_/Q _1751_/CLK _1653_/D vccd1 vssd1 vccd1 vssd1 SS_sky130_fd_sc_hd__dfxtp_2
XPHY_EDGE_ROW_9_Right_9 vccd1 vssd1 vccd1 vssd1 SS_sky130_fd_sc_hd__decap_3
XFILLER_132_519 vssd1 vccd1 vssd1 vccd1 SS_sky130_ef_sc_hd__decap_40_12
X_1584_ _1858_/A _1748_/CLK _1584_/D vccd1 vssd1 vccd1 vssd1 SS_sky130_fd_sc_hd__dfxtp_2
XFILLER_98_411 vssd1 vccd1 vccd1 vssd1 SS_sky130_fd_sc_hd__fill_8
XFILLER_59_809 vssd1 vccd1 vccd1 vssd1 SS_sky130_fd_sc_hd__fill_4
XFILLER_112_221 vssd1 vccd1 vssd1 vccd1 SS_sky130_ef_sc_hd__decap_40_12
XFILLER_98_433 vssd1 vccd1 vssd1 vccd1 SS_sky130_ef_sc_hd__decap_40_12
XFILLER_85_105 vssd1 vccd1 vccd1 vssd1 SS_sky130_fd_sc_hd__fill_4
XFILLER_112_265 vssd1 vccd1 vssd1 vccd1 SS_sky130_ef_sc_hd__decap_40_12
XPHY_EDGE_ROW_107_Right_107 vccd1 vssd1 vccd1 vssd1 SS_sky130_fd_sc_hd__decap_3
Xafe_wb_508 analog_io_out[0] afe_wb_508/HI vccd1 vssd1 vssd1 vccd1 SS_sky130_fd_sc_hd__conb_1
XFILLER_85_149 vssd1 vccd1 vssd1 vccd1 SS_sky130_ef_sc_hd__decap_40_12
XTAP_TAPCELL_ROW_1_315 vccd1 vssd1 SS_sky130_fd_sc_hd__tapvpwrvgnd_1
XFILLER_39_555 vssd1 vccd1 vccd1 vssd1 SS_sky130_fd_sc_hd__fill_4
Xafe_wb_519 analog_io_out[11] afe_wb_519/HI vccd1 vssd1 vssd1 vccd1 SS_sky130_fd_sc_hd__conb_1
XFILLER_94_661 vssd1 vccd1 vccd1 vssd1 SS_sky130_fd_sc_hd__fill_2
XFILLER_54_514 vssd1 vccd1 vccd1 vssd1 SS_sky130_fd_sc_hd__fill_2
XTAP_TAPCELL_ROW_68_1315 vccd1 vssd1 SS_sky130_fd_sc_hd__tapvpwrvgnd_1
XTAP_TAPCELL_ROW_68_1326 vccd1 vssd1 SS_sky130_fd_sc_hd__tapvpwrvgnd_1
XFILLER_26_249 vssd1 vccd1 vccd1 vssd1 SS_sky130_fd_sc_hd__fill_2
XFILLER_93_193 vssd1 vccd1 vssd1 vccd1 SS_sky130_ef_sc_hd__decap_40_12
X_1018_ vccd1 vssd1 vccd1 vssd1 _1018_/X _1828_/A _1050_/B SS_sky130_fd_sc_hd__or2_2
XFILLER_35_783 vccd1 vssd1 vccd1 vssd1 SS_sky130_fd_sc_hd__fill_1
XTAP_TAPCELL_ROW_81_1515 vccd1 vssd1 SS_sky130_fd_sc_hd__tapvpwrvgnd_1
XFILLER_22_433 vssd1 vccd1 vssd1 vccd1 SS_sky130_ef_sc_hd__decap_40_12
XFILLER_22_477 vssd1 vccd1 vssd1 vccd1 SS_sky130_ef_sc_hd__decap_40_12
XTAP_TAPCELL_ROW_20_601 vccd1 vssd1 SS_sky130_fd_sc_hd__tapvpwrvgnd_1
XFILLER_5_109 vssd1 vccd1 vccd1 vssd1 SS_sky130_fd_sc_hd__fill_2
XFILLER_2_805 vssd1 vccd1 vccd1 vssd1 SS_sky130_fd_sc_hd__fill_4
XTAP_TAPCELL_ROW_79_1488 vccd1 vssd1 SS_sky130_fd_sc_hd__tapvpwrvgnd_1
XTAP_TAPCELL_ROW_9_437 vccd1 vssd1 SS_sky130_fd_sc_hd__tapvpwrvgnd_1
Xhold640 _1424_/A _1902_/A vccd1 vssd1 vssd1 vccd1 SS_sky130_fd_sc_hd__dlygate4sd3_1
Xhold662 _1398_/A _1726_/Q vccd1 vssd1 vssd1 vccd1 SS_sky130_fd_sc_hd__dlygate4sd3_1
Xhold651 _1472_/A _1762_/Q vccd1 vssd1 vssd1 vccd1 SS_sky130_fd_sc_hd__dlygate4sd3_1
XFILLER_1_337 vssd1 vccd1 vssd1 vccd1 SS_sky130_ef_sc_hd__decap_40_12
XFILLER_131_541 vssd1 vccd1 vssd1 vccd1 SS_sky130_ef_sc_hd__decap_40_12
Xhold673 input40/A wbs_dat_i[28] vccd1 vssd1 vssd1 vccd1 SS_sky130_fd_sc_hd__dlygate4sd3_1
Xhold684 input38/A wbs_dat_i[26] vccd1 vssd1 vssd1 vccd1 SS_sky130_fd_sc_hd__dlygate4sd3_1
Xhold695 _1448_/A _1750_/Q vccd1 vssd1 vssd1 vccd1 SS_sky130_fd_sc_hd__dlygate4sd3_1
XFILLER_103_221 vssd1 vccd1 vccd1 vssd1 SS_sky130_fd_sc_hd__fill_2
XTAP_TAPCELL_ROW_92_1677 vccd1 vssd1 SS_sky130_fd_sc_hd__tapvpwrvgnd_1
XFILLER_77_617 vssd1 vccd1 vssd1 vccd1 SS_sky130_ef_sc_hd__decap_40_12
XFILLER_134_33 vssd1 vccd1 vccd1 vssd1 SS_sky130_fd_sc_hd__fill_2
XFILLER_94_15 vssd1 vccd1 vssd1 vccd1 SS_sky130_ef_sc_hd__decap_40_12
XFILLER_92_609 vssd1 vccd1 vccd1 vssd1 SS_sky130_fd_sc_hd__fill_4
XFILLER_17_205 vssd1 vccd1 vssd1 vccd1 SS_sky130_ef_sc_hd__decap_40_12
XTAP_TAPCELL_ROW_28_723 vccd1 vssd1 SS_sky130_fd_sc_hd__tapvpwrvgnd_1
XFILLER_73_823 vccd1 vssd1 vccd1 vssd1 SS_sky130_fd_sc_hd__fill_1
XFILLER_17_249 vssd1 vccd1 vssd1 vccd1 SS_sky130_ef_sc_hd__decap_40_12
XFILLER_26_750 vssd1 vccd1 vccd1 vssd1 SS_sky130_fd_sc_hd__fill_4
XFILLER_84_193 vssd1 vccd1 vccd1 vssd1 SS_sky130_fd_sc_hd__fill_2
XTAP_TAPCELL_ROW_123_2143 vccd1 vssd1 SS_sky130_fd_sc_hd__tapvpwrvgnd_1
XFILLER_72_377 vssd1 vccd1 vccd1 vssd1 SS_sky130_fd_sc_hd__fill_4
XFILLER_25_293 vssd1 vccd1 vssd1 vccd1 SS_sky130_ef_sc_hd__decap_40_12
XFILLER_43_30 vssd1 vccd1 vssd1 vccd1 SS_sky130_ef_sc_hd__decap_40_12
XFILLER_72_399 vssd1 vccd1 vssd1 vccd1 SS_sky130_ef_sc_hd__decap_40_12
XFILLER_41_797 vssd1 vccd1 vccd1 vssd1 SS_sky130_fd_sc_hd__fill_4
XFILLER_138_195 vccd1 vssd1 vccd1 vssd1 SS_sky130_fd_sc_hd__fill_1
XFILLER_5_665 vssd1 vccd1 vccd1 vssd1 SS_sky130_fd_sc_hd__fill_4
XFILLER_4_153 vssd1 vccd1 vssd1 vccd1 SS_sky130_ef_sc_hd__decap_40_12
XFILLER_4_197 vssd1 vccd1 vssd1 vccd1 SS_sky130_ef_sc_hd__decap_40_12
XFILLER_67_105 vssd1 vccd1 vccd1 vssd1 SS_sky130_fd_sc_hd__fill_4
XFILLER_110_725 vssd1 vccd1 vssd1 vccd1 SS_sky130_ef_sc_hd__decap_40_12
XFILLER_67_149 vssd1 vccd1 vssd1 vccd1 SS_sky130_ef_sc_hd__decap_40_12
XFILLER_83_609 vssd1 vccd1 vccd1 vssd1 SS_sky130_fd_sc_hd__fill_4
XFILLER_36_525 vssd1 vccd1 vccd1 vssd1 SS_sky130_fd_sc_hd__fill_4
XFILLER_48_363 vccd1 vssd1 vccd1 vssd1 SS_sky130_fd_sc_hd__fill_1
XFILLER_76_672 vssd1 vccd1 vssd1 vccd1 SS_sky130_ef_sc_hd__decap_40_12
XTAP_TAPCELL_ROW_108_1927 vccd1 vssd1 SS_sky130_fd_sc_hd__tapvpwrvgnd_1
XTAP_TAPCELL_ROW_108_1916 vccd1 vssd1 SS_sky130_fd_sc_hd__tapvpwrvgnd_1
XFILLER_75_193 vssd1 vccd1 vssd1 vccd1 SS_sky130_ef_sc_hd__decap_40_12
XFILLER_84_81 vssd1 vccd1 vccd1 vssd1 SS_sky130_fd_sc_hd__fill_2
XFILLER_90_141 vssd1 vccd1 vssd1 vccd1 SS_sky130_ef_sc_hd__decap_40_12
XFILLER_17_783 vccd1 vssd1 vccd1 vssd1 SS_sky130_fd_sc_hd__fill_1
XFILLER_51_517 vssd1 vccd1 vssd1 vccd1 SS_sky130_ef_sc_hd__decap_40_12
XFILLER_32_742 vssd1 vccd1 vssd1 vccd1 SS_sky130_ef_sc_hd__decap_40_12
XTAP_TAPCELL_ROW_63_1245 vccd1 vssd1 SS_sky130_fd_sc_hd__tapvpwrvgnd_1
XFILLER_90_3 vssd1 vccd1 vssd1 vccd1 SS_sky130_ef_sc_hd__decap_40_12
X_1705_ _1884_/A clkload7/A _1705_/D vccd1 vssd1 vccd1 vssd1 SS_sky130_fd_sc_hd__dfxtp_2
XFILLER_117_335 vccd1 vssd1 vccd1 vssd1 SS_sky130_fd_sc_hd__fill_1
X_1636_ _1636_/Q _1745_/CLK _1636_/D vccd1 vssd1 vccd1 vssd1 SS_sky130_fd_sc_hd__dfxtp_2
XFILLER_132_305 vssd1 vccd1 vccd1 vssd1 SS_sky130_fd_sc_hd__fill_2
XFILLER_125_390 vssd1 vccd1 vccd1 vssd1 SS_sky130_fd_sc_hd__fill_2
X_1567_ _1567_/Q _1760_/CLK _1567_/D vccd1 vssd1 vccd1 vssd1 SS_sky130_fd_sc_hd__dfxtp_2
XFILLER_99_753 vccd1 vssd1 vccd1 vssd1 SS_sky130_fd_sc_hd__fill_1
XFILLER_59_617 vssd1 vccd1 vssd1 vccd1 SS_sky130_ef_sc_hd__decap_40_12
Xfanout438 vssd1 vccd1 vccd1 vssd1 _0744_/X _1145_/A SS_sky130_fd_sc_hd__clkdlybuf4s25_1
Xfanout427 vssd1 vccd1 vccd1 vssd1 wire431/A _1211_/A SS_sky130_fd_sc_hd__clkdlybuf4s25_1
XFILLER_99_797 vssd1 vccd1 vssd1 vccd1 SS_sky130_ef_sc_hd__decap_40_12
XFILLER_86_425 vssd1 vccd1 vccd1 vssd1 SS_sky130_fd_sc_hd__fill_2
X_1498_ _1498_/Q _1754_/CLK _1498_/D vccd1 vssd1 vccd1 vssd1 SS_sky130_fd_sc_hd__dfxtp_2
Xfanout449 vssd1 vccd1 vccd1 vssd1 _0740_/X _1277_/A SS_sky130_fd_sc_hd__clkdlybuf4s25_1
XFILLER_74_609 vccd1 vssd1 vccd1 vssd1 SS_sky130_fd_sc_hd__fill_1
XFILLER_27_503 vccd1 vssd1 vccd1 vssd1 SS_sky130_fd_sc_hd__fill_1
XFILLER_39_385 vssd1 vccd1 vccd1 vssd1 SS_sky130_fd_sc_hd__fill_4
XFILLER_15_709 vssd1 vccd1 vccd1 vssd1 SS_sky130_fd_sc_hd__fill_2
XFILLER_54_333 vssd1 vccd1 vccd1 vssd1 SS_sky130_fd_sc_hd__fill_2
XFILLER_64_29 vssd1 vccd1 vssd1 vccd1 SS_sky130_ef_sc_hd__decap_40_12
XFILLER_66_193 vssd1 vccd1 vccd1 vssd1 SS_sky130_fd_sc_hd__fill_2
XFILLER_54_377 vssd1 vccd1 vssd1 vccd1 SS_sky130_ef_sc_hd__decap_40_12
XFILLER_82_686 vssd1 vccd1 vssd1 vccd1 SS_sky130_ef_sc_hd__decap_40_12
XFILLER_23_753 vssd1 vccd1 vssd1 vccd1 SS_sky130_ef_sc_hd__decap_40_12
XFILLER_23_797 vssd1 vccd1 vccd1 vssd1 SS_sky130_fd_sc_hd__fill_2
XFILLER_10_469 vssd1 vccd1 vccd1 vssd1 SS_sky130_fd_sc_hd__fill_4
XTAP_TAPCELL_ROW_33_792 vccd1 vssd1 SS_sky130_fd_sc_hd__tapvpwrvgnd_1
XFILLER_109_825 vssd1 vccd1 vccd1 vssd1 SS_sky130_fd_sc_hd__fill_2
XFILLER_89_15 vssd1 vccd1 vssd1 vccd1 SS_sky130_ef_sc_hd__decap_40_12
XFILLER_129_55 vccd1 vssd1 vccd1 vssd1 SS_sky130_fd_sc_hd__fill_1
XTAP_TAPCELL_ROW_94_1706 vccd1 vssd1 SS_sky130_fd_sc_hd__tapvpwrvgnd_1
XFILLER_124_817 vccd1 vssd1 vccd1 vssd1 SS_sky130_fd_sc_hd__fill_1
XFILLER_108_357 vssd1 vccd1 vccd1 vssd1 SS_sky130_fd_sc_hd__fill_4
XTAP_TAPCELL_ROW_94_1717 vccd1 vssd1 SS_sky130_fd_sc_hd__tapvpwrvgnd_1
XFILLER_2_613 vssd1 vccd1 vssd1 vccd1 SS_sky130_ef_sc_hd__decap_40_12
XFILLER_135_165 vssd1 vccd1 vccd1 vssd1 SS_sky130_fd_sc_hd__fill_2
XFILLER_136_699 vccd1 vssd1 vccd1 vssd1 SS_sky130_fd_sc_hd__fill_1
XFILLER_123_305 vssd1 vccd1 vccd1 vssd1 SS_sky130_fd_sc_hd__fill_4
XFILLER_2_657 vssd1 vccd1 vssd1 vccd1 SS_sky130_ef_sc_hd__decap_40_12
XFILLER_123_349 vssd1 vccd1 vccd1 vssd1 SS_sky130_fd_sc_hd__fill_2
XFILLER_1_167 vccd1 vssd1 vccd1 vssd1 SS_sky130_fd_sc_hd__fill_1
XFILLER_49_105 vssd1 vccd1 vccd1 vssd1 SS_sky130_fd_sc_hd__fill_4
XFILLER_77_447 vccd1 vssd1 vccd1 vssd1 SS_sky130_fd_sc_hd__fill_1
XFILLER_131_393 vssd1 vccd1 vssd1 vccd1 SS_sky130_ef_sc_hd__decap_40_12
XFILLER_38_41 vssd1 vccd1 vssd1 vccd1 SS_sky130_ef_sc_hd__decap_40_12
XFILLER_49_149 vssd1 vccd1 vssd1 vccd1 SS_sky130_ef_sc_hd__decap_40_12
XFILLER_77_469 vssd1 vccd1 vssd1 vccd1 SS_sky130_ef_sc_hd__decap_40_12
XFILLER_18_525 vssd1 vccd1 vccd1 vssd1 SS_sky130_fd_sc_hd__fill_4
XFILLER_38_85 vssd1 vccd1 vssd1 vccd1 SS_sky130_ef_sc_hd__decap_40_12
XFILLER_92_417 vssd1 vccd1 vccd1 vssd1 SS_sky130_fd_sc_hd__fill_2
XFILLER_18_569 vssd1 vccd1 vssd1 vccd1 SS_sky130_ef_sc_hd__decap_40_12
XFILLER_45_333 vssd1 vccd1 vccd1 vssd1 SS_sky130_fd_sc_hd__fill_2
XFILLER_57_193 vssd1 vccd1 vssd1 vccd1 SS_sky130_ef_sc_hd__decap_40_12
XFILLER_73_653 vssd1 vccd1 vssd1 vccd1 SS_sky130_ef_sc_hd__decap_40_12
XFILLER_33_517 vssd1 vccd1 vssd1 vccd1 SS_sky130_ef_sc_hd__decap_40_12
XFILLER_72_141 vssd1 vccd1 vssd1 vccd1 SS_sky130_ef_sc_hd__decap_40_12
XFILLER_73_697 vssd1 vccd1 vssd1 vccd1 SS_sky130_ef_sc_hd__decap_40_12
XFILLER_14_753 vssd1 vccd1 vccd1 vssd1 SS_sky130_fd_sc_hd__fill_2
XFILLER_41_561 vssd1 vccd1 vssd1 vccd1 SS_sky130_ef_sc_hd__decap_40_12
XTAP_TAPCELL_ROW_103_1846 vccd1 vssd1 SS_sky130_fd_sc_hd__tapvpwrvgnd_1
XFILLER_9_223 vccd1 vssd1 vccd1 vssd1 SS_sky130_fd_sc_hd__fill_1
XTAP_TAPCELL_ROW_136_2334 vccd1 vssd1 SS_sky130_fd_sc_hd__tapvpwrvgnd_1
XTAP_TAPCELL_ROW_136_2345 vccd1 vssd1 SS_sky130_fd_sc_hd__tapvpwrvgnd_1
XTAP_TAPCELL_ROW_11_464 vccd1 vssd1 SS_sky130_fd_sc_hd__tapvpwrvgnd_1
XFILLER_70_83 vccd1 vssd1 vccd1 vssd1 SS_sky130_fd_sc_hd__fill_1
Xclkload15 vssd1 vccd1 vccd1 vssd1 _1754_/CLK clkload15/Y SS_sky130_fd_sc_hd__clkinv_2
Xclkload26 vssd1 vccd1 vccd1 vssd1 _1727_/CLK clkload26/Y SS_sky130_fd_sc_hd__clkinv_2
XFILLER_127_666 vssd1 vccd1 vccd1 vssd1 SS_sky130_fd_sc_hd__fill_4
XFILLER_126_121 vssd1 vccd1 vssd1 vccd1 SS_sky130_ef_sc_hd__decap_40_12
XFILLER_5_473 vssd1 vccd1 vssd1 vccd1 SS_sky130_ef_sc_hd__decap_40_12
XFILLER_126_165 vssd1 vccd1 vssd1 vccd1 SS_sky130_ef_sc_hd__decap_40_12
XFILLER_114_327 vccd1 vssd1 vccd1 vssd1 SS_sky130_fd_sc_hd__fill_1
XFILLER_79_81 vssd1 vccd1 vssd1 vccd1 SS_sky130_ef_sc_hd__decap_40_12
XFILLER_130_809 vssd1 vccd1 vccd1 vssd1 SS_sky130_fd_sc_hd__fill_2
X_1421_ vssd1 vccd1 vccd1 vssd1 _1439_/A2 input47/X _1736_/D _1439_/C1 _1420_/X SS_sky130_fd_sc_hd__o211a_2
XFILLER_96_701 vssd1 vccd1 vssd1 vccd1 SS_sky130_ef_sc_hd__decap_40_12
X_1352_ vccd1 vssd1 vccd1 vssd1 _1352_/X _1352_/A _1404_/B SS_sky130_fd_sc_hd__or2_2
XFILLER_110_533 vssd1 vccd1 vssd1 vccd1 SS_sky130_ef_sc_hd__decap_40_12
X_1283_ vssd1 vccd1 vccd1 vssd1 _1337_/A2 input42/X _1669_/D _1417_/C1 _1282_/X SS_sky130_fd_sc_hd__o211a_2
XFILLER_68_469 vssd1 vccd1 vccd1 vssd1 SS_sky130_fd_sc_hd__fill_4
XFILLER_83_417 vssd1 vccd1 vccd1 vssd1 SS_sky130_fd_sc_hd__fill_4
XFILLER_95_277 vssd1 vccd1 vccd1 vssd1 SS_sky130_fd_sc_hd__fill_2
XFILLER_36_333 vssd1 vccd1 vssd1 vccd1 SS_sky130_ef_sc_hd__decap_40_12
XFILLER_48_193 vssd1 vccd1 vccd1 vssd1 SS_sky130_fd_sc_hd__fill_2
XFILLER_64_642 vssd1 vccd1 vccd1 vssd1 SS_sky130_fd_sc_hd__fill_2
XFILLER_36_377 vssd1 vccd1 vssd1 vccd1 SS_sky130_ef_sc_hd__decap_40_12
XFILLER_52_815 vccd1 vssd1 vccd1 vssd1 SS_sky130_fd_sc_hd__fill_1
XTAP_TAPCELL_ROW_19_586 vccd1 vssd1 SS_sky130_fd_sc_hd__tapvpwrvgnd_1
XFILLER_20_701 vssd1 vccd1 vccd1 vssd1 SS_sky130_fd_sc_hd__fill_2
XFILLER_32_594 vssd1 vccd1 vccd1 vssd1 SS_sky130_fd_sc_hd__fill_2
Xclkload9 clkload9/X clkload9/A vccd1 vssd1 vssd1 vccd1 SS_sky130_fd_sc_hd__clkbuf_8
XTAP_TAPCELL_ROW_30_751 vccd1 vssd1 SS_sky130_fd_sc_hd__tapvpwrvgnd_1
X_0998_ vccd1 vssd1 vccd1 vssd1 _0998_/X _0998_/A _1006_/B SS_sky130_fd_sc_hd__or2_2
Xclkbuf_leaf_22_wb_clk_i _1738_/CLK clkload0/A vccd1 vssd1 vssd1 vccd1 SS_sky130_fd_sc_hd__clkbuf_8
XTAP_TAPCELL_ROW_76_1436 vccd1 vssd1 SS_sky130_fd_sc_hd__tapvpwrvgnd_1
XTAP_TAPCELL_ROW_76_1447 vccd1 vssd1 SS_sky130_fd_sc_hd__tapvpwrvgnd_1
XFILLER_117_165 vssd1 vccd1 vccd1 vssd1 SS_sky130_fd_sc_hd__fill_2
XFILLER_105_305 vssd1 vccd1 vccd1 vssd1 SS_sky130_fd_sc_hd__fill_4
XFILLER_105_349 vssd1 vccd1 vccd1 vssd1 SS_sky130_fd_sc_hd__fill_8
X_1619_ _1619_/Q _1747_/CLK _1619_/D vccd1 vssd1 vccd1 vssd1 SS_sky130_fd_sc_hd__dfxtp_2
XFILLER_87_701 vssd1 vccd1 vccd1 vssd1 SS_sky130_fd_sc_hd__fill_2
Xfanout213 vssd1 vccd1 vccd1 vssd1 _1343_/Y _1397_/A2 SS_sky130_fd_sc_hd__clkdlybuf4s25_1
XFILLER_99_561 vssd1 vccd1 vssd1 vccd1 SS_sky130_ef_sc_hd__decap_40_12
XFILLER_59_447 vccd1 vssd1 vccd1 vssd1 SS_sky130_fd_sc_hd__fill_1
Xfanout246 vssd1 vccd1 vccd1 vssd1 _1013_/Y _1051_/A2 SS_sky130_fd_sc_hd__clkdlybuf4s25_1
Xfanout224 vssd1 vccd1 vccd1 vssd1 _1340_/B _1330_/B SS_sky130_fd_sc_hd__clkdlybuf4s25_1
XFILLER_113_393 vssd1 vccd1 vssd1 vccd1 SS_sky130_ef_sc_hd__decap_40_12
XFILLER_86_233 vssd1 vccd1 vssd1 vccd1 SS_sky130_ef_sc_hd__decap_40_12
Xfanout257 vssd1 vccd1 vccd1 vssd1 _0984_/B _1008_/B SS_sky130_fd_sc_hd__clkdlybuf4s25_1
XFILLER_115_57 vssd1 vccd1 vssd1 vccd1 SS_sky130_ef_sc_hd__decap_40_12
XFILLER_75_39 vssd1 vccd1 vssd1 vccd1 SS_sky130_ef_sc_hd__decap_40_12
XFILLER_86_277 vssd1 vccd1 vssd1 vccd1 SS_sky130_ef_sc_hd__decap_40_12
XFILLER_27_333 vssd1 vccd1 vccd1 vssd1 SS_sky130_fd_sc_hd__fill_2
XFILLER_39_193 vssd1 vccd1 vssd1 vccd1 SS_sky130_ef_sc_hd__decap_40_12
XFILLER_67_480 vssd1 vccd1 vssd1 vccd1 SS_sky130_ef_sc_hd__decap_40_12
XFILLER_15_517 vssd1 vccd1 vssd1 vccd1 SS_sky130_ef_sc_hd__decap_40_12
XTAP_TAPCELL_ROW_38_873 vccd1 vssd1 SS_sky130_fd_sc_hd__tapvpwrvgnd_1
XFILLER_54_141 vssd1 vccd1 vssd1 vccd1 SS_sky130_ef_sc_hd__decap_40_12
XFILLER_70_601 vssd1 vccd1 vssd1 vccd1 SS_sky130_ef_sc_hd__decap_40_12
XFILLER_82_450 vssd1 vccd1 vssd1 vccd1 SS_sky130_ef_sc_hd__decap_40_12
XTAP_TAPCELL_ROW_120_2102 vccd1 vssd1 SS_sky130_fd_sc_hd__tapvpwrvgnd_1
XFILLER_70_645 vssd1 vccd1 vssd1 vccd1 SS_sky130_ef_sc_hd__decap_40_12
XTAP_TAPCELL_ROW_87_1598 vccd1 vssd1 SS_sky130_fd_sc_hd__tapvpwrvgnd_1
XFILLER_23_561 vssd1 vccd1 vssd1 vccd1 SS_sky130_ef_sc_hd__decap_40_12
XFILLER_24_65 vssd1 vccd1 vssd1 vccd1 SS_sky130_ef_sc_hd__decap_40_12
XFILLER_10_233 vssd1 vccd1 vssd1 vccd1 SS_sky130_ef_sc_hd__decap_40_12
XFILLER_11_745 vssd1 vccd1 vccd1 vssd1 SS_sky130_fd_sc_hd__fill_2
XFILLER_128_419 vccd1 vssd1 vccd1 vssd1 SS_sky130_fd_sc_hd__fill_1
XFILLER_7_727 vccd1 vssd1 vccd1 vssd1 SS_sky130_fd_sc_hd__fill_1
XFILLER_10_277 vssd1 vccd1 vssd1 vccd1 SS_sky130_ef_sc_hd__decap_40_12
XTAP_TAPCELL_ROW_118_2064 vccd1 vssd1 SS_sky130_fd_sc_hd__tapvpwrvgnd_1
XFILLER_40_53 vssd1 vccd1 vssd1 vccd1 SS_sky130_ef_sc_hd__decap_40_12
XTAP_TAPCELL_ROW_118_2075 vccd1 vssd1 SS_sky130_fd_sc_hd__tapvpwrvgnd_1
XFILLER_108_121 vssd1 vccd1 vssd1 vccd1 SS_sky130_ef_sc_hd__decap_40_12
XFILLER_40_97 vssd1 vccd1 vssd1 vccd1 SS_sky130_ef_sc_hd__decap_40_12
XFILLER_136_463 vssd1 vccd1 vssd1 vccd1 SS_sky130_ef_sc_hd__decap_40_12
XFILLER_108_165 vssd1 vccd1 vssd1 vccd1 SS_sky130_ef_sc_hd__decap_40_12
XFILLER_2_421 vssd1 vccd1 vssd1 vccd1 SS_sky130_ef_sc_hd__decap_40_12
XTAP_TAPCELL_ROW_131_2264 vccd1 vssd1 SS_sky130_fd_sc_hd__tapvpwrvgnd_1
XFILLER_136_496 vssd1 vccd1 vccd1 vssd1 SS_sky130_fd_sc_hd__fill_8
XFILLER_123_113 vssd1 vccd1 vssd1 vccd1 SS_sky130_ef_sc_hd__decap_40_12
XFILLER_112_809 vssd1 vccd1 vccd1 vssd1 SS_sky130_fd_sc_hd__fill_2
XFILLER_78_701 vssd1 vccd1 vssd1 vccd1 SS_sky130_ef_sc_hd__decap_40_12
XFILLER_49_51 vssd1 vccd1 vccd1 vssd1 SS_sky130_fd_sc_hd__fill_4
XFILLER_93_704 vssd1 vccd1 vssd1 vccd1 SS_sky130_ef_sc_hd__decap_40_12
XFILLER_19_823 vccd1 vssd1 vccd1 vssd1 SS_sky130_fd_sc_hd__fill_1
XFILLER_65_417 vssd1 vccd1 vssd1 vccd1 SS_sky130_ef_sc_hd__decap_40_12
XFILLER_77_277 vssd1 vccd1 vccd1 vssd1 SS_sky130_fd_sc_hd__fill_2
XFILLER_1_69 vssd1 vccd1 vssd1 vccd1 SS_sky130_ef_sc_hd__decap_40_12
XFILLER_18_333 vssd1 vccd1 vssd1 vccd1 SS_sky130_ef_sc_hd__decap_40_12
XFILLER_46_642 vssd1 vccd1 vccd1 vssd1 SS_sky130_fd_sc_hd__fill_2
XFILLER_18_377 vssd1 vccd1 vssd1 vccd1 SS_sky130_ef_sc_hd__decap_40_12
XTAP_TAPCELL_ROW_47_1004 vccd1 vssd1 SS_sky130_fd_sc_hd__tapvpwrvgnd_1
XFILLER_73_461 vssd1 vccd1 vssd1 vccd1 SS_sky130_ef_sc_hd__decap_40_12
XFILLER_46_697 vssd1 vccd1 vccd1 vssd1 SS_sky130_fd_sc_hd__fill_2
XTAP_TAPCELL_ROW_16_534 vccd1 vssd1 SS_sky130_fd_sc_hd__tapvpwrvgnd_1
XTAP_TAPCELL_ROW_16_545 vccd1 vssd1 SS_sky130_fd_sc_hd__tapvpwrvgnd_1
XFILLER_60_133 vssd1 vccd1 vccd1 vssd1 SS_sky130_fd_sc_hd__fill_4
XFILLER_60_177 vssd1 vccd1 vssd1 vccd1 SS_sky130_ef_sc_hd__decap_40_12
XTAP_TAPCELL_ROW_60_1204 vccd1 vssd1 SS_sky130_fd_sc_hd__tapvpwrvgnd_1
X_0921_ vccd1 vssd1 vccd1 vssd1 _1663_/Q _0748_/X _1599_/Q wire445/A _0921_/X SS_sky130_fd_sc_hd__a22o_2
XFILLER_41_391 vccd1 vssd1 vccd1 vssd1 SS_sky130_fd_sc_hd__fill_1
XFILLER_81_93 vssd1 vccd1 vssd1 vccd1 SS_sky130_ef_sc_hd__decap_40_12
XFILLER_119_408 vssd1 vccd1 vssd1 vccd1 SS_sky130_ef_sc_hd__decap_40_12
X_0852_ vccd1 vssd1 vccd1 vssd1 _1523_/Q _0947_/A _1683_/Q _0891_/B1 _0852_/X SS_sky130_fd_sc_hd__a22o_2
X_0783_ vccd1 vssd1 vccd1 vssd1 input8/X _0815_/B1 _1850_/A wire443/X _0783_/X SS_sky130_fd_sc_hd__a22o_2
XFILLER_5_281 vssd1 vccd1 vssd1 vccd1 SS_sky130_ef_sc_hd__decap_40_12
XFILLER_6_793 vssd1 vccd1 vssd1 vccd1 SS_sky130_ef_sc_hd__decap_40_12
XTAP_TAPCELL_ROW_58_1166 vccd1 vssd1 SS_sky130_fd_sc_hd__tapvpwrvgnd_1
XTAP_TAPCELL_ROW_58_1177 vccd1 vssd1 SS_sky130_fd_sc_hd__tapvpwrvgnd_1
XFILLER_88_509 vssd1 vccd1 vssd1 vccd1 SS_sky130_ef_sc_hd__decap_40_12
X_1404_ vccd1 vssd1 vccd1 vssd1 _1404_/X _1729_/Q _1404_/B SS_sky130_fd_sc_hd__or2_2
XFILLER_29_609 vssd1 vccd1 vccd1 vssd1 SS_sky130_fd_sc_hd__fill_4
XFILLER_68_233 vssd1 vccd1 vssd1 vccd1 SS_sky130_ef_sc_hd__decap_40_12
XTAP_TAPCELL_ROW_71_1366 vccd1 vssd1 SS_sky130_fd_sc_hd__tapvpwrvgnd_1
XFILLER_110_341 vssd1 vccd1 vccd1 vssd1 SS_sky130_fd_sc_hd__fill_2
X_1335_ vssd1 vccd1 vccd1 vssd1 _1339_/A2 input40/X _1695_/D _1401_/C1 _1334_/X SS_sky130_fd_sc_hd__o211a_2
Xinput2 vssd1 vccd1 vccd1 vssd1 adc_data[10] input2/X SS_sky130_fd_sc_hd__clkdlybuf4s25_1
XFILLER_68_277 vssd1 vccd1 vssd1 vccd1 SS_sky130_ef_sc_hd__decap_40_12
XFILLER_84_737 vssd1 vccd1 vccd1 vssd1 SS_sky130_fd_sc_hd__fill_8
XFILLER_110_385 vccd1 vssd1 vccd1 vssd1 SS_sky130_fd_sc_hd__fill_1
XFILLER_96_597 vccd1 vssd1 vccd1 vssd1 SS_sky130_fd_sc_hd__fill_1
XFILLER_83_225 vssd1 vccd1 vssd1 vccd1 SS_sky130_ef_sc_hd__decap_40_12
X_1266_ vccd1 vssd1 vccd1 vssd1 _1266_/X _1662_/Q _1272_/B SS_sky130_fd_sc_hd__or2_2
XFILLER_36_141 vssd1 vccd1 vssd1 vccd1 SS_sky130_ef_sc_hd__decap_40_12
XFILLER_52_601 vssd1 vccd1 vccd1 vssd1 SS_sky130_fd_sc_hd__fill_8
X_1197_ vssd1 vccd1 vccd1 vssd1 _1209_/A2 input37/X _1628_/D _1329_/C1 _1196_/X SS_sky130_fd_sc_hd__o211a_2
XTAP_TAPCELL_ROW_35_821 vccd1 vssd1 SS_sky130_fd_sc_hd__tapvpwrvgnd_1
XTAP_TAPCELL_ROW_35_832 vccd1 vssd1 SS_sky130_fd_sc_hd__tapvpwrvgnd_1
XFILLER_37_697 vssd1 vccd1 vssd1 vccd1 SS_sky130_ef_sc_hd__decap_40_12
XFILLER_51_111 vccd1 vssd1 vccd1 vssd1 SS_sky130_fd_sc_hd__fill_1
XFILLER_52_634 vccd1 vssd1 vccd1 vssd1 SS_sky130_fd_sc_hd__fill_1
XFILLER_52_645 vssd1 vccd1 vssd1 vccd1 SS_sky130_ef_sc_hd__decap_40_12
XFILLER_92_781 vssd1 vccd1 vssd1 vccd1 SS_sky130_ef_sc_hd__decap_40_12
XFILLER_20_531 vccd1 vssd1 vccd1 vssd1 SS_sky130_fd_sc_hd__fill_1
XFILLER_118_485 vssd1 vccd1 vccd1 vssd1 SS_sky130_fd_sc_hd__fill_2
XFILLER_118_463 vssd1 vccd1 vssd1 vccd1 SS_sky130_ef_sc_hd__decap_40_12
XFILLER_133_411 vssd1 vccd1 vccd1 vssd1 SS_sky130_fd_sc_hd__fill_4
XFILLER_105_113 vssd1 vccd1 vssd1 vccd1 SS_sky130_ef_sc_hd__decap_40_12
XFILLER_121_617 vccd1 vssd1 vccd1 vssd1 SS_sky130_fd_sc_hd__fill_1
XFILLER_87_531 vssd1 vccd1 vssd1 vccd1 SS_sky130_ef_sc_hd__decap_40_12
XFILLER_59_277 vssd1 vccd1 vccd1 vssd1 SS_sky130_fd_sc_hd__fill_2
XFILLER_75_726 vssd1 vccd1 vccd1 vssd1 SS_sky130_fd_sc_hd__fill_2
XFILLER_87_586 vssd1 vccd1 vssd1 vccd1 SS_sky130_ef_sc_hd__decap_40_12
XTAP_TAPCELL_ROW_89_1638 vccd1 vssd1 SS_sky130_fd_sc_hd__tapvpwrvgnd_1
XFILLER_101_385 vssd1 vccd1 vccd1 vssd1 SS_sky130_fd_sc_hd__fill_4
XFILLER_16_815 vccd1 vssd1 vccd1 vssd1 SS_sky130_fd_sc_hd__fill_1
XFILLER_90_707 vssd1 vccd1 vssd1 vccd1 SS_sky130_ef_sc_hd__decap_40_12
XFILLER_28_697 vssd1 vccd1 vccd1 vssd1 SS_sky130_fd_sc_hd__fill_2
XFILLER_83_781 vssd1 vccd1 vccd1 vssd1 SS_sky130_fd_sc_hd__fill_2
XFILLER_42_133 vssd1 vccd1 vccd1 vssd1 SS_sky130_fd_sc_hd__fill_4
XFILLER_42_177 vssd1 vccd1 vssd1 vccd1 SS_sky130_ef_sc_hd__decap_40_12
XTAP_TAPCELL_ROW_100_1805 vccd1 vssd1 SS_sky130_fd_sc_hd__tapvpwrvgnd_1
XFILLER_23_391 vccd1 vssd1 vccd1 vssd1 SS_sky130_fd_sc_hd__fill_1
XFILLER_51_30 vssd1 vccd1 vssd1 vccd1 SS_sky130_ef_sc_hd__decap_40_12
XFILLER_11_553 vssd1 vccd1 vccd1 vssd1 SS_sky130_fd_sc_hd__fill_4
Xwire411 vccd1 vssd1 vssd1 vccd1 wire411/A analog_ctrl[70] SS_sky130_fd_sc_hd__buf_12
Xwire433 vssd1 vccd1 _0747_/Y wire433/X vccd1 vssd1 SS_sky130_fd_sc_hd__clkbuf_4
Xwire400 vccd1 vssd1 vssd1 vccd1 wire400/A analog_ctrl[81] SS_sky130_fd_sc_hd__buf_12
XFILLER_7_557 vssd1 vccd1 vccd1 vssd1 SS_sky130_fd_sc_hd__fill_2
XFILLER_11_597 vssd1 vccd1 vssd1 vccd1 SS_sky130_ef_sc_hd__decap_40_12
XFILLER_128_249 vssd1 vccd1 vccd1 vssd1 SS_sky130_fd_sc_hd__fill_2
Xwire455 vssd1 vccd1 _0739_/Y wire455/X vccd1 vssd1 SS_sky130_fd_sc_hd__clkbuf_2
XFILLER_137_783 vccd1 vssd1 vccd1 vssd1 SS_sky130_fd_sc_hd__fill_1
XFILLER_124_400 vssd1 vccd1 vssd1 vccd1 SS_sky130_ef_sc_hd__decap_40_12
Xwire499 vccd1 vssd1 wire499/X wire499/A vccd1 vssd1 SS_sky130_fd_sc_hd__buf_4
XFILLER_124_433 vssd1 vccd1 vccd1 vssd1 SS_sky130_fd_sc_hd__fill_8
XFILLER_3_741 vssd1 vccd1 vssd1 vccd1 SS_sky130_ef_sc_hd__decap_40_12
XFILLER_124_477 vssd1 vccd1 vccd1 vssd1 SS_sky130_fd_sc_hd__fill_8
XFILLER_98_807 vssd1 vccd1 vccd1 vssd1 SS_sky130_fd_sc_hd__fill_4
XFILLER_2_251 vccd1 vssd1 vccd1 vssd1 SS_sky130_fd_sc_hd__fill_1
XFILLER_3_785 vssd1 vccd1 vssd1 vccd1 SS_sky130_ef_sc_hd__decap_40_12
XFILLER_111_105 vssd1 vccd1 vccd1 vssd1 SS_sky130_fd_sc_hd__fill_4
XTAP_TAPCELL_ROW_111_1967 vccd1 vssd1 SS_sky130_fd_sc_hd__tapvpwrvgnd_1
XFILLER_111_149 vssd1 vccd1 vssd1 vccd1 SS_sky130_ef_sc_hd__decap_40_12
XFILLER_38_417 vssd1 vccd1 vccd1 vssd1 SS_sky130_fd_sc_hd__fill_2
X_1120_ vccd1 vssd1 vccd1 vssd1 _1120_/X _1120_/A _1126_/B SS_sky130_fd_sc_hd__or2_2
XTAP_TAPCELL_ROW_53_1096 vccd1 vssd1 SS_sky130_fd_sc_hd__tapvpwrvgnd_1
XFILLER_78_575 vccd1 vssd1 vccd1 vssd1 SS_sky130_fd_sc_hd__fill_1
XFILLER_18_6 vssd1 vccd1 vssd1 vccd1 SS_sky130_ef_sc_hd__decap_40_12
XFILLER_65_225 vssd1 vccd1 vssd1 vccd1 SS_sky130_ef_sc_hd__decap_40_12
XFILLER_18_141 vssd1 vccd1 vssd1 vccd1 SS_sky130_ef_sc_hd__decap_40_12
XFILLER_19_653 vssd1 vccd1 vssd1 vccd1 SS_sky130_ef_sc_hd__decap_40_12
XFILLER_34_601 vssd1 vccd1 vssd1 vccd1 SS_sky130_ef_sc_hd__decap_40_12
X_1051_ vssd1 vccd1 vccd1 vssd1 _1051_/A2 input29/X _1557_/D _1447_/C1 _1050_/X SS_sky130_fd_sc_hd__o211a_2
XFILLER_81_707 vssd1 vccd1 vccd1 vssd1 SS_sky130_fd_sc_hd__fill_4
XFILLER_81_729 vssd1 vccd1 vccd1 vssd1 SS_sky130_fd_sc_hd__fill_2
XFILLER_33_111 vccd1 vssd1 vccd1 vssd1 SS_sky130_fd_sc_hd__fill_1
XFILLER_74_781 vssd1 vccd1 vssd1 vccd1 SS_sky130_ef_sc_hd__decap_40_12
XFILLER_22_807 vccd1 vssd1 vccd1 vssd1 SS_sky130_fd_sc_hd__fill_1
XFILLER_34_645 vssd1 vccd1 vssd1 vccd1 SS_sky130_ef_sc_hd__decap_40_12
XFILLER_61_453 vccd1 vssd1 vccd1 vssd1 SS_sky130_fd_sc_hd__fill_1
XFILLER_92_81 vssd1 vccd1 vccd1 vssd1 SS_sky130_fd_sc_hd__fill_2
XFILLER_21_317 vssd1 vccd1 vssd1 vccd1 SS_sky130_ef_sc_hd__decap_40_12
X_1884_ vccd1 vssd1 _1884_/X _1884_/A vccd1 vssd1 SS_sky130_fd_sc_hd__buf_2
X_0904_ vccd1 vssd1 vccd1 vssd1 _0903_/X _1196_/A _0927_/A2 _1692_/Q _1277_/A _0904_/X
+ SS_sky130_fd_sc_hd__a221o_2
XFILLER_119_205 vssd1 vccd1 vssd1 vccd1 SS_sky130_ef_sc_hd__decap_40_12
X_0835_ vssd1 vccd1 vssd1 vccd1 wire421/A _1520_/Q _0831_/X _0834_/X _0835_/X wire347/A
+ SS_sky130_fd_sc_hd__a2111o_2
XFILLER_119_249 vssd1 vccd1 vssd1 vccd1 SS_sky130_ef_sc_hd__decap_40_12
X_0766_ vccd1 vssd1 vccd1 vssd1 _0765_/X _1897_/A wire435/X _1848_/A _0828_/B1 _0766_/X
+ SS_sky130_fd_sc_hd__a221o_2
XFILLER_127_293 vssd1 vccd1 vccd1 vssd1 SS_sky130_fd_sc_hd__fill_8
XFILLER_103_617 vssd1 vccd1 vccd1 vssd1 SS_sky130_fd_sc_hd__fill_2
XFILLER_69_553 vssd1 vccd1 vccd1 vssd1 SS_sky130_fd_sc_hd__fill_4
XFILLER_130_469 vssd1 vccd1 vccd1 vssd1 SS_sky130_fd_sc_hd__fill_4
XFILLER_29_417 vssd1 vccd1 vssd1 vccd1 SS_sky130_ef_sc_hd__decap_40_12
XFILLER_69_597 vssd1 vccd1 vssd1 vccd1 SS_sky130_ef_sc_hd__decap_40_12
X_1318_ vccd1 vssd1 vccd1 vssd1 _1318_/X _1318_/A _1318_/B SS_sky130_fd_sc_hd__or2_2
XFILLER_84_545 vssd1 vccd1 vssd1 vccd1 SS_sky130_ef_sc_hd__decap_40_12
XFILLER_110_193 vssd1 vccd1 vccd1 vssd1 SS_sky130_fd_sc_hd__fill_2
XFILLER_37_461 vssd1 vccd1 vssd1 vccd1 SS_sky130_ef_sc_hd__decap_40_12
XFILLER_84_589 vssd1 vccd1 vssd1 vccd1 SS_sky130_ef_sc_hd__decap_40_12
X_1249_ vssd1 vccd1 vccd1 vssd1 _1265_/A2 input29/X _1653_/D _1251_/C1 _1248_/X SS_sky130_fd_sc_hd__o211a_2
XFILLER_71_217 vssd1 vccd1 vccd1 vssd1 SS_sky130_fd_sc_hd__fill_4
XFILLER_24_133 vssd1 vccd1 vccd1 vssd1 SS_sky130_fd_sc_hd__fill_4
XFILLER_72_29 vssd1 vccd1 vssd1 vccd1 SS_sky130_ef_sc_hd__decap_40_12
XTAP_TAPCELL_ROW_84_1557 vccd1 vssd1 SS_sky130_fd_sc_hd__tapvpwrvgnd_1
XFILLER_24_177 vssd1 vccd1 vssd1 vccd1 SS_sky130_ef_sc_hd__decap_40_12
XFILLER_138_503 vccd1 vssd1 vccd1 vssd1 SS_sky130_fd_sc_hd__fill_1
XFILLER_20_361 vssd1 vccd1 vccd1 vssd1 SS_sky130_fd_sc_hd__fill_2
XFILLER_119_783 vccd1 vssd1 vccd1 vssd1 SS_sky130_fd_sc_hd__fill_1
XTAP_TAPCELL_ROW_115_2023 vccd1 vssd1 SS_sky130_fd_sc_hd__tapvpwrvgnd_1
XFILLER_137_55 vccd1 vssd1 vccd1 vssd1 SS_sky130_fd_sc_hd__fill_1
XFILLER_106_433 vccd1 vssd1 vccd1 vssd1 SS_sky130_fd_sc_hd__fill_1
XFILLER_106_411 vssd1 vccd1 vccd1 vssd1 SS_sky130_fd_sc_hd__fill_8
XFILLER_106_466 vssd1 vccd1 vccd1 vssd1 SS_sky130_fd_sc_hd__fill_8
XFILLER_97_15 vssd1 vccd1 vssd1 vccd1 SS_sky130_ef_sc_hd__decap_40_12
XFILLER_79_317 vssd1 vccd1 vccd1 vssd1 SS_sky130_fd_sc_hd__fill_4
XFILLER_106_477 vccd1 vssd1 vccd1 vssd1 SS_sky130_fd_sc_hd__fill_1
XFILLER_0_755 vccd1 vssd1 vccd1 vssd1 SS_sky130_fd_sc_hd__fill_1
Xoutput191 vccd1 vssd1 wire364/A _1503_/Q vccd1 vssd1 SS_sky130_fd_sc_hd__buf_4
Xoutput180 vccd1 vssd1 wire375/A _1493_/Q vccd1 vssd1 SS_sky130_fd_sc_hd__buf_4
XFILLER_121_447 vccd1 vssd1 vccd1 vssd1 SS_sky130_fd_sc_hd__fill_1
XFILLER_0_777 vssd1 vccd1 vccd1 vssd1 SS_sky130_fd_sc_hd__fill_4
XTAP_TAPCELL_ROW_7_398 vccd1 vssd1 SS_sky130_fd_sc_hd__tapvpwrvgnd_1
XFILLER_48_737 vssd1 vccd1 vccd1 vssd1 SS_sky130_fd_sc_hd__fill_8
XFILLER_75_501 vssd1 vccd1 vccd1 vssd1 SS_sky130_fd_sc_hd__fill_2
XFILLER_87_361 vssd1 vccd1 vccd1 vssd1 SS_sky130_fd_sc_hd__fill_8
XFILLER_47_225 vssd1 vccd1 vssd1 vccd1 SS_sky130_ef_sc_hd__decap_40_12
XFILLER_102_694 vssd1 vccd1 vccd1 vssd1 SS_sky130_fd_sc_hd__fill_4
XFILLER_46_41 vssd1 vccd1 vssd1 vccd1 SS_sky130_ef_sc_hd__decap_40_12
XFILLER_63_729 vssd1 vccd1 vssd1 vccd1 SS_sky130_ef_sc_hd__decap_40_12
XFILLER_101_193 vssd1 vccd1 vssd1 vccd1 SS_sky130_ef_sc_hd__decap_40_12
XFILLER_16_601 vssd1 vccd1 vssd1 vccd1 SS_sky130_ef_sc_hd__decap_40_12
XFILLER_46_85 vssd1 vccd1 vssd1 vccd1 SS_sky130_ef_sc_hd__decap_40_12
XFILLER_56_781 vssd1 vccd1 vssd1 vccd1 SS_sky130_ef_sc_hd__decap_40_12
XTAP_TAPCELL_ROW_126_2196 vccd1 vssd1 SS_sky130_fd_sc_hd__tapvpwrvgnd_1
XTAP_TAPCELL_ROW_126_2185 vccd1 vssd1 SS_sky130_fd_sc_hd__tapvpwrvgnd_1
XFILLER_15_111 vccd1 vssd1 vccd1 vssd1 SS_sky130_fd_sc_hd__fill_1
XFILLER_16_645 vssd1 vccd1 vssd1 vccd1 SS_sky130_ef_sc_hd__decap_40_12
XFILLER_31_615 vccd1 vssd1 vccd1 vssd1 SS_sky130_fd_sc_hd__fill_1
XTAP_TAPCELL_ROW_26_684 vccd1 vssd1 SS_sky130_fd_sc_hd__tapvpwrvgnd_1
XTAP_TAPCELL_ROW_26_695 vccd1 vssd1 SS_sky130_fd_sc_hd__tapvpwrvgnd_1
XFILLER_43_497 vssd1 vccd1 vccd1 vssd1 SS_sky130_fd_sc_hd__fill_2
XFILLER_8_811 vccd1 vssd1 vccd1 vssd1 SS_sky130_fd_sc_hd__fill_1
XFILLER_129_503 vccd1 vssd1 vccd1 vssd1 SS_sky130_fd_sc_hd__fill_1
XFILLER_11_361 vssd1 vccd1 vssd1 vccd1 SS_sky130_ef_sc_hd__decap_40_12
Xwire241 vccd1 vssd1 wire241/X wire241/A vccd1 vssd1 SS_sky130_fd_sc_hd__buf_4
XFILLER_7_57 vssd1 vccd1 vssd1 vccd1 SS_sky130_ef_sc_hd__decap_40_12
Xwire274 vccd1 vssd1 vssd1 vccd1 wire274/A analog_ctrl[21] SS_sky130_fd_sc_hd__buf_12
Xwire263 vccd1 vssd1 vssd1 vccd1 wire263/A analog_ctrl[31] SS_sky130_fd_sc_hd__buf_12
Xwire285 vccd1 vssd1 vssd1 vccd1 wire285/A analog_ctrl[122] SS_sky130_fd_sc_hd__buf_12
Xwire296 vccd1 vssd1 vssd1 vccd1 wire296/A analog_ctrl[112] SS_sky130_fd_sc_hd__buf_12
XFILLER_109_293 vssd1 vccd1 vssd1 vccd1 SS_sky130_ef_sc_hd__decap_40_12
XTAP_TAPCELL_ROW_55_1125 vccd1 vssd1 SS_sky130_fd_sc_hd__tapvpwrvgnd_1
XFILLER_125_797 vssd1 vccd1 vccd1 vssd1 SS_sky130_fd_sc_hd__fill_4
XFILLER_98_637 vssd1 vccd1 vccd1 vssd1 SS_sky130_fd_sc_hd__fill_4
XFILLER_97_125 vssd1 vccd1 vssd1 vccd1 SS_sky130_ef_sc_hd__decap_40_12
XFILLER_78_350 vccd1 vssd1 vccd1 vssd1 SS_sky130_fd_sc_hd__fill_1
XFILLER_87_81 vssd1 vccd1 vssd1 vccd1 SS_sky130_ef_sc_hd__decap_40_12
XFILLER_112_469 vssd1 vccd1 vccd1 vssd1 SS_sky130_fd_sc_hd__fill_4
XFILLER_97_169 vssd1 vccd1 vssd1 vccd1 SS_sky130_ef_sc_hd__decap_40_12
X_1103_ vssd1 vccd1 vccd1 vssd1 wire239/X wire500/X _1582_/D wire467/X _1102_/X SS_sky130_fd_sc_hd__o211a_2
XFILLER_66_589 vssd1 vccd1 vssd1 vccd1 SS_sky130_ef_sc_hd__decap_40_12
XFILLER_19_461 vssd1 vccd1 vssd1 vccd1 SS_sky130_ef_sc_hd__decap_40_12
XFILLER_47_781 vssd1 vccd1 vccd1 vssd1 SS_sky130_fd_sc_hd__fill_2
XFILLER_53_217 vssd1 vccd1 vccd1 vssd1 SS_sky130_fd_sc_hd__fill_4
X_1034_ vccd1 vssd1 vccd1 vssd1 _1034_/X _1034_/A _1050_/B SS_sky130_fd_sc_hd__or2_2
XFILLER_93_386 vssd1 vccd1 vccd1 vssd1 SS_sky130_fd_sc_hd__fill_4
XFILLER_22_615 vssd1 vccd1 vssd1 vccd1 SS_sky130_ef_sc_hd__decap_40_12
XFILLER_34_475 vccd1 vssd1 vccd1 vssd1 SS_sky130_fd_sc_hd__fill_1
XTAP_TAPCELL_ROW_45_971 vccd1 vssd1 SS_sky130_fd_sc_hd__tapvpwrvgnd_1
XTAP_TAPCELL_ROW_45_982 vccd1 vssd1 SS_sky130_fd_sc_hd__tapvpwrvgnd_1
XFILLER_61_261 vssd1 vccd1 vssd1 vccd1 SS_sky130_ef_sc_hd__decap_40_12
XTAP_TAPCELL_ROW_66_1287 vccd1 vssd1 SS_sky130_fd_sc_hd__tapvpwrvgnd_1
XFILLER_21_125 vssd1 vccd1 vssd1 vccd1 SS_sky130_ef_sc_hd__decap_40_12
XFILLER_21_169 vssd1 vccd1 vssd1 vccd1 SS_sky130_ef_sc_hd__decap_40_12
XFILLER_108_709 vssd1 vccd1 vssd1 vccd1 SS_sky130_ef_sc_hd__decap_40_12
X_1867_ vccd1 vssd1 _1867_/X _1867_/A vccd1 vssd1 SS_sky130_fd_sc_hd__buf_2
XFILLER_135_517 vssd1 vccd1 vccd1 vssd1 SS_sky130_fd_sc_hd__fill_2
X_0818_ vccd1 vssd1 vssd1 vccd1 _0814_/X _0817_/X _0926_/A2 _1485_/Q _1485_/D _1299_/C1
+ SS_sky130_fd_sc_hd__o221a_2
Xhold811 hold811/X _1497_/Q vccd1 vssd1 vssd1 vccd1 SS_sky130_fd_sc_hd__dlygate4sd3_1
Xhold800 hold800/X _1494_/Q vccd1 vssd1 vssd1 vccd1 SS_sky130_fd_sc_hd__dlygate4sd3_1
XFILLER_116_753 vssd1 vccd1 vccd1 vssd1 SS_sky130_fd_sc_hd__fill_2
X_0749_ vccd1 vssd1 vccd1 vssd1 _1635_/Q wire430/X input1/X _0815_/B1 _0757_/B SS_sky130_fd_sc_hd__a22o_2
XFILLER_89_615 vccd1 vssd1 vccd1 vssd1 SS_sky130_fd_sc_hd__fill_1
XFILLER_131_712 vccd1 vssd1 vccd1 vssd1 SS_sky130_fd_sc_hd__fill_1
XFILLER_130_233 vssd1 vccd1 vssd1 vccd1 SS_sky130_ef_sc_hd__decap_40_12
XFILLER_107_69 vssd1 vccd1 vssd1 vccd1 SS_sky130_ef_sc_hd__decap_40_12
XFILLER_69_361 vssd1 vccd1 vssd1 vccd1 SS_sky130_ef_sc_hd__decap_40_12
XFILLER_76_309 vssd1 vccd1 vssd1 vccd1 SS_sky130_ef_sc_hd__decap_40_12
XFILLER_130_277 vssd1 vccd1 vssd1 vccd1 SS_sky130_ef_sc_hd__decap_40_12
XFILLER_97_670 vssd1 vccd1 vccd1 vssd1 SS_sky130_fd_sc_hd__fill_2
XTAP_TAPCELL_ROW_4_357 vccd1 vssd1 SS_sky130_fd_sc_hd__tapvpwrvgnd_1
XFILLER_29_225 vssd1 vccd1 vssd1 vccd1 SS_sky130_ef_sc_hd__decap_40_12
XFILLER_45_718 vssd1 vccd1 vccd1 vssd1 SS_sky130_fd_sc_hd__fill_8
XFILLER_123_57 vssd1 vccd1 vssd1 vccd1 SS_sky130_ef_sc_hd__decap_40_12
XFILLER_38_781 vssd1 vccd1 vccd1 vssd1 SS_sky130_fd_sc_hd__fill_8
XFILLER_45_729 vssd1 vccd1 vssd1 vccd1 SS_sky130_ef_sc_hd__decap_40_12
XFILLER_13_615 vccd1 vssd1 vccd1 vssd1 SS_sky130_fd_sc_hd__fill_1
XFILLER_16_77 vssd1 vccd1 vccd1 vssd1 SS_sky130_fd_sc_hd__fill_4
XFILLER_40_401 vssd1 vccd1 vssd1 vccd1 SS_sky130_ef_sc_hd__decap_40_12
XFILLER_25_497 vssd1 vccd1 vccd1 vssd1 SS_sky130_fd_sc_hd__fill_4
XFILLER_40_445 vssd1 vccd1 vssd1 vccd1 SS_sky130_ef_sc_hd__decap_40_12
XTAP_TAPCELL_ROW_23_643 vccd1 vssd1 SS_sky130_fd_sc_hd__tapvpwrvgnd_1
XFILLER_32_65 vssd1 vccd1 vssd1 vccd1 SS_sky130_ef_sc_hd__decap_40_12
XFILLER_40_489 vssd1 vccd1 vssd1 vccd1 SS_sky130_ef_sc_hd__decap_40_12
XFILLER_120_3 vssd1 vccd1 vssd1 vccd1 SS_sky130_ef_sc_hd__decap_40_12
XTAP_TAPCELL_ROW_97_1748 vccd1 vssd1 SS_sky130_fd_sc_hd__tapvpwrvgnd_1
XTAP_TAPCELL_ROW_97_1759 vccd1 vssd1 SS_sky130_fd_sc_hd__tapvpwrvgnd_1
XFILLER_4_357 vssd1 vccd1 vccd1 vssd1 SS_sky130_fd_sc_hd__fill_4
XFILLER_134_583 vssd1 vccd1 vccd1 vssd1 SS_sky130_fd_sc_hd__fill_4
XFILLER_122_734 vssd1 vccd1 vssd1 vccd1 SS_sky130_ef_sc_hd__decap_40_12
XFILLER_122_701 vssd1 vccd1 vccd1 vssd1 SS_sky130_fd_sc_hd__fill_4
XFILLER_79_125 vssd1 vccd1 vssd1 vccd1 SS_sky130_ef_sc_hd__decap_40_12
XFILLER_48_501 vssd1 vccd1 vssd1 vccd1 SS_sky130_ef_sc_hd__decap_40_12
XFILLER_79_169 vssd1 vccd1 vssd1 vccd1 SS_sky130_ef_sc_hd__decap_40_12
XTAP_TAPCELL_ROW_128_2214 vccd1 vssd1 SS_sky130_fd_sc_hd__tapvpwrvgnd_1
XTAP_TAPCELL_ROW_128_2225 vccd1 vssd1 SS_sky130_fd_sc_hd__tapvpwrvgnd_1
XFILLER_121_277 vssd1 vccd1 vccd1 vssd1 SS_sky130_fd_sc_hd__fill_2
XFILLER_95_629 vssd1 vccd1 vssd1 vccd1 SS_sky130_ef_sc_hd__decap_40_12
XFILLER_0_585 vssd1 vccd1 vccd1 vssd1 SS_sky130_fd_sc_hd__fill_2
XFILLER_48_545 vssd1 vccd1 vssd1 vccd1 SS_sky130_ef_sc_hd__decap_40_12
XTAP_TAPCELL_ROW_50_1044 vccd1 vssd1 SS_sky130_fd_sc_hd__tapvpwrvgnd_1
XTAP_TAPCELL_ROW_50_1055 vccd1 vssd1 SS_sky130_fd_sc_hd__tapvpwrvgnd_1
XFILLER_57_51 vssd1 vccd1 vccd1 vssd1 SS_sky130_fd_sc_hd__fill_4
XFILLER_94_139 vccd1 vssd1 vccd1 vssd1 SS_sky130_fd_sc_hd__fill_1
XFILLER_29_781 vssd1 vccd1 vccd1 vssd1 SS_sky130_fd_sc_hd__fill_2
XFILLER_35_217 vssd1 vccd1 vccd1 vssd1 SS_sky130_fd_sc_hd__fill_4
XFILLER_48_589 vssd1 vccd1 vssd1 vccd1 SS_sky130_ef_sc_hd__decap_40_12
XFILLER_90_301 vssd1 vccd1 vccd1 vssd1 SS_sky130_fd_sc_hd__fill_4
XFILLER_63_559 vccd1 vssd1 vccd1 vssd1 SS_sky130_fd_sc_hd__fill_1
XFILLER_16_475 vccd1 vssd1 vccd1 vssd1 SS_sky130_fd_sc_hd__fill_1
XFILLER_43_261 vssd1 vccd1 vssd1 vccd1 SS_sky130_ef_sc_hd__decap_40_12
XFILLER_50_209 vssd1 vccd1 vssd1 vccd1 SS_sky130_ef_sc_hd__decap_40_12
XTAP_TAPCELL_ROW_106_1888 vccd1 vssd1 SS_sky130_fd_sc_hd__tapvpwrvgnd_1
XTAP_TAPCELL_ROW_42_930 vccd1 vssd1 SS_sky130_fd_sc_hd__tapvpwrvgnd_1
XFILLER_31_445 vssd1 vccd1 vccd1 vssd1 SS_sky130_fd_sc_hd__fill_2
XFILLER_12_681 vssd1 vccd1 vssd1 vccd1 SS_sky130_ef_sc_hd__decap_40_12
XFILLER_8_641 vssd1 vccd1 vccd1 vssd1 SS_sky130_fd_sc_hd__fill_2
XPHY_EDGE_ROW_130_Left_269 vccd1 vssd1 vccd1 vssd1 SS_sky130_fd_sc_hd__decap_3
XFILLER_117_517 vssd1 vccd1 vssd1 vccd1 SS_sky130_ef_sc_hd__decap_40_12
X_1721_ _1721_/Q _1753_/CLK _1721_/D vccd1 vssd1 vccd1 vssd1 SS_sky130_fd_sc_hd__dfxtp_2
X_1652_ _1652_/Q _1717_/CLK _1652_/D vccd1 vssd1 vccd1 vssd1 SS_sky130_fd_sc_hd__dfxtp_2
X_1583_ _1857_/A _1610_/CLK _1583_/D vccd1 vssd1 vccd1 vssd1 SS_sky130_fd_sc_hd__dfxtp_2
XFILLER_125_561 vssd1 vccd1 vssd1 vccd1 SS_sky130_ef_sc_hd__decap_40_12
XFILLER_113_756 vssd1 vccd1 vssd1 vccd1 SS_sky130_ef_sc_hd__decap_40_12
XFILLER_112_233 vssd1 vccd1 vssd1 vccd1 SS_sky130_ef_sc_hd__decap_40_12
XFILLER_98_445 vssd1 vccd1 vssd1 vccd1 SS_sky130_ef_sc_hd__decap_40_12
XFILLER_58_309 vssd1 vccd1 vssd1 vccd1 SS_sky130_ef_sc_hd__decap_40_12
XFILLER_112_277 vssd1 vccd1 vssd1 vccd1 SS_sky130_ef_sc_hd__decap_40_12
Xafe_wb_509 analog_io_out[1] afe_wb_509/HI vccd1 vssd1 vssd1 vccd1 SS_sky130_fd_sc_hd__conb_1
XTAP_TAPCELL_ROW_1_316 vccd1 vssd1 SS_sky130_fd_sc_hd__tapvpwrvgnd_1
XFILLER_27_718 vccd1 vssd1 vccd1 vssd1 SS_sky130_fd_sc_hd__fill_1
XFILLER_82_813 vccd1 vssd1 vccd1 vssd1 SS_sky130_fd_sc_hd__fill_1
XFILLER_27_729 vssd1 vccd1 vssd1 vccd1 SS_sky130_ef_sc_hd__decap_40_12
XTAP_TAPCELL_ROW_68_1316 vccd1 vssd1 SS_sky130_fd_sc_hd__tapvpwrvgnd_1
XTAP_TAPCELL_ROW_68_1327 vccd1 vssd1 SS_sky130_fd_sc_hd__tapvpwrvgnd_1
XFILLER_93_161 vssd1 vccd1 vccd1 vssd1 SS_sky130_fd_sc_hd__fill_4
X_1017_ vssd1 vccd1 vccd1 vssd1 _1033_/A2 input31/X _1540_/D _1149_/C1 _1016_/X SS_sky130_fd_sc_hd__o211a_2
XFILLER_22_401 vssd1 vccd1 vssd1 vccd1 SS_sky130_ef_sc_hd__decap_40_12
XTAP_TAPCELL_ROW_81_1516 vccd1 vssd1 SS_sky130_fd_sc_hd__tapvpwrvgnd_1
XFILLER_22_445 vssd1 vccd1 vssd1 vccd1 SS_sky130_ef_sc_hd__decap_40_12
XTAP_TAPCELL_ROW_20_602 vccd1 vssd1 SS_sky130_fd_sc_hd__tapvpwrvgnd_1
XFILLER_22_489 vssd1 vccd1 vssd1 vccd1 SS_sky130_ef_sc_hd__decap_40_12
XFILLER_108_506 vssd1 vccd1 vccd1 vssd1 SS_sky130_fd_sc_hd__fill_8
Xhold630 _1166_/A _1873_/A vccd1 vssd1 vssd1 vccd1 SS_sky130_fd_sc_hd__dlygate4sd3_1
XTAP_TAPCELL_ROW_79_1478 vccd1 vssd1 SS_sky130_fd_sc_hd__tapvpwrvgnd_1
XTAP_TAPCELL_ROW_79_1489 vccd1 vssd1 SS_sky130_fd_sc_hd__tapvpwrvgnd_1
XFILLER_135_347 vccd1 vssd1 vccd1 vssd1 SS_sky130_fd_sc_hd__fill_1
XFILLER_1_305 vssd1 vccd1 vssd1 vccd1 SS_sky130_ef_sc_hd__decap_40_12
XTAP_TAPCELL_ROW_9_438 vccd1 vssd1 SS_sky130_fd_sc_hd__tapvpwrvgnd_1
Xhold641 _1028_/A _1546_/Q vccd1 vssd1 vssd1 vccd1 SS_sky130_fd_sc_hd__dlygate4sd3_1
Xhold663 _1464_/A _1758_/Q vccd1 vssd1 vssd1 vccd1 SS_sky130_fd_sc_hd__dlygate4sd3_1
Xhold652 _1008_/A _1537_/Q vccd1 vssd1 vssd1 vccd1 SS_sky130_fd_sc_hd__dlygate4sd3_1
XFILLER_104_701 vssd1 vccd1 vssd1 vccd1 SS_sky130_ef_sc_hd__decap_40_12
XFILLER_1_349 vssd1 vccd1 vssd1 vccd1 SS_sky130_ef_sc_hd__decap_40_12
Xhold685 input30/A wbs_dat_i[19] vccd1 vssd1 vssd1 vccd1 SS_sky130_fd_sc_hd__dlygate4sd3_1
Xhold674 _1567_/D _1071_/X vccd1 vssd1 vssd1 vccd1 SS_sky130_fd_sc_hd__dlygate4sd3_1
Xhold696 _1382_/A _1718_/Q vccd1 vssd1 vssd1 vccd1 SS_sky130_fd_sc_hd__dlygate4sd3_1
XTAP_TAPCELL_ROW_92_1678 vccd1 vssd1 SS_sky130_fd_sc_hd__tapvpwrvgnd_1
XFILLER_77_629 vssd1 vccd1 vssd1 vccd1 SS_sky130_ef_sc_hd__decap_40_12
XFILLER_131_553 vssd1 vccd1 vccd1 vssd1 SS_sky130_fd_sc_hd__fill_2
XFILLER_76_139 vccd1 vssd1 vccd1 vssd1 SS_sky130_fd_sc_hd__fill_1
XFILLER_103_277 vssd1 vccd1 vccd1 vssd1 SS_sky130_fd_sc_hd__fill_2
XFILLER_94_27 vccd1 vssd1 vccd1 vssd1 SS_sky130_fd_sc_hd__fill_1
XFILLER_91_109 vssd1 vccd1 vccd1 vssd1 SS_sky130_fd_sc_hd__fill_2
XFILLER_17_217 vssd1 vccd1 vccd1 vssd1 SS_sky130_fd_sc_hd__fill_4
XTAP_TAPCELL_ROW_28_713 vccd1 vssd1 SS_sky130_fd_sc_hd__tapvpwrvgnd_1
XTAP_TAPCELL_ROW_28_724 vccd1 vssd1 SS_sky130_fd_sc_hd__tapvpwrvgnd_1
XFILLER_45_515 vssd1 vccd1 vssd1 vccd1 SS_sky130_ef_sc_hd__decap_40_12
XFILLER_72_301 vssd1 vccd1 vccd1 vssd1 SS_sky130_fd_sc_hd__fill_4
XFILLER_85_673 vssd1 vccd1 vssd1 vccd1 SS_sky130_ef_sc_hd__decap_40_12
XTAP_TAPCELL_ROW_123_2144 vccd1 vssd1 SS_sky130_fd_sc_hd__tapvpwrvgnd_1
XFILLER_32_209 vssd1 vccd1 vssd1 vccd1 SS_sky130_ef_sc_hd__decap_40_12
XFILLER_25_261 vssd1 vccd1 vssd1 vccd1 SS_sky130_ef_sc_hd__decap_40_12
XFILLER_41_721 vssd1 vccd1 vccd1 vssd1 SS_sky130_fd_sc_hd__fill_4
XFILLER_9_405 vssd1 vccd1 vssd1 vccd1 SS_sky130_ef_sc_hd__decap_40_12
XFILLER_13_445 vssd1 vccd1 vccd1 vssd1 SS_sky130_fd_sc_hd__fill_2
XFILLER_40_253 vssd1 vccd1 vssd1 vccd1 SS_sky130_ef_sc_hd__decap_40_12
XFILLER_41_765 vssd1 vccd1 vssd1 vccd1 SS_sky130_ef_sc_hd__decap_40_12
XFILLER_43_42 vssd1 vccd1 vssd1 vccd1 SS_sky130_ef_sc_hd__decap_40_12
XFILLER_9_449 vssd1 vccd1 vssd1 vccd1 SS_sky130_ef_sc_hd__decap_40_12
XFILLER_138_141 vssd1 vccd1 vccd1 vssd1 SS_sky130_fd_sc_hd__fill_4
XFILLER_138_185 vssd1 vccd1 vccd1 vssd1 SS_sky130_fd_sc_hd__fill_2
XFILLER_138_163 vssd1 vccd1 vccd1 vssd1 SS_sky130_fd_sc_hd__fill_4
XFILLER_126_303 vccd1 vssd1 vccd1 vssd1 SS_sky130_fd_sc_hd__fill_1
XFILLER_4_121 vssd1 vccd1 vssd1 vccd1 SS_sky130_ef_sc_hd__decap_40_12
XFILLER_4_165 vssd1 vccd1 vssd1 vccd1 SS_sky130_ef_sc_hd__decap_40_12
XFILLER_107_561 vssd1 vccd1 vssd1 vccd1 SS_sky130_ef_sc_hd__decap_40_12
XFILLER_68_83 vccd1 vssd1 vccd1 vssd1 SS_sky130_fd_sc_hd__fill_1
XFILLER_110_759 vccd1 vssd1 vccd1 vssd1 SS_sky130_fd_sc_hd__fill_1
XFILLER_110_737 vssd1 vccd1 vssd1 vccd1 SS_sky130_ef_sc_hd__decap_40_12
XFILLER_0_393 vssd1 vccd1 vssd1 vccd1 SS_sky130_ef_sc_hd__decap_40_12
XFILLER_64_813 vccd1 vssd1 vccd1 vssd1 SS_sky130_fd_sc_hd__fill_1
XFILLER_75_161 vssd1 vccd1 vccd1 vssd1 SS_sky130_fd_sc_hd__fill_4
XFILLER_76_684 vssd1 vccd1 vssd1 vccd1 SS_sky130_ef_sc_hd__decap_40_12
XFILLER_82_109 vssd1 vccd1 vssd1 vccd1 SS_sky130_ef_sc_hd__decap_40_12
XTAP_TAPCELL_ROW_108_1917 vccd1 vssd1 SS_sky130_fd_sc_hd__tapvpwrvgnd_1
XFILLER_63_345 vssd1 vccd1 vccd1 vssd1 SS_sky130_fd_sc_hd__fill_2
XFILLER_51_529 vssd1 vccd1 vssd1 vccd1 SS_sky130_ef_sc_hd__decap_40_12
XFILLER_63_356 vssd1 vccd1 vssd1 vccd1 SS_sky130_ef_sc_hd__decap_40_12
XFILLER_90_153 vssd1 vccd1 vssd1 vccd1 SS_sky130_ef_sc_hd__decap_40_12
XFILLER_90_197 vssd1 vccd1 vssd1 vccd1 SS_sky130_ef_sc_hd__decap_40_12
XFILLER_32_754 vssd1 vccd1 vccd1 vssd1 SS_sky130_fd_sc_hd__fill_2
XTAP_TAPCELL_ROW_63_1246 vccd1 vssd1 SS_sky130_fd_sc_hd__tapvpwrvgnd_1
X_1704_ _1883_/A _1745_/CLK _1704_/D vccd1 vssd1 vccd1 vssd1 SS_sky130_fd_sc_hd__dfxtp_2
X_1635_ _1635_/Q clkload8/A _1635_/D vccd1 vssd1 vccd1 vssd1 SS_sky130_fd_sc_hd__dfxtp_2
X_1566_ _1566_/Q _1758_/CLK _1566_/D vccd1 vssd1 vccd1 vssd1 SS_sky130_fd_sc_hd__dfxtp_2
XFILLER_59_629 vssd1 vccd1 vccd1 vssd1 SS_sky130_fd_sc_hd__fill_4
XFILLER_98_253 vssd1 vccd1 vssd1 vccd1 SS_sky130_ef_sc_hd__decap_40_12
XFILLER_58_139 vccd1 vssd1 vccd1 vssd1 SS_sky130_fd_sc_hd__fill_1
X_1497_ _1497_/Q _1755_/CLK _1497_/D vccd1 vssd1 vccd1 vssd1 SS_sky130_fd_sc_hd__dfxtp_2
XFILLER_104_15 vssd1 vccd1 vssd1 vccd1 SS_sky130_ef_sc_hd__decap_40_12
XFILLER_54_301 vssd1 vccd1 vccd1 vssd1 SS_sky130_fd_sc_hd__fill_4
XFILLER_67_673 vssd1 vccd1 vssd1 vccd1 SS_sky130_ef_sc_hd__decap_40_12
XFILLER_73_109 vssd1 vccd1 vccd1 vssd1 SS_sky130_fd_sc_hd__fill_2
XFILLER_27_559 vccd1 vssd1 vccd1 vssd1 SS_sky130_fd_sc_hd__fill_1
XFILLER_82_643 vccd1 vssd1 vccd1 vssd1 SS_sky130_fd_sc_hd__fill_1
XFILLER_14_209 vssd1 vccd1 vssd1 vccd1 SS_sky130_ef_sc_hd__decap_40_12
XFILLER_54_389 vssd1 vccd1 vssd1 vccd1 SS_sky130_ef_sc_hd__decap_40_12
XFILLER_82_698 vssd1 vccd1 vccd1 vssd1 SS_sky130_fd_sc_hd__fill_2
XFILLER_23_765 vssd1 vccd1 vssd1 vccd1 SS_sky130_ef_sc_hd__decap_40_12
XFILLER_80_29 vssd1 vccd1 vssd1 vccd1 SS_sky130_ef_sc_hd__decap_40_12
XFILLER_22_253 vssd1 vccd1 vssd1 vccd1 SS_sky130_ef_sc_hd__decap_40_12
XFILLER_50_595 vccd1 vssd1 vccd1 vssd1 SS_sky130_fd_sc_hd__fill_1
XTAP_TAPCELL_ROW_33_793 vccd1 vssd1 SS_sky130_fd_sc_hd__tapvpwrvgnd_1
XFILLER_136_601 vssd1 vccd1 vssd1 vccd1 SS_sky130_ef_sc_hd__decap_40_12
XFILLER_6_419 vccd1 vssd1 vccd1 vssd1 SS_sky130_fd_sc_hd__fill_1
XFILLER_135_111 vccd1 vssd1 vccd1 vssd1 SS_sky130_fd_sc_hd__fill_1
XFILLER_89_27 vssd1 vccd1 vssd1 vccd1 SS_sky130_ef_sc_hd__decap_40_12
XTAP_TAPCELL_ROW_94_1707 vccd1 vssd1 SS_sky130_fd_sc_hd__tapvpwrvgnd_1
XFILLER_1_113 vssd1 vccd1 vssd1 vccd1 SS_sky130_ef_sc_hd__decap_40_12
XFILLER_2_625 vssd1 vccd1 vssd1 vccd1 SS_sky130_ef_sc_hd__decap_40_12
XFILLER_2_669 vssd1 vccd1 vssd1 vccd1 SS_sky130_ef_sc_hd__decap_40_12
XFILLER_131_361 vssd1 vccd1 vssd1 vccd1 SS_sky130_ef_sc_hd__decap_40_12
XFILLER_104_586 vssd1 vccd1 vccd1 vssd1 SS_sky130_fd_sc_hd__fill_2
XFILLER_38_53 vssd1 vccd1 vssd1 vccd1 SS_sky130_ef_sc_hd__decap_40_12
XFILLER_38_97 vssd1 vccd1 vssd1 vccd1 SS_sky130_ef_sc_hd__decap_40_12
XFILLER_57_161 vssd1 vccd1 vccd1 vssd1 SS_sky130_fd_sc_hd__fill_4
XFILLER_64_109 vssd1 vccd1 vssd1 vccd1 SS_sky130_ef_sc_hd__decap_40_12
XFILLER_54_41 vssd1 vccd1 vssd1 vccd1 SS_sky130_ef_sc_hd__decap_40_12
XFILLER_72_153 vssd1 vccd1 vssd1 vccd1 SS_sky130_ef_sc_hd__decap_40_12
XFILLER_73_665 vssd1 vccd1 vccd1 vssd1 SS_sky130_fd_sc_hd__fill_4
XFILLER_26_581 vssd1 vccd1 vccd1 vssd1 SS_sky130_fd_sc_hd__fill_4
XFILLER_33_529 vssd1 vccd1 vssd1 vccd1 SS_sky130_ef_sc_hd__decap_40_12
XFILLER_45_389 vssd1 vccd1 vccd1 vssd1 SS_sky130_fd_sc_hd__fill_2
XFILLER_72_197 vssd1 vccd1 vssd1 vccd1 SS_sky130_ef_sc_hd__decap_40_12
XFILLER_41_540 vssd1 vccd1 vccd1 vssd1 SS_sky130_fd_sc_hd__fill_8
XFILLER_54_85 vssd1 vccd1 vssd1 vccd1 SS_sky130_ef_sc_hd__decap_40_12
XTAP_TAPCELL_ROW_103_1847 vccd1 vssd1 SS_sky130_fd_sc_hd__tapvpwrvgnd_1
XFILLER_41_573 vssd1 vccd1 vssd1 vccd1 SS_sky130_ef_sc_hd__decap_40_12
XTAP_TAPCELL_ROW_136_2335 vccd1 vssd1 SS_sky130_fd_sc_hd__tapvpwrvgnd_1
XTAP_TAPCELL_ROW_136_2346 vccd1 vssd1 SS_sky130_fd_sc_hd__tapvpwrvgnd_1
XFILLER_127_601 vccd1 vssd1 vccd1 vssd1 SS_sky130_fd_sc_hd__fill_1
XFILLER_9_279 vccd1 vssd1 vccd1 vssd1 SS_sky130_fd_sc_hd__fill_1
XTAP_TAPCELL_ROW_11_465 vccd1 vssd1 SS_sky130_fd_sc_hd__tapvpwrvgnd_1
Xclkload16 clkload16/X _1755_/CLK vccd1 vssd1 vssd1 vccd1 SS_sky130_fd_sc_hd__clkbuf_8
XFILLER_126_133 vssd1 vccd1 vccd1 vssd1 SS_sky130_fd_sc_hd__fill_4
Xclkload27 clkload27/X _1745_/CLK vccd1 vssd1 vssd1 vccd1 SS_sky130_fd_sc_hd__clkbuf_8
XFILLER_5_441 vssd1 vccd1 vccd1 vssd1 SS_sky130_fd_sc_hd__fill_4
XFILLER_126_177 vssd1 vccd1 vssd1 vccd1 SS_sky130_ef_sc_hd__decap_40_12
XFILLER_5_485 vssd1 vccd1 vssd1 vccd1 SS_sky130_ef_sc_hd__decap_40_12
XFILLER_48_6 vssd1 vccd1 vssd1 vccd1 SS_sky130_ef_sc_hd__decap_40_12
XFILLER_107_391 vccd1 vssd1 vccd1 vssd1 SS_sky130_fd_sc_hd__fill_1
X_1420_ vccd1 vssd1 vccd1 vssd1 _1420_/X _1420_/A _1466_/B SS_sky130_fd_sc_hd__or2_2
X_1351_ vssd1 vccd1 vccd1 vssd1 _1369_/A2 input45/X _1702_/D _1417_/C1 _1350_/X SS_sky130_fd_sc_hd__o211a_2
XFILLER_68_404 vssd1 vccd1 vssd1 vccd1 SS_sky130_ef_sc_hd__decap_40_12
XFILLER_79_93 vssd1 vccd1 vssd1 vccd1 SS_sky130_ef_sc_hd__decap_40_12
XFILLER_96_713 vssd1 vccd1 vssd1 vccd1 SS_sky130_ef_sc_hd__decap_40_12
XFILLER_95_223 vccd1 vssd1 vccd1 vssd1 SS_sky130_fd_sc_hd__fill_1
X_1282_ vccd1 vssd1 vccd1 vssd1 _1282_/X _1893_/A _1338_/B SS_sky130_fd_sc_hd__or2_2
XFILLER_110_545 vssd1 vccd1 vssd1 vccd1 SS_sky130_ef_sc_hd__decap_40_12
XFILLER_96_757 vssd1 vccd1 vssd1 vccd1 SS_sky130_ef_sc_hd__decap_40_12
XFILLER_36_301 vssd1 vccd1 vccd1 vssd1 SS_sky130_fd_sc_hd__fill_4
XFILLER_49_673 vssd1 vccd1 vssd1 vccd1 SS_sky130_ef_sc_hd__decap_40_12
XFILLER_55_109 vssd1 vccd1 vccd1 vssd1 SS_sky130_fd_sc_hd__fill_2
XFILLER_110_589 vssd1 vccd1 vssd1 vccd1 SS_sky130_ef_sc_hd__decap_40_12
XFILLER_95_81 vssd1 vccd1 vssd1 vccd1 SS_sky130_ef_sc_hd__decap_40_12
XFILLER_36_345 vssd1 vccd1 vssd1 vccd1 SS_sky130_ef_sc_hd__decap_40_12
XTAP_TAPCELL_ROW_19_587 vccd1 vssd1 SS_sky130_fd_sc_hd__tapvpwrvgnd_1
XFILLER_24_529 vssd1 vccd1 vccd1 vssd1 SS_sky130_fd_sc_hd__fill_2
XFILLER_36_389 vssd1 vccd1 vssd1 vccd1 SS_sky130_ef_sc_hd__decap_40_12
XFILLER_51_337 vssd1 vccd1 vssd1 vccd1 SS_sky130_ef_sc_hd__decap_40_12
XFILLER_20_757 vssd1 vccd1 vccd1 vssd1 SS_sky130_fd_sc_hd__fill_2
XTAP_TAPCELL_ROW_30_752 vccd1 vssd1 SS_sky130_fd_sc_hd__tapvpwrvgnd_1
X_0997_ vssd1 vccd1 vccd1 vssd1 wire253/A input36/X _1531_/D _1327_/C1 _0996_/X SS_sky130_fd_sc_hd__o211a_2
XFILLER_118_601 vssd1 vccd1 vssd1 vccd1 SS_sky130_ef_sc_hd__decap_40_12
XFILLER_118_645 vssd1 vccd1 vssd1 vccd1 SS_sky130_ef_sc_hd__decap_40_12
XFILLER_117_111 vccd1 vssd1 vccd1 vssd1 SS_sky130_fd_sc_hd__fill_1
XTAP_TAPCELL_ROW_76_1437 vccd1 vssd1 SS_sky130_fd_sc_hd__tapvpwrvgnd_1
XFILLER_133_615 vccd1 vssd1 vccd1 vssd1 SS_sky130_fd_sc_hd__fill_1
X_1618_ _1618_/Q _1717_/CLK _1618_/D vccd1 vssd1 vccd1 vssd1 SS_sky130_fd_sc_hd__dfxtp_2
Xfanout203 vssd1 vccd1 vccd1 vssd1 wire207/A _1467_/A2 SS_sky130_fd_sc_hd__clkdlybuf4s25_1
XFILLER_99_573 vssd1 vccd1 vssd1 vccd1 SS_sky130_ef_sc_hd__decap_40_12
X_1549_ _1549_/Q clkload7/A _1549_/D vccd1 vssd1 vccd1 vssd1 SS_sky130_fd_sc_hd__dfxtp_2
Xfanout236 vssd1 vccd1 vccd1 vssd1 _1144_/X _1186_/B SS_sky130_fd_sc_hd__clkdlybuf4s25_1
XFILLER_86_245 vssd1 vccd1 vccd1 vssd1 SS_sky130_fd_sc_hd__fill_4
XFILLER_115_69 vssd1 vccd1 vssd1 vccd1 SS_sky130_ef_sc_hd__decap_40_12
XFILLER_28_813 vssd1 vccd1 vccd1 vssd1 SS_sky130_fd_sc_hd__fill_4
XFILLER_39_161 vssd1 vccd1 vccd1 vssd1 SS_sky130_fd_sc_hd__fill_4
XFILLER_46_109 vssd1 vccd1 vssd1 vccd1 SS_sky130_ef_sc_hd__decap_40_12
XFILLER_86_289 vssd1 vccd1 vssd1 vccd1 SS_sky130_ef_sc_hd__decap_40_12
XFILLER_67_492 vssd1 vccd1 vssd1 vccd1 SS_sky130_ef_sc_hd__decap_40_12
XTAP_TAPCELL_ROW_38_863 vccd1 vssd1 SS_sky130_fd_sc_hd__tapvpwrvgnd_1
XTAP_TAPCELL_ROW_38_874 vccd1 vssd1 SS_sky130_fd_sc_hd__tapvpwrvgnd_1
XFILLER_54_153 vssd1 vccd1 vssd1 vccd1 SS_sky130_ef_sc_hd__decap_40_12
XFILLER_82_462 vssd1 vccd1 vssd1 vccd1 SS_sky130_ef_sc_hd__decap_40_12
XFILLER_131_57 vssd1 vccd1 vssd1 vccd1 SS_sky130_ef_sc_hd__decap_40_12
XTAP_TAPCELL_ROW_120_2103 vccd1 vssd1 SS_sky130_fd_sc_hd__tapvpwrvgnd_1
XFILLER_15_529 vssd1 vccd1 vssd1 vccd1 SS_sky130_ef_sc_hd__decap_40_12
XFILLER_27_389 vssd1 vccd1 vccd1 vssd1 SS_sky130_fd_sc_hd__fill_2
XFILLER_54_197 vssd1 vccd1 vssd1 vccd1 SS_sky130_ef_sc_hd__decap_40_12
XFILLER_55_698 vssd1 vccd1 vssd1 vccd1 SS_sky130_ef_sc_hd__decap_40_12
XFILLER_70_613 vssd1 vccd1 vssd1 vccd1 SS_sky130_ef_sc_hd__decap_40_12
XFILLER_70_635 vccd1 vssd1 vccd1 vssd1 SS_sky130_fd_sc_hd__fill_1
XFILLER_82_495 vssd1 vccd1 vssd1 vccd1 SS_sky130_ef_sc_hd__decap_40_12
XTAP_TAPCELL_ROW_87_1599 vccd1 vssd1 SS_sky130_fd_sc_hd__tapvpwrvgnd_1
XFILLER_70_657 vssd1 vccd1 vccd1 vssd1 SS_sky130_fd_sc_hd__fill_4
XFILLER_23_573 vssd1 vccd1 vssd1 vccd1 SS_sky130_ef_sc_hd__decap_40_12
XFILLER_24_77 vssd1 vccd1 vccd1 vssd1 SS_sky130_fd_sc_hd__fill_4
XFILLER_10_245 vssd1 vccd1 vccd1 vssd1 SS_sky130_fd_sc_hd__fill_4
XFILLER_6_249 vssd1 vccd1 vccd1 vssd1 SS_sky130_fd_sc_hd__fill_2
XFILLER_10_289 vssd1 vccd1 vssd1 vccd1 SS_sky130_ef_sc_hd__decap_40_12
XTAP_TAPCELL_ROW_118_2076 vccd1 vssd1 SS_sky130_fd_sc_hd__tapvpwrvgnd_1
XTAP_TAPCELL_ROW_118_2065 vccd1 vssd1 SS_sky130_fd_sc_hd__tapvpwrvgnd_1
XFILLER_108_133 vssd1 vccd1 vccd1 vssd1 SS_sky130_fd_sc_hd__fill_4
XFILLER_40_65 vssd1 vccd1 vssd1 vccd1 SS_sky130_ef_sc_hd__decap_40_12
XFILLER_136_475 vccd1 vssd1 vccd1 vssd1 SS_sky130_fd_sc_hd__fill_1
XFILLER_108_177 vssd1 vccd1 vssd1 vccd1 SS_sky130_ef_sc_hd__decap_40_12
XTAP_TAPCELL_ROW_131_2265 vccd1 vssd1 SS_sky130_fd_sc_hd__tapvpwrvgnd_1
XFILLER_123_125 vssd1 vccd1 vssd1 vccd1 SS_sky130_ef_sc_hd__decap_40_12
XFILLER_2_433 vssd1 vccd1 vssd1 vccd1 SS_sky130_ef_sc_hd__decap_40_12
XFILLER_78_713 vssd1 vccd1 vssd1 vccd1 SS_sky130_ef_sc_hd__decap_40_12
XFILLER_123_169 vssd1 vccd1 vssd1 vccd1 SS_sky130_ef_sc_hd__decap_40_12
XFILLER_2_477 vssd1 vccd1 vssd1 vccd1 SS_sky130_ef_sc_hd__decap_40_12
XFILLER_77_223 vccd1 vssd1 vccd1 vssd1 SS_sky130_fd_sc_hd__fill_1
XFILLER_78_757 vssd1 vccd1 vssd1 vccd1 SS_sky130_ef_sc_hd__decap_40_12
XFILLER_18_301 vssd1 vccd1 vccd1 vssd1 SS_sky130_fd_sc_hd__fill_4
XFILLER_19_802 vssd1 vccd1 vccd1 vssd1 SS_sky130_fd_sc_hd__fill_4
XFILLER_37_109 vssd1 vccd1 vccd1 vssd1 SS_sky130_fd_sc_hd__fill_2
XFILLER_58_470 vssd1 vccd1 vccd1 vssd1 SS_sky130_fd_sc_hd__fill_4
XFILLER_65_429 vssd1 vccd1 vssd1 vccd1 SS_sky130_ef_sc_hd__decap_40_12
XFILLER_93_727 vccd1 vssd1 vccd1 vssd1 SS_sky130_fd_sc_hd__fill_1
XFILLER_93_716 vssd1 vccd1 vccd1 vssd1 SS_sky130_fd_sc_hd__fill_4
XFILLER_65_51 vssd1 vccd1 vccd1 vssd1 SS_sky130_fd_sc_hd__fill_4
XFILLER_93_749 vssd1 vccd1 vccd1 vssd1 SS_sky130_fd_sc_hd__fill_2
XFILLER_18_345 vssd1 vccd1 vssd1 vccd1 SS_sky130_ef_sc_hd__decap_40_12
XTAP_TAPCELL_ROW_47_1005 vccd1 vssd1 SS_sky130_fd_sc_hd__tapvpwrvgnd_1
XFILLER_18_389 vssd1 vccd1 vssd1 vccd1 SS_sky130_ef_sc_hd__decap_40_12
XFILLER_33_337 vssd1 vccd1 vssd1 vccd1 SS_sky130_ef_sc_hd__decap_40_12
XFILLER_73_473 vssd1 vccd1 vccd1 vssd1 SS_sky130_fd_sc_hd__fill_8
XTAP_TAPCELL_ROW_16_535 vccd1 vssd1 SS_sky130_fd_sc_hd__tapvpwrvgnd_1
XTAP_TAPCELL_ROW_16_546 vccd1 vssd1 SS_sky130_fd_sc_hd__tapvpwrvgnd_1
XFILLER_60_189 vssd1 vccd1 vccd1 vssd1 SS_sky130_fd_sc_hd__fill_4
XTAP_TAPCELL_ROW_60_1205 vccd1 vssd1 SS_sky130_fd_sc_hd__tapvpwrvgnd_1
X_0920_ vccd1 vssd1 vssd1 vccd1 _0917_/X _0919_/X _0932_/A2 hold797/X _1502_/D _1403_/C1
+ SS_sky130_fd_sc_hd__o221a_2
X_0851_ vccd1 vssd1 vccd1 vssd1 _1651_/Q _0894_/B1 _1861_/A wire445/X _0851_/X SS_sky130_fd_sc_hd__a22o_2
X_0782_ vccd1 vssd1 vssd1 vccd1 _0778_/X _0781_/X _0860_/A2 _1479_/Q _1479_/D _1299_/C1
+ SS_sky130_fd_sc_hd__o221a_2
XFILLER_115_615 vccd1 vssd1 vccd1 vssd1 SS_sky130_fd_sc_hd__fill_1
XTAP_TAPCELL_ROW_58_1167 vccd1 vssd1 SS_sky130_fd_sc_hd__tapvpwrvgnd_1
XFILLER_5_293 vssd1 vccd1 vssd1 vccd1 SS_sky130_ef_sc_hd__decap_40_12
XFILLER_102_309 vssd1 vccd1 vssd1 vccd1 SS_sky130_ef_sc_hd__decap_40_12
XPHY_EDGE_ROW_18_Right_18 vccd1 vssd1 vccd1 vssd1 SS_sky130_fd_sc_hd__decap_3
X_1403_ vssd1 vccd1 vccd1 vssd1 _1405_/A2 input41/X _1728_/D _1403_/C1 _1402_/X SS_sky130_fd_sc_hd__o211a_2
XFILLER_111_821 vssd1 vccd1 vccd1 vssd1 SS_sky130_fd_sc_hd__fill_2
XFILLER_68_245 vssd1 vccd1 vccd1 vssd1 SS_sky130_fd_sc_hd__fill_4
XTAP_TAPCELL_ROW_71_1367 vccd1 vssd1 SS_sky130_fd_sc_hd__tapvpwrvgnd_1
X_1334_ vccd1 vssd1 vccd1 vssd1 _1334_/X _1334_/A _1338_/B SS_sky130_fd_sc_hd__or2_2
XFILLER_96_565 vssd1 vccd1 vccd1 vssd1 SS_sky130_fd_sc_hd__fill_2
XFILLER_28_109 vssd1 vccd1 vssd1 vccd1 SS_sky130_ef_sc_hd__decap_40_12
XFILLER_68_289 vssd1 vccd1 vssd1 vccd1 SS_sky130_ef_sc_hd__decap_40_12
X_1265_ vssd1 vccd1 vccd1 vssd1 _1265_/A2 input38/X _1661_/D _1465_/C1 _1264_/X SS_sky130_fd_sc_hd__o211a_2
Xinput3 vssd1 vccd1 vccd1 vssd1 adc_data[11] input3/X SS_sky130_fd_sc_hd__clkdlybuf4s25_1
XFILLER_83_237 vssd1 vccd1 vssd1 vccd1 SS_sky130_ef_sc_hd__decap_40_12
XFILLER_25_805 vccd1 vssd1 vccd1 vssd1 SS_sky130_fd_sc_hd__fill_1
XFILLER_36_153 vssd1 vccd1 vssd1 vccd1 SS_sky130_ef_sc_hd__decap_40_12
X_1196_ vccd1 vssd1 vccd1 vssd1 _1196_/X _1196_/A _1208_/B SS_sky130_fd_sc_hd__or2_2
XTAP_TAPCELL_ROW_35_822 vccd1 vssd1 SS_sky130_fd_sc_hd__tapvpwrvgnd_1
XFILLER_64_495 vccd1 vssd1 vccd1 vssd1 SS_sky130_fd_sc_hd__fill_1
XFILLER_91_281 vssd1 vccd1 vssd1 vccd1 SS_sky130_ef_sc_hd__decap_40_12
XPHY_EDGE_ROW_27_Right_27 vccd1 vssd1 vccd1 vssd1 SS_sky130_fd_sc_hd__decap_3
XFILLER_36_197 vssd1 vccd1 vssd1 vccd1 SS_sky130_ef_sc_hd__decap_40_12
XFILLER_40_808 vssd1 vccd1 vccd1 vssd1 SS_sky130_fd_sc_hd__fill_4
XFILLER_52_657 vssd1 vccd1 vssd1 vccd1 SS_sky130_ef_sc_hd__decap_40_12
XFILLER_51_167 vccd1 vssd1 vccd1 vssd1 SS_sky130_fd_sc_hd__fill_1
XFILLER_60_690 vssd1 vccd1 vccd1 vssd1 SS_sky130_fd_sc_hd__fill_8
XFILLER_137_217 vccd1 vssd1 vccd1 vssd1 SS_sky130_fd_sc_hd__fill_1
XFILLER_20_587 vccd1 vssd1 vccd1 vssd1 SS_sky130_fd_sc_hd__fill_1
XFILLER_118_475 vccd1 vssd1 vccd1 vssd1 SS_sky130_fd_sc_hd__fill_1
XFILLER_105_125 vssd1 vccd1 vssd1 vccd1 SS_sky130_ef_sc_hd__decap_40_12
XPHY_EDGE_ROW_36_Right_36 vccd1 vssd1 vccd1 vssd1 SS_sky130_fd_sc_hd__decap_3
XFILLER_133_478 vccd1 vssd1 vccd1 vssd1 SS_sky130_fd_sc_hd__fill_1
XFILLER_105_169 vssd1 vccd1 vssd1 vccd1 SS_sky130_ef_sc_hd__decap_40_12
XFILLER_114_681 vssd1 vccd1 vssd1 vccd1 SS_sky130_ef_sc_hd__decap_40_12
XFILLER_59_223 vccd1 vssd1 vccd1 vssd1 SS_sky130_fd_sc_hd__fill_1
XFILLER_87_543 vssd1 vccd1 vssd1 vccd1 SS_sky130_ef_sc_hd__decap_40_12
XFILLER_120_139 vccd1 vssd1 vccd1 vssd1 SS_sky130_fd_sc_hd__fill_1
XFILLER_19_55 vccd1 vssd1 vccd1 vssd1 SS_sky130_fd_sc_hd__fill_1
XFILLER_19_109 vssd1 vccd1 vccd1 vssd1 SS_sky130_fd_sc_hd__fill_2
XFILLER_47_407 vssd1 vccd1 vssd1 vccd1 SS_sky130_ef_sc_hd__decap_40_12
XFILLER_87_598 vssd1 vccd1 vssd1 vccd1 SS_sky130_ef_sc_hd__decap_40_12
XTAP_TAPCELL_ROW_89_1628 vccd1 vssd1 SS_sky130_fd_sc_hd__tapvpwrvgnd_1
XTAP_TAPCELL_ROW_89_1639 vccd1 vssd1 SS_sky130_fd_sc_hd__tapvpwrvgnd_1
XFILLER_28_643 vccd1 vssd1 vccd1 vssd1 SS_sky130_fd_sc_hd__fill_1
XFILLER_16_805 vssd1 vccd1 vccd1 vssd1 SS_sky130_fd_sc_hd__fill_4
XFILLER_90_719 vssd1 vccd1 vssd1 vccd1 SS_sky130_ef_sc_hd__decap_40_12
XFILLER_43_613 vssd1 vccd1 vccd1 vssd1 SS_sky130_fd_sc_hd__fill_2
XPHY_EDGE_ROW_45_Right_45 vccd1 vssd1 vccd1 vssd1 SS_sky130_fd_sc_hd__decap_3
XFILLER_70_421 vccd1 vssd1 vccd1 vssd1 SS_sky130_fd_sc_hd__fill_1
XFILLER_15_337 vssd1 vccd1 vssd1 vccd1 SS_sky130_ef_sc_hd__decap_40_12
XFILLER_30_307 vccd1 vssd1 vccd1 vssd1 SS_sky130_fd_sc_hd__fill_1
XTAP_TAPCELL_ROW_100_1806 vccd1 vssd1 SS_sky130_fd_sc_hd__tapvpwrvgnd_1
XFILLER_42_189 vssd1 vccd1 vccd1 vssd1 SS_sky130_fd_sc_hd__fill_4
XFILLER_7_503 vccd1 vssd1 vccd1 vssd1 SS_sky130_fd_sc_hd__fill_1
XFILLER_51_42 vssd1 vccd1 vssd1 vccd1 SS_sky130_ef_sc_hd__decap_40_12
Xwire412 vccd1 vssd1 vssd1 vccd1 wire412/A analog_ctrl[69] SS_sky130_fd_sc_hd__buf_12
Xwire401 vccd1 vssd1 vssd1 vccd1 wire401/A analog_ctrl[80] SS_sky130_fd_sc_hd__buf_12
XFILLER_129_729 vssd1 vccd1 vssd1 vccd1 SS_sky130_ef_sc_hd__decap_40_12
Xwire467 vccd1 vssd1 wire467/X wire467/A vccd1 vssd1 SS_sky130_fd_sc_hd__buf_4
Xwire445 vccd1 vssd1 wire445/X wire445/A vccd1 vssd1 SS_sky130_fd_sc_hd__buf_4
XPHY_EDGE_ROW_54_Right_54 vccd1 vssd1 vccd1 vssd1 SS_sky130_fd_sc_hd__decap_3
XFILLER_124_412 vssd1 vccd1 vccd1 vssd1 SS_sky130_fd_sc_hd__fill_8
XFILLER_3_753 vssd1 vccd1 vssd1 vccd1 SS_sky130_ef_sc_hd__decap_40_12
XFILLER_3_797 vssd1 vccd1 vssd1 vccd1 SS_sky130_ef_sc_hd__decap_40_12
Xload_slew428 vccd1 vssd1 _0894_/B1 _1211_/A vccd1 vssd1 SS_sky130_fd_sc_hd__buf_4
XTAP_TAPCELL_ROW_111_1968 vccd1 vssd1 SS_sky130_fd_sc_hd__tapvpwrvgnd_1
XTAP_TAPCELL_ROW_53_1097 vccd1 vssd1 SS_sky130_fd_sc_hd__tapvpwrvgnd_1
XFILLER_78_565 vccd1 vssd1 vccd1 vssd1 SS_sky130_fd_sc_hd__fill_1
XFILLER_120_651 vccd1 vssd1 vccd1 vssd1 SS_sky130_fd_sc_hd__fill_1
XFILLER_65_237 vssd1 vccd1 vssd1 vccd1 SS_sky130_ef_sc_hd__decap_40_12
XFILLER_76_83 vccd1 vssd1 vccd1 vssd1 SS_sky130_fd_sc_hd__fill_1
XFILLER_19_665 vssd1 vccd1 vccd1 vssd1 SS_sky130_fd_sc_hd__fill_4
XPHY_EDGE_ROW_63_Right_63 vccd1 vssd1 vccd1 vssd1 SS_sky130_fd_sc_hd__decap_3
X_1050_ vccd1 vssd1 vccd1 vssd1 _1050_/X _1050_/A _1050_/B SS_sky130_fd_sc_hd__or2_2
XFILLER_81_719 vssd1 vccd1 vccd1 vssd1 SS_sky130_fd_sc_hd__fill_8
XFILLER_93_579 vssd1 vccd1 vssd1 vccd1 SS_sky130_ef_sc_hd__decap_40_12
XFILLER_93_557 vssd1 vccd1 vccd1 vssd1 SS_sky130_fd_sc_hd__fill_2
XFILLER_18_153 vssd1 vccd1 vssd1 vccd1 SS_sky130_ef_sc_hd__decap_40_12
XFILLER_34_613 vssd1 vccd1 vssd1 vccd1 SS_sky130_ef_sc_hd__decap_40_12
XFILLER_74_793 vssd1 vccd1 vssd1 vccd1 SS_sky130_ef_sc_hd__decap_40_12
XFILLER_18_197 vssd1 vccd1 vssd1 vccd1 SS_sky130_ef_sc_hd__decap_40_12
XFILLER_34_657 vssd1 vccd1 vssd1 vccd1 SS_sky130_ef_sc_hd__decap_40_12
XFILLER_73_281 vssd1 vccd1 vssd1 vccd1 SS_sky130_ef_sc_hd__decap_40_12
XFILLER_33_167 vccd1 vssd1 vccd1 vssd1 SS_sky130_fd_sc_hd__fill_1
XFILLER_61_465 vssd1 vccd1 vccd1 vssd1 SS_sky130_fd_sc_hd__fill_2
XFILLER_21_329 vssd1 vccd1 vccd1 vssd1 SS_sky130_fd_sc_hd__fill_4
X_0903_ vccd1 vssd1 vccd1 vssd1 _1564_/Q _1012_/A _1596_/Q wire445/A _0903_/X SS_sky130_fd_sc_hd__a22o_2
XFILLER_119_217 vssd1 vccd1 vccd1 vssd1 SS_sky130_fd_sc_hd__fill_4
X_1883_ vccd1 vssd1 _1883_/X _1883_/A vccd1 vssd1 SS_sky130_fd_sc_hd__buf_2
X_0834_ vccd1 vssd1 vccd1 vssd1 _1552_/Q wire424/A _1876_/A _0876_/B1 _0834_/X SS_sky130_fd_sc_hd__a22o_2
XPHY_EDGE_ROW_72_Right_72 vccd1 vssd1 vccd1 vssd1 SS_sky130_fd_sc_hd__decap_3
XFILLER_128_751 vssd1 vccd1 vccd1 vssd1 SS_sky130_fd_sc_hd__fill_4
XFILLER_134_209 vssd1 vccd1 vssd1 vccd1 SS_sky130_ef_sc_hd__decap_40_12
X_0765_ vccd1 vssd1 vccd1 vssd1 _1828_/A wire424/X _1843_/A wire443/X _0765_/X SS_sky130_fd_sc_hd__a22o_2
XFILLER_127_261 vssd1 vccd1 vssd1 vccd1 SS_sky130_ef_sc_hd__decap_40_12
XFILLER_88_307 vccd1 vssd1 vccd1 vssd1 SS_sky130_fd_sc_hd__fill_1
XFILLER_115_445 vssd1 vccd1 vccd1 vssd1 SS_sky130_fd_sc_hd__fill_2
XFILLER_115_478 vssd1 vccd1 vccd1 vssd1 SS_sky130_fd_sc_hd__fill_4
XFILLER_102_139 vccd1 vssd1 vccd1 vssd1 SS_sky130_fd_sc_hd__fill_1
XFILLER_97_841 vccd1 vssd1 vccd1 vssd1 SS_sky130_fd_sc_hd__fill_1
XFILLER_111_673 vssd1 vccd1 vssd1 vccd1 SS_sky130_ef_sc_hd__decap_40_12
XFILLER_111_651 vssd1 vccd1 vssd1 vccd1 SS_sky130_ef_sc_hd__decap_40_12
XPHY_EDGE_ROW_16_Left_155 vccd1 vssd1 vccd1 vssd1 SS_sky130_fd_sc_hd__decap_3
XFILLER_29_429 vssd1 vccd1 vssd1 vccd1 SS_sky130_ef_sc_hd__decap_40_12
XPHY_EDGE_ROW_81_Right_81 vccd1 vssd1 vccd1 vssd1 SS_sky130_fd_sc_hd__decap_3
X_1317_ vssd1 vccd1 vccd1 vssd1 _1325_/A2 input30/X _1686_/D _1381_/C1 _1316_/X SS_sky130_fd_sc_hd__o211a_2
XFILLER_96_395 vssd1 vccd1 vssd1 vccd1 SS_sky130_ef_sc_hd__decap_40_12
XFILLER_84_557 vssd1 vccd1 vssd1 vccd1 SS_sky130_ef_sc_hd__decap_40_12
X_1248_ vccd1 vssd1 vccd1 vssd1 _1248_/X _1653_/Q _1264_/B SS_sky130_fd_sc_hd__or2_2
XFILLER_112_15 vssd1 vccd1 vssd1 vccd1 SS_sky130_ef_sc_hd__decap_40_12
XFILLER_25_613 vssd1 vccd1 vccd1 vssd1 SS_sky130_fd_sc_hd__fill_2
XFILLER_37_473 vssd1 vccd1 vssd1 vccd1 SS_sky130_ef_sc_hd__decap_40_12
XFILLER_65_782 vssd1 vccd1 vccd1 vssd1 SS_sky130_fd_sc_hd__fill_2
XFILLER_65_793 vccd1 vssd1 vccd1 vssd1 SS_sky130_fd_sc_hd__fill_1
XTAP_TAPCELL_ROW_84_1558 vccd1 vssd1 SS_sky130_fd_sc_hd__tapvpwrvgnd_1
X_1179_ vssd1 vccd1 vccd1 vssd1 _1195_/A2 input27/X _1619_/D _1309_/C1 _1178_/X SS_sky130_fd_sc_hd__o211a_2
XFILLER_12_307 vccd1 vssd1 vccd1 vssd1 SS_sky130_fd_sc_hd__fill_1
XFILLER_21_841 vccd1 vssd1 vccd1 vssd1 SS_sky130_fd_sc_hd__fill_1
XFILLER_24_189 vssd1 vccd1 vccd1 vssd1 SS_sky130_fd_sc_hd__fill_4
XPHY_EDGE_ROW_25_Left_164 vccd1 vssd1 vccd1 vssd1 SS_sky130_fd_sc_hd__decap_3
XPHY_EDGE_ROW_90_Right_90 vccd1 vssd1 vccd1 vssd1 SS_sky130_fd_sc_hd__decap_3
XFILLER_138_559 vccd1 vssd1 vccd1 vssd1 SS_sky130_fd_sc_hd__fill_1
XTAP_TAPCELL_ROW_115_2024 vccd1 vssd1 SS_sky130_fd_sc_hd__tapvpwrvgnd_1
XTAP_TAPCELL_ROW_99_1790 vccd1 vssd1 SS_sky130_fd_sc_hd__tapvpwrvgnd_1
XFILLER_134_710 vccd1 vssd1 vccd1 vssd1 SS_sky130_fd_sc_hd__fill_1
XFILLER_134_776 vssd1 vccd1 vssd1 vccd1 SS_sky130_ef_sc_hd__decap_40_12
XFILLER_137_89 vssd1 vccd1 vccd1 vssd1 SS_sky130_fd_sc_hd__fill_2
XFILLER_97_27 vssd1 vccd1 vssd1 vccd1 SS_sky130_ef_sc_hd__decap_40_12
XFILLER_0_701 vssd1 vccd1 vssd1 vccd1 SS_sky130_ef_sc_hd__decap_40_12
XFILLER_134_798 vccd1 vssd1 vccd1 vssd1 SS_sky130_fd_sc_hd__fill_1
Xoutput170 vccd1 vssd1 wire385/A _1474_/Q vccd1 vssd1 SS_sky130_fd_sc_hd__buf_4
Xoutput181 vccd1 vssd1 wire374/A _1494_/Q vccd1 vssd1 SS_sky130_fd_sc_hd__buf_4
Xoutput192 vccd1 vssd1 wire363/A _1504_/Q vccd1 vssd1 SS_sky130_fd_sc_hd__buf_4
XTAP_TAPCELL_ROW_7_399 vccd1 vssd1 SS_sky130_fd_sc_hd__tapvpwrvgnd_1
XPHY_EDGE_ROW_34_Left_173 vccd1 vssd1 vccd1 vssd1 SS_sky130_fd_sc_hd__decap_3
XFILLER_102_673 vccd1 vssd1 vccd1 vssd1 SS_sky130_fd_sc_hd__fill_1
XFILLER_47_237 vssd1 vccd1 vssd1 vccd1 SS_sky130_ef_sc_hd__decap_40_12
XFILLER_101_161 vssd1 vccd1 vccd1 vssd1 SS_sky130_fd_sc_hd__fill_4
XFILLER_75_557 vssd1 vccd1 vccd1 vssd1 SS_sky130_fd_sc_hd__fill_2
XFILLER_16_613 vssd1 vccd1 vssd1 vccd1 SS_sky130_ef_sc_hd__decap_40_12
XFILLER_28_473 vssd1 vccd1 vccd1 vssd1 SS_sky130_fd_sc_hd__fill_2
XFILLER_46_53 vssd1 vccd1 vssd1 vccd1 SS_sky130_ef_sc_hd__decap_40_12
XTAP_TAPCELL_ROW_126_2197 vccd1 vssd1 SS_sky130_fd_sc_hd__tapvpwrvgnd_1
XTAP_TAPCELL_ROW_126_2186 vccd1 vssd1 SS_sky130_fd_sc_hd__tapvpwrvgnd_1
XFILLER_16_657 vssd1 vccd1 vssd1 vccd1 SS_sky130_ef_sc_hd__decap_40_12
XFILLER_43_421 vssd1 vccd1 vccd1 vssd1 SS_sky130_fd_sc_hd__fill_2
XFILLER_46_97 vssd1 vccd1 vssd1 vccd1 SS_sky130_ef_sc_hd__decap_40_12
XFILLER_55_281 vssd1 vccd1 vssd1 vccd1 SS_sky130_ef_sc_hd__decap_40_12
XFILLER_15_167 vccd1 vssd1 vccd1 vssd1 SS_sky130_fd_sc_hd__fill_1
XFILLER_16_679 vccd1 vssd1 vccd1 vssd1 SS_sky130_fd_sc_hd__fill_1
XFILLER_70_251 vccd1 vssd1 vccd1 vssd1 SS_sky130_fd_sc_hd__fill_1
XFILLER_102_81 vssd1 vccd1 vccd1 vssd1 SS_sky130_fd_sc_hd__fill_2
XTAP_TAPCELL_ROW_26_685 vccd1 vssd1 SS_sky130_fd_sc_hd__tapvpwrvgnd_1
XTAP_TAPCELL_ROW_26_696 vccd1 vssd1 SS_sky130_fd_sc_hd__tapvpwrvgnd_1
XFILLER_30_137 vssd1 vccd1 vccd1 vssd1 SS_sky130_fd_sc_hd__fill_2
XPHY_EDGE_ROW_43_Left_182 vccd1 vssd1 vccd1 vssd1 SS_sky130_fd_sc_hd__decap_3
XFILLER_62_41 vssd1 vccd1 vssd1 vccd1 SS_sky130_ef_sc_hd__decap_40_12
XFILLER_62_85 vssd1 vccd1 vssd1 vccd1 SS_sky130_ef_sc_hd__decap_40_12
XFILLER_7_333 vssd1 vccd1 vccd1 vssd1 SS_sky130_fd_sc_hd__fill_2
XFILLER_11_373 vssd1 vccd1 vssd1 vccd1 SS_sky130_ef_sc_hd__decap_40_12
XFILLER_7_69 vssd1 vccd1 vssd1 vccd1 SS_sky130_ef_sc_hd__decap_40_12
Xwire275 vccd1 vssd1 vssd1 vccd1 wire275/A analog_ctrl[20] SS_sky130_fd_sc_hd__buf_12
Xwire264 vccd1 vssd1 vssd1 vccd1 wire264/A analog_ctrl[30] SS_sky130_fd_sc_hd__buf_12
Xwire253 vccd1 vssd1 wire253/X wire253/A vccd1 vssd1 SS_sky130_fd_sc_hd__buf_4
XFILLER_116_209 vssd1 vccd1 vssd1 vccd1 SS_sky130_ef_sc_hd__decap_40_12
Xwire286 vccd1 vssd1 vssd1 vccd1 wire286/A analog_ctrl[121] SS_sky130_fd_sc_hd__buf_12
Xwire297 vccd1 vssd1 vssd1 vccd1 wire297/A analog_ctrl[111] SS_sky130_fd_sc_hd__buf_12
XFILLER_109_261 vssd1 vccd1 vssd1 vccd1 SS_sky130_ef_sc_hd__decap_40_12
XFILLER_3_561 vssd1 vccd1 vssd1 vccd1 SS_sky130_ef_sc_hd__decap_40_12
XTAP_TAPCELL_ROW_55_1126 vccd1 vssd1 SS_sky130_fd_sc_hd__tapvpwrvgnd_1
XFILLER_124_253 vssd1 vccd1 vssd1 vccd1 SS_sky130_ef_sc_hd__decap_40_12
XPHY_EDGE_ROW_52_Left_191 vccd1 vssd1 vccd1 vssd1 SS_sky130_fd_sc_hd__decap_3
XFILLER_79_841 vccd1 vssd1 vccd1 vssd1 SS_sky130_fd_sc_hd__fill_1
Xload_slew214 vccd1 vssd1 _1385_/A2 _1391_/A2 vccd1 vssd1 SS_sky130_fd_sc_hd__buf_4
XFILLER_97_137 vssd1 vccd1 vssd1 vccd1 SS_sky130_ef_sc_hd__decap_40_12
Xload_slew247 vccd1 vssd1 _1033_/A2 _1051_/A2 vccd1 vssd1 SS_sky130_fd_sc_hd__buf_4
XFILLER_87_93 vssd1 vccd1 vssd1 vccd1 SS_sky130_ef_sc_hd__decap_40_12
Xload_slew258 vccd1 vssd1 _1006_/B _1008_/B vccd1 vssd1 SS_sky130_fd_sc_hd__buf_4
X_1102_ vccd1 vssd1 vccd1 vssd1 _1102_/X _1102_/A _1116_/B SS_sky130_fd_sc_hd__or2_2
XFILLER_81_505 vssd1 vccd1 vssd1 vccd1 SS_sky130_ef_sc_hd__decap_40_12
XFILLER_19_473 vssd1 vccd1 vssd1 vccd1 SS_sky130_ef_sc_hd__decap_40_12
X_1033_ vssd1 vccd1 vccd1 vssd1 _1033_/A2 wire494/X _1548_/D _1165_/C1 _1032_/X SS_sky130_fd_sc_hd__o211a_2
XFILLER_34_421 vssd1 vccd1 vssd1 vccd1 SS_sky130_ef_sc_hd__decap_40_12
XTAP_TAPCELL_ROW_45_972 vccd1 vssd1 SS_sky130_fd_sc_hd__tapvpwrvgnd_1
XTAP_TAPCELL_ROW_66_1288 vccd1 vssd1 SS_sky130_fd_sc_hd__tapvpwrvgnd_1
XFILLER_22_627 vssd1 vccd1 vssd1 vccd1 SS_sky130_ef_sc_hd__decap_40_12
XFILLER_61_273 vssd1 vccd1 vccd1 vssd1 SS_sky130_fd_sc_hd__fill_4
XFILLER_21_137 vssd1 vccd1 vssd1 vccd1 SS_sky130_ef_sc_hd__decap_40_12
X_1866_ vccd1 vssd1 _1866_/X _1866_/A vccd1 vssd1 SS_sky130_fd_sc_hd__buf_2
X_0817_ vssd1 vccd1 vssd1 vccd1 wire421/A _0968_/A _0815_/X _0816_/X _0817_/X wire347/X
+ SS_sky130_fd_sc_hd__a2111o_2
Xhold812 hold812/X _1488_/Q vccd1 vssd1 vssd1 vccd1 SS_sky130_fd_sc_hd__dlygate4sd3_1
Xhold801 hold801/X _1493_/Q vccd1 vssd1 vssd1 vccd1 SS_sky130_fd_sc_hd__dlygate4sd3_1
Xinput50 vssd1 vccd1 wire495/A input50/A vccd1 vssd1 SS_sky130_fd_sc_hd__buf_1
XFILLER_116_721 vssd1 vccd1 vssd1 vccd1 SS_sky130_ef_sc_hd__decap_40_12
X_0748_ vssd1 vccd1 vssd1 vccd1 _0754_/D _0748_/X _0755_/C _0755_/A _0755_/B SS_sky130_fd_sc_hd__and4bb_2
XFILLER_107_15 vssd1 vccd1 vssd1 vccd1 SS_sky130_ef_sc_hd__decap_40_12
XFILLER_88_137 vssd1 vccd1 vccd1 vssd1 SS_sky130_fd_sc_hd__fill_2
XFILLER_57_502 vssd1 vccd1 vccd1 vssd1 SS_sky130_fd_sc_hd__fill_2
XFILLER_130_245 vssd1 vccd1 vccd1 vssd1 SS_sky130_fd_sc_hd__fill_4
XTAP_TAPCELL_ROW_4_358 vccd1 vssd1 SS_sky130_fd_sc_hd__tapvpwrvgnd_1
XFILLER_69_373 vssd1 vccd1 vssd1 vccd1 SS_sky130_ef_sc_hd__decap_40_12
XFILLER_130_289 vssd1 vccd1 vccd1 vssd1 SS_sky130_fd_sc_hd__fill_2
XFILLER_29_237 vssd1 vccd1 vssd1 vccd1 SS_sky130_ef_sc_hd__decap_40_12
XFILLER_57_557 vssd1 vccd1 vccd1 vssd1 SS_sky130_fd_sc_hd__fill_2
XFILLER_72_516 vssd1 vccd1 vccd1 vssd1 SS_sky130_fd_sc_hd__fill_2
XFILLER_83_18 vssd1 vccd1 vssd1 vccd1 SS_sky130_ef_sc_hd__decap_40_12
XFILLER_84_365 vssd1 vccd1 vssd1 vccd1 SS_sky130_ef_sc_hd__decap_40_12
XFILLER_123_69 vssd1 vccd1 vssd1 vccd1 SS_sky130_ef_sc_hd__decap_40_12
XFILLER_37_281 vssd1 vccd1 vssd1 vccd1 SS_sky130_ef_sc_hd__decap_40_12
XFILLER_53_741 vssd1 vccd1 vccd1 vssd1 SS_sky130_fd_sc_hd__fill_4
XPHY_EDGE_ROW_0_Right_0 vccd1 vssd1 vccd1 vssd1 SS_sky130_fd_sc_hd__decap_3
XFILLER_52_251 vccd1 vssd1 vccd1 vssd1 SS_sky130_fd_sc_hd__fill_1
XFILLER_53_774 vssd1 vccd1 vccd1 vssd1 SS_sky130_fd_sc_hd__fill_8
XFILLER_53_785 vssd1 vccd1 vssd1 vccd1 SS_sky130_ef_sc_hd__decap_40_12
XFILLER_80_571 vssd1 vccd1 vssd1 vccd1 SS_sky130_ef_sc_hd__decap_40_12
XFILLER_40_413 vssd1 vccd1 vccd1 vssd1 SS_sky130_fd_sc_hd__fill_4
XFILLER_9_609 vssd1 vccd1 vccd1 vssd1 SS_sky130_fd_sc_hd__fill_4
XFILLER_12_137 vssd1 vccd1 vccd1 vssd1 SS_sky130_fd_sc_hd__fill_2
XTAP_TAPCELL_ROW_23_644 vccd1 vssd1 SS_sky130_fd_sc_hd__tapvpwrvgnd_1
XFILLER_40_457 vssd1 vccd1 vccd1 vssd1 SS_sky130_fd_sc_hd__fill_4
XFILLER_21_671 vccd1 vssd1 vccd1 vssd1 SS_sky130_fd_sc_hd__fill_1
XFILLER_138_334 vssd1 vccd1 vccd1 vssd1 SS_sky130_fd_sc_hd__fill_2
XFILLER_138_312 vssd1 vccd1 vccd1 vssd1 SS_sky130_fd_sc_hd__fill_2
XFILLER_32_77 vssd1 vccd1 vccd1 vssd1 SS_sky130_fd_sc_hd__fill_4
XTAP_TAPCELL_ROW_97_1749 vccd1 vssd1 SS_sky130_fd_sc_hd__tapvpwrvgnd_1
XFILLER_5_837 vssd1 vccd1 vccd1 vssd1 SS_sky130_fd_sc_hd__fill_2
XFILLER_106_253 vssd1 vccd1 vssd1 vccd1 SS_sky130_ef_sc_hd__decap_40_12
XFILLER_0_531 vccd1 vssd1 vccd1 vssd1 SS_sky130_fd_sc_hd__fill_1
XFILLER_79_137 vssd1 vccd1 vssd1 vccd1 SS_sky130_ef_sc_hd__decap_40_12
XFILLER_122_757 vssd1 vccd1 vssd1 vccd1 SS_sky130_ef_sc_hd__decap_40_12
XFILLER_122_746 vssd1 vccd1 vccd1 vssd1 SS_sky130_fd_sc_hd__fill_8
XFILLER_121_223 vccd1 vssd1 vccd1 vssd1 SS_sky130_fd_sc_hd__fill_1
XFILLER_88_671 vssd1 vccd1 vssd1 vccd1 SS_sky130_ef_sc_hd__decap_40_12
XTAP_TAPCELL_ROW_128_2215 vccd1 vssd1 SS_sky130_fd_sc_hd__tapvpwrvgnd_1
XTAP_TAPCELL_ROW_128_2226 vccd1 vssd1 SS_sky130_fd_sc_hd__tapvpwrvgnd_1
XFILLER_48_513 vssd1 vccd1 vssd1 vccd1 SS_sky130_ef_sc_hd__decap_40_12
XTAP_TAPCELL_ROW_50_1045 vccd1 vssd1 SS_sky130_fd_sc_hd__tapvpwrvgnd_1
XFILLER_87_181 vssd1 vccd1 vssd1 vccd1 SS_sky130_ef_sc_hd__decap_40_12
XFILLER_102_470 vccd1 vssd1 vccd1 vssd1 SS_sky130_fd_sc_hd__fill_1
XFILLER_48_557 vssd1 vccd1 vccd1 vssd1 SS_sky130_fd_sc_hd__fill_8
XTAP_TAPCELL_ROW_50_1056 vccd1 vssd1 SS_sky130_fd_sc_hd__tapvpwrvgnd_1
XFILLER_63_505 vssd1 vccd1 vssd1 vccd1 SS_sky130_ef_sc_hd__decap_40_12
XFILLER_75_365 vssd1 vccd1 vssd1 vccd1 SS_sky130_ef_sc_hd__decap_40_12
XFILLER_16_421 vssd1 vccd1 vssd1 vccd1 SS_sky130_ef_sc_hd__decap_40_12
XFILLER_90_335 vssd1 vccd1 vssd1 vccd1 SS_sky130_ef_sc_hd__decap_40_12
XPHY_EDGE_ROW_121_Right_121 vccd1 vssd1 vccd1 vssd1 SS_sky130_fd_sc_hd__decap_3
XTAP_TAPCELL_ROW_106_1889 vccd1 vssd1 SS_sky130_fd_sc_hd__tapvpwrvgnd_1
XTAP_TAPCELL_ROW_42_931 vccd1 vssd1 SS_sky130_fd_sc_hd__tapvpwrvgnd_1
XFILLER_43_273 vssd1 vccd1 vccd1 vssd1 SS_sky130_fd_sc_hd__fill_4
XFILLER_71_582 vssd1 vccd1 vccd1 vssd1 SS_sky130_fd_sc_hd__fill_2
XFILLER_71_593 vssd1 vccd1 vssd1 vccd1 SS_sky130_ef_sc_hd__decap_40_12
XFILLER_129_334 vssd1 vccd1 vccd1 vssd1 SS_sky130_fd_sc_hd__fill_2
XFILLER_11_181 vssd1 vccd1 vssd1 vccd1 SS_sky130_ef_sc_hd__decap_40_12
XFILLER_12_693 vssd1 vccd1 vccd1 vssd1 SS_sky130_fd_sc_hd__fill_4
XFILLER_78_6 vssd1 vccd1 vssd1 vccd1 SS_sky130_ef_sc_hd__decap_40_12
X_1720_ _1720_/Q _1752_/CLK _1720_/D vccd1 vssd1 vccd1 vssd1 SS_sky130_fd_sc_hd__dfxtp_2
XFILLER_8_697 vssd1 vccd1 vccd1 vssd1 SS_sky130_fd_sc_hd__fill_2
X_1651_ _1651_/Q _1717_/CLK _1651_/D vccd1 vssd1 vccd1 vssd1 SS_sky130_fd_sc_hd__dfxtp_2
XFILLER_117_529 vssd1 vccd1 vssd1 vccd1 SS_sky130_ef_sc_hd__decap_40_12
X_1582_ _1856_/A clkload3/A _1582_/D vccd1 vssd1 vccd1 vssd1 SS_sky130_fd_sc_hd__dfxtp_2
XFILLER_125_573 vssd1 vccd1 vssd1 vccd1 SS_sky130_ef_sc_hd__decap_40_12
XFILLER_98_457 vssd1 vccd1 vssd1 vccd1 SS_sky130_ef_sc_hd__decap_40_12
XFILLER_98_81 vssd1 vccd1 vccd1 vssd1 SS_sky130_fd_sc_hd__fill_2
XFILLER_3_391 vccd1 vssd1 vccd1 vssd1 SS_sky130_fd_sc_hd__fill_1
XFILLER_113_768 vssd1 vccd1 vssd1 vccd1 SS_sky130_ef_sc_hd__decap_40_12
XFILLER_112_245 vssd1 vccd1 vccd1 vssd1 SS_sky130_fd_sc_hd__fill_4
XFILLER_66_321 vssd1 vccd1 vssd1 vccd1 SS_sky130_ef_sc_hd__decap_40_12
XFILLER_79_671 vccd1 vssd1 vccd1 vssd1 SS_sky130_fd_sc_hd__fill_1
XFILLER_112_289 vssd1 vccd1 vccd1 vssd1 SS_sky130_fd_sc_hd__fill_8
XTAP_TAPCELL_ROW_1_317 vccd1 vssd1 SS_sky130_fd_sc_hd__tapvpwrvgnd_1
XFILLER_66_365 vssd1 vccd1 vssd1 vccd1 SS_sky130_ef_sc_hd__decap_40_12
XFILLER_66_387 vssd1 vccd1 vccd1 vssd1 SS_sky130_fd_sc_hd__fill_2
XTAP_TAPCELL_ROW_68_1317 vccd1 vssd1 SS_sky130_fd_sc_hd__tapvpwrvgnd_1
XFILLER_94_674 vssd1 vccd1 vssd1 vccd1 SS_sky130_ef_sc_hd__decap_40_12
XFILLER_19_281 vssd1 vccd1 vssd1 vccd1 SS_sky130_ef_sc_hd__decap_40_12
XFILLER_35_741 vssd1 vccd1 vccd1 vssd1 SS_sky130_fd_sc_hd__fill_4
XFILLER_54_549 vssd1 vccd1 vccd1 vssd1 SS_sky130_fd_sc_hd__fill_2
XFILLER_66_398 vssd1 vccd1 vssd1 vccd1 SS_sky130_ef_sc_hd__decap_40_12
X_1016_ vccd1 vssd1 vccd1 vssd1 _1016_/X _1827_/A _1050_/B SS_sky130_fd_sc_hd__or2_2
XFILLER_34_251 vccd1 vssd1 vccd1 vssd1 SS_sky130_fd_sc_hd__fill_1
XFILLER_62_560 vssd1 vccd1 vssd1 vccd1 SS_sky130_ef_sc_hd__decap_40_12
XTAP_TAPCELL_ROW_81_1517 vccd1 vssd1 SS_sky130_fd_sc_hd__tapvpwrvgnd_1
Xclkbuf_leaf_16_wb_clk_i _1745_/CLK clkbuf_leaf_7_wb_clk_i/A vccd1 vssd1 vssd1 vccd1
+ SS_sky130_fd_sc_hd__clkbuf_8
XFILLER_22_413 vssd1 vccd1 vccd1 vssd1 SS_sky130_fd_sc_hd__fill_4
XFILLER_35_785 vssd1 vccd1 vccd1 vssd1 SS_sky130_fd_sc_hd__fill_8
XFILLER_22_457 vssd1 vccd1 vssd1 vccd1 SS_sky130_ef_sc_hd__decap_40_12
XTAP_TAPCELL_ROW_20_603 vccd1 vssd1 SS_sky130_fd_sc_hd__tapvpwrvgnd_1
X_1849_ vccd1 vssd1 _1849_/X _1849_/A vccd1 vssd1 SS_sky130_fd_sc_hd__buf_2
XTAP_TAPCELL_ROW_79_1479 vccd1 vssd1 SS_sky130_fd_sc_hd__tapvpwrvgnd_1
Xhold620 _1602_/D _1143_/X vccd1 vssd1 vssd1 vccd1 SS_sky130_fd_sc_hd__dlygate4sd3_1
XTAP_TAPCELL_ROW_9_428 vccd1 vssd1 SS_sky130_fd_sc_hd__tapvpwrvgnd_1
XTAP_TAPCELL_ROW_9_439 vccd1 vssd1 SS_sky130_fd_sc_hd__tapvpwrvgnd_1
Xhold631 _1032_/A _1548_/Q vccd1 vssd1 vssd1 vccd1 SS_sky130_fd_sc_hd__dlygate4sd3_1
XFILLER_78_18 vssd1 vccd1 vccd1 vssd1 SS_sky130_fd_sc_hd__fill_8
XFILLER_78_29 vssd1 vccd1 vssd1 vccd1 SS_sky130_ef_sc_hd__decap_40_12
Xhold642 input48/A wbs_dat_i[6] vccd1 vssd1 vssd1 vccd1 SS_sky130_fd_sc_hd__dlygate4sd3_1
Xhold653 _1406_/A _1730_/Q vccd1 vssd1 vssd1 vccd1 SS_sky130_fd_sc_hd__dlygate4sd3_1
XFILLER_104_713 vssd1 vccd1 vssd1 vccd1 SS_sky130_ef_sc_hd__decap_40_12
XFILLER_1_317 vssd1 vccd1 vssd1 vccd1 SS_sky130_ef_sc_hd__decap_40_12
Xhold697 _1462_/A _1757_/Q vccd1 vssd1 vssd1 vccd1 SS_sky130_fd_sc_hd__dlygate4sd3_1
Xhold664 _1134_/A _1598_/Q vccd1 vssd1 vssd1 vccd1 SS_sky130_fd_sc_hd__dlygate4sd3_1
Xhold675 _1202_/A _1631_/Q vccd1 vssd1 vssd1 vccd1 SS_sky130_fd_sc_hd__dlygate4sd3_1
XFILLER_103_223 vccd1 vssd1 vccd1 vssd1 SS_sky130_fd_sc_hd__fill_1
Xhold686 _1590_/D _1119_/X vccd1 vssd1 vssd1 vccd1 SS_sky130_fd_sc_hd__dlygate4sd3_1
XTAP_TAPCELL_ROW_92_1679 vccd1 vssd1 SS_sky130_fd_sc_hd__tapvpwrvgnd_1
XFILLER_134_35 vccd1 vssd1 vccd1 vssd1 SS_sky130_fd_sc_hd__fill_1
XFILLER_134_46 vssd1 vccd1 vssd1 vccd1 SS_sky130_ef_sc_hd__decap_40_12
XFILLER_57_354 vssd1 vccd1 vssd1 vccd1 SS_sky130_ef_sc_hd__decap_40_12
XFILLER_69_181 vssd1 vccd1 vssd1 vccd1 SS_sky130_ef_sc_hd__decap_40_12
XFILLER_85_641 vssd1 vccd1 vssd1 vccd1 SS_sky130_ef_sc_hd__decap_40_12
XTAP_TAPCELL_ROW_28_714 vccd1 vssd1 SS_sky130_fd_sc_hd__tapvpwrvgnd_1
XFILLER_45_527 vssd1 vccd1 vssd1 vccd1 SS_sky130_ef_sc_hd__decap_40_12
XFILLER_85_685 vssd1 vccd1 vssd1 vccd1 SS_sky130_ef_sc_hd__decap_40_12
XFILLER_27_55 vccd1 vssd1 vccd1 vssd1 SS_sky130_fd_sc_hd__fill_1
XTAP_TAPCELL_ROW_28_725 vccd1 vssd1 SS_sky130_fd_sc_hd__tapvpwrvgnd_1
XFILLER_84_195 vccd1 vssd1 vccd1 vssd1 SS_sky130_fd_sc_hd__fill_1
XTAP_TAPCELL_ROW_123_2145 vccd1 vssd1 SS_sky130_fd_sc_hd__tapvpwrvgnd_1
XFILLER_60_508 vssd1 vccd1 vssd1 vccd1 SS_sky130_ef_sc_hd__decap_40_12
XFILLER_25_273 vssd1 vccd1 vccd1 vssd1 SS_sky130_fd_sc_hd__fill_4
XFILLER_9_417 vssd1 vccd1 vssd1 vccd1 SS_sky130_ef_sc_hd__decap_40_12
XFILLER_40_221 vssd1 vccd1 vssd1 vccd1 SS_sky130_ef_sc_hd__decap_40_12
XFILLER_41_777 vssd1 vccd1 vccd1 vssd1 SS_sky130_fd_sc_hd__fill_4
XFILLER_43_54 vssd1 vccd1 vccd1 vssd1 SS_sky130_fd_sc_hd__fill_2
XFILLER_40_265 vssd1 vccd1 vssd1 vccd1 SS_sky130_ef_sc_hd__decap_40_12
XFILLER_4_133 vssd1 vccd1 vccd1 vssd1 SS_sky130_fd_sc_hd__fill_4
XFILLER_4_15 vssd1 vccd1 vssd1 vccd1 SS_sky130_ef_sc_hd__decap_40_12
XFILLER_107_573 vssd1 vccd1 vssd1 vccd1 SS_sky130_ef_sc_hd__decap_40_12
XFILLER_4_177 vssd1 vccd1 vssd1 vccd1 SS_sky130_ef_sc_hd__decap_40_12
XFILLER_122_521 vssd1 vccd1 vccd1 vssd1 SS_sky130_fd_sc_hd__fill_2
XFILLER_95_405 vssd1 vccd1 vccd1 vssd1 SS_sky130_fd_sc_hd__fill_2
XFILLER_49_833 vccd1 vssd1 vccd1 vssd1 SS_sky130_fd_sc_hd__fill_1
XFILLER_122_587 vccd1 vssd1 vccd1 vssd1 SS_sky130_fd_sc_hd__fill_1
XFILLER_110_749 vssd1 vccd1 vccd1 vssd1 SS_sky130_fd_sc_hd__fill_4
XFILLER_95_449 vssd1 vccd1 vssd1 vccd1 SS_sky130_ef_sc_hd__decap_40_12
XFILLER_48_321 vssd1 vccd1 vssd1 vccd1 SS_sky130_ef_sc_hd__decap_40_12
XFILLER_76_663 vccd1 vssd1 vccd1 vssd1 SS_sky130_fd_sc_hd__fill_1
XFILLER_76_696 vssd1 vccd1 vccd1 vssd1 SS_sky130_fd_sc_hd__fill_4
XTAP_TAPCELL_ROW_108_1918 vccd1 vssd1 SS_sky130_fd_sc_hd__tapvpwrvgnd_1
XFILLER_17_741 vssd1 vccd1 vssd1 vccd1 SS_sky130_ef_sc_hd__decap_40_12
XFILLER_84_83 vccd1 vssd1 vccd1 vssd1 SS_sky130_fd_sc_hd__fill_1
XFILLER_90_121 vssd1 vccd1 vssd1 vccd1 SS_sky130_ef_sc_hd__decap_40_12
XFILLER_16_251 vccd1 vssd1 vccd1 vssd1 SS_sky130_fd_sc_hd__fill_1
XFILLER_63_368 vssd1 vccd1 vssd1 vccd1 SS_sky130_ef_sc_hd__decap_40_12
XFILLER_90_165 vssd1 vccd1 vssd1 vccd1 SS_sky130_ef_sc_hd__decap_40_12
XFILLER_91_666 vssd1 vccd1 vccd1 vssd1 SS_sky130_fd_sc_hd__fill_4
XFILLER_17_785 vssd1 vccd1 vssd1 vccd1 SS_sky130_ef_sc_hd__decap_40_12
XFILLER_31_221 vssd1 vccd1 vccd1 vssd1 SS_sky130_fd_sc_hd__fill_2
XTAP_TAPCELL_ROW_63_1247 vccd1 vssd1 SS_sky130_fd_sc_hd__tapvpwrvgnd_1
X_1703_ _1882_/A _1731_/CLK _1703_/D vccd1 vssd1 vccd1 vssd1 SS_sky130_fd_sc_hd__dfxtp_2
XFILLER_117_337 vssd1 vccd1 vssd1 vccd1 SS_sky130_ef_sc_hd__decap_40_12
X_1634_ _1634_/Q _1634_/CLK _1634_/D vccd1 vssd1 vccd1 vssd1 SS_sky130_fd_sc_hd__dfxtp_2
XFILLER_132_307 vccd1 vssd1 vccd1 vssd1 SS_sky130_fd_sc_hd__fill_1
XFILLER_132_318 vssd1 vccd1 vssd1 vccd1 SS_sky130_ef_sc_hd__decap_40_12
X_1565_ _1565_/Q _1692_/CLK _1565_/D vccd1 vssd1 vccd1 vssd1 SS_sky130_fd_sc_hd__dfxtp_2
XFILLER_98_221 vssd1 vccd1 vssd1 vccd1 SS_sky130_ef_sc_hd__decap_40_12
Xfanout418 vssd1 vccd1 vccd1 vssd1 _0755_/Y _0947_/A SS_sky130_fd_sc_hd__clkdlybuf4s25_1
Xfanout429 vssd1 vccd1 vccd1 vssd1 _0748_/X wire431/A SS_sky130_fd_sc_hd__clkdlybuf4s25_1
XFILLER_98_265 vssd1 vccd1 vssd1 vccd1 SS_sky130_ef_sc_hd__decap_40_12
XFILLER_86_427 vccd1 vssd1 vccd1 vssd1 SS_sky130_fd_sc_hd__fill_1
X_1496_ _1496_/Q _1724_/CLK _1496_/D vccd1 vssd1 vccd1 vssd1 SS_sky130_fd_sc_hd__dfxtp_2
XFILLER_104_27 vccd1 vssd1 vccd1 vssd1 SS_sky130_fd_sc_hd__fill_1
XFILLER_27_505 vssd1 vccd1 vssd1 vccd1 SS_sky130_ef_sc_hd__decap_40_12
XFILLER_66_195 vccd1 vssd1 vccd1 vssd1 SS_sky130_fd_sc_hd__fill_1
XFILLER_81_165 vssd1 vccd1 vccd1 vssd1 SS_sky130_fd_sc_hd__fill_2
XFILLER_82_677 vccd1 vssd1 vccd1 vssd1 SS_sky130_fd_sc_hd__fill_1
XFILLER_120_15 vssd1 vccd1 vssd1 vccd1 SS_sky130_ef_sc_hd__decap_40_12
XFILLER_22_221 vssd1 vccd1 vssd1 vccd1 SS_sky130_ef_sc_hd__decap_40_12
XFILLER_22_265 vssd1 vccd1 vssd1 vccd1 SS_sky130_ef_sc_hd__decap_40_12
XFILLER_23_777 vssd1 vccd1 vccd1 vssd1 SS_sky130_fd_sc_hd__fill_4
XFILLER_23_799 vccd1 vssd1 vccd1 vssd1 SS_sky130_fd_sc_hd__fill_1
XFILLER_50_585 vssd1 vccd1 vccd1 vssd1 SS_sky130_fd_sc_hd__fill_2
XFILLER_13_57 vssd1 vccd1 vssd1 vccd1 SS_sky130_ef_sc_hd__decap_40_12
XTAP_TAPCELL_ROW_33_794 vccd1 vssd1 SS_sky130_fd_sc_hd__tapvpwrvgnd_1
XFILLER_129_57 vssd1 vccd1 vssd1 vccd1 SS_sky130_ef_sc_hd__decap_40_12
XFILLER_136_613 vssd1 vccd1 vccd1 vssd1 SS_sky130_fd_sc_hd__fill_4
XFILLER_109_827 vccd1 vssd1 vccd1 vssd1 SS_sky130_fd_sc_hd__fill_1
XFILLER_89_39 vssd1 vccd1 vssd1 vccd1 SS_sky130_ef_sc_hd__decap_40_12
XFILLER_136_657 vssd1 vccd1 vccd1 vssd1 SS_sky130_fd_sc_hd__fill_2
XTAP_TAPCELL_ROW_94_1708 vccd1 vssd1 SS_sky130_fd_sc_hd__tapvpwrvgnd_1
XFILLER_135_167 vccd1 vssd1 vccd1 vssd1 SS_sky130_fd_sc_hd__fill_1
XFILLER_123_318 vssd1 vccd1 vssd1 vccd1 SS_sky130_ef_sc_hd__decap_40_12
XFILLER_1_125 vssd1 vccd1 vssd1 vccd1 SS_sky130_ef_sc_hd__decap_40_12
XFILLER_2_637 vssd1 vccd1 vccd1 vssd1 SS_sky130_fd_sc_hd__fill_4
XFILLER_8_6 vssd1 vccd1 vssd1 vccd1 SS_sky130_ef_sc_hd__decap_40_12
XFILLER_89_221 vssd1 vccd1 vccd1 vssd1 SS_sky130_fd_sc_hd__fill_2
XPHY_EDGE_ROW_8_Left_147 vccd1 vssd1 vccd1 vssd1 SS_sky130_fd_sc_hd__decap_3
XFILLER_77_405 vssd1 vccd1 vssd1 vccd1 SS_sky130_ef_sc_hd__decap_40_12
XFILLER_1_169 vssd1 vccd1 vssd1 vccd1 SS_sky130_ef_sc_hd__decap_40_12
XFILLER_131_373 vssd1 vccd1 vssd1 vccd1 SS_sky130_ef_sc_hd__decap_40_12
XFILLER_77_449 vssd1 vccd1 vssd1 vccd1 SS_sky130_ef_sc_hd__decap_40_12
XFILLER_38_65 vssd1 vccd1 vssd1 vccd1 SS_sky130_ef_sc_hd__decap_40_12
XFILLER_46_825 vccd1 vssd1 vccd1 vssd1 SS_sky130_fd_sc_hd__fill_1
XFILLER_73_611 vssd1 vccd1 vccd1 vssd1 SS_sky130_fd_sc_hd__fill_4
XFILLER_92_419 vccd1 vssd1 vccd1 vssd1 SS_sky130_fd_sc_hd__fill_1
XFILLER_45_335 vccd1 vssd1 vccd1 vssd1 SS_sky130_fd_sc_hd__fill_1
XFILLER_72_121 vssd1 vccd1 vssd1 vccd1 SS_sky130_ef_sc_hd__decap_40_12
XFILLER_54_53 vssd1 vccd1 vssd1 vccd1 SS_sky130_ef_sc_hd__decap_40_12
XFILLER_60_305 vssd1 vccd1 vccd1 vssd1 SS_sky130_fd_sc_hd__fill_2
XFILLER_72_165 vssd1 vccd1 vssd1 vccd1 SS_sky130_ef_sc_hd__decap_40_12
XFILLER_13_221 vssd1 vccd1 vccd1 vssd1 SS_sky130_fd_sc_hd__fill_2
XFILLER_14_755 vccd1 vssd1 vccd1 vssd1 SS_sky130_fd_sc_hd__fill_1
XFILLER_54_97 vssd1 vccd1 vssd1 vccd1 SS_sky130_ef_sc_hd__decap_40_12
XTAP_TAPCELL_ROW_103_1848 vccd1 vssd1 SS_sky130_fd_sc_hd__tapvpwrvgnd_1
XFILLER_9_225 vssd1 vccd1 vssd1 vccd1 SS_sky130_ef_sc_hd__decap_40_12
XFILLER_41_585 vssd1 vccd1 vssd1 vccd1 SS_sky130_ef_sc_hd__decap_40_12
XFILLER_70_41 vssd1 vccd1 vssd1 vccd1 SS_sky130_ef_sc_hd__decap_40_12
XTAP_TAPCELL_ROW_136_2336 vccd1 vssd1 SS_sky130_fd_sc_hd__tapvpwrvgnd_1
XFILLER_110_81 vssd1 vccd1 vccd1 vssd1 SS_sky130_fd_sc_hd__fill_2
XFILLER_70_85 vssd1 vccd1 vssd1 vccd1 SS_sky130_ef_sc_hd__decap_40_12
XTAP_TAPCELL_ROW_136_2347 vccd1 vssd1 SS_sky130_fd_sc_hd__tapvpwrvgnd_1
Xclkload17 vssd1 vccd1 _1753_/CLK clkload17/X vccd1 vssd1 SS_sky130_fd_sc_hd__clkbuf_4
XTAP_TAPCELL_ROW_11_466 vccd1 vssd1 SS_sky130_fd_sc_hd__tapvpwrvgnd_1
Xclkload28 clkload28/X _1741_/CLK vccd1 vssd1 vssd1 vccd1 SS_sky130_fd_sc_hd__clkbuf_8
XFILLER_114_307 vccd1 vssd1 vccd1 vssd1 SS_sky130_fd_sc_hd__fill_1
XFILLER_5_497 vssd1 vccd1 vccd1 vssd1 SS_sky130_fd_sc_hd__fill_4
XFILLER_126_189 vssd1 vccd1 vccd1 vssd1 SS_sky130_fd_sc_hd__fill_4
XFILLER_123_841 vccd1 vssd1 vccd1 vssd1 SS_sky130_fd_sc_hd__fill_1
X_1350_ vccd1 vssd1 vccd1 vssd1 _1350_/X _1350_/A _1404_/B SS_sky130_fd_sc_hd__or2_2
XFILLER_68_416 vssd1 vccd1 vccd1 vssd1 SS_sky130_fd_sc_hd__fill_4
XFILLER_96_725 vssd1 vccd1 vssd1 vccd1 SS_sky130_ef_sc_hd__decap_40_12
XFILLER_110_557 vssd1 vccd1 vssd1 vccd1 SS_sky130_ef_sc_hd__decap_40_12
XFILLER_96_769 vssd1 vccd1 vssd1 vccd1 SS_sky130_ef_sc_hd__decap_40_12
X_1281_ vssd1 vccd1 vccd1 vssd1 _1339_/A2 input31/X _1281_/X _1439_/C1 _1280_/X SS_sky130_fd_sc_hd__o211a_2
XFILLER_95_279 vccd1 vssd1 vccd1 vssd1 SS_sky130_fd_sc_hd__fill_1
XFILLER_95_93 vssd1 vccd1 vssd1 vccd1 SS_sky130_ef_sc_hd__decap_40_12
XFILLER_48_195 vccd1 vssd1 vccd1 vssd1 SS_sky130_fd_sc_hd__fill_1
XFILLER_36_357 vssd1 vccd1 vccd1 vssd1 SS_sky130_fd_sc_hd__fill_4
XFILLER_64_677 vssd1 vccd1 vccd1 vssd1 SS_sky130_fd_sc_hd__fill_2
XFILLER_91_441 vssd1 vccd1 vccd1 vssd1 SS_sky130_fd_sc_hd__fill_4
XTAP_TAPCELL_ROW_19_588 vccd1 vssd1 SS_sky130_fd_sc_hd__tapvpwrvgnd_1
XFILLER_51_305 vssd1 vccd1 vssd1 vccd1 SS_sky130_ef_sc_hd__decap_40_12
XFILLER_63_165 vssd1 vccd1 vccd1 vssd1 SS_sky130_fd_sc_hd__fill_2
XFILLER_64_688 vssd1 vccd1 vssd1 vccd1 SS_sky130_ef_sc_hd__decap_40_12
XFILLER_51_349 vssd1 vccd1 vssd1 vccd1 SS_sky130_ef_sc_hd__decap_40_12
XFILLER_32_596 vccd1 vssd1 vccd1 vssd1 SS_sky130_fd_sc_hd__fill_1
XFILLER_9_781 vssd1 vccd1 vccd1 vssd1 SS_sky130_fd_sc_hd__fill_2
XTAP_TAPCELL_ROW_30_753 vccd1 vssd1 SS_sky130_fd_sc_hd__tapvpwrvgnd_1
X_0996_ vccd1 vssd1 vccd1 vssd1 _0996_/X _0996_/A _1008_/B SS_sky130_fd_sc_hd__or2_2
XFILLER_118_613 vssd1 vccd1 vssd1 vccd1 SS_sky130_ef_sc_hd__decap_40_12
XFILLER_118_657 vssd1 vccd1 vssd1 vccd1 SS_sky130_ef_sc_hd__decap_40_12
XTAP_TAPCELL_ROW_76_1438 vccd1 vssd1 SS_sky130_fd_sc_hd__tapvpwrvgnd_1
XFILLER_117_167 vccd1 vssd1 vccd1 vssd1 SS_sky130_fd_sc_hd__fill_1
X_1617_ _1877_/A clkload6/A _1617_/D vccd1 vssd1 vccd1 vssd1 SS_sky130_fd_sc_hd__dfxtp_2
XFILLER_132_137 vssd1 vccd1 vccd1 vssd1 SS_sky130_fd_sc_hd__fill_2
XFILLER_87_703 vccd1 vssd1 vccd1 vssd1 SS_sky130_fd_sc_hd__fill_1
X_1548_ _1548_/Q _1610_/CLK _1548_/D vccd1 vssd1 vccd1 vssd1 SS_sky130_fd_sc_hd__dfxtp_2
XFILLER_59_405 vssd1 vccd1 vssd1 vccd1 SS_sky130_ef_sc_hd__decap_40_12
XFILLER_87_725 vssd1 vccd1 vccd1 vssd1 SS_sky130_fd_sc_hd__fill_2
Xfanout237 vssd1 vccd1 vccd1 vssd1 _1144_/X _1208_/B SS_sky130_fd_sc_hd__clkdlybuf4s25_1
XFILLER_115_15 vssd1 vccd1 vssd1 vccd1 SS_sky130_ef_sc_hd__decap_40_12
XFILLER_113_373 vssd1 vccd1 vccd1 vssd1 SS_sky130_fd_sc_hd__fill_2
Xfanout226 vssd1 vccd1 vccd1 vssd1 _1265_/A2 _1273_/A2 SS_sky130_fd_sc_hd__clkdlybuf4s25_1
XFILLER_99_585 vssd1 vccd1 vssd1 vccd1 SS_sky130_ef_sc_hd__decap_40_12
X_1479_ _1479_/Q clkload9/A _1479_/D vccd1 vssd1 vccd1 vssd1 SS_sky130_fd_sc_hd__dfxtp_2
XFILLER_59_449 vssd1 vccd1 vssd1 vccd1 SS_sky130_ef_sc_hd__decap_40_12
Xfanout259 vssd1 vccd1 vccd1 vssd1 _1010_/B _0984_/B SS_sky130_fd_sc_hd__clkdlybuf4s25_1
Xfanout248 vssd1 vccd1 vccd1 vssd1 _1013_/Y _1065_/A2 SS_sky130_fd_sc_hd__clkdlybuf4s25_1
XFILLER_101_557 vssd1 vccd1 vccd1 vssd1 SS_sky130_fd_sc_hd__fill_2
Xclkbuf_leaf_31_wb_clk_i clkload3/A clkload0/A vccd1 vssd1 vssd1 vccd1 SS_sky130_fd_sc_hd__clkbuf_8
XFILLER_74_408 vssd1 vccd1 vssd1 vccd1 SS_sky130_ef_sc_hd__decap_40_12
XFILLER_27_335 vccd1 vssd1 vccd1 vssd1 SS_sky130_fd_sc_hd__fill_1
XFILLER_54_121 vssd1 vccd1 vssd1 vccd1 SS_sky130_ef_sc_hd__decap_40_12
XFILLER_55_633 vccd1 vssd1 vccd1 vssd1 SS_sky130_fd_sc_hd__fill_1
XTAP_TAPCELL_ROW_38_864 vccd1 vssd1 SS_sky130_fd_sc_hd__tapvpwrvgnd_1
XTAP_TAPCELL_ROW_120_2104 vccd1 vssd1 SS_sky130_fd_sc_hd__tapvpwrvgnd_1
XTAP_TAPCELL_ROW_38_875 vccd1 vssd1 SS_sky130_fd_sc_hd__tapvpwrvgnd_1
XFILLER_42_305 vssd1 vccd1 vccd1 vssd1 SS_sky130_fd_sc_hd__fill_2
XFILLER_54_165 vssd1 vccd1 vssd1 vccd1 SS_sky130_ef_sc_hd__decap_40_12
XFILLER_70_625 vssd1 vccd1 vccd1 vssd1 SS_sky130_fd_sc_hd__fill_8
XFILLER_82_474 vssd1 vccd1 vccd1 vssd1 SS_sky130_fd_sc_hd__fill_2
XFILLER_82_485 vssd1 vccd1 vccd1 vssd1 SS_sky130_fd_sc_hd__fill_2
XFILLER_91_18 vssd1 vccd1 vssd1 vccd1 SS_sky130_ef_sc_hd__decap_40_12
XFILLER_131_69 vssd1 vccd1 vssd1 vccd1 SS_sky130_ef_sc_hd__decap_40_12
XFILLER_23_541 vssd1 vccd1 vssd1 vccd1 SS_sky130_ef_sc_hd__decap_40_12
XFILLER_11_725 vssd1 vccd1 vccd1 vssd1 SS_sky130_fd_sc_hd__fill_2
XFILLER_23_585 vssd1 vccd1 vssd1 vccd1 SS_sky130_ef_sc_hd__decap_40_12
XFILLER_7_729 vssd1 vccd1 vssd1 vccd1 SS_sky130_ef_sc_hd__decap_40_12
XFILLER_136_410 vccd1 vssd1 vccd1 vssd1 SS_sky130_fd_sc_hd__fill_1
XFILLER_136_421 vssd1 vccd1 vccd1 vssd1 SS_sky130_fd_sc_hd__fill_4
XTAP_TAPCELL_ROW_118_2077 vccd1 vssd1 SS_sky130_fd_sc_hd__tapvpwrvgnd_1
XTAP_TAPCELL_ROW_118_2066 vccd1 vssd1 SS_sky130_fd_sc_hd__tapvpwrvgnd_1
XFILLER_40_77 vssd1 vccd1 vccd1 vssd1 SS_sky130_fd_sc_hd__fill_4
XFILLER_2_401 vssd1 vccd1 vssd1 vccd1 SS_sky130_ef_sc_hd__decap_40_12
XTAP_TAPCELL_ROW_131_2266 vccd1 vssd1 SS_sky130_fd_sc_hd__tapvpwrvgnd_1
XFILLER_108_189 vssd1 vccd1 vccd1 vssd1 SS_sky130_fd_sc_hd__fill_4
XFILLER_2_445 vssd1 vccd1 vssd1 vccd1 SS_sky130_ef_sc_hd__decap_40_12
XFILLER_123_137 vssd1 vccd1 vssd1 vccd1 SS_sky130_ef_sc_hd__decap_40_12
XFILLER_105_841 vccd1 vssd1 vccd1 vssd1 SS_sky130_fd_sc_hd__fill_1
XFILLER_2_489 vssd1 vccd1 vssd1 vccd1 SS_sky130_ef_sc_hd__decap_40_12
XFILLER_78_725 vssd1 vccd1 vssd1 vccd1 SS_sky130_ef_sc_hd__decap_40_12
XFILLER_78_769 vssd1 vccd1 vssd1 vccd1 SS_sky130_ef_sc_hd__decap_40_12
XFILLER_131_181 vssd1 vccd1 vssd1 vccd1 SS_sky130_ef_sc_hd__decap_40_12
XFILLER_77_279 vccd1 vssd1 vccd1 vssd1 SS_sky130_fd_sc_hd__fill_1
XFILLER_58_493 vssd1 vccd1 vccd1 vssd1 SS_sky130_fd_sc_hd__fill_2
XFILLER_86_791 vccd1 vssd1 vccd1 vssd1 SS_sky130_fd_sc_hd__fill_1
XFILLER_105_81 vssd1 vccd1 vssd1 vccd1 SS_sky130_ef_sc_hd__decap_40_12
XFILLER_92_249 vssd1 vccd1 vccd1 vssd1 SS_sky130_fd_sc_hd__fill_2
XFILLER_18_357 vssd1 vccd1 vccd1 vssd1 SS_sky130_fd_sc_hd__fill_4
XTAP_TAPCELL_ROW_47_1006 vccd1 vssd1 SS_sky130_fd_sc_hd__tapvpwrvgnd_1
XFILLER_33_305 vssd1 vccd1 vssd1 vccd1 SS_sky130_ef_sc_hd__decap_40_12
XFILLER_45_165 vssd1 vccd1 vccd1 vssd1 SS_sky130_fd_sc_hd__fill_2
XFILLER_46_699 vccd1 vssd1 vccd1 vssd1 SS_sky130_fd_sc_hd__fill_1
XTAP_TAPCELL_ROW_16_536 vccd1 vssd1 SS_sky130_fd_sc_hd__tapvpwrvgnd_1
XTAP_TAPCELL_ROW_16_547 vccd1 vssd1 SS_sky130_fd_sc_hd__tapvpwrvgnd_1
XFILLER_33_349 vssd1 vccd1 vssd1 vccd1 SS_sky130_ef_sc_hd__decap_40_12
XTAP_TAPCELL_ROW_60_1206 vccd1 vssd1 SS_sky130_fd_sc_hd__tapvpwrvgnd_1
XFILLER_14_585 vssd1 vccd1 vccd1 vssd1 SS_sky130_fd_sc_hd__fill_2
XFILLER_41_393 vssd1 vccd1 vssd1 vccd1 SS_sky130_ef_sc_hd__decap_40_12
X_0850_ vssd1 vccd1 vssd1 vccd1 _1343_/A _1376_/A _0849_/X _0850_/X SS_sky130_fd_sc_hd__a21o_2
X_0781_ vssd1 vccd1 vssd1 vccd1 _0781_/X _0828_/B1 _1867_/A _0779_/X _0780_/X SS_sky130_fd_sc_hd__a211o_2
XFILLER_5_261 vssd1 vccd1 vssd1 vccd1 SS_sky130_ef_sc_hd__decap_40_12
XTAP_TAPCELL_ROW_58_1168 vccd1 vssd1 SS_sky130_fd_sc_hd__tapvpwrvgnd_1
XFILLER_127_487 vccd1 vssd1 vccd1 vssd1 SS_sky130_fd_sc_hd__fill_1
X_1402_ vccd1 vssd1 vccd1 vssd1 _1402_/X _1402_/A _1404_/B SS_sky130_fd_sc_hd__or2_2
XFILLER_114_137 vssd1 vccd1 vccd1 vssd1 SS_sky130_fd_sc_hd__fill_2
XFILLER_39_3 vssd1 vccd1 vssd1 vccd1 SS_sky130_ef_sc_hd__decap_40_12
XFILLER_69_725 vssd1 vccd1 vccd1 vssd1 SS_sky130_fd_sc_hd__fill_2
XTAP_TAPCELL_ROW_71_1368 vccd1 vssd1 SS_sky130_fd_sc_hd__tapvpwrvgnd_1
X_1333_ vssd1 vccd1 vccd1 vssd1 _1339_/A2 input39/X _1694_/D _1465_/C1 _1332_/X SS_sky130_fd_sc_hd__o211a_2
XFILLER_110_321 vssd1 vccd1 vssd1 vccd1 SS_sky130_ef_sc_hd__decap_40_12
XFILLER_96_533 vssd1 vccd1 vssd1 vccd1 SS_sky130_ef_sc_hd__decap_40_12
XFILLER_83_205 vssd1 vccd1 vssd1 vccd1 SS_sky130_ef_sc_hd__decap_40_12
X_1264_ vccd1 vssd1 vccd1 vssd1 _1264_/X _1661_/Q _1264_/B SS_sky130_fd_sc_hd__or2_2
XFILLER_110_365 vssd1 vccd1 vssd1 vccd1 SS_sky130_ef_sc_hd__decap_40_12
XFILLER_110_354 vssd1 vccd1 vccd1 vssd1 SS_sky130_fd_sc_hd__fill_8
Xinput4 vssd1 vccd1 vccd1 vssd1 adc_data[1] input4/X SS_sky130_fd_sc_hd__clkdlybuf4s25_1
XFILLER_37_611 vccd1 vssd1 vccd1 vssd1 SS_sky130_fd_sc_hd__fill_1
XFILLER_83_249 vssd1 vccd1 vssd1 vccd1 SS_sky130_ef_sc_hd__decap_40_12
XFILLER_36_121 vssd1 vccd1 vssd1 vccd1 SS_sky130_ef_sc_hd__decap_40_12
X_1195_ vssd1 vccd1 vccd1 vssd1 _1195_/A2 input36/X _1627_/D _1461_/C1 _1194_/X SS_sky130_fd_sc_hd__o211a_2
XFILLER_24_305 vssd1 vccd1 vccd1 vssd1 SS_sky130_fd_sc_hd__fill_2
XTAP_TAPCELL_ROW_35_823 vccd1 vssd1 SS_sky130_fd_sc_hd__tapvpwrvgnd_1
XFILLER_36_165 vssd1 vccd1 vssd1 vccd1 SS_sky130_ef_sc_hd__decap_40_12
XFILLER_64_474 vssd1 vccd1 vccd1 vssd1 SS_sky130_fd_sc_hd__fill_2
XFILLER_51_113 vssd1 vccd1 vssd1 vccd1 SS_sky130_ef_sc_hd__decap_40_12
XFILLER_52_669 vssd1 vccd1 vccd1 vssd1 SS_sky130_fd_sc_hd__fill_2
XFILLER_91_293 vssd1 vccd1 vssd1 vccd1 SS_sky130_ef_sc_hd__decap_40_12
XFILLER_20_533 vssd1 vccd1 vssd1 vccd1 SS_sky130_ef_sc_hd__decap_40_12
XFILLER_137_229 vssd1 vccd1 vccd1 vssd1 SS_sky130_fd_sc_hd__fill_2
X_0979_ vssd1 vccd1 vccd1 vssd1 wire253/A input26/X _1522_/D _1441_/C1 _0978_/X SS_sky130_fd_sc_hd__o211a_2
XPHY_EDGE_ROW_89_Left_228 vccd1 vssd1 vccd1 vssd1 SS_sky130_fd_sc_hd__decap_3
XFILLER_118_454 vccd1 vssd1 vccd1 vssd1 SS_sky130_fd_sc_hd__fill_1
XFILLER_118_487 vccd1 vssd1 vccd1 vssd1 SS_sky130_fd_sc_hd__fill_1
XFILLER_105_137 vssd1 vccd1 vssd1 vccd1 SS_sky130_ef_sc_hd__decap_40_12
XFILLER_86_18 vssd1 vccd1 vccd1 vssd1 SS_sky130_fd_sc_hd__fill_8
XFILLER_86_29 vssd1 vccd1 vssd1 vccd1 SS_sky130_ef_sc_hd__decap_40_12
XFILLER_87_555 vssd1 vccd1 vccd1 vssd1 SS_sky130_fd_sc_hd__fill_4
XFILLER_114_693 vssd1 vccd1 vccd1 vssd1 SS_sky130_fd_sc_hd__fill_4
XFILLER_113_181 vssd1 vccd1 vssd1 vccd1 SS_sky130_ef_sc_hd__decap_40_12
XFILLER_99_393 vssd1 vccd1 vssd1 vccd1 SS_sky130_ef_sc_hd__decap_40_12
XFILLER_47_419 vssd1 vccd1 vssd1 vccd1 SS_sky130_ef_sc_hd__decap_40_12
XFILLER_59_279 vccd1 vssd1 vccd1 vssd1 SS_sky130_fd_sc_hd__fill_1
XTAP_TAPCELL_ROW_89_1629 vccd1 vssd1 SS_sky130_fd_sc_hd__tapvpwrvgnd_1
XFILLER_101_398 vssd1 vccd1 vssd1 vccd1 SS_sky130_ef_sc_hd__decap_40_12
XPHY_EDGE_ROW_98_Left_237 vccd1 vssd1 vccd1 vssd1 SS_sky130_fd_sc_hd__decap_3
XFILLER_74_249 vssd1 vccd1 vccd1 vssd1 SS_sky130_fd_sc_hd__fill_2
XFILLER_15_305 vssd1 vccd1 vssd1 vccd1 SS_sky130_ef_sc_hd__decap_40_12
XFILLER_27_165 vssd1 vccd1 vccd1 vssd1 SS_sky130_fd_sc_hd__fill_2
XFILLER_28_699 vccd1 vssd1 vccd1 vssd1 SS_sky130_fd_sc_hd__fill_1
XFILLER_70_400 vssd1 vccd1 vssd1 vccd1 SS_sky130_ef_sc_hd__decap_40_12
XFILLER_83_783 vccd1 vssd1 vccd1 vssd1 SS_sky130_fd_sc_hd__fill_1
XFILLER_15_349 vssd1 vccd1 vssd1 vccd1 SS_sky130_ef_sc_hd__decap_40_12
XFILLER_35_55 vccd1 vssd1 vccd1 vssd1 SS_sky130_fd_sc_hd__fill_1
XFILLER_43_658 vssd1 vccd1 vccd1 vssd1 SS_sky130_fd_sc_hd__fill_2
XFILLER_43_669 vssd1 vccd1 vccd1 vssd1 SS_sky130_fd_sc_hd__fill_2
XFILLER_55_496 vssd1 vccd1 vccd1 vssd1 SS_sky130_fd_sc_hd__fill_8
XFILLER_70_444 vssd1 vccd1 vssd1 vccd1 SS_sky130_ef_sc_hd__decap_40_12
XFILLER_70_477 vssd1 vccd1 vccd1 vssd1 SS_sky130_fd_sc_hd__fill_4
XTAP_TAPCELL_ROW_100_1807 vccd1 vssd1 SS_sky130_fd_sc_hd__tapvpwrvgnd_1
XFILLER_23_393 vssd1 vccd1 vssd1 vccd1 SS_sky130_ef_sc_hd__decap_40_12
XFILLER_51_54 vssd1 vccd1 vccd1 vssd1 SS_sky130_fd_sc_hd__fill_2
Xwire424 vccd1 vssd1 wire424/X wire424/A vccd1 vssd1 SS_sky130_fd_sc_hd__buf_4
Xwire413 vccd1 vssd1 vssd1 vccd1 wire413/A analog_ctrl[68] SS_sky130_fd_sc_hd__buf_12
Xwire402 vccd1 vssd1 vssd1 vccd1 wire402/A analog_ctrl[79] SS_sky130_fd_sc_hd__buf_12
Xwire446 vssd1 vccd1 _1079_/A wire446/X vccd1 vssd1 SS_sky130_fd_sc_hd__clkbuf_2
Xwire435 vccd1 vssd1 wire435/X wire435/A vccd1 vssd1 SS_sky130_fd_sc_hd__buf_4
XFILLER_7_559 vccd1 vssd1 vccd1 vssd1 SS_sky130_fd_sc_hd__fill_1
XFILLER_136_251 vccd1 vssd1 vccd1 vssd1 SS_sky130_fd_sc_hd__fill_1
XFILLER_137_763 vssd1 vccd1 vccd1 vssd1 SS_sky130_fd_sc_hd__fill_2
XFILLER_109_443 vssd1 vccd1 vccd1 vssd1 SS_sky130_fd_sc_hd__fill_4
XFILLER_3_721 vssd1 vccd1 vccd1 vssd1 SS_sky130_fd_sc_hd__fill_4
XFILLER_137_785 vssd1 vccd1 vccd1 vssd1 SS_sky130_fd_sc_hd__fill_2
XFILLER_2_253 vssd1 vccd1 vssd1 vccd1 SS_sky130_ef_sc_hd__decap_40_12
XFILLER_3_765 vssd1 vccd1 vssd1 vccd1 SS_sky130_ef_sc_hd__decap_40_12
XFILLER_78_533 vssd1 vccd1 vssd1 vccd1 SS_sky130_ef_sc_hd__decap_40_12
XTAP_TAPCELL_ROW_111_1969 vccd1 vssd1 SS_sky130_fd_sc_hd__tapvpwrvgnd_1
XTAP_TAPCELL_ROW_111_1958 vccd1 vssd1 SS_sky130_fd_sc_hd__tapvpwrvgnd_1
XFILLER_38_419 vccd1 vssd1 vccd1 vssd1 SS_sky130_fd_sc_hd__fill_1
XTAP_TAPCELL_ROW_53_1098 vccd1 vssd1 SS_sky130_fd_sc_hd__tapvpwrvgnd_1
XFILLER_65_205 vssd1 vccd1 vssd1 vccd1 SS_sky130_ef_sc_hd__decap_40_12
XFILLER_120_663 vssd1 vccd1 vssd1 vccd1 SS_sky130_ef_sc_hd__decap_40_12
XFILLER_18_121 vssd1 vccd1 vssd1 vccd1 SS_sky130_ef_sc_hd__decap_40_12
XFILLER_65_249 vssd1 vccd1 vssd1 vccd1 SS_sky130_ef_sc_hd__decap_40_12
XFILLER_93_569 vssd1 vccd1 vccd1 vssd1 SS_sky130_fd_sc_hd__fill_2
XFILLER_18_165 vssd1 vccd1 vssd1 vccd1 SS_sky130_ef_sc_hd__decap_40_12
XFILLER_34_625 vssd1 vccd1 vssd1 vccd1 SS_sky130_ef_sc_hd__decap_40_12
XFILLER_46_463 vssd1 vccd1 vssd1 vccd1 SS_sky130_ef_sc_hd__decap_40_12
XFILLER_61_400 vssd1 vccd1 vssd1 vccd1 SS_sky130_ef_sc_hd__decap_40_12
XFILLER_33_113 vssd1 vccd1 vssd1 vccd1 SS_sky130_ef_sc_hd__decap_40_12
XFILLER_34_669 vssd1 vccd1 vssd1 vccd1 SS_sky130_ef_sc_hd__decap_40_12
XFILLER_61_433 vssd1 vccd1 vssd1 vccd1 SS_sky130_ef_sc_hd__decap_40_12
XFILLER_73_293 vssd1 vccd1 vssd1 vccd1 SS_sky130_ef_sc_hd__decap_40_12
XFILLER_92_83 vccd1 vssd1 vccd1 vssd1 SS_sky130_fd_sc_hd__fill_1
XFILLER_42_680 vssd1 vccd1 vssd1 vccd1 SS_sky130_ef_sc_hd__decap_40_12
X_1882_ vccd1 vssd1 _1882_/X _1882_/A vccd1 vssd1 SS_sky130_fd_sc_hd__buf_2
X_0902_ vccd1 vssd1 vssd1 vccd1 _0898_/X _0901_/X _0932_/A2 hold803/X _0902_/X _1329_/C1
+ SS_sky130_fd_sc_hd__o221a_2
X_0833_ vssd1 vccd1 vssd1 vccd1 wire431/X _1648_/Q _0832_/X _0833_/X SS_sky130_fd_sc_hd__a21o_2
XFILLER_6_581 vssd1 vccd1 vccd1 vssd1 SS_sky130_fd_sc_hd__fill_4
X_0764_ vccd1 vssd1 vssd1 vccd1 _0760_/X _0763_/X _0878_/A2 _1476_/Q _1476_/D _1431_/C1
+ SS_sky130_fd_sc_hd__o221a_2
XFILLER_127_273 vssd1 vccd1 vccd1 vssd1 SS_sky130_fd_sc_hd__fill_4
XFILLER_89_809 vssd1 vccd1 vccd1 vssd1 SS_sky130_fd_sc_hd__fill_8
XFILLER_103_619 vccd1 vssd1 vccd1 vssd1 SS_sky130_fd_sc_hd__fill_1
XPHY_EDGE_ROW_135_Right_135 vccd1 vssd1 vccd1 vssd1 SS_sky130_fd_sc_hd__decap_3
XFILLER_111_663 vssd1 vccd1 vccd1 vssd1 SS_sky130_fd_sc_hd__fill_8
XFILLER_96_363 vccd1 vssd1 vccd1 vssd1 SS_sky130_fd_sc_hd__fill_1
XFILLER_96_352 vssd1 vccd1 vccd1 vssd1 SS_sky130_fd_sc_hd__fill_2
X_1316_ vccd1 vssd1 vccd1 vssd1 _1316_/X _1316_/A _1318_/B SS_sky130_fd_sc_hd__or2_2
XFILLER_111_685 vssd1 vccd1 vssd1 vccd1 SS_sky130_ef_sc_hd__decap_40_12
XFILLER_2_81 vssd1 vccd1 vccd1 vssd1 SS_sky130_fd_sc_hd__fill_2
XFILLER_37_441 vssd1 vccd1 vccd1 vssd1 SS_sky130_fd_sc_hd__fill_4
XFILLER_56_249 vssd1 vccd1 vccd1 vssd1 SS_sky130_fd_sc_hd__fill_2
XFILLER_65_750 vssd1 vccd1 vssd1 vccd1 SS_sky130_ef_sc_hd__decap_40_12
X_1247_ vssd1 vccd1 vccd1 vssd1 _1261_/A2 input28/X _1652_/D _1381_/C1 _1246_/X SS_sky130_fd_sc_hd__o211a_2
XFILLER_84_569 vssd1 vccd1 vssd1 vccd1 SS_sky130_ef_sc_hd__decap_40_12
XFILLER_110_195 vccd1 vssd1 vccd1 vssd1 SS_sky130_fd_sc_hd__fill_1
XFILLER_37_485 vssd1 vccd1 vccd1 vssd1 SS_sky130_fd_sc_hd__fill_4
XFILLER_52_411 vccd1 vssd1 vccd1 vssd1 SS_sky130_fd_sc_hd__fill_1
XFILLER_112_27 vccd1 vssd1 vccd1 vssd1 SS_sky130_fd_sc_hd__fill_1
X_1178_ vccd1 vssd1 vccd1 vssd1 _1178_/X _1178_/A _1208_/B SS_sky130_fd_sc_hd__or2_2
XFILLER_80_753 vssd1 vccd1 vccd1 vssd1 SS_sky130_fd_sc_hd__fill_2
XTAP_TAPCELL_ROW_84_1559 vccd1 vssd1 SS_sky130_fd_sc_hd__tapvpwrvgnd_1
XFILLER_52_477 vssd1 vccd1 vssd1 vccd1 SS_sky130_ef_sc_hd__decap_40_12
XFILLER_138_505 vssd1 vccd1 vccd1 vssd1 SS_sky130_fd_sc_hd__fill_2
XFILLER_20_363 vccd1 vssd1 vccd1 vssd1 SS_sky130_fd_sc_hd__fill_1
XFILLER_118_251 vccd1 vssd1 vccd1 vssd1 SS_sky130_fd_sc_hd__fill_1
XTAP_TAPCELL_ROW_115_2025 vccd1 vssd1 SS_sky130_fd_sc_hd__tapvpwrvgnd_1
XTAP_TAPCELL_ROW_99_1791 vccd1 vssd1 SS_sky130_fd_sc_hd__tapvpwrvgnd_1
XTAP_TAPCELL_ROW_99_1780 vccd1 vssd1 SS_sky130_fd_sc_hd__tapvpwrvgnd_1
XFILLER_4_529 vssd1 vccd1 vccd1 vssd1 SS_sky130_fd_sc_hd__fill_2
XFILLER_21_57 vssd1 vccd1 vssd1 vccd1 SS_sky130_ef_sc_hd__decap_40_12
XFILLER_137_35 vssd1 vccd1 vssd1 vccd1 SS_sky130_ef_sc_hd__decap_40_12
XFILLER_119_785 vssd1 vccd1 vssd1 vccd1 SS_sky130_ef_sc_hd__decap_40_12
XFILLER_133_221 vssd1 vccd1 vccd1 vssd1 SS_sky130_fd_sc_hd__fill_2
XFILLER_137_57 vssd1 vccd1 vccd1 vssd1 SS_sky130_fd_sc_hd__fill_2
XFILLER_108_6 vssd1 vccd1 vssd1 vccd1 SS_sky130_ef_sc_hd__decap_40_12
XFILLER_0_713 vssd1 vccd1 vssd1 vccd1 SS_sky130_ef_sc_hd__decap_40_12
Xoutput160 vccd1 vssd1 wire310/A _1833_/X vccd1 vssd1 SS_sky130_fd_sc_hd__buf_4
XFILLER_134_788 vssd1 vccd1 vccd1 vssd1 SS_sky130_fd_sc_hd__fill_8
XFILLER_121_405 vssd1 vccd1 vssd1 vccd1 SS_sky130_ef_sc_hd__decap_40_12
XFILLER_97_39 vssd1 vccd1 vssd1 vccd1 SS_sky130_ef_sc_hd__decap_40_12
Xoutput193 vccd1 vssd1 wire362/A _1477_/Q vccd1 vssd1 SS_sky130_fd_sc_hd__buf_4
Xoutput182 vccd1 vssd1 wire373/A _1476_/Q vccd1 vssd1 SS_sky130_fd_sc_hd__buf_4
Xoutput171 vccd1 vssd1 wire384/A _1475_/Q vccd1 vssd1 SS_sky130_fd_sc_hd__buf_4
XFILLER_121_449 vssd1 vccd1 vssd1 vccd1 SS_sky130_ef_sc_hd__decap_40_12
XFILLER_75_503 vccd1 vssd1 vccd1 vssd1 SS_sky130_fd_sc_hd__fill_1
XPHY_EDGE_ROW_102_Right_102 vccd1 vssd1 vccd1 vssd1 SS_sky130_fd_sc_hd__decap_3
XFILLER_102_641 vssd1 vccd1 vccd1 vssd1 SS_sky130_fd_sc_hd__fill_2
XFILLER_47_205 vssd1 vccd1 vssd1 vccd1 SS_sky130_ef_sc_hd__decap_40_12
XFILLER_87_385 vssd1 vccd1 vccd1 vssd1 SS_sky130_fd_sc_hd__fill_4
XFILLER_47_249 vssd1 vccd1 vssd1 vccd1 SS_sky130_ef_sc_hd__decap_40_12
XFILLER_63_709 vssd1 vccd1 vssd1 vccd1 SS_sky130_ef_sc_hd__decap_40_12
XFILLER_16_625 vssd1 vccd1 vssd1 vccd1 SS_sky130_ef_sc_hd__decap_40_12
XFILLER_46_65 vssd1 vccd1 vssd1 vccd1 SS_sky130_ef_sc_hd__decap_40_12
XTAP_TAPCELL_ROW_126_2187 vccd1 vssd1 SS_sky130_fd_sc_hd__tapvpwrvgnd_1
XFILLER_15_113 vssd1 vccd1 vssd1 vccd1 SS_sky130_ef_sc_hd__decap_40_12
XFILLER_55_293 vssd1 vccd1 vssd1 vccd1 SS_sky130_ef_sc_hd__decap_40_12
XFILLER_16_669 vssd1 vccd1 vccd1 vssd1 SS_sky130_fd_sc_hd__fill_8
XFILLER_31_617 vssd1 vccd1 vccd1 vssd1 SS_sky130_fd_sc_hd__fill_2
XFILLER_71_775 vccd1 vssd1 vccd1 vssd1 SS_sky130_fd_sc_hd__fill_1
XTAP_TAPCELL_ROW_26_686 vccd1 vssd1 SS_sky130_fd_sc_hd__tapvpwrvgnd_1
XTAP_TAPCELL_ROW_26_697 vccd1 vssd1 SS_sky130_fd_sc_hd__tapvpwrvgnd_1
XFILLER_62_53 vssd1 vccd1 vssd1 vccd1 SS_sky130_ef_sc_hd__decap_40_12
XFILLER_8_813 vssd1 vccd1 vccd1 vssd1 SS_sky130_fd_sc_hd__fill_4
XFILLER_62_97 vssd1 vccd1 vssd1 vccd1 SS_sky130_ef_sc_hd__decap_40_12
XFILLER_129_505 vssd1 vccd1 vssd1 vccd1 SS_sky130_ef_sc_hd__decap_40_12
XFILLER_7_15 vssd1 vccd1 vssd1 vccd1 SS_sky130_ef_sc_hd__decap_40_12
XFILLER_129_549 vssd1 vccd1 vccd1 vssd1 SS_sky130_fd_sc_hd__fill_2
Xwire265 vccd1 vssd1 vssd1 vccd1 wire265/A analog_ctrl[2] SS_sky130_fd_sc_hd__buf_12
XFILLER_11_385 vssd1 vccd1 vccd1 vssd1 SS_sky130_fd_sc_hd__fill_4
XFILLER_7_389 vssd1 vccd1 vccd1 vssd1 SS_sky130_fd_sc_hd__fill_2
Xwire276 vccd1 vssd1 vssd1 vccd1 wire276/A analog_ctrl[1] SS_sky130_fd_sc_hd__buf_12
Xwire287 vccd1 vssd1 vssd1 vccd1 wire287/A analog_ctrl[120] SS_sky130_fd_sc_hd__buf_12
Xwire298 vccd1 vssd1 vssd1 vccd1 wire298/A analog_ctrl[110] SS_sky130_fd_sc_hd__buf_12
XFILLER_109_273 vssd1 vccd1 vccd1 vssd1 SS_sky130_fd_sc_hd__fill_4
XFILLER_124_221 vssd1 vccd1 vssd1 vccd1 SS_sky130_ef_sc_hd__decap_40_12
XFILLER_3_573 vssd1 vccd1 vssd1 vccd1 SS_sky130_ef_sc_hd__decap_40_12
XTAP_TAPCELL_ROW_55_1127 vccd1 vssd1 SS_sky130_fd_sc_hd__tapvpwrvgnd_1
XFILLER_124_265 vssd1 vccd1 vssd1 vccd1 SS_sky130_ef_sc_hd__decap_40_12
XFILLER_97_105 vssd1 vccd1 vccd1 vssd1 SS_sky130_fd_sc_hd__fill_4
Xload_slew204 vccd1 vssd1 _1439_/A2 _1463_/A2 vccd1 vssd1 SS_sky130_fd_sc_hd__buf_4
Xload_slew215 vccd1 vssd1 _1391_/A2 _1397_/A2 vccd1 vssd1 SS_sky130_fd_sc_hd__buf_4
XFILLER_97_149 vssd1 vccd1 vssd1 vccd1 SS_sky130_ef_sc_hd__decap_40_12
XFILLER_23_6 vssd1 vccd1 vssd1 vccd1 SS_sky130_ef_sc_hd__decap_40_12
XFILLER_78_330 vssd1 vccd1 vccd1 vssd1 SS_sky130_fd_sc_hd__fill_2
XFILLER_78_363 vccd1 vssd1 vccd1 vssd1 SS_sky130_fd_sc_hd__fill_1
XFILLER_78_385 vssd1 vccd1 vccd1 vssd1 SS_sky130_fd_sc_hd__fill_2
XFILLER_19_441 vssd1 vccd1 vccd1 vssd1 SS_sky130_fd_sc_hd__fill_4
XFILLER_38_249 vssd1 vccd1 vccd1 vssd1 SS_sky130_fd_sc_hd__fill_2
X_1101_ vssd1 vccd1 vccd1 vssd1 wire239/X wire501/X _1581_/D _1165_/C1 _1100_/X SS_sky130_fd_sc_hd__o211a_2
XFILLER_93_333 vssd1 vccd1 vccd1 vssd1 SS_sky130_fd_sc_hd__fill_2
X_1032_ vccd1 vssd1 vccd1 vssd1 _1032_/X _1032_/A _1050_/B SS_sky130_fd_sc_hd__or2_2
XFILLER_47_783 vccd1 vssd1 vccd1 vssd1 SS_sky130_fd_sc_hd__fill_1
XFILLER_81_517 vssd1 vccd1 vssd1 vccd1 SS_sky130_ef_sc_hd__decap_40_12
XFILLER_19_485 vssd1 vccd1 vssd1 vccd1 SS_sky130_ef_sc_hd__decap_40_12
XFILLER_34_433 vssd1 vccd1 vssd1 vccd1 SS_sky130_ef_sc_hd__decap_40_12
XFILLER_34_477 vssd1 vccd1 vssd1 vccd1 SS_sky130_ef_sc_hd__decap_40_12
XTAP_TAPCELL_ROW_45_973 vccd1 vssd1 SS_sky130_fd_sc_hd__tapvpwrvgnd_1
XFILLER_62_753 vssd1 vccd1 vccd1 vssd1 SS_sky130_fd_sc_hd__fill_2
XFILLER_21_105 vssd1 vccd1 vccd1 vssd1 SS_sky130_fd_sc_hd__fill_4
XFILLER_22_639 vssd1 vccd1 vccd1 vssd1 SS_sky130_fd_sc_hd__fill_4
XTAP_TAPCELL_ROW_66_1289 vccd1 vssd1 SS_sky130_fd_sc_hd__tapvpwrvgnd_1
XFILLER_21_149 vssd1 vccd1 vssd1 vccd1 SS_sky130_ef_sc_hd__decap_40_12
X_1865_ vccd1 vssd1 _1865_/X _1865_/A vccd1 vssd1 SS_sky130_fd_sc_hd__buf_2
Xinput40 vssd1 vccd1 vccd1 vssd1 input40/A input40/X SS_sky130_fd_sc_hd__clkdlybuf4s25_1
X_0816_ vccd1 vssd1 vccd1 vssd1 _1645_/Q wire430/X _1677_/Q wire448/X _0816_/X SS_sky130_fd_sc_hd__a22o_2
Xinput51 vssd1 vccd1 wire494/A input51/A vccd1 vssd1 SS_sky130_fd_sc_hd__buf_1
Xhold802 hold802/X _1500_/Q vccd1 vssd1 vssd1 vccd1 SS_sky130_fd_sc_hd__dlygate4sd3_1
Xhold813 hold813/X _1492_/Q vccd1 vssd1 vssd1 vccd1 SS_sky130_fd_sc_hd__dlygate4sd3_1
X_0747_ vccd1 vssd1 vssd1 vccd1 _0755_/B _0755_/A _0754_/D _0755_/C _0747_/Y SS_sky130_fd_sc_hd__nor4b_4
XFILLER_116_755 vccd1 vssd1 vccd1 vssd1 SS_sky130_fd_sc_hd__fill_1
XFILLER_116_733 vssd1 vccd1 vssd1 vccd1 SS_sky130_ef_sc_hd__decap_40_12
XFILLER_115_221 vssd1 vccd1 vccd1 vssd1 SS_sky130_fd_sc_hd__fill_2
XFILLER_89_617 vssd1 vccd1 vssd1 vccd1 SS_sky130_ef_sc_hd__decap_40_12
XFILLER_131_725 vssd1 vccd1 vccd1 vssd1 SS_sky130_fd_sc_hd__fill_2
XFILLER_107_27 vssd1 vccd1 vssd1 vccd1 SS_sky130_ef_sc_hd__decap_40_12
XFILLER_103_405 vssd1 vccd1 vssd1 vccd1 SS_sky130_ef_sc_hd__decap_40_12
XFILLER_103_449 vssd1 vccd1 vssd1 vccd1 SS_sky130_ef_sc_hd__decap_40_12
XFILLER_69_330 vssd1 vccd1 vccd1 vssd1 SS_sky130_fd_sc_hd__fill_4
XFILLER_29_205 vssd1 vccd1 vssd1 vccd1 SS_sky130_ef_sc_hd__decap_40_12
XFILLER_69_385 vssd1 vccd1 vccd1 vssd1 SS_sky130_fd_sc_hd__fill_4
XTAP_TAPCELL_ROW_4_359 vccd1 vssd1 SS_sky130_fd_sc_hd__tapvpwrvgnd_1
XFILLER_29_249 vssd1 vccd1 vssd1 vccd1 SS_sky130_ef_sc_hd__decap_40_12
XFILLER_96_193 vssd1 vccd1 vccd1 vssd1 SS_sky130_fd_sc_hd__fill_2
XFILLER_72_528 vssd1 vccd1 vccd1 vssd1 SS_sky130_fd_sc_hd__fill_4
XFILLER_84_377 vssd1 vccd1 vssd1 vccd1 SS_sky130_ef_sc_hd__decap_40_12
XFILLER_37_293 vssd1 vccd1 vssd1 vccd1 SS_sky130_ef_sc_hd__decap_40_12
XFILLER_13_617 vssd1 vccd1 vssd1 vccd1 SS_sky130_ef_sc_hd__decap_40_12
XFILLER_53_797 vssd1 vccd1 vccd1 vssd1 SS_sky130_fd_sc_hd__fill_4
XFILLER_80_583 vssd1 vccd1 vccd1 vssd1 SS_sky130_fd_sc_hd__fill_4
XFILLER_8_109 vssd1 vccd1 vssd1 vccd1 SS_sky130_ef_sc_hd__decap_40_12
XTAP_TAPCELL_ROW_23_645 vccd1 vssd1 SS_sky130_fd_sc_hd__tapvpwrvgnd_1
XFILLER_40_469 vssd1 vccd1 vccd1 vssd1 SS_sky130_fd_sc_hd__fill_4
XFILLER_20_193 vssd1 vccd1 vccd1 vssd1 SS_sky130_fd_sc_hd__fill_2
XFILLER_126_508 vssd1 vccd1 vssd1 vccd1 SS_sky130_ef_sc_hd__decap_40_12
XFILLER_107_755 vssd1 vccd1 vssd1 vccd1 SS_sky130_ef_sc_hd__decap_40_12
XFILLER_106_221 vssd1 vccd1 vssd1 vccd1 SS_sky130_ef_sc_hd__decap_40_12
XFILLER_79_105 vssd1 vccd1 vccd1 vssd1 SS_sky130_fd_sc_hd__fill_4
XFILLER_106_265 vssd1 vccd1 vssd1 vccd1 SS_sky130_ef_sc_hd__decap_40_12
XFILLER_79_149 vssd1 vccd1 vssd1 vccd1 SS_sky130_ef_sc_hd__decap_40_12
XTAP_TAPCELL_ROW_128_2216 vccd1 vssd1 SS_sky130_fd_sc_hd__tapvpwrvgnd_1
XFILLER_122_769 vssd1 vccd1 vssd1 vccd1 SS_sky130_ef_sc_hd__decap_40_12
XFILLER_0_587 vccd1 vssd1 vccd1 vssd1 SS_sky130_fd_sc_hd__fill_1
XFILLER_48_525 vssd1 vccd1 vccd1 vssd1 SS_sky130_fd_sc_hd__fill_4
XTAP_TAPCELL_ROW_50_1046 vccd1 vssd1 SS_sky130_fd_sc_hd__tapvpwrvgnd_1
XFILLER_88_683 vssd1 vccd1 vssd1 vccd1 SS_sky130_ef_sc_hd__decap_40_12
XTAP_TAPCELL_ROW_128_2227 vccd1 vssd1 SS_sky130_fd_sc_hd__tapvpwrvgnd_1
XFILLER_121_279 vccd1 vssd1 vccd1 vssd1 SS_sky130_fd_sc_hd__fill_1
XTAP_TAPCELL_ROW_50_1057 vccd1 vssd1 SS_sky130_fd_sc_hd__tapvpwrvgnd_1
XFILLER_75_333 vssd1 vccd1 vccd1 vssd1 SS_sky130_fd_sc_hd__fill_2
XFILLER_87_193 vssd1 vccd1 vssd1 vccd1 SS_sky130_ef_sc_hd__decap_40_12
XFILLER_29_761 vssd1 vccd1 vssd1 vccd1 SS_sky130_ef_sc_hd__decap_40_12
XFILLER_29_783 vccd1 vssd1 vccd1 vssd1 SS_sky130_fd_sc_hd__fill_1
XFILLER_63_517 vssd1 vccd1 vssd1 vccd1 SS_sky130_ef_sc_hd__decap_40_12
XFILLER_75_377 vssd1 vccd1 vssd1 vccd1 SS_sky130_ef_sc_hd__decap_40_12
XFILLER_16_433 vssd1 vccd1 vssd1 vccd1 SS_sky130_ef_sc_hd__decap_40_12
XFILLER_44_720 vssd1 vccd1 vssd1 vccd1 SS_sky130_ef_sc_hd__decap_40_12
XFILLER_73_30 vssd1 vccd1 vssd1 vccd1 SS_sky130_ef_sc_hd__decap_40_12
XFILLER_90_347 vccd1 vssd1 vccd1 vssd1 SS_sky130_fd_sc_hd__fill_1
XFILLER_113_81 vssd1 vccd1 vssd1 vccd1 SS_sky130_ef_sc_hd__decap_40_12
XFILLER_71_561 vssd1 vccd1 vssd1 vccd1 SS_sky130_ef_sc_hd__decap_40_12
XFILLER_16_477 vssd1 vccd1 vssd1 vccd1 SS_sky130_ef_sc_hd__decap_40_12
XTAP_TAPCELL_ROW_42_932 vccd1 vssd1 SS_sky130_fd_sc_hd__tapvpwrvgnd_1
XFILLER_31_447 vccd1 vssd1 vccd1 vssd1 SS_sky130_fd_sc_hd__fill_1
XFILLER_8_643 vccd1 vssd1 vccd1 vssd1 SS_sky130_fd_sc_hd__fill_1
XFILLER_11_193 vssd1 vccd1 vssd1 vccd1 SS_sky130_ef_sc_hd__decap_40_12
X_1650_ _1650_/Q _1717_/CLK _1650_/D vccd1 vssd1 vccd1 vssd1 SS_sky130_fd_sc_hd__dfxtp_2
X_1581_ _1855_/A clkload9/A _1581_/D vccd1 vssd1 vccd1 vssd1 SS_sky130_fd_sc_hd__dfxtp_2
XFILLER_137_390 vssd1 vccd1 vccd1 vssd1 SS_sky130_fd_sc_hd__fill_2
XFILLER_125_541 vssd1 vccd1 vssd1 vccd1 SS_sky130_ef_sc_hd__decap_40_12
XFILLER_125_585 vssd1 vccd1 vssd1 vccd1 SS_sky130_ef_sc_hd__decap_40_12
XFILLER_113_736 vssd1 vccd1 vccd1 vssd1 SS_sky130_fd_sc_hd__fill_2
XFILLER_113_725 vssd1 vccd1 vccd1 vssd1 SS_sky130_fd_sc_hd__fill_2
XFILLER_79_661 vssd1 vccd1 vccd1 vssd1 SS_sky130_fd_sc_hd__fill_8
XFILLER_100_408 vssd1 vccd1 vccd1 vssd1 SS_sky130_fd_sc_hd__fill_2
XFILLER_98_469 vccd1 vssd1 vccd1 vssd1 SS_sky130_fd_sc_hd__fill_1
XFILLER_121_780 vssd1 vccd1 vccd1 vssd1 SS_sky130_fd_sc_hd__fill_4
XFILLER_66_333 vssd1 vccd1 vccd1 vssd1 SS_sky130_fd_sc_hd__fill_2
XFILLER_78_193 vssd1 vccd1 vccd1 vssd1 SS_sky130_fd_sc_hd__fill_2
XFILLER_94_653 vssd1 vccd1 vccd1 vssd1 SS_sky130_fd_sc_hd__fill_8
XFILLER_94_642 vssd1 vccd1 vccd1 vssd1 SS_sky130_fd_sc_hd__fill_2
XTAP_TAPCELL_ROW_1_318 vccd1 vssd1 SS_sky130_fd_sc_hd__tapvpwrvgnd_1
XFILLER_66_377 vssd1 vccd1 vccd1 vssd1 SS_sky130_fd_sc_hd__fill_2
XTAP_TAPCELL_ROW_68_1318 vccd1 vssd1 SS_sky130_fd_sc_hd__tapvpwrvgnd_1
XFILLER_94_686 vssd1 vccd1 vssd1 vccd1 SS_sky130_ef_sc_hd__decap_40_12
XFILLER_19_293 vssd1 vccd1 vssd1 vccd1 SS_sky130_ef_sc_hd__decap_40_12
X_1015_ vssd1 vccd1 vccd1 vssd1 _1033_/A2 input20/X _1539_/D _1149_/C1 _1014_/X SS_sky130_fd_sc_hd__o211a_2
XFILLER_50_701 vssd1 vccd1 vccd1 vssd1 SS_sky130_fd_sc_hd__fill_4
XFILLER_81_369 vccd1 vssd1 vccd1 vssd1 SS_sky130_fd_sc_hd__fill_1
XFILLER_62_572 vssd1 vccd1 vssd1 vccd1 SS_sky130_ef_sc_hd__decap_40_12
XTAP_TAPCELL_ROW_81_1518 vccd1 vssd1 SS_sky130_fd_sc_hd__tapvpwrvgnd_1
XTAP_TAPCELL_ROW_20_604 vccd1 vssd1 SS_sky130_fd_sc_hd__tapvpwrvgnd_1
XFILLER_22_469 vssd1 vccd1 vccd1 vssd1 SS_sky130_fd_sc_hd__fill_4
X_1848_ vccd1 vssd1 _1848_/X _1848_/A vccd1 vssd1 SS_sky130_fd_sc_hd__buf_2
XFILLER_135_305 vssd1 vccd1 vssd1 vccd1 SS_sky130_ef_sc_hd__decap_40_12
Xhold610 _1168_/A _1874_/A vccd1 vssd1 vssd1 vccd1 SS_sky130_fd_sc_hd__dlygate4sd3_1
Xhold621 input21/A wbs_dat_i[10] vccd1 vssd1 vssd1 vccd1 SS_sky130_fd_sc_hd__dlygate4sd3_1
XFILLER_118_26 vssd1 vccd1 vccd1 vssd1 SS_sky130_fd_sc_hd__fill_2
XFILLER_116_530 vssd1 vccd1 vccd1 vssd1 SS_sky130_fd_sc_hd__fill_2
XTAP_TAPCELL_ROW_9_429 vccd1 vssd1 SS_sky130_fd_sc_hd__tapvpwrvgnd_1
Xhold643 _1290_/A _1673_/Q vccd1 vssd1 vssd1 vccd1 SS_sky130_fd_sc_hd__dlygate4sd3_1
Xhold632 _1298_/A _1677_/Q vccd1 vssd1 vssd1 vccd1 SS_sky130_fd_sc_hd__dlygate4sd3_1
Xhold654 _1206_/A _1633_/Q vccd1 vssd1 vssd1 vccd1 SS_sky130_fd_sc_hd__dlygate4sd3_1
XFILLER_1_329 vssd1 vccd1 vccd1 vssd1 SS_sky130_fd_sc_hd__fill_4
XFILLER_89_447 vccd1 vssd1 vccd1 vssd1 SS_sky130_fd_sc_hd__fill_1
XFILLER_116_585 vssd1 vccd1 vccd1 vssd1 SS_sky130_fd_sc_hd__fill_2
Xhold665 _1200_/A _1630_/Q vccd1 vssd1 vssd1 vccd1 SS_sky130_fd_sc_hd__dlygate4sd3_1
Xhold676 _1136_/A _1599_/Q vccd1 vssd1 vssd1 vccd1 SS_sky130_fd_sc_hd__dlygate4sd3_1
XFILLER_104_725 vssd1 vccd1 vssd1 vccd1 SS_sky130_ef_sc_hd__decap_40_12
Xhold687 _1316_/A _1686_/Q vccd1 vssd1 vssd1 vccd1 SS_sky130_fd_sc_hd__dlygate4sd3_1
XFILLER_58_801 vssd1 vccd1 vccd1 vssd1 SS_sky130_fd_sc_hd__fill_2
XFILLER_77_609 vssd1 vccd1 vccd1 vssd1 SS_sky130_fd_sc_hd__fill_4
Xhold698 _1066_/A _1565_/Q vccd1 vssd1 vssd1 vccd1 SS_sky130_fd_sc_hd__dlygate4sd3_1
XFILLER_134_58 vssd1 vccd1 vssd1 vccd1 SS_sky130_ef_sc_hd__decap_40_12
XFILLER_103_279 vccd1 vssd1 vccd1 vssd1 SS_sky130_fd_sc_hd__fill_1
XFILLER_57_333 vssd1 vccd1 vccd1 vssd1 SS_sky130_fd_sc_hd__fill_2
XFILLER_69_193 vssd1 vccd1 vssd1 vccd1 SS_sky130_ef_sc_hd__decap_40_12
XFILLER_85_653 vssd1 vccd1 vssd1 vccd1 SS_sky130_ef_sc_hd__decap_40_12
XFILLER_94_29 vssd1 vccd1 vssd1 vccd1 SS_sky130_ef_sc_hd__decap_40_12
XTAP_TAPCELL_ROW_28_715 vccd1 vssd1 SS_sky130_fd_sc_hd__tapvpwrvgnd_1
XFILLER_57_366 vssd1 vccd1 vccd1 vssd1 SS_sky130_fd_sc_hd__fill_4
XFILLER_84_141 vssd1 vccd1 vssd1 vccd1 SS_sky130_ef_sc_hd__decap_40_12
XFILLER_26_720 vccd1 vssd1 vccd1 vssd1 SS_sky130_fd_sc_hd__fill_1
XTAP_TAPCELL_ROW_28_726 vccd1 vssd1 SS_sky130_fd_sc_hd__tapvpwrvgnd_1
XFILLER_45_539 vssd1 vccd1 vccd1 vssd1 SS_sky130_fd_sc_hd__fill_4
XFILLER_85_697 vssd1 vccd1 vssd1 vccd1 SS_sky130_ef_sc_hd__decap_40_12
XTAP_TAPCELL_ROW_123_2146 vccd1 vssd1 SS_sky130_fd_sc_hd__tapvpwrvgnd_1
XFILLER_53_561 vssd1 vccd1 vccd1 vssd1 SS_sky130_fd_sc_hd__fill_4
XFILLER_13_447 vccd1 vssd1 vccd1 vssd1 SS_sky130_fd_sc_hd__fill_1
XFILLER_40_233 vssd1 vccd1 vssd1 vccd1 SS_sky130_ef_sc_hd__decap_40_12
XFILLER_9_429 vssd1 vccd1 vssd1 vccd1 SS_sky130_ef_sc_hd__decap_40_12
XFILLER_40_277 vssd1 vccd1 vssd1 vccd1 SS_sky130_ef_sc_hd__decap_40_12
XFILLER_5_613 vssd1 vccd1 vccd1 vssd1 SS_sky130_fd_sc_hd__fill_2
XFILLER_4_27 vccd1 vssd1 vccd1 vssd1 SS_sky130_fd_sc_hd__fill_1
XFILLER_4_189 vssd1 vccd1 vccd1 vssd1 SS_sky130_fd_sc_hd__fill_4
XFILLER_107_585 vssd1 vccd1 vssd1 vccd1 SS_sky130_ef_sc_hd__decap_40_12
XFILLER_1_841 vccd1 vssd1 vccd1 vssd1 SS_sky130_fd_sc_hd__fill_1
XFILLER_68_41 vssd1 vccd1 vssd1 vccd1 SS_sky130_ef_sc_hd__decap_40_12
XFILLER_108_81 vssd1 vccd1 vccd1 vssd1 SS_sky130_fd_sc_hd__fill_2
XFILLER_68_85 vssd1 vccd1 vssd1 vccd1 SS_sky130_ef_sc_hd__decap_40_12
XFILLER_48_333 vssd1 vccd1 vssd1 vccd1 SS_sky130_ef_sc_hd__decap_40_12
XFILLER_76_642 vssd1 vccd1 vccd1 vssd1 SS_sky130_fd_sc_hd__fill_2
XFILLER_88_491 vccd1 vssd1 vccd1 vssd1 SS_sky130_fd_sc_hd__fill_1
XTAP_TAPCELL_ROW_108_1919 vccd1 vssd1 SS_sky130_fd_sc_hd__tapvpwrvgnd_1
XFILLER_63_325 vssd1 vccd1 vccd1 vssd1 SS_sky130_fd_sc_hd__fill_2
XFILLER_91_645 vssd1 vccd1 vssd1 vccd1 SS_sky130_ef_sc_hd__decap_40_12
XFILLER_17_753 vssd1 vccd1 vccd1 vssd1 SS_sky130_fd_sc_hd__fill_4
XFILLER_63_347 vccd1 vssd1 vccd1 vssd1 SS_sky130_fd_sc_hd__fill_1
XFILLER_90_133 vssd1 vccd1 vccd1 vssd1 SS_sky130_fd_sc_hd__fill_4
XFILLER_17_775 vssd1 vccd1 vccd1 vssd1 SS_sky130_fd_sc_hd__fill_8
XFILLER_17_797 vssd1 vccd1 vccd1 vssd1 SS_sky130_fd_sc_hd__fill_4
XFILLER_32_701 vssd1 vccd1 vccd1 vssd1 SS_sky130_fd_sc_hd__fill_4
XFILLER_90_177 vssd1 vccd1 vssd1 vccd1 SS_sky130_ef_sc_hd__decap_40_12
XTAP_TAPCELL_ROW_63_1248 vccd1 vssd1 SS_sky130_fd_sc_hd__tapvpwrvgnd_1
XFILLER_71_391 vccd1 vssd1 vccd1 vssd1 SS_sky130_fd_sc_hd__fill_1
XFILLER_31_277 vssd1 vccd1 vccd1 vssd1 SS_sky130_fd_sc_hd__fill_2
XFILLER_8_473 vssd1 vccd1 vccd1 vssd1 SS_sky130_fd_sc_hd__fill_2
X_1702_ _1881_/A _1731_/CLK _1702_/D vccd1 vssd1 vccd1 vssd1 SS_sky130_fd_sc_hd__dfxtp_2
XFILLER_129_165 vssd1 vccd1 vccd1 vssd1 SS_sky130_fd_sc_hd__fill_2
XFILLER_117_305 vssd1 vccd1 vssd1 vccd1 SS_sky130_ef_sc_hd__decap_40_12
XFILLER_69_3 vssd1 vccd1 vssd1 vccd1 SS_sky130_ef_sc_hd__decap_40_12
X_1633_ _1633_/Q _1634_/CLK _1633_/D vccd1 vssd1 vccd1 vssd1 SS_sky130_fd_sc_hd__dfxtp_2
XFILLER_117_349 vssd1 vccd1 vssd1 vccd1 SS_sky130_ef_sc_hd__decap_40_12
X_1564_ _1564_/Q _1692_/CLK _1564_/D vccd1 vssd1 vccd1 vssd1 SS_sky130_fd_sc_hd__dfxtp_2
X_1495_ _1495_/Q _1751_/CLK _1495_/D vccd1 vssd1 vccd1 vssd1 SS_sky130_fd_sc_hd__dfxtp_2
XFILLER_86_406 vccd1 vssd1 vccd1 vssd1 SS_sky130_fd_sc_hd__fill_1
XFILLER_125_393 vssd1 vccd1 vccd1 vssd1 SS_sky130_fd_sc_hd__fill_4
XFILLER_98_233 vssd1 vccd1 vssd1 vccd1 SS_sky130_ef_sc_hd__decap_40_12
XFILLER_86_439 vssd1 vccd1 vssd1 vccd1 SS_sky130_ef_sc_hd__decap_40_12
XFILLER_98_277 vssd1 vccd1 vssd1 vccd1 SS_sky130_ef_sc_hd__decap_40_12
XFILLER_39_333 vssd1 vccd1 vccd1 vssd1 SS_sky130_fd_sc_hd__fill_2
XFILLER_100_249 vssd1 vccd1 vccd1 vssd1 SS_sky130_fd_sc_hd__fill_2
XFILLER_27_517 vssd1 vccd1 vssd1 vccd1 SS_sky130_ef_sc_hd__decap_40_12
XFILLER_66_141 vssd1 vccd1 vssd1 vccd1 SS_sky130_ef_sc_hd__decap_40_12
XFILLER_82_601 vssd1 vccd1 vssd1 vccd1 SS_sky130_ef_sc_hd__decap_40_12
XFILLER_81_111 vccd1 vssd1 vccd1 vssd1 SS_sky130_fd_sc_hd__fill_1
XFILLER_82_645 vssd1 vccd1 vssd1 vccd1 SS_sky130_ef_sc_hd__decap_40_12
XFILLER_35_561 vssd1 vccd1 vssd1 vccd1 SS_sky130_ef_sc_hd__decap_40_12
XFILLER_120_27 vccd1 vssd1 vccd1 vssd1 SS_sky130_fd_sc_hd__fill_1
XFILLER_22_233 vssd1 vccd1 vssd1 vccd1 SS_sky130_ef_sc_hd__decap_40_12
XFILLER_50_531 vccd1 vssd1 vccd1 vssd1 SS_sky130_fd_sc_hd__fill_1
XFILLER_10_417 vssd1 vccd1 vccd1 vssd1 SS_sky130_fd_sc_hd__fill_2
XFILLER_22_277 vssd1 vccd1 vssd1 vccd1 SS_sky130_ef_sc_hd__decap_40_12
XTAP_TAPCELL_ROW_33_795 vccd1 vssd1 SS_sky130_fd_sc_hd__tapvpwrvgnd_1
XFILLER_13_69 vssd1 vccd1 vssd1 vccd1 SS_sky130_ef_sc_hd__decap_40_12
XPHY_EDGE_ROW_70_Left_209 vccd1 vssd1 vccd1 vssd1 SS_sky130_fd_sc_hd__decap_3
XFILLER_136_625 vssd1 vccd1 vssd1 vccd1 SS_sky130_ef_sc_hd__decap_40_12
XFILLER_109_817 vssd1 vccd1 vccd1 vssd1 SS_sky130_fd_sc_hd__fill_8
XFILLER_108_305 vssd1 vccd1 vccd1 vssd1 SS_sky130_fd_sc_hd__fill_2
XFILLER_129_69 vssd1 vccd1 vssd1 vccd1 SS_sky130_ef_sc_hd__decap_40_12
XFILLER_135_113 vssd1 vccd1 vssd1 vccd1 SS_sky130_ef_sc_hd__decap_40_12
XFILLER_124_809 vssd1 vccd1 vccd1 vssd1 SS_sky130_fd_sc_hd__fill_2
XTAP_TAPCELL_ROW_94_1709 vccd1 vssd1 SS_sky130_fd_sc_hd__tapvpwrvgnd_1
XFILLER_1_137 vssd1 vccd1 vssd1 vccd1 SS_sky130_ef_sc_hd__decap_40_12
XFILLER_104_533 vssd1 vccd1 vssd1 vccd1 SS_sky130_ef_sc_hd__decap_40_12
XFILLER_77_417 vssd1 vccd1 vssd1 vccd1 SS_sky130_ef_sc_hd__decap_40_12
XFILLER_89_277 vssd1 vccd1 vccd1 vssd1 SS_sky130_fd_sc_hd__fill_2
XFILLER_131_385 vssd1 vccd1 vccd1 vssd1 SS_sky130_fd_sc_hd__fill_4
XFILLER_58_642 vssd1 vccd1 vccd1 vssd1 SS_sky130_fd_sc_hd__fill_2
XFILLER_38_77 vssd1 vccd1 vccd1 vssd1 SS_sky130_fd_sc_hd__fill_4
XFILLER_85_461 vssd1 vccd1 vssd1 vccd1 SS_sky130_ef_sc_hd__decap_40_12
XFILLER_100_750 vccd1 vssd1 vccd1 vssd1 SS_sky130_fd_sc_hd__fill_1
XFILLER_72_133 vssd1 vccd1 vccd1 vssd1 SS_sky130_fd_sc_hd__fill_4
XFILLER_14_701 vssd1 vccd1 vssd1 vccd1 SS_sky130_ef_sc_hd__decap_40_12
XFILLER_54_65 vssd1 vccd1 vssd1 vccd1 SS_sky130_ef_sc_hd__decap_40_12
XFILLER_72_177 vssd1 vccd1 vssd1 vccd1 SS_sky130_ef_sc_hd__decap_40_12
XFILLER_53_391 vccd1 vssd1 vccd1 vssd1 SS_sky130_fd_sc_hd__fill_1
XTAP_TAPCELL_ROW_103_1849 vccd1 vssd1 SS_sky130_fd_sc_hd__tapvpwrvgnd_1
XTAP_TAPCELL_ROW_103_1838 vccd1 vssd1 SS_sky130_fd_sc_hd__tapvpwrvgnd_1
XPHY_EDGE_ROW_109_Left_248 vccd1 vssd1 vccd1 vssd1 SS_sky130_fd_sc_hd__decap_3
XFILLER_9_237 vssd1 vccd1 vssd1 vccd1 SS_sky130_ef_sc_hd__decap_40_12
XFILLER_13_277 vssd1 vccd1 vccd1 vssd1 SS_sky130_fd_sc_hd__fill_2
XFILLER_41_597 vssd1 vccd1 vssd1 vccd1 SS_sky130_ef_sc_hd__decap_40_12
XFILLER_70_53 vssd1 vccd1 vssd1 vccd1 SS_sky130_ef_sc_hd__decap_40_12
XTAP_TAPCELL_ROW_136_2337 vccd1 vssd1 SS_sky130_fd_sc_hd__tapvpwrvgnd_1
XTAP_TAPCELL_ROW_11_467 vccd1 vssd1 SS_sky130_fd_sc_hd__tapvpwrvgnd_1
XFILLER_70_97 vssd1 vccd1 vssd1 vccd1 SS_sky130_ef_sc_hd__decap_40_12
Xclkload18 vssd1 vccd1 _1686_/CLK clkload18/X vccd1 vssd1 SS_sky130_fd_sc_hd__clkbuf_4
Xclkload29 clkload29/X _1752_/CLK vccd1 vssd1 vssd1 vccd1 SS_sky130_fd_sc_hd__clkbuf_8
Xclkbuf_leaf_1_wb_clk_i _1754_/CLK clkbuf_leaf_9_wb_clk_i/A vccd1 vssd1 vssd1 vccd1
+ SS_sky130_fd_sc_hd__clkbuf_8
XFILLER_79_51 vssd1 vccd1 vccd1 vssd1 SS_sky130_fd_sc_hd__fill_4
XFILLER_107_393 vssd1 vccd1 vssd1 vccd1 SS_sky130_ef_sc_hd__decap_40_12
XFILLER_1_671 vccd1 vssd1 vccd1 vssd1 SS_sky130_fd_sc_hd__fill_1
XFILLER_122_363 vccd1 vssd1 vccd1 vssd1 SS_sky130_fd_sc_hd__fill_1
XFILLER_122_352 vssd1 vccd1 vccd1 vssd1 SS_sky130_fd_sc_hd__fill_2
XPHY_EDGE_ROW_118_Left_257 vccd1 vssd1 vccd1 vssd1 SS_sky130_fd_sc_hd__decap_3
XFILLER_96_737 vssd1 vccd1 vssd1 vccd1 SS_sky130_ef_sc_hd__decap_40_12
XFILLER_0_181 vssd1 vccd1 vssd1 vccd1 SS_sky130_ef_sc_hd__decap_40_12
X_1280_ vccd1 vssd1 vccd1 vssd1 _1280_/X _1892_/A _1338_/B SS_sky130_fd_sc_hd__or2_2
XFILLER_95_225 vssd1 vccd1 vssd1 vccd1 SS_sky130_ef_sc_hd__decap_40_12
XFILLER_48_141 vssd1 vccd1 vssd1 vccd1 SS_sky130_ef_sc_hd__decap_40_12
XFILLER_49_653 vssd1 vccd1 vccd1 vssd1 SS_sky130_fd_sc_hd__fill_2
XFILLER_49_664 vssd1 vccd1 vccd1 vssd1 SS_sky130_fd_sc_hd__fill_8
XFILLER_110_569 vssd1 vccd1 vssd1 vccd1 SS_sky130_ef_sc_hd__decap_40_12
XFILLER_63_111 vccd1 vssd1 vccd1 vssd1 SS_sky130_fd_sc_hd__fill_1
XFILLER_64_645 vssd1 vccd1 vssd1 vccd1 SS_sky130_ef_sc_hd__decap_40_12
XFILLER_52_807 vssd1 vccd1 vccd1 vssd1 SS_sky130_fd_sc_hd__fill_4
XFILLER_17_561 vssd1 vccd1 vssd1 vccd1 SS_sky130_ef_sc_hd__decap_40_12
XTAP_TAPCELL_ROW_19_578 vccd1 vssd1 SS_sky130_fd_sc_hd__tapvpwrvgnd_1
XTAP_TAPCELL_ROW_19_589 vccd1 vssd1 SS_sky130_fd_sc_hd__tapvpwrvgnd_1
XFILLER_51_317 vssd1 vccd1 vssd1 vccd1 SS_sky130_ef_sc_hd__decap_40_12
XFILLER_32_531 vccd1 vssd1 vccd1 vssd1 SS_sky130_fd_sc_hd__fill_1
XPHY_EDGE_ROW_127_Left_266 vccd1 vssd1 vccd1 vssd1 SS_sky130_fd_sc_hd__decap_3
XTAP_TAPCELL_ROW_30_743 vccd1 vssd1 SS_sky130_fd_sc_hd__tapvpwrvgnd_1
XTAP_TAPCELL_ROW_30_754 vccd1 vssd1 SS_sky130_fd_sc_hd__tapvpwrvgnd_1
X_0995_ vssd1 vccd1 vccd1 vssd1 wire253/A input35/X _1530_/D _1457_/C1 _0994_/X SS_sky130_fd_sc_hd__o211a_2
XFILLER_118_625 vssd1 vccd1 vssd1 vccd1 SS_sky130_ef_sc_hd__decap_40_12
XFILLER_117_113 vssd1 vccd1 vssd1 vccd1 SS_sky130_ef_sc_hd__decap_40_12
XTAP_TAPCELL_ROW_76_1439 vccd1 vssd1 SS_sky130_fd_sc_hd__tapvpwrvgnd_1
XFILLER_118_669 vssd1 vccd1 vccd1 vssd1 SS_sky130_fd_sc_hd__fill_4
X_1616_ _1876_/A _1748_/CLK _1616_/D vccd1 vssd1 vccd1 vssd1 SS_sky130_fd_sc_hd__dfxtp_2
XPHY_EDGE_ROW_136_Left_275 vccd1 vssd1 vccd1 vssd1 SS_sky130_fd_sc_hd__decap_3
XFILLER_5_81 vssd1 vccd1 vssd1 vccd1 SS_sky130_ef_sc_hd__decap_40_12
X_1547_ _1547_/Q _1742_/CLK _1547_/D vccd1 vssd1 vccd1 vssd1 SS_sky130_fd_sc_hd__dfxtp_2
XFILLER_59_417 vssd1 vccd1 vssd1 vccd1 SS_sky130_ef_sc_hd__decap_40_12
Xfanout238 vssd1 vccd1 vccd1 vssd1 wire241/X wire239/A SS_sky130_fd_sc_hd__clkdlybuf4s25_1
Xfanout216 vssd1 vccd1 vccd1 vssd1 _1396_/B _1404_/B SS_sky130_fd_sc_hd__clkdlybuf4s25_1
XFILLER_115_27 vssd1 vccd1 vssd1 vccd1 SS_sky130_ef_sc_hd__decap_40_12
XFILLER_101_503 vccd1 vssd1 vccd1 vssd1 SS_sky130_fd_sc_hd__fill_1
XFILLER_99_597 vssd1 vccd1 vssd1 vccd1 SS_sky130_ef_sc_hd__decap_40_12
X_1478_ _1478_/Q clkload6/A _1478_/D vccd1 vssd1 vccd1 vssd1 SS_sky130_fd_sc_hd__dfxtp_2
XFILLER_67_461 vssd1 vccd1 vssd1 vccd1 SS_sky130_ef_sc_hd__decap_40_12
XTAP_TAPCELL_ROW_38_865 vccd1 vssd1 SS_sky130_fd_sc_hd__tapvpwrvgnd_1
XFILLER_54_133 vssd1 vccd1 vccd1 vssd1 SS_sky130_fd_sc_hd__fill_4
XFILLER_82_431 vccd1 vssd1 vccd1 vssd1 SS_sky130_fd_sc_hd__fill_1
XTAP_TAPCELL_ROW_38_876 vccd1 vssd1 SS_sky130_fd_sc_hd__tapvpwrvgnd_1
XFILLER_54_177 vssd1 vccd1 vssd1 vccd1 SS_sky130_ef_sc_hd__decap_40_12
XTAP_TAPCELL_ROW_120_2105 vccd1 vssd1 SS_sky130_fd_sc_hd__tapvpwrvgnd_1
XFILLER_35_391 vccd1 vssd1 vccd1 vssd1 SS_sky130_fd_sc_hd__fill_1
XFILLER_23_553 vssd1 vccd1 vccd1 vssd1 SS_sky130_fd_sc_hd__fill_4
XFILLER_50_361 vssd1 vccd1 vccd1 vssd1 SS_sky130_fd_sc_hd__fill_2
XFILLER_23_597 vssd1 vccd1 vssd1 vccd1 SS_sky130_ef_sc_hd__decap_40_12
XFILLER_138_6 vssd1 vccd1 vccd1 vssd1 SS_sky130_fd_sc_hd__fill_4
XFILLER_109_614 vssd1 vccd1 vccd1 vssd1 SS_sky130_fd_sc_hd__fill_2
XTAP_TAPCELL_ROW_118_2067 vccd1 vssd1 SS_sky130_fd_sc_hd__tapvpwrvgnd_1
XFILLER_2_413 vssd1 vccd1 vccd1 vssd1 SS_sky130_fd_sc_hd__fill_4
XTAP_TAPCELL_ROW_131_2267 vccd1 vssd1 SS_sky130_fd_sc_hd__tapvpwrvgnd_1
XFILLER_123_105 vssd1 vccd1 vccd1 vssd1 SS_sky130_fd_sc_hd__fill_4
XFILLER_2_457 vssd1 vccd1 vssd1 vccd1 SS_sky130_ef_sc_hd__decap_40_12
XFILLER_123_149 vssd1 vccd1 vssd1 vccd1 SS_sky130_ef_sc_hd__decap_40_12
XFILLER_78_737 vssd1 vccd1 vssd1 vccd1 SS_sky130_ef_sc_hd__decap_40_12
XFILLER_132_683 vssd1 vccd1 vssd1 vccd1 SS_sky130_ef_sc_hd__decap_40_12
XFILLER_77_225 vssd1 vccd1 vssd1 vccd1 SS_sky130_ef_sc_hd__decap_40_12
XFILLER_131_193 vssd1 vccd1 vssd1 vccd1 SS_sky130_ef_sc_hd__decap_40_12
XFILLER_46_601 vssd1 vccd1 vccd1 vssd1 SS_sky130_fd_sc_hd__fill_8
XFILLER_93_729 vssd1 vccd1 vccd1 vssd1 SS_sky130_fd_sc_hd__fill_4
XFILLER_45_111 vccd1 vssd1 vccd1 vssd1 SS_sky130_fd_sc_hd__fill_1
XFILLER_105_93 vssd1 vccd1 vssd1 vccd1 SS_sky130_ef_sc_hd__decap_40_12
XFILLER_34_818 vssd1 vccd1 vccd1 vssd1 SS_sky130_fd_sc_hd__fill_2
XFILLER_46_645 vssd1 vccd1 vssd1 vccd1 SS_sky130_ef_sc_hd__decap_40_12
XFILLER_73_442 vssd1 vccd1 vccd1 vssd1 SS_sky130_fd_sc_hd__fill_4
XFILLER_33_317 vssd1 vccd1 vssd1 vccd1 SS_sky130_ef_sc_hd__decap_40_12
XTAP_TAPCELL_ROW_47_1007 vccd1 vssd1 SS_sky130_fd_sc_hd__tapvpwrvgnd_1
XFILLER_14_531 vccd1 vssd1 vccd1 vssd1 SS_sky130_fd_sc_hd__fill_1
XTAP_TAPCELL_ROW_16_537 vccd1 vssd1 SS_sky130_fd_sc_hd__tapvpwrvgnd_1
XTAP_TAPCELL_ROW_60_1207 vccd1 vssd1 SS_sky130_fd_sc_hd__tapvpwrvgnd_1
XFILLER_81_30 vssd1 vccd1 vssd1 vccd1 SS_sky130_ef_sc_hd__decap_40_12
XFILLER_121_81 vssd1 vccd1 vssd1 vccd1 SS_sky130_ef_sc_hd__decap_40_12
XFILLER_41_361 vssd1 vccd1 vssd1 vccd1 SS_sky130_ef_sc_hd__decap_40_12
X_0780_ vccd1 vssd1 vccd1 vssd1 _0865_/B1 _1639_/Q wire430/X _1899_/A wire435/X _0780_/X
+ SS_sky130_fd_sc_hd__a221o_2
XPHY_EDGE_ROW_116_Right_116 vccd1 vssd1 vccd1 vssd1 SS_sky130_fd_sc_hd__decap_3
XFILLER_115_617 vssd1 vccd1 vccd1 vssd1 SS_sky130_fd_sc_hd__fill_4
XFILLER_5_273 vssd1 vccd1 vccd1 vssd1 SS_sky130_fd_sc_hd__fill_4
XFILLER_53_6 vssd1 vccd1 vssd1 vccd1 SS_sky130_ef_sc_hd__decap_40_12
XFILLER_127_477 vssd1 vccd1 vccd1 vssd1 SS_sky130_fd_sc_hd__fill_2
XTAP_TAPCELL_ROW_58_1169 vccd1 vssd1 SS_sky130_fd_sc_hd__tapvpwrvgnd_1
X_1401_ vssd1 vccd1 vccd1 vssd1 _1405_/A2 input40/X _1727_/D _1401_/C1 _1400_/X SS_sky130_fd_sc_hd__o211a_2
XFILLER_111_823 vccd1 vssd1 vccd1 vssd1 SS_sky130_fd_sc_hd__fill_1
XTAP_TAPCELL_ROW_71_1358 vccd1 vssd1 SS_sky130_fd_sc_hd__tapvpwrvgnd_1
XTAP_TAPCELL_ROW_71_1369 vccd1 vssd1 SS_sky130_fd_sc_hd__tapvpwrvgnd_1
XFILLER_122_193 vssd1 vccd1 vccd1 vssd1 SS_sky130_fd_sc_hd__fill_2
X_1332_ vccd1 vssd1 vccd1 vssd1 _1332_/X _1332_/A _1338_/B SS_sky130_fd_sc_hd__or2_2
XFILLER_110_333 vssd1 vccd1 vccd1 vssd1 SS_sky130_fd_sc_hd__fill_8
XFILLER_96_545 vssd1 vccd1 vssd1 vccd1 SS_sky130_ef_sc_hd__decap_40_12
X_1263_ vssd1 vccd1 vccd1 vssd1 _1265_/A2 input37/X _1660_/D _1465_/C1 _1262_/X SS_sky130_fd_sc_hd__o211a_2
XFILLER_96_589 vssd1 vccd1 vccd1 vssd1 SS_sky130_fd_sc_hd__fill_8
Xinput5 vssd1 vccd1 vccd1 vssd1 adc_data[2] input5/X SS_sky130_fd_sc_hd__clkdlybuf4s25_1
XFILLER_49_461 vssd1 vccd1 vssd1 vccd1 SS_sky130_ef_sc_hd__decap_40_12
XFILLER_77_781 vssd1 vccd1 vccd1 vssd1 SS_sky130_fd_sc_hd__fill_2
XFILLER_83_217 vssd1 vccd1 vccd1 vssd1 SS_sky130_fd_sc_hd__fill_4
XFILLER_110_377 vssd1 vccd1 vccd1 vssd1 SS_sky130_fd_sc_hd__fill_8
XFILLER_36_133 vssd1 vccd1 vccd1 vssd1 SS_sky130_fd_sc_hd__fill_4
X_1194_ vccd1 vssd1 vccd1 vssd1 _1194_/X _1194_/A _1208_/B SS_sky130_fd_sc_hd__or2_2
XFILLER_36_177 vssd1 vccd1 vssd1 vccd1 SS_sky130_ef_sc_hd__decap_40_12
XFILLER_52_626 vssd1 vccd1 vccd1 vssd1 SS_sky130_fd_sc_hd__fill_8
XFILLER_91_261 vssd1 vccd1 vssd1 vccd1 SS_sky130_ef_sc_hd__decap_40_12
XFILLER_17_391 vccd1 vssd1 vccd1 vssd1 SS_sky130_fd_sc_hd__fill_1
XTAP_TAPCELL_ROW_35_824 vccd1 vssd1 SS_sky130_fd_sc_hd__tapvpwrvgnd_1
XFILLER_51_125 vssd1 vccd1 vssd1 vccd1 SS_sky130_ef_sc_hd__decap_40_12
XTAP_TAPCELL_ROW_86_1590 vccd1 vssd1 SS_sky130_fd_sc_hd__tapvpwrvgnd_1
XFILLER_101_18 vssd1 vccd1 vssd1 vccd1 SS_sky130_ef_sc_hd__decap_40_12
XFILLER_51_169 vssd1 vccd1 vssd1 vccd1 SS_sky130_ef_sc_hd__decap_40_12
XFILLER_20_501 vssd1 vccd1 vssd1 vccd1 SS_sky130_ef_sc_hd__decap_40_12
XFILLER_32_361 vssd1 vccd1 vccd1 vssd1 SS_sky130_fd_sc_hd__fill_2
XFILLER_20_545 vssd1 vccd1 vssd1 vccd1 SS_sky130_ef_sc_hd__decap_40_12
XFILLER_20_589 vssd1 vccd1 vssd1 vccd1 SS_sky130_ef_sc_hd__decap_40_12
XFILLER_118_411 vccd1 vssd1 vccd1 vssd1 SS_sky130_fd_sc_hd__fill_1
X_0978_ vccd1 vssd1 vccd1 vssd1 _0978_/X _0978_/A _1008_/B SS_sky130_fd_sc_hd__or2_2
XFILLER_10_15 vssd1 vccd1 vssd1 vccd1 SS_sky130_ef_sc_hd__decap_40_12
XFILLER_118_477 vssd1 vccd1 vccd1 vssd1 SS_sky130_fd_sc_hd__fill_8
XFILLER_105_105 vssd1 vccd1 vccd1 vssd1 SS_sky130_fd_sc_hd__fill_4
XFILLER_133_447 vccd1 vssd1 vccd1 vssd1 SS_sky130_fd_sc_hd__fill_1
XFILLER_133_458 vssd1 vccd1 vccd1 vssd1 SS_sky130_fd_sc_hd__fill_4
XFILLER_126_26 vssd1 vccd1 vccd1 vssd1 SS_sky130_fd_sc_hd__fill_2
XFILLER_105_149 vssd1 vccd1 vssd1 vccd1 SS_sky130_ef_sc_hd__decap_40_12
XFILLER_99_361 vssd1 vccd1 vccd1 vssd1 SS_sky130_fd_sc_hd__fill_4
XFILLER_59_225 vssd1 vccd1 vssd1 vccd1 SS_sky130_ef_sc_hd__decap_40_12
XFILLER_75_729 vssd1 vccd1 vccd1 vssd1 SS_sky130_fd_sc_hd__fill_4
XFILLER_113_193 vssd1 vccd1 vssd1 vccd1 SS_sky130_ef_sc_hd__decap_40_12
XFILLER_19_57 vssd1 vccd1 vssd1 vccd1 SS_sky130_ef_sc_hd__decap_40_12
XFILLER_28_601 vssd1 vccd1 vssd1 vccd1 SS_sky130_ef_sc_hd__decap_40_12
XFILLER_68_781 vssd1 vccd1 vssd1 vccd1 SS_sky130_ef_sc_hd__decap_40_12
XFILLER_27_111 vccd1 vssd1 vccd1 vssd1 SS_sky130_fd_sc_hd__fill_1
XFILLER_28_645 vssd1 vccd1 vssd1 vccd1 SS_sky130_ef_sc_hd__decap_40_12
XFILLER_15_317 vssd1 vccd1 vssd1 vccd1 SS_sky130_ef_sc_hd__decap_40_12
XFILLER_43_615 vccd1 vssd1 vccd1 vssd1 SS_sky130_fd_sc_hd__fill_1
XFILLER_70_412 vssd1 vccd1 vccd1 vssd1 SS_sky130_fd_sc_hd__fill_8
XFILLER_30_309 vssd1 vccd1 vssd1 vccd1 SS_sky130_ef_sc_hd__decap_40_12
XFILLER_70_456 vssd1 vccd1 vssd1 vccd1 SS_sky130_ef_sc_hd__decap_40_12
XFILLER_11_501 vssd1 vccd1 vccd1 vssd1 SS_sky130_fd_sc_hd__fill_2
XFILLER_23_361 vssd1 vccd1 vssd1 vccd1 SS_sky130_ef_sc_hd__decap_40_12
XFILLER_51_681 vssd1 vccd1 vccd1 vssd1 SS_sky130_fd_sc_hd__fill_2
XFILLER_70_489 vssd1 vccd1 vssd1 vccd1 SS_sky130_ef_sc_hd__decap_40_12
XFILLER_7_505 vssd1 vccd1 vssd1 vccd1 SS_sky130_ef_sc_hd__decap_40_12
Xwire414 vccd1 vssd1 vssd1 vccd1 wire414/A analog_ctrl[67] SS_sky130_fd_sc_hd__buf_12
Xwire403 vccd1 vssd1 vssd1 vccd1 wire403/A analog_ctrl[78] SS_sky130_fd_sc_hd__buf_12
XFILLER_2_221 vssd1 vccd1 vssd1 vccd1 SS_sky130_ef_sc_hd__decap_40_12
XFILLER_2_265 vssd1 vccd1 vssd1 vccd1 SS_sky130_ef_sc_hd__decap_40_12
XFILLER_3_777 vssd1 vccd1 vccd1 vssd1 SS_sky130_fd_sc_hd__fill_4
XFILLER_78_501 vssd1 vccd1 vccd1 vssd1 SS_sky130_fd_sc_hd__fill_4
Xload_slew419 vccd1 vssd1 _0930_/B1 _0947_/A vccd1 vssd1 SS_sky130_fd_sc_hd__buf_4
XFILLER_112_609 vssd1 vccd1 vssd1 vccd1 SS_sky130_ef_sc_hd__decap_40_12
XFILLER_78_545 vssd1 vccd1 vssd1 vccd1 SS_sky130_ef_sc_hd__decap_40_12
XTAP_TAPCELL_ROW_111_1959 vccd1 vssd1 SS_sky130_fd_sc_hd__tapvpwrvgnd_1
XTAP_TAPCELL_ROW_53_1088 vccd1 vssd1 SS_sky130_fd_sc_hd__tapvpwrvgnd_1
XFILLER_76_41 vssd1 vccd1 vssd1 vccd1 SS_sky130_ef_sc_hd__decap_40_12
XFILLER_120_675 vssd1 vccd1 vssd1 vccd1 SS_sky130_ef_sc_hd__decap_40_12
XFILLER_120_642 vssd1 vccd1 vccd1 vssd1 SS_sky130_fd_sc_hd__fill_2
XFILLER_116_81 vssd1 vccd1 vccd1 vssd1 SS_sky130_fd_sc_hd__fill_2
XFILLER_104_193 vssd1 vccd1 vccd1 vssd1 SS_sky130_fd_sc_hd__fill_2
XTAP_TAPCELL_ROW_53_1099 vccd1 vssd1 SS_sky130_fd_sc_hd__tapvpwrvgnd_1
XFILLER_59_781 vssd1 vccd1 vccd1 vssd1 SS_sky130_fd_sc_hd__fill_2
XFILLER_65_217 vssd1 vccd1 vccd1 vssd1 SS_sky130_fd_sc_hd__fill_4
XFILLER_76_85 vssd1 vccd1 vssd1 vccd1 SS_sky130_ef_sc_hd__decap_40_12
XFILLER_78_589 vssd1 vccd1 vssd1 vccd1 SS_sky130_ef_sc_hd__decap_40_12
XFILLER_18_133 vssd1 vccd1 vccd1 vssd1 SS_sky130_fd_sc_hd__fill_4
XFILLER_74_751 vssd1 vccd1 vccd1 vssd1 SS_sky130_fd_sc_hd__fill_4
XFILLER_93_559 vccd1 vssd1 vccd1 vssd1 SS_sky130_fd_sc_hd__fill_1
XFILLER_18_177 vssd1 vccd1 vssd1 vccd1 SS_sky130_ef_sc_hd__decap_40_12
XFILLER_46_475 vccd1 vssd1 vccd1 vssd1 SS_sky130_fd_sc_hd__fill_1
XFILLER_73_261 vssd1 vccd1 vssd1 vccd1 SS_sky130_ef_sc_hd__decap_40_12
XFILLER_80_209 vssd1 vccd1 vssd1 vccd1 SS_sky130_ef_sc_hd__decap_40_12
XFILLER_33_125 vssd1 vccd1 vssd1 vccd1 SS_sky130_ef_sc_hd__decap_40_12
XFILLER_34_637 vssd1 vccd1 vccd1 vssd1 SS_sky130_fd_sc_hd__fill_4
XFILLER_61_412 vssd1 vccd1 vssd1 vccd1 SS_sky130_ef_sc_hd__decap_40_12
XFILLER_61_445 vssd1 vccd1 vccd1 vssd1 SS_sky130_fd_sc_hd__fill_2
XFILLER_33_169 vssd1 vccd1 vssd1 vccd1 SS_sky130_ef_sc_hd__decap_40_12
XFILLER_61_467 vccd1 vssd1 vccd1 vssd1 SS_sky130_fd_sc_hd__fill_1
XFILLER_14_361 vssd1 vccd1 vccd1 vssd1 SS_sky130_fd_sc_hd__fill_2
XFILLER_30_810 vssd1 vccd1 vccd1 vssd1 SS_sky130_fd_sc_hd__fill_2
XFILLER_42_692 vssd1 vccd1 vccd1 vssd1 SS_sky130_fd_sc_hd__fill_8
X_1881_ vccd1 vssd1 _1881_/X _1881_/A vccd1 vssd1 SS_sky130_fd_sc_hd__buf_2
X_0901_ vssd1 vccd1 vccd1 vssd1 _0901_/B _0901_/C _0943_/A _0901_/X SS_sky130_fd_sc_hd__or3_2
X_0832_ vccd1 vssd1 vccd1 vssd1 _1858_/A wire443/A _1712_/Q wire454/A _0832_/X SS_sky130_fd_sc_hd__a22o_2
XTAP_TAPCELL_ROW_40_893 vccd1 vssd1 SS_sky130_fd_sc_hd__tapvpwrvgnd_1
X_0763_ vssd1 vccd1 vssd1 vccd1 wire421/X _1836_/A _0761_/X _0762_/X _0763_/X wire347/X
+ SS_sky130_fd_sc_hd__a2111o_2
XFILLER_115_447 vccd1 vssd1 vccd1 vssd1 SS_sky130_fd_sc_hd__fill_1
XFILLER_69_501 vssd1 vccd1 vccd1 vssd1 SS_sky130_fd_sc_hd__fill_2
XFILLER_88_309 vssd1 vccd1 vccd1 vssd1 SS_sky130_fd_sc_hd__fill_4
XFILLER_130_417 vssd1 vccd1 vccd1 vssd1 SS_sky130_fd_sc_hd__fill_2
XFILLER_103_609 vssd1 vccd1 vccd1 vssd1 SS_sky130_fd_sc_hd__fill_4
X_1315_ vssd1 vccd1 vccd1 vssd1 _1325_/A2 input29/X _1685_/D _1425_/C1 _1314_/X SS_sky130_fd_sc_hd__o211a_2
XFILLER_110_141 vssd1 vccd1 vssd1 vccd1 SS_sky130_ef_sc_hd__decap_40_12
XFILLER_57_729 vccd1 vssd1 vccd1 vssd1 SS_sky130_fd_sc_hd__fill_1
XFILLER_111_697 vssd1 vccd1 vssd1 vccd1 SS_sky130_ef_sc_hd__decap_40_12
X_1246_ vccd1 vssd1 vccd1 vssd1 _1246_/X _1652_/Q _1264_/B SS_sky130_fd_sc_hd__or2_2
XFILLER_25_615 vccd1 vssd1 vccd1 vssd1 SS_sky130_fd_sc_hd__fill_1
XFILLER_52_401 vssd1 vccd1 vccd1 vssd1 SS_sky130_fd_sc_hd__fill_8
XFILLER_65_762 vssd1 vccd1 vssd1 vccd1 SS_sky130_ef_sc_hd__decap_40_12
X_1177_ vssd1 vccd1 vccd1 vssd1 _1195_/A2 input26/X _1177_/X _1309_/C1 _1176_/X SS_sky130_fd_sc_hd__o211a_2
XFILLER_25_637 vccd1 vssd1 vccd1 vssd1 SS_sky130_fd_sc_hd__fill_1
XFILLER_92_581 vssd1 vccd1 vccd1 vssd1 SS_sky130_fd_sc_hd__fill_4
XFILLER_12_309 vssd1 vccd1 vssd1 vccd1 SS_sky130_ef_sc_hd__decap_40_12
XFILLER_33_670 vssd1 vccd1 vccd1 vssd1 SS_sky130_fd_sc_hd__fill_2
XFILLER_52_489 vssd1 vccd1 vccd1 vssd1 SS_sky130_fd_sc_hd__fill_4
XANTENNA_10 _1643_/Q vssd1 vccd1 vccd1 vssd1 SS_sky130_fd_sc_hd__diode_2
XTAP_TAPCELL_ROW_115_2026 vccd1 vssd1 SS_sky130_fd_sc_hd__tapvpwrvgnd_1
XTAP_TAPCELL_ROW_99_1781 vccd1 vssd1 SS_sky130_fd_sc_hd__tapvpwrvgnd_1
XFILLER_21_69 vssd1 vccd1 vssd1 vccd1 SS_sky130_ef_sc_hd__decap_40_12
XFILLER_137_47 vssd1 vccd1 vccd1 vssd1 SS_sky130_fd_sc_hd__fill_8
XFILLER_119_797 vssd1 vccd1 vccd1 vssd1 SS_sky130_fd_sc_hd__fill_8
XTAP_TAPCELL_ROW_99_1792 vccd1 vssd1 SS_sky130_fd_sc_hd__tapvpwrvgnd_1
Xoutput150 vccd1 vssd1 wire401/A _1651_/Q vccd1 vssd1 SS_sky130_fd_sc_hd__buf_4
XFILLER_133_277 vssd1 vccd1 vccd1 vssd1 SS_sky130_fd_sc_hd__fill_2
XFILLER_121_417 vssd1 vccd1 vssd1 vccd1 SS_sky130_ef_sc_hd__decap_40_12
Xoutput161 vccd1 vssd1 wire391/A _1661_/Q vccd1 vssd1 SS_sky130_fd_sc_hd__buf_4
XFILLER_0_725 vssd1 vccd1 vccd1 vssd1 SS_sky130_fd_sc_hd__fill_2
Xoutput183 vccd1 vssd1 wire372/A _1495_/Q vccd1 vssd1 SS_sky130_fd_sc_hd__buf_4
Xoutput194 vccd1 vssd1 wire361/A _1505_/Q vccd1 vssd1 SS_sky130_fd_sc_hd__buf_4
Xoutput172 vccd1 vssd1 wire383/A _1485_/Q vccd1 vssd1 SS_sky130_fd_sc_hd__buf_4
XFILLER_47_217 vssd1 vccd1 vccd1 vssd1 SS_sky130_fd_sc_hd__fill_4
XFILLER_75_559 vccd1 vssd1 vccd1 vssd1 SS_sky130_fd_sc_hd__fill_1
XFILLER_28_475 vccd1 vssd1 vccd1 vssd1 SS_sky130_fd_sc_hd__fill_1
XFILLER_46_77 vssd1 vccd1 vccd1 vssd1 SS_sky130_fd_sc_hd__fill_4
XFILLER_55_261 vssd1 vccd1 vssd1 vccd1 SS_sky130_ef_sc_hd__decap_40_12
XFILLER_62_209 vssd1 vccd1 vssd1 vccd1 SS_sky130_ef_sc_hd__decap_40_12
XFILLER_90_529 vssd1 vccd1 vccd1 vssd1 SS_sky130_fd_sc_hd__fill_2
XTAP_TAPCELL_ROW_126_2188 vccd1 vssd1 SS_sky130_fd_sc_hd__tapvpwrvgnd_1
XFILLER_15_125 vssd1 vccd1 vssd1 vccd1 SS_sky130_ef_sc_hd__decap_40_12
XFILLER_16_637 vssd1 vccd1 vccd1 vssd1 SS_sky130_fd_sc_hd__fill_4
XFILLER_15_169 vssd1 vccd1 vssd1 vccd1 SS_sky130_ef_sc_hd__decap_40_12
XFILLER_70_253 vssd1 vccd1 vssd1 vccd1 SS_sky130_ef_sc_hd__decap_40_12
XFILLER_12_810 vssd1 vccd1 vccd1 vssd1 SS_sky130_fd_sc_hd__fill_2
XTAP_TAPCELL_ROW_26_687 vccd1 vssd1 SS_sky130_fd_sc_hd__tapvpwrvgnd_1
XFILLER_102_83 vccd1 vssd1 vccd1 vssd1 SS_sky130_fd_sc_hd__fill_1
XFILLER_30_139 vccd1 vssd1 vccd1 vssd1 SS_sky130_fd_sc_hd__fill_1
XFILLER_62_65 vssd1 vccd1 vssd1 vccd1 SS_sky130_ef_sc_hd__decap_40_12
XFILLER_129_517 vssd1 vccd1 vssd1 vccd1 SS_sky130_ef_sc_hd__decap_40_12
XFILLER_7_27 vssd1 vccd1 vssd1 vccd1 SS_sky130_ef_sc_hd__decap_40_12
XFILLER_7_335 vccd1 vssd1 vccd1 vssd1 SS_sky130_fd_sc_hd__fill_1
Xwire266 vccd1 vssd1 vssd1 vccd1 wire266/A analog_ctrl[29] SS_sky130_fd_sc_hd__buf_12
Xwire233 vccd1 vssd1 wire233/X wire233/A vccd1 vssd1 SS_sky130_fd_sc_hd__buf_4
Xwire299 vccd1 vssd1 vssd1 vccd1 wire299/A analog_ctrl[10] SS_sky130_fd_sc_hd__buf_12
Xwire288 vccd1 vssd1 vssd1 vccd1 wire288/A analog_ctrl[11] SS_sky130_fd_sc_hd__buf_12
Xwire277 vccd1 vssd1 vssd1 vccd1 wire277/A analog_ctrl[19] SS_sky130_fd_sc_hd__buf_12
XFILLER_137_561 vssd1 vccd1 vccd1 vssd1 SS_sky130_fd_sc_hd__fill_8
XFILLER_125_745 vssd1 vccd1 vssd1 vccd1 SS_sky130_ef_sc_hd__decap_40_12
XFILLER_124_233 vssd1 vccd1 vssd1 vccd1 SS_sky130_ef_sc_hd__decap_40_12
XFILLER_3_541 vssd1 vccd1 vssd1 vccd1 SS_sky130_ef_sc_hd__decap_40_12
XTAP_TAPCELL_ROW_55_1128 vccd1 vssd1 SS_sky130_fd_sc_hd__tapvpwrvgnd_1
XFILLER_3_585 vssd1 vccd1 vssd1 vccd1 SS_sky130_ef_sc_hd__decap_40_12
XFILLER_87_51 vssd1 vccd1 vccd1 vssd1 SS_sky130_fd_sc_hd__fill_4
Xload_slew205 vccd1 vssd1 _1463_/A2 _1467_/A2 vccd1 vssd1 SS_sky130_fd_sc_hd__buf_4
XFILLER_124_277 vssd1 vccd1 vssd1 vccd1 SS_sky130_ef_sc_hd__decap_40_12
Xload_slew249 vccd1 vssd1 _1077_/A2 _1065_/A2 vccd1 vssd1 SS_sky130_fd_sc_hd__buf_4
X_1100_ vccd1 vssd1 vccd1 vssd1 _1100_/X _1100_/A _1116_/B SS_sky130_fd_sc_hd__or2_2
XFILLER_39_729 vssd1 vccd1 vssd1 vccd1 SS_sky130_ef_sc_hd__decap_40_12
XFILLER_94_824 vssd1 vccd1 vccd1 vssd1 SS_sky130_fd_sc_hd__fill_2
XFILLER_94_813 vssd1 vccd1 vccd1 vssd1 SS_sky130_fd_sc_hd__fill_4
XTAP_TAPCELL_ROW_6_390 vccd1 vssd1 SS_sky130_fd_sc_hd__tapvpwrvgnd_1
XFILLER_16_6 vssd1 vccd1 vssd1 vccd1 SS_sky130_ef_sc_hd__decap_40_12
XFILLER_34_401 vssd1 vccd1 vssd1 vccd1 SS_sky130_ef_sc_hd__decap_40_12
X_1031_ vssd1 vccd1 vccd1 vssd1 _1051_/A2 wire495/X _1547_/D _1447_/C1 _1030_/X SS_sky130_fd_sc_hd__o211a_2
XFILLER_81_529 vssd1 vccd1 vssd1 vccd1 SS_sky130_ef_sc_hd__decap_40_12
XFILLER_19_497 vssd1 vccd1 vccd1 vssd1 SS_sky130_fd_sc_hd__fill_4
XFILLER_34_445 vssd1 vccd1 vssd1 vccd1 SS_sky130_ef_sc_hd__decap_40_12
XFILLER_34_489 vssd1 vccd1 vssd1 vccd1 SS_sky130_ef_sc_hd__decap_40_12
XTAP_TAPCELL_ROW_45_974 vccd1 vssd1 SS_sky130_fd_sc_hd__tapvpwrvgnd_1
XFILLER_99_3 vssd1 vccd1 vssd1 vccd1 SS_sky130_ef_sc_hd__decap_40_12
Xinput30 vssd1 vccd1 vccd1 vssd1 input30/A input30/X SS_sky130_fd_sc_hd__clkdlybuf4s25_1
X_1864_ vccd1 vssd1 _1864_/X _1864_/A vccd1 vssd1 SS_sky130_fd_sc_hd__buf_2
X_0815_ vccd1 vssd1 vccd1 vssd1 input2/X _0815_/B1 _1855_/A wire443/X _0815_/X SS_sky130_fd_sc_hd__a22o_2
Xhold803 hold803/X _1499_/Q vccd1 vssd1 vssd1 vccd1 SS_sky130_fd_sc_hd__dlygate4sd3_1
Xinput41 vssd1 vccd1 vccd1 vssd1 input41/A input41/X SS_sky130_fd_sc_hd__clkdlybuf4s25_1
Xinput52 vssd1 vccd1 vccd1 vssd1 wbs_stb_i _0945_/B SS_sky130_fd_sc_hd__clkdlybuf4s25_1
X_0746_ vccd1 vssd1 vccd1 vssd1 _1895_/A wire435/X _1846_/A _0828_/B1 _0757_/A SS_sky130_fd_sc_hd__a22o_2
XFILLER_116_745 vssd1 vccd1 vccd1 vssd1 SS_sky130_fd_sc_hd__fill_8
XFILLER_89_629 vssd1 vccd1 vssd1 vccd1 SS_sky130_ef_sc_hd__decap_40_12
XFILLER_107_39 vssd1 vccd1 vssd1 vccd1 SS_sky130_ef_sc_hd__decap_40_12
XFILLER_88_139 vccd1 vssd1 vccd1 vssd1 SS_sky130_fd_sc_hd__fill_1
XFILLER_115_277 vssd1 vccd1 vccd1 vssd1 SS_sky130_fd_sc_hd__fill_2
XFILLER_103_417 vssd1 vccd1 vccd1 vssd1 SS_sky130_fd_sc_hd__fill_4
XFILLER_29_217 vssd1 vccd1 vccd1 vssd1 SS_sky130_fd_sc_hd__fill_4
XFILLER_84_301 vssd1 vccd1 vccd1 vssd1 SS_sky130_fd_sc_hd__fill_4
XFILLER_111_461 vssd1 vccd1 vssd1 vccd1 SS_sky130_ef_sc_hd__decap_40_12
XFILLER_97_673 vssd1 vccd1 vssd1 vccd1 SS_sky130_ef_sc_hd__decap_40_12
XFILLER_57_559 vccd1 vssd1 vccd1 vssd1 SS_sky130_fd_sc_hd__fill_1
XFILLER_44_209 vssd1 vccd1 vssd1 vccd1 SS_sky130_ef_sc_hd__decap_40_12
X_1229_ vssd1 vccd1 vccd1 vssd1 _1261_/A2 wire495/X _1643_/D _1381_/C1 _1228_/X SS_sky130_fd_sc_hd__o211a_2
XFILLER_84_389 vssd1 vccd1 vssd1 vccd1 SS_sky130_ef_sc_hd__decap_40_12
XFILLER_37_261 vssd1 vccd1 vssd1 vccd1 SS_sky130_ef_sc_hd__decap_40_12
XFILLER_25_445 vssd1 vccd1 vccd1 vssd1 SS_sky130_fd_sc_hd__fill_2
XFILLER_52_253 vssd1 vccd1 vssd1 vccd1 SS_sky130_ef_sc_hd__decap_40_12
XFILLER_13_629 vssd1 vccd1 vssd1 vccd1 SS_sky130_ef_sc_hd__decap_40_12
XFILLER_12_139 vccd1 vssd1 vccd1 vssd1 SS_sky130_fd_sc_hd__fill_1
XTAP_TAPCELL_ROW_23_646 vccd1 vssd1 SS_sky130_fd_sc_hd__tapvpwrvgnd_1
XFILLER_21_673 vssd1 vccd1 vccd1 vssd1 SS_sky130_fd_sc_hd__fill_8
XFILLER_138_314 vccd1 vssd1 vccd1 vssd1 SS_sky130_fd_sc_hd__fill_1
XFILLER_4_305 vssd1 vccd1 vccd1 vssd1 SS_sky130_fd_sc_hd__fill_2
XFILLER_5_839 vccd1 vssd1 vccd1 vssd1 SS_sky130_fd_sc_hd__fill_1
XFILLER_119_561 vssd1 vccd1 vssd1 vccd1 SS_sky130_ef_sc_hd__decap_40_12
XFILLER_107_712 vssd1 vccd1 vssd1 vccd1 SS_sky130_ef_sc_hd__decap_40_12
XFILLER_106_233 vssd1 vccd1 vssd1 vccd1 SS_sky130_ef_sc_hd__decap_40_12
XFILLER_107_767 vssd1 vccd1 vssd1 vccd1 SS_sky130_ef_sc_hd__decap_40_12
XFILLER_134_597 vssd1 vccd1 vccd1 vssd1 SS_sky130_fd_sc_hd__fill_2
XFILLER_121_225 vssd1 vccd1 vssd1 vccd1 SS_sky130_ef_sc_hd__decap_40_12
XFILLER_106_277 vssd1 vccd1 vssd1 vccd1 SS_sky130_ef_sc_hd__decap_40_12
XFILLER_0_533 vssd1 vccd1 vssd1 vccd1 SS_sky130_ef_sc_hd__decap_40_12
XTAP_TAPCELL_ROW_128_2217 vccd1 vssd1 SS_sky130_fd_sc_hd__tapvpwrvgnd_1
XFILLER_76_813 vssd1 vccd1 vccd1 vssd1 SS_sky130_fd_sc_hd__fill_4
XFILLER_76_835 vccd1 vssd1 vccd1 vssd1 SS_sky130_fd_sc_hd__fill_1
XFILLER_87_161 vssd1 vccd1 vccd1 vssd1 SS_sky130_fd_sc_hd__fill_4
XFILLER_88_695 vssd1 vccd1 vccd1 vssd1 SS_sky130_fd_sc_hd__fill_4
XFILLER_130_781 vssd1 vccd1 vssd1 vccd1 SS_sky130_ef_sc_hd__decap_40_12
XFILLER_94_109 vssd1 vccd1 vssd1 vccd1 SS_sky130_ef_sc_hd__decap_40_12
XTAP_TAPCELL_ROW_50_1047 vccd1 vssd1 SS_sky130_fd_sc_hd__tapvpwrvgnd_1
XFILLER_29_773 vssd1 vccd1 vccd1 vssd1 SS_sky130_fd_sc_hd__fill_8
XFILLER_63_529 vssd1 vccd1 vssd1 vccd1 SS_sky130_ef_sc_hd__decap_40_12
XFILLER_16_401 vssd1 vccd1 vssd1 vccd1 SS_sky130_ef_sc_hd__decap_40_12
XFILLER_44_732 vssd1 vccd1 vssd1 vccd1 SS_sky130_ef_sc_hd__decap_40_12
XFILLER_75_389 vssd1 vccd1 vccd1 vssd1 SS_sky130_fd_sc_hd__fill_2
XFILLER_16_445 vssd1 vccd1 vssd1 vccd1 SS_sky130_ef_sc_hd__decap_40_12
XFILLER_71_540 vssd1 vccd1 vssd1 vccd1 SS_sky130_ef_sc_hd__decap_40_12
XFILLER_73_42 vssd1 vccd1 vssd1 vccd1 SS_sky130_ef_sc_hd__decap_40_12
XFILLER_113_93 vssd1 vccd1 vssd1 vccd1 SS_sky130_ef_sc_hd__decap_40_12
XFILLER_16_489 vssd1 vccd1 vssd1 vccd1 SS_sky130_ef_sc_hd__decap_40_12
XFILLER_71_573 vccd1 vssd1 vccd1 vssd1 SS_sky130_fd_sc_hd__fill_1
XFILLER_71_584 vccd1 vssd1 vccd1 vssd1 SS_sky130_fd_sc_hd__fill_1
XTAP_TAPCELL_ROW_42_933 vccd1 vssd1 SS_sky130_fd_sc_hd__tapvpwrvgnd_1
XFILLER_11_161 vssd1 vccd1 vccd1 vssd1 SS_sky130_fd_sc_hd__fill_4
XFILLER_7_165 vssd1 vccd1 vccd1 vssd1 SS_sky130_fd_sc_hd__fill_2
XFILLER_8_699 vccd1 vssd1 vccd1 vssd1 SS_sky130_fd_sc_hd__fill_1
X_1580_ _1854_/A _1610_/CLK _1580_/D vccd1 vssd1 vccd1 vssd1 SS_sky130_fd_sc_hd__dfxtp_2
XFILLER_125_553 vssd1 vccd1 vccd1 vssd1 SS_sky130_fd_sc_hd__fill_4
XFILLER_125_597 vssd1 vccd1 vssd1 vccd1 SS_sky130_ef_sc_hd__decap_40_12
XFILLER_98_83 vccd1 vssd1 vccd1 vssd1 SS_sky130_fd_sc_hd__fill_1
XFILLER_3_393 vssd1 vccd1 vssd1 vccd1 SS_sky130_ef_sc_hd__decap_40_12
XFILLER_66_301 vssd1 vccd1 vccd1 vssd1 SS_sky130_fd_sc_hd__fill_4
XFILLER_79_673 vssd1 vccd1 vssd1 vccd1 SS_sky130_ef_sc_hd__decap_40_12
XFILLER_85_109 vssd1 vccd1 vccd1 vssd1 SS_sky130_fd_sc_hd__fill_2
XFILLER_14_3 vssd1 vccd1 vssd1 vccd1 SS_sky130_ef_sc_hd__decap_40_12
XFILLER_39_559 vccd1 vssd1 vccd1 vssd1 SS_sky130_fd_sc_hd__fill_1
XTAP_TAPCELL_ROW_1_308 vccd1 vssd1 SS_sky130_fd_sc_hd__tapvpwrvgnd_1
XTAP_TAPCELL_ROW_1_319 vccd1 vssd1 SS_sky130_fd_sc_hd__tapvpwrvgnd_1
XFILLER_26_209 vssd1 vccd1 vssd1 vccd1 SS_sky130_ef_sc_hd__decap_40_12
XTAP_TAPCELL_ROW_68_1319 vccd1 vssd1 SS_sky130_fd_sc_hd__tapvpwrvgnd_1
XFILLER_19_261 vssd1 vccd1 vssd1 vccd1 SS_sky130_ef_sc_hd__decap_40_12
XFILLER_47_581 vssd1 vccd1 vssd1 vccd1 SS_sky130_ef_sc_hd__decap_40_12
XFILLER_66_389 vccd1 vssd1 vccd1 vssd1 SS_sky130_fd_sc_hd__fill_1
XFILLER_81_326 vssd1 vccd1 vccd1 vssd1 SS_sky130_fd_sc_hd__fill_2
XFILLER_81_337 vccd1 vssd1 vccd1 vssd1 SS_sky130_fd_sc_hd__fill_1
XFILLER_94_698 vssd1 vccd1 vccd1 vssd1 SS_sky130_fd_sc_hd__fill_2
X_1014_ vccd1 vssd1 vccd1 vssd1 _1014_/X _1826_/A _1050_/B SS_sky130_fd_sc_hd__or2_2
XTAP_TAPCELL_ROW_81_1508 vccd1 vssd1 SS_sky130_fd_sc_hd__tapvpwrvgnd_1
XFILLER_34_253 vssd1 vccd1 vssd1 vccd1 SS_sky130_ef_sc_hd__decap_40_12
XFILLER_62_584 vssd1 vccd1 vccd1 vssd1 SS_sky130_fd_sc_hd__fill_4
XTAP_TAPCELL_ROW_81_1519 vccd1 vssd1 SS_sky130_fd_sc_hd__tapvpwrvgnd_1
XFILLER_50_757 vssd1 vccd1 vssd1 vccd1 SS_sky130_ef_sc_hd__decap_40_12
XTAP_TAPCELL_ROW_20_605 vccd1 vssd1 SS_sky130_fd_sc_hd__tapvpwrvgnd_1
XFILLER_8_81 vssd1 vccd1 vccd1 vssd1 SS_sky130_fd_sc_hd__fill_2
X_1847_ vccd1 vssd1 _1847_/X _1847_/A vccd1 vssd1 SS_sky130_fd_sc_hd__buf_2
XFILLER_135_317 vssd1 vccd1 vccd1 vssd1 SS_sky130_fd_sc_hd__fill_2
Xclkbuf_leaf_25_wb_clk_i _1731_/CLK clkload1/A vccd1 vssd1 vssd1 vccd1 SS_sky130_fd_sc_hd__clkbuf_8
Xhold600 input25/A wbs_dat_i[14] vccd1 vssd1 vssd1 vccd1 SS_sky130_fd_sc_hd__dlygate4sd3_1
XTAP_TAPCELL_ROW_96_1740 vccd1 vssd1 SS_sky130_fd_sc_hd__tapvpwrvgnd_1
Xhold611 _1354_/A _1883_/A vccd1 vssd1 vssd1 vccd1 SS_sky130_fd_sc_hd__dlygate4sd3_1
XFILLER_2_809 vssd1 vccd1 vccd1 vssd1 SS_sky130_fd_sc_hd__fill_2
Xhold644 _1092_/A _1851_/A vccd1 vssd1 vssd1 vccd1 SS_sky130_fd_sc_hd__dlygate4sd3_1
Xhold633 _0968_/A _1517_/Q vccd1 vssd1 vssd1 vccd1 SS_sky130_fd_sc_hd__dlygate4sd3_1
Xhold622 input51/A wbs_dat_i[9] vccd1 vssd1 vssd1 vccd1 SS_sky130_fd_sc_hd__dlygate4sd3_1
XFILLER_89_415 vssd1 vccd1 vssd1 vccd1 SS_sky130_ef_sc_hd__decap_40_12
Xhold655 _1338_/A _1697_/Q vccd1 vssd1 vssd1 vccd1 SS_sky130_fd_sc_hd__dlygate4sd3_1
Xhold666 _1002_/A _1534_/Q vccd1 vssd1 vssd1 vccd1 SS_sky130_fd_sc_hd__dlygate4sd3_1
XFILLER_104_737 vssd1 vccd1 vssd1 vccd1 SS_sky130_ef_sc_hd__decap_40_12
XFILLER_103_225 vssd1 vccd1 vssd1 vccd1 SS_sky130_ef_sc_hd__decap_40_12
Xhold688 _0986_/A _1526_/Q vccd1 vssd1 vssd1 vccd1 SS_sky130_fd_sc_hd__dlygate4sd3_1
Xhold677 _1122_/A _1866_/A vccd1 vssd1 vssd1 vccd1 SS_sky130_fd_sc_hd__dlygate4sd3_1
XFILLER_134_15 vssd1 vccd1 vssd1 vccd1 SS_sky130_ef_sc_hd__decap_40_12
Xhold699 input37/A wbs_dat_i[25] vccd1 vssd1 vssd1 vccd1 SS_sky130_fd_sc_hd__dlygate4sd3_1
XFILLER_58_813 vssd1 vccd1 vccd1 vssd1 SS_sky130_fd_sc_hd__fill_4
XFILLER_69_161 vssd1 vccd1 vccd1 vssd1 SS_sky130_fd_sc_hd__fill_4
XFILLER_76_109 vssd1 vccd1 vssd1 vccd1 SS_sky130_ef_sc_hd__decap_40_12
XFILLER_112_781 vssd1 vccd1 vssd1 vccd1 SS_sky130_ef_sc_hd__decap_40_12
XFILLER_84_153 vssd1 vccd1 vssd1 vccd1 SS_sky130_ef_sc_hd__decap_40_12
XFILLER_85_665 vssd1 vccd1 vccd1 vssd1 SS_sky130_fd_sc_hd__fill_4
XFILLER_27_57 vssd1 vccd1 vssd1 vccd1 SS_sky130_ef_sc_hd__decap_40_12
XTAP_TAPCELL_ROW_28_716 vccd1 vssd1 SS_sky130_fd_sc_hd__tapvpwrvgnd_1
XTAP_TAPCELL_ROW_28_727 vccd1 vssd1 SS_sky130_fd_sc_hd__tapvpwrvgnd_1
XFILLER_38_581 vssd1 vccd1 vccd1 vssd1 SS_sky130_fd_sc_hd__fill_2
XFILLER_84_197 vssd1 vccd1 vssd1 vccd1 SS_sky130_ef_sc_hd__decap_40_12
XTAP_TAPCELL_ROW_123_2147 vccd1 vssd1 SS_sky130_fd_sc_hd__tapvpwrvgnd_1
XFILLER_26_754 vssd1 vccd1 vccd1 vssd1 SS_sky130_fd_sc_hd__fill_2
Xclkbuf_2_3__f_wb_clk_i vssd1 vccd1 vssd1 vccd1 clkbuf_0_wb_clk_i/X clkbuf_leaf_7_wb_clk_i/A
+ SS_sky130_fd_sc_hd__clkbuf_16
XFILLER_53_573 vssd1 vccd1 vssd1 vccd1 SS_sky130_ef_sc_hd__decap_40_12
XFILLER_80_392 vssd1 vccd1 vccd1 vssd1 SS_sky130_fd_sc_hd__fill_4
XTAP_TAPCELL_ROW_105_1880 vccd1 vssd1 SS_sky130_fd_sc_hd__tapvpwrvgnd_1
XFILLER_40_245 vssd1 vccd1 vccd1 vssd1 SS_sky130_fd_sc_hd__fill_4
XFILLER_40_289 vssd1 vccd1 vssd1 vccd1 SS_sky130_ef_sc_hd__decap_40_12
XTAP_TAPCELL_ROW_138_2390 vccd1 vssd1 SS_sky130_fd_sc_hd__tapvpwrvgnd_1
XFILLER_107_531 vssd1 vccd1 vccd1 vssd1 SS_sky130_fd_sc_hd__fill_4
XFILLER_5_669 vssd1 vccd1 vccd1 vssd1 SS_sky130_fd_sc_hd__fill_2
XFILLER_122_523 vccd1 vssd1 vccd1 vssd1 SS_sky130_fd_sc_hd__fill_1
XFILLER_122_501 vssd1 vccd1 vssd1 vccd1 SS_sky130_ef_sc_hd__decap_40_12
XFILLER_107_597 vssd1 vccd1 vssd1 vccd1 SS_sky130_ef_sc_hd__decap_40_12
XFILLER_68_53 vssd1 vccd1 vssd1 vccd1 SS_sky130_ef_sc_hd__decap_40_12
XFILLER_48_301 vssd1 vccd1 vccd1 vssd1 SS_sky130_fd_sc_hd__fill_4
XFILLER_67_109 vssd1 vccd1 vccd1 vssd1 SS_sky130_fd_sc_hd__fill_2
XFILLER_122_589 vssd1 vccd1 vssd1 vccd1 SS_sky130_ef_sc_hd__decap_40_12
XFILLER_68_97 vssd1 vccd1 vssd1 vccd1 SS_sky130_ef_sc_hd__decap_40_12
XFILLER_103_781 vssd1 vccd1 vccd1 vssd1 SS_sky130_fd_sc_hd__fill_2
XFILLER_48_345 vssd1 vccd1 vssd1 vccd1 SS_sky130_ef_sc_hd__decap_40_12
XFILLER_64_805 vssd1 vccd1 vccd1 vssd1 SS_sky130_fd_sc_hd__fill_2
XFILLER_84_41 vssd1 vccd1 vssd1 vccd1 SS_sky130_ef_sc_hd__decap_40_12
XFILLER_124_81 vssd1 vccd1 vccd1 vssd1 SS_sky130_fd_sc_hd__fill_2
XFILLER_91_613 vssd1 vccd1 vccd1 vssd1 SS_sky130_fd_sc_hd__fill_2
XFILLER_17_721 vssd1 vccd1 vccd1 vssd1 SS_sky130_fd_sc_hd__fill_4
XFILLER_36_529 vssd1 vccd1 vccd1 vssd1 SS_sky130_fd_sc_hd__fill_2
XFILLER_63_337 vssd1 vccd1 vccd1 vssd1 SS_sky130_fd_sc_hd__fill_8
XFILLER_84_85 vssd1 vccd1 vssd1 vccd1 SS_sky130_ef_sc_hd__decap_40_12
XFILLER_91_657 vssd1 vccd1 vccd1 vssd1 SS_sky130_fd_sc_hd__fill_4
XFILLER_16_253 vssd1 vccd1 vssd1 vccd1 SS_sky130_ef_sc_hd__decap_40_12
XFILLER_90_189 vssd1 vccd1 vccd1 vssd1 SS_sky130_fd_sc_hd__fill_4
XFILLER_31_223 vccd1 vssd1 vccd1 vssd1 SS_sky130_fd_sc_hd__fill_1
XFILLER_32_757 vssd1 vccd1 vssd1 vccd1 SS_sky130_ef_sc_hd__decap_40_12
XTAP_TAPCELL_ROW_63_1238 vccd1 vssd1 SS_sky130_fd_sc_hd__tapvpwrvgnd_1
XTAP_TAPCELL_ROW_63_1249 vccd1 vssd1 SS_sky130_fd_sc_hd__tapvpwrvgnd_1
XFILLER_83_6 vssd1 vccd1 vssd1 vccd1 SS_sky130_ef_sc_hd__decap_40_12
XFILLER_129_111 vccd1 vssd1 vccd1 vssd1 SS_sky130_fd_sc_hd__fill_1
X_1701_ _1880_/A _1731_/CLK _1701_/D vccd1 vssd1 vccd1 vssd1 SS_sky130_fd_sc_hd__dfxtp_2
XFILLER_117_317 vssd1 vccd1 vssd1 vccd1 SS_sky130_ef_sc_hd__decap_40_12
X_1632_ _1632_/Q _1727_/CLK _1632_/D vccd1 vssd1 vccd1 vssd1 SS_sky130_fd_sc_hd__dfxtp_2
XTAP_TAPCELL_ROW_78_1470 vccd1 vssd1 SS_sky130_fd_sc_hd__tapvpwrvgnd_1
XFILLER_132_309 vssd1 vccd1 vccd1 vssd1 SS_sky130_fd_sc_hd__fill_2
XFILLER_99_702 vssd1 vccd1 vssd1 vccd1 SS_sky130_ef_sc_hd__decap_40_12
X_1563_ _1563_/Q _1755_/CLK _1563_/D vccd1 vssd1 vccd1 vssd1 SS_sky130_fd_sc_hd__dfxtp_2
XFILLER_113_501 vssd1 vccd1 vccd1 vssd1 SS_sky130_fd_sc_hd__fill_2
X_1494_ _1494_/Q _1686_/CLK _1494_/D vccd1 vssd1 vccd1 vssd1 SS_sky130_fd_sc_hd__dfxtp_2
XFILLER_98_245 vssd1 vccd1 vccd1 vssd1 SS_sky130_fd_sc_hd__fill_4
XFILLER_58_109 vssd1 vccd1 vssd1 vccd1 SS_sky130_ef_sc_hd__decap_40_12
XFILLER_101_729 vssd1 vccd1 vssd1 vccd1 SS_sky130_ef_sc_hd__decap_40_12
XFILLER_98_289 vssd1 vccd1 vssd1 vccd1 SS_sky130_ef_sc_hd__decap_40_12
XTAP_TAPCELL_ROW_91_1670 vccd1 vssd1 SS_sky130_fd_sc_hd__tapvpwrvgnd_1
XFILLER_79_481 vssd1 vccd1 vssd1 vccd1 SS_sky130_ef_sc_hd__decap_40_12
XFILLER_66_153 vssd1 vccd1 vssd1 vccd1 SS_sky130_ef_sc_hd__decap_40_12
XFILLER_104_29 vssd1 vccd1 vssd1 vccd1 SS_sky130_ef_sc_hd__decap_40_12
XFILLER_27_529 vssd1 vccd1 vssd1 vccd1 SS_sky130_ef_sc_hd__decap_40_12
XFILLER_39_389 vssd1 vccd1 vccd1 vssd1 SS_sky130_fd_sc_hd__fill_2
XFILLER_82_613 vssd1 vccd1 vssd1 vccd1 SS_sky130_ef_sc_hd__decap_40_12
XFILLER_66_197 vssd1 vccd1 vssd1 vccd1 SS_sky130_ef_sc_hd__decap_40_12
XFILLER_82_657 vssd1 vccd1 vssd1 vccd1 SS_sky130_ef_sc_hd__decap_40_12
XFILLER_35_573 vssd1 vccd1 vssd1 vccd1 SS_sky130_ef_sc_hd__decap_40_12
XFILLER_81_167 vccd1 vssd1 vccd1 vssd1 SS_sky130_fd_sc_hd__fill_1
XFILLER_22_245 vssd1 vccd1 vccd1 vssd1 SS_sky130_fd_sc_hd__fill_4
XFILLER_22_289 vssd1 vccd1 vssd1 vccd1 SS_sky130_ef_sc_hd__decap_40_12
XTAP_TAPCELL_ROW_33_796 vccd1 vssd1 SS_sky130_fd_sc_hd__tapvpwrvgnd_1
XFILLER_50_587 vccd1 vssd1 vccd1 vssd1 SS_sky130_fd_sc_hd__fill_1
XFILLER_129_15 vssd1 vccd1 vssd1 vccd1 SS_sky130_ef_sc_hd__decap_40_12
XFILLER_135_125 vssd1 vccd1 vssd1 vccd1 SS_sky130_ef_sc_hd__decap_40_12
XFILLER_136_637 vssd1 vccd1 vccd1 vssd1 SS_sky130_fd_sc_hd__fill_4
XFILLER_135_169 vssd1 vccd1 vssd1 vccd1 SS_sky130_ef_sc_hd__decap_40_12
XFILLER_123_309 vssd1 vccd1 vccd1 vssd1 SS_sky130_fd_sc_hd__fill_2
XFILLER_1_105 vssd1 vccd1 vccd1 vssd1 SS_sky130_fd_sc_hd__fill_4
XFILLER_104_501 vssd1 vccd1 vssd1 vccd1 SS_sky130_ef_sc_hd__decap_40_12
XFILLER_1_149 vssd1 vccd1 vssd1 vccd1 SS_sky130_ef_sc_hd__decap_40_12
XFILLER_89_223 vccd1 vssd1 vccd1 vssd1 SS_sky130_fd_sc_hd__fill_1
XFILLER_131_320 vssd1 vccd1 vccd1 vssd1 SS_sky130_fd_sc_hd__fill_4
XFILLER_104_545 vssd1 vccd1 vssd1 vccd1 SS_sky130_ef_sc_hd__decap_40_12
XFILLER_49_109 vssd1 vccd1 vccd1 vssd1 SS_sky130_fd_sc_hd__fill_2
XFILLER_77_429 vssd1 vccd1 vccd1 vssd1 SS_sky130_fd_sc_hd__fill_4
XFILLER_104_589 vssd1 vccd1 vssd1 vccd1 SS_sky130_ef_sc_hd__decap_40_12
XFILLER_46_805 vccd1 vssd1 vccd1 vssd1 SS_sky130_fd_sc_hd__fill_1
XFILLER_18_529 vssd1 vccd1 vccd1 vssd1 SS_sky130_fd_sc_hd__fill_2
XFILLER_58_687 vssd1 vccd1 vssd1 vccd1 SS_sky130_ef_sc_hd__decap_40_12
XFILLER_85_473 vssd1 vccd1 vssd1 vccd1 SS_sky130_ef_sc_hd__decap_40_12
XFILLER_45_337 vssd1 vccd1 vssd1 vccd1 SS_sky130_ef_sc_hd__decap_40_12
XFILLER_14_713 vssd1 vccd1 vssd1 vccd1 SS_sky130_ef_sc_hd__decap_40_12
XFILLER_60_307 vccd1 vssd1 vccd1 vssd1 SS_sky130_fd_sc_hd__fill_1
XFILLER_72_189 vssd1 vccd1 vccd1 vssd1 SS_sky130_fd_sc_hd__fill_4
XFILLER_13_223 vccd1 vssd1 vccd1 vssd1 SS_sky130_fd_sc_hd__fill_1
XFILLER_14_757 vssd1 vccd1 vssd1 vccd1 SS_sky130_ef_sc_hd__decap_40_12
XFILLER_54_77 vssd1 vccd1 vccd1 vssd1 SS_sky130_fd_sc_hd__fill_4
XTAP_TAPCELL_ROW_103_1839 vccd1 vssd1 SS_sky130_fd_sc_hd__tapvpwrvgnd_1
XFILLER_9_205 vssd1 vccd1 vssd1 vccd1 SS_sky130_ef_sc_hd__decap_40_12
XFILLER_9_249 vssd1 vccd1 vssd1 vccd1 SS_sky130_ef_sc_hd__decap_40_12
XFILLER_110_83 vccd1 vssd1 vccd1 vssd1 SS_sky130_fd_sc_hd__fill_1
XFILLER_70_65 vssd1 vccd1 vssd1 vccd1 SS_sky130_ef_sc_hd__decap_40_12
XTAP_TAPCELL_ROW_136_2338 vccd1 vssd1 SS_sky130_fd_sc_hd__tapvpwrvgnd_1
XFILLER_127_615 vccd1 vssd1 vccd1 vssd1 SS_sky130_fd_sc_hd__fill_1
XTAP_TAPCELL_ROW_11_468 vccd1 vssd1 SS_sky130_fd_sc_hd__tapvpwrvgnd_1
Xclkload19 vssd1 vccd1 _1756_/CLK clkload19/X vccd1 vssd1 SS_sky130_fd_sc_hd__clkbuf_4
XFILLER_119_81 vssd1 vccd1 vssd1 vccd1 SS_sky130_ef_sc_hd__decap_40_12
XFILLER_114_309 vssd1 vccd1 vssd1 vccd1 SS_sky130_ef_sc_hd__decap_40_12
XFILLER_123_821 vssd1 vccd1 vccd1 vssd1 SS_sky130_fd_sc_hd__fill_2
XFILLER_107_361 vssd1 vccd1 vssd1 vccd1 SS_sky130_ef_sc_hd__decap_40_12
XFILLER_122_320 vssd1 vccd1 vssd1 vccd1 SS_sky130_ef_sc_hd__decap_40_12
XFILLER_96_749 vssd1 vccd1 vccd1 vssd1 SS_sky130_fd_sc_hd__fill_4
XFILLER_95_237 vssd1 vccd1 vssd1 vccd1 SS_sky130_ef_sc_hd__decap_40_12
XFILLER_0_193 vssd1 vccd1 vccd1 vssd1 SS_sky130_fd_sc_hd__fill_2
XFILLER_48_153 vssd1 vccd1 vssd1 vccd1 SS_sky130_ef_sc_hd__decap_40_12
XFILLER_95_51 vssd1 vccd1 vccd1 vssd1 SS_sky130_fd_sc_hd__fill_4
XFILLER_76_473 vssd1 vccd1 vccd1 vssd1 SS_sky130_fd_sc_hd__fill_2
XFILLER_48_197 vssd1 vccd1 vssd1 vccd1 SS_sky130_ef_sc_hd__decap_40_12
XFILLER_64_657 vssd1 vccd1 vssd1 vccd1 SS_sky130_ef_sc_hd__decap_40_12
XFILLER_17_573 vssd1 vccd1 vssd1 vccd1 SS_sky130_ef_sc_hd__decap_40_12
XTAP_TAPCELL_ROW_19_579 vccd1 vssd1 SS_sky130_fd_sc_hd__tapvpwrvgnd_1
XFILLER_51_329 vssd1 vccd1 vccd1 vssd1 SS_sky130_fd_sc_hd__fill_4
XFILLER_63_167 vccd1 vssd1 vccd1 vssd1 SS_sky130_fd_sc_hd__fill_1
XFILLER_64_679 vccd1 vssd1 vccd1 vssd1 SS_sky130_fd_sc_hd__fill_1
XFILLER_20_727 vssd1 vccd1 vssd1 vccd1 SS_sky130_ef_sc_hd__decap_40_12
XTAP_TAPCELL_ROW_30_744 vccd1 vssd1 SS_sky130_fd_sc_hd__tapvpwrvgnd_1
XTAP_TAPCELL_ROW_30_755 vccd1 vssd1 SS_sky130_fd_sc_hd__tapvpwrvgnd_1
X_0994_ vccd1 vssd1 vccd1 vssd1 _0994_/X _0994_/A _1008_/B SS_sky130_fd_sc_hd__or2_2
XFILLER_9_783 vccd1 vssd1 vccd1 vssd1 SS_sky130_fd_sc_hd__fill_1
XFILLER_118_637 vssd1 vccd1 vccd1 vssd1 SS_sky130_fd_sc_hd__fill_4
XFILLER_117_125 vssd1 vccd1 vssd1 vccd1 SS_sky130_ef_sc_hd__decap_40_12
XFILLER_105_309 vssd1 vccd1 vccd1 vssd1 SS_sky130_fd_sc_hd__fill_2
X_1615_ _1875_/A _1738_/CLK _1615_/D vccd1 vssd1 vccd1 vssd1 SS_sky130_fd_sc_hd__dfxtp_2
XFILLER_117_169 vssd1 vccd1 vssd1 vccd1 SS_sky130_ef_sc_hd__decap_40_12
X_1546_ _1546_/Q clkload4/A _1546_/D vccd1 vssd1 vccd1 vssd1 SS_sky130_fd_sc_hd__dfxtp_2
XFILLER_132_139 vccd1 vssd1 vccd1 vssd1 SS_sky130_fd_sc_hd__fill_1
XFILLER_5_93 vssd1 vccd1 vssd1 vccd1 SS_sky130_ef_sc_hd__decap_40_12
XFILLER_59_429 vssd1 vccd1 vssd1 vccd1 SS_sky130_ef_sc_hd__decap_40_12
XFILLER_87_727 vccd1 vssd1 vccd1 vssd1 SS_sky130_fd_sc_hd__fill_1
Xfanout206 vssd1 vccd1 vccd1 vssd1 _1409_/Y wire207/A SS_sky130_fd_sc_hd__clkdlybuf4s25_1
Xfanout228 vssd1 vccd1 vccd1 vssd1 _1211_/Y _1265_/A2 SS_sky130_fd_sc_hd__clkdlybuf4s25_1
Xfanout217 vssd1 vccd1 vccd1 vssd1 _1406_/B _1396_/B SS_sky130_fd_sc_hd__clkdlybuf4s25_1
X_1477_ _1477_/Q _1731_/CLK _1477_/D vccd1 vssd1 vccd1 vssd1 SS_sky130_fd_sc_hd__dfxtp_2
XFILLER_115_39 vssd1 vccd1 vssd1 vccd1 SS_sky130_ef_sc_hd__decap_40_12
XFILLER_28_805 vssd1 vccd1 vccd1 vssd1 SS_sky130_fd_sc_hd__fill_4
XFILLER_101_559 vccd1 vssd1 vccd1 vssd1 SS_sky130_fd_sc_hd__fill_1
XFILLER_55_613 vssd1 vccd1 vccd1 vssd1 SS_sky130_fd_sc_hd__fill_2
XFILLER_67_473 vssd1 vccd1 vccd1 vssd1 SS_sky130_fd_sc_hd__fill_2
XFILLER_27_337 vssd1 vccd1 vssd1 vccd1 SS_sky130_ef_sc_hd__decap_40_12
XFILLER_82_421 vssd1 vccd1 vccd1 vssd1 SS_sky130_fd_sc_hd__fill_8
XTAP_TAPCELL_ROW_38_866 vccd1 vssd1 SS_sky130_fd_sc_hd__tapvpwrvgnd_1
XTAP_TAPCELL_ROW_38_877 vccd1 vssd1 SS_sky130_fd_sc_hd__tapvpwrvgnd_1
XFILLER_42_307 vccd1 vssd1 vccd1 vssd1 SS_sky130_fd_sc_hd__fill_1
XTAP_TAPCELL_ROW_120_2106 vccd1 vssd1 SS_sky130_fd_sc_hd__tapvpwrvgnd_1
XFILLER_51_841 vccd1 vssd1 vccd1 vssd1 SS_sky130_fd_sc_hd__fill_1
XFILLER_54_189 vssd1 vccd1 vccd1 vssd1 SS_sky130_fd_sc_hd__fill_4
XFILLER_11_727 vccd1 vssd1 vccd1 vssd1 SS_sky130_fd_sc_hd__fill_1
XFILLER_7_709 vssd1 vccd1 vssd1 vccd1 SS_sky130_ef_sc_hd__decap_40_12
XTAP_TAPCELL_ROW_118_2068 vccd1 vssd1 SS_sky130_fd_sc_hd__tapvpwrvgnd_1
XFILLER_117_670 vssd1 vccd1 vccd1 vssd1 SS_sky130_fd_sc_hd__fill_2
XTAP_TAPCELL_ROW_131_2268 vccd1 vssd1 SS_sky130_fd_sc_hd__tapvpwrvgnd_1
XFILLER_2_469 vssd1 vccd1 vccd1 vssd1 SS_sky130_fd_sc_hd__fill_4
XFILLER_49_55 vccd1 vssd1 vccd1 vssd1 SS_sky130_fd_sc_hd__fill_1
XFILLER_120_813 vssd1 vccd1 vccd1 vssd1 SS_sky130_fd_sc_hd__fill_4
XFILLER_77_237 vssd1 vccd1 vssd1 vccd1 SS_sky130_ef_sc_hd__decap_40_12
XFILLER_78_749 vssd1 vccd1 vccd1 vssd1 SS_sky130_fd_sc_hd__fill_4
XFILLER_131_161 vssd1 vccd1 vccd1 vssd1 SS_sky130_fd_sc_hd__fill_4
XFILLER_132_695 vssd1 vccd1 vccd1 vssd1 SS_sky130_fd_sc_hd__fill_4
XFILLER_120_835 vccd1 vssd1 vccd1 vssd1 SS_sky130_fd_sc_hd__fill_1
XTAP_TAPCELL_ROW_113_1990 vccd1 vssd1 SS_sky130_fd_sc_hd__tapvpwrvgnd_1
XFILLER_1_18 vssd1 vccd1 vssd1 vccd1 SS_sky130_ef_sc_hd__decap_40_12
XFILLER_86_771 vssd1 vccd1 vssd1 vccd1 SS_sky130_ef_sc_hd__decap_40_12
XFILLER_46_657 vssd1 vccd1 vssd1 vccd1 SS_sky130_ef_sc_hd__decap_40_12
XFILLER_58_495 vccd1 vssd1 vccd1 vssd1 SS_sky130_fd_sc_hd__fill_1
XFILLER_85_281 vssd1 vccd1 vssd1 vccd1 SS_sky130_ef_sc_hd__decap_40_12
XFILLER_45_167 vccd1 vssd1 vccd1 vssd1 SS_sky130_fd_sc_hd__fill_1
XTAP_TAPCELL_ROW_47_1008 vccd1 vssd1 SS_sky130_fd_sc_hd__tapvpwrvgnd_1
XTAP_TAPCELL_ROW_16_538 vccd1 vssd1 SS_sky130_fd_sc_hd__tapvpwrvgnd_1
XFILLER_33_329 vssd1 vccd1 vccd1 vssd1 SS_sky130_fd_sc_hd__fill_4
XFILLER_60_137 vssd1 vccd1 vccd1 vssd1 SS_sky130_fd_sc_hd__fill_2
XFILLER_81_42 vssd1 vccd1 vssd1 vccd1 SS_sky130_ef_sc_hd__decap_40_12
XFILLER_121_93 vssd1 vccd1 vssd1 vccd1 SS_sky130_ef_sc_hd__decap_40_12
XFILLER_14_587 vccd1 vssd1 vccd1 vssd1 SS_sky130_fd_sc_hd__fill_1
XFILLER_41_373 vssd1 vccd1 vssd1 vccd1 SS_sky130_ef_sc_hd__decap_40_12
XFILLER_6_753 vssd1 vccd1 vccd1 vssd1 SS_sky130_fd_sc_hd__fill_2
XFILLER_10_782 vssd1 vccd1 vssd1 vccd1 SS_sky130_ef_sc_hd__decap_40_12
XFILLER_127_445 vssd1 vccd1 vccd1 vssd1 SS_sky130_fd_sc_hd__fill_2
XFILLER_115_607 vssd1 vccd1 vccd1 vssd1 SS_sky130_fd_sc_hd__fill_8
XFILLER_46_6 vssd1 vccd1 vssd1 vccd1 SS_sky130_ef_sc_hd__decap_40_12
XFILLER_114_139 vccd1 vssd1 vccd1 vssd1 SS_sky130_fd_sc_hd__fill_1
X_1400_ vccd1 vssd1 vccd1 vssd1 _1400_/X _1400_/A _1404_/B SS_sky130_fd_sc_hd__or2_2
XFILLER_69_727 vccd1 vssd1 vccd1 vssd1 SS_sky130_fd_sc_hd__fill_1
XFILLER_123_673 vssd1 vccd1 vssd1 vccd1 SS_sky130_ef_sc_hd__decap_40_12
XFILLER_123_662 vssd1 vccd1 vccd1 vssd1 SS_sky130_fd_sc_hd__fill_2
XTAP_TAPCELL_ROW_71_1359 vccd1 vssd1 SS_sky130_fd_sc_hd__tapvpwrvgnd_1
X_1331_ vssd1 vccd1 vccd1 vssd1 _1331_/A2 input38/X _1693_/D _1465_/C1 _1330_/X SS_sky130_fd_sc_hd__o211a_2
XFILLER_110_301 vssd1 vccd1 vccd1 vssd1 SS_sky130_fd_sc_hd__fill_4
XFILLER_49_440 vssd1 vccd1 vccd1 vssd1 SS_sky130_fd_sc_hd__fill_8
X_1262_ vccd1 vssd1 vccd1 vssd1 _1262_/X _1660_/Q _1264_/B SS_sky130_fd_sc_hd__or2_2
XFILLER_96_557 vssd1 vccd1 vccd1 vssd1 SS_sky130_fd_sc_hd__fill_8
Xinput6 vssd1 vccd1 vccd1 vssd1 adc_data[3] input6/X SS_sky130_fd_sc_hd__clkdlybuf4s25_1
XFILLER_49_473 vssd1 vccd1 vssd1 vccd1 SS_sky130_ef_sc_hd__decap_40_12
XFILLER_64_421 vssd1 vccd1 vssd1 vccd1 SS_sky130_ef_sc_hd__decap_40_12
X_1193_ vssd1 vccd1 vccd1 vssd1 _1195_/A2 input35/X _1626_/D _1309_/C1 _1192_/X SS_sky130_fd_sc_hd__o211a_2
XFILLER_24_307 vccd1 vssd1 vccd1 vssd1 SS_sky130_fd_sc_hd__fill_1
XFILLER_33_841 vccd1 vssd1 vccd1 vssd1 SS_sky130_fd_sc_hd__fill_1
XTAP_TAPCELL_ROW_35_825 vccd1 vssd1 SS_sky130_fd_sc_hd__tapvpwrvgnd_1
XFILLER_36_189 vssd1 vccd1 vccd1 vssd1 SS_sky130_fd_sc_hd__fill_4
XFILLER_51_137 vssd1 vccd1 vssd1 vccd1 SS_sky130_ef_sc_hd__decap_40_12
XTAP_TAPCELL_ROW_86_1591 vccd1 vssd1 SS_sky130_fd_sc_hd__tapvpwrvgnd_1
XFILLER_91_273 vssd1 vccd1 vccd1 vssd1 SS_sky130_fd_sc_hd__fill_4
XFILLER_20_513 vssd1 vccd1 vssd1 vccd1 SS_sky130_ef_sc_hd__decap_40_12
XFILLER_20_557 vssd1 vccd1 vssd1 vccd1 SS_sky130_ef_sc_hd__decap_40_12
XFILLER_118_401 vssd1 vccd1 vccd1 vssd1 SS_sky130_fd_sc_hd__fill_8
X_0977_ vssd1 vccd1 vccd1 vssd1 wire253/X wire498/X _0977_/X _1431_/C1 _0976_/X SS_sky130_fd_sc_hd__o211a_2
XFILLER_10_27 vccd1 vssd1 vccd1 vssd1 SS_sky130_fd_sc_hd__fill_1
XFILLER_133_415 vssd1 vccd1 vccd1 vssd1 SS_sky130_fd_sc_hd__fill_2
XFILLER_106_618 vssd1 vccd1 vssd1 vccd1 SS_sky130_ef_sc_hd__decap_40_12
XFILLER_120_109 vssd1 vccd1 vssd1 vccd1 SS_sky130_ef_sc_hd__decap_40_12
XFILLER_102_813 vccd1 vssd1 vccd1 vssd1 SS_sky130_fd_sc_hd__fill_1
XFILLER_59_237 vssd1 vccd1 vssd1 vccd1 SS_sky130_ef_sc_hd__decap_40_12
X_1529_ _1529_/Q _1753_/CLK _1529_/D vccd1 vssd1 vccd1 vssd1 SS_sky130_fd_sc_hd__dfxtp_2
XFILLER_113_161 vssd1 vccd1 vccd1 vssd1 SS_sky130_fd_sc_hd__fill_4
XFILLER_19_69 vssd1 vccd1 vssd1 vccd1 SS_sky130_ef_sc_hd__decap_40_12
XFILLER_28_613 vssd1 vccd1 vssd1 vccd1 SS_sky130_ef_sc_hd__decap_40_12
XFILLER_68_793 vssd1 vccd1 vssd1 vccd1 SS_sky130_ef_sc_hd__decap_40_12
XFILLER_101_389 vssd1 vccd1 vccd1 vssd1 SS_sky130_fd_sc_hd__fill_2
XFILLER_28_657 vssd1 vccd1 vssd1 vccd1 SS_sky130_ef_sc_hd__decap_40_12
XFILLER_67_281 vssd1 vccd1 vssd1 vccd1 SS_sky130_ef_sc_hd__decap_40_12
XFILLER_83_741 vssd1 vccd1 vssd1 vccd1 SS_sky130_ef_sc_hd__decap_40_12
XFILLER_27_167 vccd1 vssd1 vccd1 vssd1 SS_sky130_fd_sc_hd__fill_1
XFILLER_43_605 vssd1 vccd1 vccd1 vssd1 SS_sky130_fd_sc_hd__fill_8
XFILLER_82_251 vccd1 vssd1 vccd1 vssd1 SS_sky130_fd_sc_hd__fill_1
XFILLER_83_785 vssd1 vccd1 vssd1 vccd1 SS_sky130_ef_sc_hd__decap_40_12
XFILLER_15_329 vssd1 vccd1 vccd1 vssd1 SS_sky130_fd_sc_hd__fill_4
XFILLER_35_57 vssd1 vccd1 vssd1 vccd1 SS_sky130_ef_sc_hd__decap_40_12
XFILLER_42_137 vssd1 vccd1 vccd1 vssd1 SS_sky130_fd_sc_hd__fill_2
XFILLER_70_468 vssd1 vccd1 vccd1 vssd1 SS_sky130_fd_sc_hd__fill_8
XFILLER_23_373 vssd1 vccd1 vssd1 vccd1 SS_sky130_ef_sc_hd__decap_40_12
XFILLER_11_557 vssd1 vccd1 vccd1 vssd1 SS_sky130_fd_sc_hd__fill_2
XPHY_EDGE_ROW_14_Right_14 vccd1 vssd1 vccd1 vssd1 SS_sky130_fd_sc_hd__decap_3
Xwire415 vccd1 vssd1 vssd1 vccd1 wire415/A analog_ctrl[66] SS_sky130_fd_sc_hd__buf_12
Xwire404 vccd1 vssd1 vssd1 vccd1 wire404/A analog_ctrl[77] SS_sky130_fd_sc_hd__buf_12
XFILLER_128_209 vssd1 vccd1 vssd1 vccd1 SS_sky130_ef_sc_hd__decap_40_12
XFILLER_7_517 vssd1 vccd1 vssd1 vccd1 SS_sky130_ef_sc_hd__decap_40_12
Xwire448 vccd1 vssd1 wire448/X wire448/A vccd1 vssd1 SS_sky130_fd_sc_hd__buf_4
XFILLER_129_3 vssd1 vccd1 vssd1 vccd1 SS_sky130_ef_sc_hd__decap_40_12
XFILLER_136_253 vssd1 vccd1 vssd1 vccd1 SS_sky130_ef_sc_hd__decap_40_12
XFILLER_124_459 vssd1 vccd1 vssd1 vccd1 SS_sky130_ef_sc_hd__decap_40_12
XFILLER_2_233 vssd1 vccd1 vssd1 vccd1 SS_sky130_ef_sc_hd__decap_40_12
XFILLER_111_109 vssd1 vccd1 vccd1 vssd1 SS_sky130_fd_sc_hd__fill_2
XFILLER_105_673 vssd1 vccd1 vssd1 vccd1 SS_sky130_ef_sc_hd__decap_40_12
XFILLER_2_277 vssd1 vccd1 vssd1 vccd1 SS_sky130_ef_sc_hd__decap_40_12
XPHY_EDGE_ROW_23_Right_23 vccd1 vssd1 vccd1 vssd1 SS_sky130_fd_sc_hd__decap_3
XFILLER_132_470 vssd1 vccd1 vccd1 vssd1 SS_sky130_fd_sc_hd__fill_4
XTAP_TAPCELL_ROW_53_1089 vccd1 vssd1 SS_sky130_fd_sc_hd__tapvpwrvgnd_1
XFILLER_78_557 vssd1 vccd1 vccd1 vssd1 SS_sky130_fd_sc_hd__fill_8
XFILLER_93_505 vssd1 vccd1 vssd1 vccd1 SS_sky130_ef_sc_hd__decap_40_12
XFILLER_19_613 vssd1 vccd1 vccd1 vssd1 SS_sky130_fd_sc_hd__fill_2
XFILLER_76_53 vssd1 vccd1 vssd1 vccd1 SS_sky130_ef_sc_hd__decap_40_12
XFILLER_120_687 vssd1 vccd1 vssd1 vccd1 SS_sky130_ef_sc_hd__decap_40_12
XFILLER_46_410 vssd1 vccd1 vccd1 vssd1 SS_sky130_fd_sc_hd__fill_8
XFILLER_46_421 vssd1 vccd1 vssd1 vccd1 SS_sky130_ef_sc_hd__decap_40_12
XFILLER_46_443 vssd1 vccd1 vssd1 vccd1 SS_sky130_ef_sc_hd__decap_40_12
XFILLER_76_97 vssd1 vccd1 vssd1 vccd1 SS_sky130_ef_sc_hd__decap_40_12
XFILLER_132_81 vssd1 vccd1 vccd1 vssd1 SS_sky130_fd_sc_hd__fill_2
XFILLER_18_189 vssd1 vccd1 vccd1 vssd1 SS_sky130_fd_sc_hd__fill_4
XFILLER_61_424 vccd1 vssd1 vccd1 vssd1 SS_sky130_fd_sc_hd__fill_1
XFILLER_73_273 vssd1 vccd1 vccd1 vssd1 SS_sky130_fd_sc_hd__fill_4
XFILLER_92_41 vssd1 vccd1 vssd1 vccd1 SS_sky130_ef_sc_hd__decap_40_12
XFILLER_15_841 vccd1 vssd1 vccd1 vssd1 SS_sky130_fd_sc_hd__fill_1
XPHY_EDGE_ROW_32_Right_32 vccd1 vssd1 vccd1 vssd1 SS_sky130_fd_sc_hd__decap_3
XFILLER_33_137 vssd1 vccd1 vssd1 vccd1 SS_sky130_ef_sc_hd__decap_40_12
XFILLER_92_85 vssd1 vccd1 vssd1 vccd1 SS_sky130_ef_sc_hd__decap_40_12
X_0900_ vccd1 vssd1 vccd1 vssd1 _1659_/Q _1211_/A _1627_/Q _0927_/A2 _0901_/C SS_sky130_fd_sc_hd__a22o_2
XFILLER_41_181 vssd1 vccd1 vssd1 vccd1 SS_sky130_ef_sc_hd__decap_40_12
X_1880_ vccd1 vssd1 _1880_/X _1880_/A vccd1 vssd1 SS_sky130_fd_sc_hd__buf_2
X_0831_ vccd1 vssd1 vccd1 vssd1 _1908_/A _0874_/A2 _1680_/Q _0891_/B1 _0831_/X SS_sky130_fd_sc_hd__a22o_2
X_0762_ vccd1 vssd1 vccd1 vssd1 _1827_/A wire424/X _1847_/A _0828_/B1 _0762_/X SS_sky130_fd_sc_hd__a22o_2
XTAP_TAPCELL_ROW_40_894 vccd1 vssd1 SS_sky130_fd_sc_hd__tapvpwrvgnd_1
XPHY_EDGE_ROW_41_Right_41 vccd1 vssd1 vccd1 vssd1 SS_sky130_fd_sc_hd__decap_3
XFILLER_44_3 vssd1 vccd1 vssd1 vccd1 SS_sky130_ef_sc_hd__decap_40_12
XFILLER_102_109 vssd1 vccd1 vssd1 vccd1 SS_sky130_ef_sc_hd__decap_40_12
XFILLER_123_481 vssd1 vccd1 vssd1 vccd1 SS_sky130_ef_sc_hd__decap_40_12
XFILLER_69_557 vssd1 vccd1 vccd1 vssd1 SS_sky130_fd_sc_hd__fill_2
X_1314_ vccd1 vssd1 vccd1 vssd1 _1314_/X _1314_/A _1318_/B SS_sky130_fd_sc_hd__or2_2
XFILLER_96_354 vccd1 vssd1 vccd1 vssd1 SS_sky130_fd_sc_hd__fill_1
XFILLER_96_332 vssd1 vccd1 vssd1 vccd1 SS_sky130_ef_sc_hd__decap_40_12
XFILLER_110_153 vssd1 vccd1 vssd1 vccd1 SS_sky130_ef_sc_hd__decap_40_12
XFILLER_96_365 vssd1 vccd1 vccd1 vssd1 SS_sky130_fd_sc_hd__fill_4
XFILLER_2_83 vccd1 vssd1 vccd1 vssd1 SS_sky130_fd_sc_hd__fill_1
XFILLER_49_281 vssd1 vccd1 vssd1 vccd1 SS_sky130_ef_sc_hd__decap_40_12
XTAP_TAPCELL_ROW_88_1620 vccd1 vssd1 SS_sky130_fd_sc_hd__tapvpwrvgnd_1
XFILLER_110_197 vssd1 vccd1 vssd1 vccd1 SS_sky130_ef_sc_hd__decap_40_12
X_1245_ vssd1 vccd1 vccd1 vssd1 _1261_/A2 input27/X _1651_/D _1381_/C1 _1244_/X SS_sky130_fd_sc_hd__o211a_2
XFILLER_64_251 vccd1 vssd1 vccd1 vssd1 SS_sky130_fd_sc_hd__fill_1
XFILLER_65_774 vssd1 vccd1 vccd1 vssd1 SS_sky130_fd_sc_hd__fill_8
XFILLER_65_785 vssd1 vccd1 vccd1 vssd1 SS_sky130_fd_sc_hd__fill_2
X_1176_ vccd1 vssd1 vccd1 vssd1 _1176_/X _1618_/Q _1208_/B SS_sky130_fd_sc_hd__or2_2
XFILLER_112_29 vssd1 vccd1 vssd1 vccd1 SS_sky130_ef_sc_hd__decap_40_12
XPHY_EDGE_ROW_50_Right_50 vccd1 vssd1 vccd1 vssd1 SS_sky130_fd_sc_hd__decap_3
XFILLER_24_137 vssd1 vccd1 vccd1 vssd1 SS_sky130_fd_sc_hd__fill_2
XFILLER_80_755 vccd1 vssd1 vccd1 vssd1 SS_sky130_fd_sc_hd__fill_1
XFILLER_20_321 vssd1 vccd1 vssd1 vccd1 SS_sky130_ef_sc_hd__decap_40_12
XFILLER_33_693 vssd1 vccd1 vccd1 vssd1 SS_sky130_fd_sc_hd__fill_2
XANTENNA_11 _1478_/Q vssd1 vccd1 vccd1 vssd1 SS_sky130_fd_sc_hd__diode_2
XFILLER_20_365 vssd1 vccd1 vssd1 vccd1 SS_sky130_ef_sc_hd__decap_40_12
XFILLER_119_721 vssd1 vccd1 vccd1 vssd1 SS_sky130_fd_sc_hd__fill_4
XTAP_TAPCELL_ROW_115_2027 vccd1 vssd1 SS_sky130_fd_sc_hd__tapvpwrvgnd_1
XTAP_TAPCELL_ROW_99_1782 vccd1 vssd1 SS_sky130_fd_sc_hd__tapvpwrvgnd_1
XFILLER_137_15 vssd1 vccd1 vccd1 vssd1 SS_sky130_fd_sc_hd__fill_4
XFILLER_118_253 vssd1 vccd1 vssd1 vccd1 SS_sky130_ef_sc_hd__decap_40_12
XFILLER_133_223 vccd1 vssd1 vccd1 vssd1 SS_sky130_fd_sc_hd__fill_1
XFILLER_134_757 vssd1 vccd1 vccd1 vssd1 SS_sky130_fd_sc_hd__fill_2
XFILLER_118_297 vssd1 vccd1 vccd1 vssd1 SS_sky130_fd_sc_hd__fill_2
Xoutput140 vccd1 vssd1 wire411/A _1641_/Q vccd1 vssd1 SS_sky130_fd_sc_hd__buf_4
XFILLER_88_811 vccd1 vssd1 vccd1 vssd1 SS_sky130_fd_sc_hd__fill_1
Xoutput151 vccd1 vssd1 wire400/A _1652_/Q vccd1 vssd1 SS_sky130_fd_sc_hd__buf_4
Xoutput195 vccd1 vssd1 wire360/A _1506_/Q vccd1 vssd1 SS_sky130_fd_sc_hd__buf_4
Xoutput184 vccd1 vssd1 wire371/A _1496_/Q vccd1 vssd1 SS_sky130_fd_sc_hd__buf_4
Xoutput173 vccd1 vssd1 wire382/A _1486_/Q vccd1 vssd1 SS_sky130_fd_sc_hd__buf_4
XFILLER_121_429 vssd1 vccd1 vssd1 vccd1 SS_sky130_ef_sc_hd__decap_40_12
Xoutput162 vccd1 vssd1 wire390/A _1662_/Q vccd1 vssd1 SS_sky130_fd_sc_hd__buf_4
XFILLER_99_181 vssd1 vccd1 vssd1 vccd1 SS_sky130_ef_sc_hd__decap_40_12
XFILLER_102_643 vccd1 vssd1 vccd1 vssd1 SS_sky130_fd_sc_hd__fill_1
XFILLER_75_505 vssd1 vccd1 vssd1 vccd1 SS_sky130_ef_sc_hd__decap_40_12
XFILLER_102_698 vssd1 vccd1 vccd1 vssd1 SS_sky130_fd_sc_hd__fill_2
XFILLER_28_421 vssd1 vccd1 vssd1 vccd1 SS_sky130_ef_sc_hd__decap_40_12
XTAP_TAPCELL_ROW_126_2189 vccd1 vssd1 SS_sky130_fd_sc_hd__tapvpwrvgnd_1
XFILLER_55_273 vssd1 vccd1 vccd1 vssd1 SS_sky130_fd_sc_hd__fill_4
XFILLER_15_137 vssd1 vccd1 vssd1 vccd1 SS_sky130_ef_sc_hd__decap_40_12
XFILLER_70_221 vssd1 vccd1 vssd1 vccd1 SS_sky130_ef_sc_hd__decap_40_12
XFILLER_24_671 vssd1 vccd1 vssd1 vccd1 SS_sky130_ef_sc_hd__decap_40_12
XTAP_TAPCELL_ROW_26_688 vccd1 vssd1 SS_sky130_fd_sc_hd__tapvpwrvgnd_1
XFILLER_31_619 vccd1 vssd1 vccd1 vssd1 SS_sky130_fd_sc_hd__fill_1
XFILLER_70_265 vssd1 vccd1 vssd1 vccd1 SS_sky130_ef_sc_hd__decap_40_12
XFILLER_23_181 vssd1 vccd1 vssd1 vccd1 SS_sky130_ef_sc_hd__decap_40_12
XFILLER_62_77 vssd1 vccd1 vccd1 vssd1 SS_sky130_fd_sc_hd__fill_4
XFILLER_129_529 vssd1 vccd1 vssd1 vccd1 SS_sky130_ef_sc_hd__decap_40_12
XFILLER_7_39 vssd1 vccd1 vssd1 vccd1 SS_sky130_ef_sc_hd__decap_40_12
XPHY_EDGE_ROW_12_Left_151 vccd1 vssd1 vccd1 vssd1 SS_sky130_fd_sc_hd__decap_3
Xwire278 vccd1 vssd1 vssd1 vccd1 wire278/A analog_ctrl[18] SS_sky130_fd_sc_hd__buf_12
Xwire267 vccd1 vssd1 vssd1 vccd1 wire267/A analog_ctrl[28] SS_sky130_fd_sc_hd__buf_12
Xwire289 vccd1 vssd1 vssd1 vccd1 wire289/A analog_ctrl[119] SS_sky130_fd_sc_hd__buf_12
XFILLER_125_757 vssd1 vccd1 vssd1 vccd1 SS_sky130_ef_sc_hd__decap_40_12
XFILLER_3_553 vssd1 vccd1 vccd1 vssd1 SS_sky130_fd_sc_hd__fill_4
XFILLER_11_81 vssd1 vccd1 vssd1 vccd1 SS_sky130_ef_sc_hd__decap_40_12
XTAP_TAPCELL_ROW_55_1118 vccd1 vssd1 SS_sky130_fd_sc_hd__tapvpwrvgnd_1
XTAP_TAPCELL_ROW_55_1129 vccd1 vssd1 SS_sky130_fd_sc_hd__tapvpwrvgnd_1
XFILLER_124_245 vssd1 vccd1 vccd1 vssd1 SS_sky130_fd_sc_hd__fill_4
XFILLER_3_597 vssd1 vccd1 vssd1 vccd1 SS_sky130_ef_sc_hd__decap_40_12
XFILLER_127_81 vssd1 vccd1 vssd1 vccd1 SS_sky130_ef_sc_hd__decap_40_12
XFILLER_124_289 vssd1 vccd1 vccd1 vssd1 SS_sky130_fd_sc_hd__fill_4
XFILLER_112_418 vssd1 vccd1 vccd1 vssd1 SS_sky130_fd_sc_hd__fill_2
XFILLER_39_708 vssd1 vccd1 vssd1 vccd1 SS_sky130_ef_sc_hd__decap_40_12
XFILLER_78_332 vccd1 vssd1 vccd1 vssd1 SS_sky130_fd_sc_hd__fill_1
XFILLER_94_803 vssd1 vccd1 vccd1 vssd1 SS_sky130_fd_sc_hd__fill_4
XFILLER_78_365 vssd1 vccd1 vssd1 vccd1 SS_sky130_ef_sc_hd__decap_40_12
XFILLER_78_387 vccd1 vssd1 vccd1 vssd1 SS_sky130_fd_sc_hd__fill_1
XFILLER_120_451 vssd1 vccd1 vssd1 vccd1 SS_sky130_ef_sc_hd__decap_40_12
XTAP_TAPCELL_ROW_6_391 vccd1 vssd1 SS_sky130_fd_sc_hd__tapvpwrvgnd_1
XPHY_EDGE_ROW_21_Left_160 vccd1 vssd1 vccd1 vssd1 SS_sky130_fd_sc_hd__decap_3
XFILLER_47_741 vssd1 vccd1 vssd1 vccd1 SS_sky130_ef_sc_hd__decap_40_12
XFILLER_93_335 vccd1 vssd1 vccd1 vssd1 SS_sky130_fd_sc_hd__fill_1
XFILLER_46_251 vccd1 vssd1 vccd1 vssd1 SS_sky130_fd_sc_hd__fill_1
X_1030_ vccd1 vssd1 vccd1 vssd1 _1030_/X _1030_/A _1050_/B SS_sky130_fd_sc_hd__or2_2
XFILLER_34_413 vssd1 vccd1 vccd1 vssd1 SS_sky130_fd_sc_hd__fill_4
XFILLER_47_785 vssd1 vccd1 vssd1 vccd1 SS_sky130_ef_sc_hd__decap_40_12
XFILLER_34_457 vssd1 vccd1 vssd1 vccd1 SS_sky130_ef_sc_hd__decap_40_12
XFILLER_61_221 vssd1 vccd1 vccd1 vssd1 SS_sky130_fd_sc_hd__fill_2
XFILLER_62_755 vccd1 vssd1 vccd1 vssd1 SS_sky130_fd_sc_hd__fill_1
XFILLER_15_671 vccd1 vssd1 vccd1 vssd1 SS_sky130_fd_sc_hd__fill_1
XTAP_TAPCELL_ROW_45_975 vccd1 vssd1 SS_sky130_fd_sc_hd__tapvpwrvgnd_1
XTAP_TAPCELL_ROW_83_1550 vccd1 vssd1 SS_sky130_fd_sc_hd__tapvpwrvgnd_1
X_1863_ vccd1 vssd1 _1863_/X _1863_/A vccd1 vssd1 SS_sky130_fd_sc_hd__buf_2
X_0814_ vccd1 vssd1 vccd1 vssd1 _0813_/X _1905_/A wire435/A _1873_/A _0828_/B1 _0814_/X
+ SS_sky130_fd_sc_hd__a221o_2
Xinput31 vccd1 vssd1 input31/X input31/A vccd1 vssd1 SS_sky130_fd_sc_hd__buf_2
Xinput20 vccd1 vssd1 input20/X input20/A vccd1 vssd1 SS_sky130_fd_sc_hd__buf_2
Xinput53 vssd1 vccd1 vccd1 vssd1 wbs_we_i _0945_/D SS_sky130_fd_sc_hd__clkdlybuf4s25_1
Xinput42 vccd1 vssd1 input42/X input42/A vccd1 vssd1 SS_sky130_fd_sc_hd__buf_2
X_0745_ vssd1 vccd1 vssd1 vccd1 _0755_/A _0745_/X _0755_/B _0754_/D _0755_/C SS_sky130_fd_sc_hd__and4bb_2
Xhold804 _1499_/D _0902_/X vccd1 vssd1 vssd1 vccd1 SS_sky130_fd_sc_hd__dlygate4sd3_1
XFILLER_116_757 vssd1 vccd1 vssd1 vccd1 SS_sky130_ef_sc_hd__decap_40_12
XFILLER_115_223 vccd1 vssd1 vccd1 vssd1 SS_sky130_fd_sc_hd__fill_1
XFILLER_131_705 vssd1 vccd1 vccd1 vssd1 SS_sky130_fd_sc_hd__fill_2
XFILLER_131_727 vccd1 vssd1 vccd1 vssd1 SS_sky130_fd_sc_hd__fill_1
XFILLER_69_321 vccd1 vssd1 vccd1 vssd1 SS_sky130_fd_sc_hd__fill_1
XFILLER_111_440 vssd1 vccd1 vccd1 vssd1 SS_sky130_fd_sc_hd__fill_8
XFILLER_57_505 vssd1 vccd1 vssd1 vccd1 SS_sky130_ef_sc_hd__decap_40_12
XFILLER_111_473 vssd1 vccd1 vssd1 vccd1 SS_sky130_ef_sc_hd__decap_40_12
XFILLER_97_685 vssd1 vccd1 vssd1 vccd1 SS_sky130_ef_sc_hd__decap_40_12
XFILLER_38_730 vssd1 vccd1 vssd1 vccd1 SS_sky130_ef_sc_hd__decap_40_12
XFILLER_96_195 vccd1 vssd1 vccd1 vssd1 SS_sky130_fd_sc_hd__fill_1
X_1228_ vccd1 vssd1 vccd1 vssd1 _1228_/X _1643_/Q _1264_/B SS_sky130_fd_sc_hd__or2_2
Xclkbuf_2_2__f_wb_clk_i vssd1 vccd1 vssd1 vccd1 clkbuf_0_wb_clk_i/X clkbuf_leaf_9_wb_clk_i/A
+ SS_sky130_fd_sc_hd__clkbuf_16
XFILLER_16_26 vssd1 vccd1 vccd1 vssd1 SS_sky130_fd_sc_hd__fill_2
XFILLER_37_273 vssd1 vccd1 vccd1 vssd1 SS_sky130_fd_sc_hd__fill_4
X_1159_ vssd1 vccd1 vccd1 vssd1 wire233/X wire497/X _1609_/D _1299_/C1 _1158_/X SS_sky130_fd_sc_hd__o211a_2
XFILLER_52_221 vssd1 vccd1 vssd1 vccd1 SS_sky130_ef_sc_hd__decap_40_12
XFILLER_52_265 vssd1 vccd1 vssd1 vccd1 SS_sky130_ef_sc_hd__decap_40_12
XTAP_TAPCELL_ROW_23_647 vccd1 vssd1 SS_sky130_fd_sc_hd__tapvpwrvgnd_1
XFILLER_21_641 vssd1 vccd1 vssd1 vccd1 SS_sky130_ef_sc_hd__decap_40_12
XFILLER_138_337 vssd1 vccd1 vccd1 vssd1 SS_sky130_fd_sc_hd__fill_2
XFILLER_20_195 vccd1 vssd1 vccd1 vssd1 SS_sky130_fd_sc_hd__fill_1
XFILLER_119_573 vssd1 vccd1 vssd1 vccd1 SS_sky130_ef_sc_hd__decap_40_12
XFILLER_113_6 vssd1 vccd1 vssd1 vccd1 SS_sky130_ef_sc_hd__decap_40_12
XFILLER_107_724 vssd1 vccd1 vccd1 vssd1 SS_sky130_fd_sc_hd__fill_4
XFILLER_107_779 vssd1 vccd1 vccd1 vssd1 SS_sky130_fd_sc_hd__fill_4
XFILLER_106_245 vssd1 vccd1 vccd1 vssd1 SS_sky130_fd_sc_hd__fill_4
XFILLER_0_501 vssd1 vccd1 vccd1 vssd1 SS_sky130_fd_sc_hd__fill_2
XFILLER_134_587 vccd1 vssd1 vccd1 vssd1 SS_sky130_fd_sc_hd__fill_1
XFILLER_106_289 vssd1 vccd1 vssd1 vccd1 SS_sky130_ef_sc_hd__decap_40_12
XFILLER_0_545 vssd1 vccd1 vccd1 vssd1 SS_sky130_fd_sc_hd__fill_4
XFILLER_121_237 vssd1 vccd1 vssd1 vccd1 SS_sky130_ef_sc_hd__decap_40_12
XFILLER_0_589 vssd1 vccd1 vssd1 vccd1 SS_sky130_ef_sc_hd__decap_40_12
XTAP_TAPCELL_ROW_128_2218 vccd1 vssd1 SS_sky130_fd_sc_hd__tapvpwrvgnd_1
XFILLER_102_440 vssd1 vccd1 vssd1 vccd1 SS_sky130_ef_sc_hd__decap_40_12
XTAP_TAPCELL_ROW_50_1048 vccd1 vssd1 SS_sky130_fd_sc_hd__tapvpwrvgnd_1
XFILLER_57_55 vccd1 vssd1 vccd1 vssd1 SS_sky130_fd_sc_hd__fill_1
XFILLER_75_335 vccd1 vssd1 vccd1 vssd1 SS_sky130_fd_sc_hd__fill_1
XFILLER_130_793 vssd1 vccd1 vssd1 vccd1 SS_sky130_ef_sc_hd__decap_40_12
XTAP_TAPCELL_ROW_3_350 vccd1 vssd1 SS_sky130_fd_sc_hd__tapvpwrvgnd_1
XFILLER_90_305 vssd1 vccd1 vccd1 vssd1 SS_sky130_fd_sc_hd__fill_2
XFILLER_16_413 vssd1 vccd1 vccd1 vssd1 SS_sky130_fd_sc_hd__fill_4
XFILLER_28_251 vccd1 vssd1 vccd1 vssd1 SS_sky130_fd_sc_hd__fill_1
XFILLER_29_785 vssd1 vccd1 vssd1 vccd1 SS_sky130_ef_sc_hd__decap_40_12
XFILLER_16_457 vssd1 vccd1 vssd1 vccd1 SS_sky130_ef_sc_hd__decap_40_12
XFILLER_43_221 vssd1 vccd1 vccd1 vssd1 SS_sky130_fd_sc_hd__fill_2
XFILLER_44_744 vssd1 vccd1 vssd1 vccd1 SS_sky130_ef_sc_hd__decap_40_12
XFILLER_71_552 vssd1 vccd1 vccd1 vssd1 SS_sky130_fd_sc_hd__fill_8
XFILLER_73_54 vssd1 vccd1 vccd1 vssd1 SS_sky130_fd_sc_hd__fill_2
XFILLER_31_405 vssd1 vccd1 vssd1 vccd1 SS_sky130_ef_sc_hd__decap_40_12
XTAP_TAPCELL_ROW_42_923 vccd1 vssd1 SS_sky130_fd_sc_hd__tapvpwrvgnd_1
XFILLER_31_449 vssd1 vccd1 vssd1 vccd1 SS_sky130_ef_sc_hd__decap_40_12
XTAP_TAPCELL_ROW_42_934 vccd1 vssd1 SS_sky130_fd_sc_hd__tapvpwrvgnd_1
XTAP_TAPCELL_ROW_65_1280 vccd1 vssd1 SS_sky130_fd_sc_hd__tapvpwrvgnd_1
XFILLER_8_601 vssd1 vccd1 vssd1 vccd1 SS_sky130_ef_sc_hd__decap_40_12
XFILLER_12_641 vssd1 vccd1 vccd1 vssd1 SS_sky130_fd_sc_hd__fill_2
XFILLER_7_111 vccd1 vssd1 vccd1 vssd1 SS_sky130_fd_sc_hd__fill_1
XFILLER_8_645 vssd1 vccd1 vssd1 vccd1 SS_sky130_ef_sc_hd__decap_40_12
XFILLER_129_337 vssd1 vccd1 vccd1 vssd1 SS_sky130_fd_sc_hd__fill_4
XFILLER_3_361 vssd1 vccd1 vssd1 vccd1 SS_sky130_ef_sc_hd__decap_40_12
XFILLER_113_738 vccd1 vssd1 vccd1 vssd1 SS_sky130_fd_sc_hd__fill_1
XFILLER_113_727 vccd1 vssd1 vccd1 vssd1 SS_sky130_fd_sc_hd__fill_1
XFILLER_39_505 vccd1 vssd1 vccd1 vssd1 SS_sky130_fd_sc_hd__fill_1
XFILLER_79_685 vssd1 vccd1 vssd1 vccd1 SS_sky130_ef_sc_hd__decap_40_12
XFILLER_66_335 vccd1 vssd1 vccd1 vssd1 SS_sky130_fd_sc_hd__fill_1
XFILLER_78_195 vccd1 vssd1 vccd1 vssd1 SS_sky130_fd_sc_hd__fill_1
XTAP_TAPCELL_ROW_1_309 vccd1 vssd1 SS_sky130_fd_sc_hd__tapvpwrvgnd_1
XFILLER_19_273 vssd1 vccd1 vccd1 vssd1 SS_sky130_fd_sc_hd__fill_4
XFILLER_47_593 vssd1 vccd1 vssd1 vccd1 SS_sky130_ef_sc_hd__decap_40_12
X_1013_ vccd1 vssd1 vssd1 vccd1 _1013_/Y _1013_/A _1409_/B SS_sky130_fd_sc_hd__nand2_2
XFILLER_93_165 vssd1 vccd1 vccd1 vssd1 SS_sky130_fd_sc_hd__fill_2
XFILLER_34_221 vssd1 vccd1 vssd1 vccd1 SS_sky130_ef_sc_hd__decap_40_12
XFILLER_62_541 vssd1 vccd1 vccd1 vssd1 SS_sky130_fd_sc_hd__fill_2
XFILLER_81_349 vssd1 vccd1 vssd1 vccd1 SS_sky130_ef_sc_hd__decap_40_12
XFILLER_34_265 vssd1 vccd1 vssd1 vccd1 SS_sky130_ef_sc_hd__decap_40_12
XFILLER_50_725 vssd1 vccd1 vssd1 vccd1 SS_sky130_ef_sc_hd__decap_40_12
XTAP_TAPCELL_ROW_81_1509 vccd1 vssd1 SS_sky130_fd_sc_hd__tapvpwrvgnd_1
XFILLER_62_596 vssd1 vccd1 vccd1 vssd1 SS_sky130_fd_sc_hd__fill_2
XTAP_TAPCELL_ROW_20_606 vccd1 vssd1 SS_sky130_fd_sc_hd__tapvpwrvgnd_1
XFILLER_50_769 vssd1 vccd1 vssd1 vccd1 SS_sky130_ef_sc_hd__decap_40_12
X_1846_ vccd1 vssd1 _1846_/X _1846_/A vccd1 vssd1 SS_sky130_fd_sc_hd__buf_2
Xhold612 _1084_/A _1843_/A vccd1 vssd1 vssd1 vccd1 SS_sky130_fd_sc_hd__dlygate4sd3_1
XTAP_TAPCELL_ROW_96_1741 vccd1 vssd1 SS_sky130_fd_sc_hd__tapvpwrvgnd_1
Xhold601 _1521_/D _0977_/X vccd1 vssd1 vssd1 vccd1 SS_sky130_fd_sc_hd__dlygate4sd3_1
XFILLER_89_405 vssd1 vccd1 vccd1 vssd1 SS_sky130_fd_sc_hd__fill_2
Xhold645 input44/A wbs_dat_i[31] vccd1 vssd1 vssd1 vccd1 SS_sky130_fd_sc_hd__dlygate4sd3_1
Xhold634 input49/A wbs_dat_i[7] vccd1 vssd1 vssd1 vccd1 SS_sky130_fd_sc_hd__dlygate4sd3_1
Xhold623 _1740_/D _1429_/X vccd1 vssd1 vssd1 vccd1 SS_sky130_fd_sc_hd__dlygate4sd3_1
XPHY_EDGE_ROW_4_Right_4 vccd1 vssd1 vccd1 vssd1 SS_sky130_fd_sc_hd__decap_3
XFILLER_89_427 vssd1 vccd1 vssd1 vccd1 SS_sky130_ef_sc_hd__decap_40_12
Xhold656 _1470_/A _1761_/Q vccd1 vssd1 vssd1 vccd1 SS_sky130_fd_sc_hd__dlygate4sd3_1
XFILLER_116_587 vccd1 vssd1 vccd1 vssd1 SS_sky130_fd_sc_hd__fill_1
Xhold667 _1332_/A _1694_/Q vccd1 vssd1 vssd1 vccd1 SS_sky130_fd_sc_hd__dlygate4sd3_1
Xhold678 _1320_/A _1688_/Q vccd1 vssd1 vssd1 vccd1 SS_sky130_fd_sc_hd__dlygate4sd3_1
XFILLER_89_449 vssd1 vccd1 vssd1 vccd1 SS_sky130_ef_sc_hd__decap_40_12
Xhold689 _1000_/A _1533_/Q vccd1 vssd1 vssd1 vccd1 SS_sky130_fd_sc_hd__dlygate4sd3_1
XFILLER_104_749 vssd1 vccd1 vccd1 vssd1 SS_sky130_fd_sc_hd__fill_2
XFILLER_103_237 vssd1 vccd1 vssd1 vccd1 SS_sky130_ef_sc_hd__decap_40_12
XFILLER_58_803 vccd1 vssd1 vccd1 vssd1 SS_sky130_fd_sc_hd__fill_1
XFILLER_134_27 vccd1 vssd1 vccd1 vssd1 SS_sky130_fd_sc_hd__fill_1
XFILLER_57_335 vccd1 vssd1 vccd1 vssd1 SS_sky130_fd_sc_hd__fill_1
XFILLER_84_121 vssd1 vccd1 vssd1 vccd1 SS_sky130_ef_sc_hd__decap_40_12
XFILLER_112_793 vssd1 vccd1 vssd1 vccd1 SS_sky130_ef_sc_hd__decap_40_12
XFILLER_111_281 vssd1 vccd1 vssd1 vccd1 SS_sky130_ef_sc_hd__decap_40_12
XFILLER_27_69 vssd1 vccd1 vssd1 vccd1 SS_sky130_ef_sc_hd__decap_40_12
XTAP_TAPCELL_ROW_28_717 vccd1 vssd1 SS_sky130_fd_sc_hd__tapvpwrvgnd_1
XFILLER_72_305 vssd1 vccd1 vccd1 vssd1 SS_sky130_fd_sc_hd__fill_2
XFILLER_84_165 vssd1 vccd1 vssd1 vccd1 SS_sky130_ef_sc_hd__decap_40_12
XFILLER_25_221 vssd1 vccd1 vccd1 vssd1 SS_sky130_fd_sc_hd__fill_2
XTAP_TAPCELL_ROW_123_2148 vccd1 vssd1 SS_sky130_fd_sc_hd__tapvpwrvgnd_1
XFILLER_13_405 vssd1 vccd1 vssd1 vccd1 SS_sky130_ef_sc_hd__decap_40_12
XFILLER_41_725 vssd1 vccd1 vccd1 vssd1 SS_sky130_fd_sc_hd__fill_2
XFILLER_53_585 vssd1 vccd1 vssd1 vccd1 SS_sky130_ef_sc_hd__decap_40_12
XFILLER_13_449 vssd1 vccd1 vssd1 vccd1 SS_sky130_ef_sc_hd__decap_40_12
XTAP_TAPCELL_ROW_105_1881 vccd1 vssd1 SS_sky130_fd_sc_hd__tapvpwrvgnd_1
XTAP_TAPCELL_ROW_105_1870 vccd1 vssd1 SS_sky130_fd_sc_hd__tapvpwrvgnd_1
XFILLER_43_57 vssd1 vccd1 vssd1 vccd1 SS_sky130_ef_sc_hd__decap_40_12
XTAP_TAPCELL_ROW_138_2380 vccd1 vssd1 SS_sky130_fd_sc_hd__tapvpwrvgnd_1
XTAP_TAPCELL_ROW_138_2391 vccd1 vssd1 SS_sky130_fd_sc_hd__tapvpwrvgnd_1
XFILLER_138_167 vccd1 vssd1 vccd1 vssd1 SS_sky130_fd_sc_hd__fill_1
XFILLER_138_145 vssd1 vccd1 vccd1 vssd1 SS_sky130_fd_sc_hd__fill_2
XFILLER_5_615 vccd1 vssd1 vccd1 vssd1 SS_sky130_fd_sc_hd__fill_1
XFILLER_134_340 vssd1 vccd1 vssd1 vccd1 SS_sky130_ef_sc_hd__decap_40_12
XFILLER_135_841 vccd1 vssd1 vccd1 vssd1 SS_sky130_fd_sc_hd__fill_1
XFILLER_107_543 vssd1 vccd1 vssd1 vccd1 SS_sky130_ef_sc_hd__decap_40_12
XFILLER_4_29 vssd1 vccd1 vssd1 vccd1 SS_sky130_ef_sc_hd__decap_40_12
XTAP_TAPCELL_ROW_8_420 vccd1 vssd1 SS_sky130_fd_sc_hd__tapvpwrvgnd_1
XFILLER_122_513 vssd1 vccd1 vccd1 vssd1 SS_sky130_fd_sc_hd__fill_8
XFILLER_1_821 vssd1 vccd1 vssd1 vccd1 SS_sky130_ef_sc_hd__decap_40_12
XFILLER_108_83 vccd1 vssd1 vccd1 vssd1 SS_sky130_fd_sc_hd__fill_1
XFILLER_0_353 vssd1 vccd1 vccd1 vssd1 SS_sky130_fd_sc_hd__fill_2
XFILLER_68_65 vssd1 vccd1 vssd1 vccd1 SS_sky130_ef_sc_hd__decap_40_12
XFILLER_76_611 vccd1 vssd1 vccd1 vssd1 SS_sky130_fd_sc_hd__fill_1
XFILLER_76_622 vssd1 vccd1 vssd1 vccd1 SS_sky130_ef_sc_hd__decap_40_12
XFILLER_48_357 vssd1 vccd1 vccd1 vssd1 SS_sky130_fd_sc_hd__fill_4
XFILLER_63_305 vssd1 vccd1 vssd1 vccd1 SS_sky130_ef_sc_hd__decap_40_12
XFILLER_63_327 vccd1 vssd1 vccd1 vssd1 SS_sky130_fd_sc_hd__fill_1
XFILLER_75_165 vssd1 vccd1 vccd1 vssd1 SS_sky130_fd_sc_hd__fill_2
XFILLER_84_53 vssd1 vccd1 vssd1 vccd1 SS_sky130_ef_sc_hd__decap_40_12
XFILLER_16_221 vssd1 vccd1 vssd1 vccd1 SS_sky130_ef_sc_hd__decap_40_12
XFILLER_84_97 vssd1 vccd1 vssd1 vccd1 SS_sky130_ef_sc_hd__decap_40_12
XFILLER_16_265 vssd1 vccd1 vssd1 vccd1 SS_sky130_ef_sc_hd__decap_40_12
XTAP_TAPCELL_ROW_63_1239 vccd1 vssd1 SS_sky130_fd_sc_hd__tapvpwrvgnd_1
XFILLER_32_769 vssd1 vccd1 vssd1 vccd1 SS_sky130_ef_sc_hd__decap_40_12
XFILLER_31_279 vccd1 vssd1 vccd1 vssd1 SS_sky130_fd_sc_hd__fill_1
XFILLER_76_6 vssd1 vccd1 vssd1 vccd1 SS_sky130_ef_sc_hd__decap_40_12
X_1700_ _1879_/A _1745_/CLK _1700_/D vccd1 vssd1 vccd1 vssd1 SS_sky130_fd_sc_hd__dfxtp_2
XFILLER_129_167 vccd1 vssd1 vccd1 vssd1 SS_sky130_fd_sc_hd__fill_1
XFILLER_8_475 vccd1 vssd1 vccd1 vssd1 SS_sky130_fd_sc_hd__fill_1
XFILLER_117_329 vssd1 vccd1 vccd1 vssd1 SS_sky130_fd_sc_hd__fill_4
X_1631_ _1631_/Q _1760_/CLK _1631_/D vccd1 vssd1 vccd1 vssd1 SS_sky130_fd_sc_hd__dfxtp_2
XTAP_TAPCELL_ROW_78_1471 vccd1 vssd1 SS_sky130_fd_sc_hd__tapvpwrvgnd_1
X_1562_ _1562_/Q _1754_/CLK _1562_/D vccd1 vssd1 vccd1 vssd1 SS_sky130_fd_sc_hd__dfxtp_2
XFILLER_113_513 vccd1 vssd1 vccd1 vssd1 SS_sky130_fd_sc_hd__fill_1
XFILLER_99_714 vssd1 vccd1 vssd1 vccd1 SS_sky130_ef_sc_hd__decap_40_12
XFILLER_4_681 vssd1 vccd1 vssd1 vccd1 SS_sky130_ef_sc_hd__decap_40_12
X_1493_ _1493_/Q _1751_/CLK _1493_/D vccd1 vssd1 vccd1 vssd1 SS_sky130_fd_sc_hd__dfxtp_2
XTAP_TAPCELL_ROW_91_1660 vccd1 vssd1 SS_sky130_fd_sc_hd__tapvpwrvgnd_1
XFILLER_101_708 vssd1 vccd1 vccd1 vssd1 SS_sky130_fd_sc_hd__fill_2
XTAP_TAPCELL_ROW_91_1671 vccd1 vssd1 SS_sky130_fd_sc_hd__tapvpwrvgnd_1
XFILLER_39_335 vccd1 vssd1 vccd1 vssd1 SS_sky130_fd_sc_hd__fill_1
XFILLER_79_493 vssd1 vccd1 vccd1 vssd1 SS_sky130_fd_sc_hd__fill_8
XFILLER_55_817 vccd1 vssd1 vccd1 vssd1 SS_sky130_fd_sc_hd__fill_1
XFILLER_66_121 vssd1 vccd1 vssd1 vccd1 SS_sky130_ef_sc_hd__decap_40_12
XFILLER_54_305 vssd1 vccd1 vccd1 vssd1 SS_sky130_fd_sc_hd__fill_2
XFILLER_66_165 vssd1 vccd1 vssd1 vccd1 SS_sky130_ef_sc_hd__decap_40_12
XFILLER_81_113 vssd1 vccd1 vssd1 vccd1 SS_sky130_ef_sc_hd__decap_40_12
XFILLER_82_625 vssd1 vccd1 vssd1 vccd1 SS_sky130_ef_sc_hd__decap_40_12
XFILLER_35_541 vssd1 vccd1 vccd1 vssd1 SS_sky130_fd_sc_hd__fill_2
XFILLER_82_669 vssd1 vccd1 vccd1 vssd1 SS_sky130_fd_sc_hd__fill_8
XFILLER_23_703 vssd1 vccd1 vssd1 vccd1 SS_sky130_ef_sc_hd__decap_40_12
XFILLER_120_29 vssd1 vccd1 vssd1 vccd1 SS_sky130_ef_sc_hd__decap_40_12
XFILLER_35_585 vssd1 vccd1 vccd1 vssd1 SS_sky130_fd_sc_hd__fill_4
XFILLER_50_533 vssd1 vccd1 vssd1 vccd1 SS_sky130_ef_sc_hd__decap_40_12
XFILLER_90_680 vssd1 vccd1 vssd1 vccd1 SS_sky130_ef_sc_hd__decap_40_12
XFILLER_10_419 vccd1 vssd1 vccd1 vssd1 SS_sky130_fd_sc_hd__fill_1
XTAP_TAPCELL_ROW_33_797 vccd1 vssd1 SS_sky130_fd_sc_hd__tapvpwrvgnd_1
XFILLER_129_27 vssd1 vccd1 vssd1 vccd1 SS_sky130_ef_sc_hd__decap_40_12
XFILLER_108_307 vccd1 vssd1 vccd1 vssd1 SS_sky130_fd_sc_hd__fill_1
X_1829_ vccd1 vssd1 _1829_/X _1829_/A vccd1 vssd1 SS_sky130_fd_sc_hd__buf_2
XFILLER_135_137 vssd1 vccd1 vssd1 vccd1 SS_sky130_ef_sc_hd__decap_40_12
XFILLER_117_841 vccd1 vssd1 vccd1 vssd1 SS_sky130_fd_sc_hd__fill_1
XFILLER_132_811 vccd1 vssd1 vccd1 vssd1 SS_sky130_fd_sc_hd__fill_1
XFILLER_116_362 vssd1 vccd1 vccd1 vssd1 SS_sky130_fd_sc_hd__fill_2
XFILLER_104_513 vssd1 vccd1 vssd1 vccd1 SS_sky130_ef_sc_hd__decap_40_12
XFILLER_131_332 vssd1 vccd1 vccd1 vssd1 SS_sky130_fd_sc_hd__fill_4
XFILLER_104_557 vssd1 vccd1 vccd1 vssd1 SS_sky130_fd_sc_hd__fill_4
XFILLER_89_279 vccd1 vssd1 vccd1 vssd1 SS_sky130_fd_sc_hd__fill_1
XFILLER_58_633 vccd1 vssd1 vccd1 vssd1 SS_sky130_fd_sc_hd__fill_1
XFILLER_45_305 vssd1 vccd1 vssd1 vccd1 SS_sky130_ef_sc_hd__decap_40_12
XFILLER_57_165 vssd1 vccd1 vccd1 vssd1 SS_sky130_fd_sc_hd__fill_2
XFILLER_58_699 vccd1 vssd1 vccd1 vssd1 SS_sky130_fd_sc_hd__fill_1
XPHY_EDGE_ROW_79_Right_79 vccd1 vssd1 vccd1 vssd1 SS_sky130_fd_sc_hd__decap_3
XFILLER_85_485 vssd1 vccd1 vssd1 vccd1 SS_sky130_ef_sc_hd__decap_40_12
XTAP_TAPCELL_ROW_107_1910 vccd1 vssd1 SS_sky130_fd_sc_hd__tapvpwrvgnd_1
XFILLER_100_774 vssd1 vccd1 vssd1 vccd1 SS_sky130_ef_sc_hd__decap_40_12
XFILLER_45_349 vssd1 vccd1 vssd1 vccd1 SS_sky130_ef_sc_hd__decap_40_12
XFILLER_61_809 vccd1 vssd1 vccd1 vssd1 SS_sky130_fd_sc_hd__fill_1
XFILLER_73_669 vssd1 vccd1 vccd1 vssd1 SS_sky130_fd_sc_hd__fill_2
XFILLER_14_725 vssd1 vccd1 vssd1 vccd1 SS_sky130_ef_sc_hd__decap_40_12
XFILLER_26_585 vssd1 vccd1 vccd1 vssd1 SS_sky130_fd_sc_hd__fill_2
XFILLER_53_393 vssd1 vccd1 vssd1 vccd1 SS_sky130_ef_sc_hd__decap_40_12
XFILLER_14_769 vssd1 vccd1 vssd1 vccd1 SS_sky130_ef_sc_hd__decap_40_12
XFILLER_9_217 vssd1 vccd1 vccd1 vssd1 SS_sky130_fd_sc_hd__fill_4
XFILLER_13_279 vccd1 vssd1 vccd1 vssd1 SS_sky130_fd_sc_hd__fill_1
XFILLER_70_77 vssd1 vccd1 vccd1 vssd1 SS_sky130_fd_sc_hd__fill_4
XTAP_TAPCELL_ROW_136_2339 vccd1 vssd1 SS_sky130_fd_sc_hd__tapvpwrvgnd_1
XTAP_TAPCELL_ROW_11_458 vccd1 vssd1 SS_sky130_fd_sc_hd__tapvpwrvgnd_1
XTAP_TAPCELL_ROW_11_469 vccd1 vssd1 SS_sky130_fd_sc_hd__tapvpwrvgnd_1
XPHY_EDGE_ROW_88_Right_88 vccd1 vssd1 vccd1 vssd1 SS_sky130_fd_sc_hd__decap_3
XFILLER_5_445 vssd1 vccd1 vccd1 vssd1 SS_sky130_fd_sc_hd__fill_2
XFILLER_126_137 vssd1 vccd1 vccd1 vssd1 SS_sky130_fd_sc_hd__fill_2
XFILLER_135_671 vccd1 vssd1 vccd1 vssd1 SS_sky130_fd_sc_hd__fill_1
XFILLER_119_93 vssd1 vccd1 vssd1 vccd1 SS_sky130_ef_sc_hd__decap_40_12
XFILLER_107_373 vssd1 vccd1 vssd1 vccd1 SS_sky130_ef_sc_hd__decap_40_12
XFILLER_122_332 vssd1 vccd1 vssd1 vccd1 SS_sky130_ef_sc_hd__decap_40_12
XFILLER_122_365 vssd1 vccd1 vssd1 vccd1 SS_sky130_ef_sc_hd__decap_40_12
XFILLER_95_205 vssd1 vccd1 vssd1 vccd1 SS_sky130_ef_sc_hd__decap_40_12
XFILLER_1_673 vssd1 vccd1 vssd1 vccd1 SS_sky130_ef_sc_hd__decap_40_12
XTAP_TAPCELL_ROW_73_1390 vccd1 vssd1 SS_sky130_fd_sc_hd__tapvpwrvgnd_1
XFILLER_135_81 vssd1 vccd1 vssd1 vccd1 SS_sky130_ef_sc_hd__decap_40_12
XFILLER_48_121 vssd1 vccd1 vssd1 vccd1 SS_sky130_ef_sc_hd__decap_40_12
XFILLER_49_655 vccd1 vssd1 vccd1 vssd1 SS_sky130_fd_sc_hd__fill_1
XPHY_EDGE_ROW_97_Right_97 vccd1 vssd1 vccd1 vssd1 SS_sky130_fd_sc_hd__decap_3
XFILLER_95_249 vssd1 vccd1 vssd1 vccd1 SS_sky130_ef_sc_hd__decap_40_12
XFILLER_36_305 vssd1 vccd1 vccd1 vssd1 SS_sky130_fd_sc_hd__fill_2
XFILLER_48_165 vssd1 vccd1 vssd1 vccd1 SS_sky130_ef_sc_hd__decap_40_12
XFILLER_63_113 vssd1 vccd1 vssd1 vccd1 SS_sky130_ef_sc_hd__decap_40_12
XFILLER_64_669 vssd1 vccd1 vccd1 vssd1 SS_sky130_fd_sc_hd__fill_8
XFILLER_17_541 vssd1 vccd1 vssd1 vccd1 SS_sky130_ef_sc_hd__decap_40_12
XFILLER_17_585 vssd1 vccd1 vssd1 vccd1 SS_sky130_ef_sc_hd__decap_40_12
XFILLER_32_533 vssd1 vccd1 vssd1 vccd1 SS_sky130_ef_sc_hd__decap_40_12
XPHY_EDGE_ROW_4_Left_143 vccd1 vssd1 vccd1 vssd1 SS_sky130_fd_sc_hd__decap_3
XFILLER_20_739 vssd1 vccd1 vssd1 vccd1 SS_sky130_ef_sc_hd__decap_40_12
XFILLER_32_577 vssd1 vccd1 vccd1 vssd1 SS_sky130_fd_sc_hd__fill_2
X_0993_ vssd1 vccd1 vccd1 vssd1 wire253/A input34/X _1529_/D _1457_/C1 _0992_/X SS_sky130_fd_sc_hd__o211a_2
XTAP_TAPCELL_ROW_30_745 vccd1 vssd1 SS_sky130_fd_sc_hd__tapvpwrvgnd_1
XTAP_TAPCELL_ROW_30_756 vccd1 vssd1 SS_sky130_fd_sc_hd__tapvpwrvgnd_1
XFILLER_74_3 vssd1 vccd1 vssd1 vccd1 SS_sky130_ef_sc_hd__decap_40_12
XFILLER_117_137 vssd1 vccd1 vssd1 vccd1 SS_sky130_ef_sc_hd__decap_40_12
XTAP_TAPCELL_ROW_93_1700 vccd1 vssd1 SS_sky130_fd_sc_hd__tapvpwrvgnd_1
X_1614_ _1874_/A clkload4/A _1614_/D vccd1 vssd1 vccd1 vssd1 SS_sky130_fd_sc_hd__dfxtp_2
XFILLER_114_811 vccd1 vssd1 vccd1 vssd1 SS_sky130_fd_sc_hd__fill_1
XFILLER_99_500 vssd1 vccd1 vccd1 vssd1 SS_sky130_fd_sc_hd__fill_4
X_1545_ _1832_/A _1576_/CLK _1545_/D vccd1 vssd1 vccd1 vssd1 SS_sky130_fd_sc_hd__dfxtp_2
XFILLER_125_181 vssd1 vccd1 vssd1 vccd1 SS_sky130_ef_sc_hd__decap_40_12
XFILLER_113_321 vssd1 vccd1 vccd1 vssd1 SS_sky130_fd_sc_hd__fill_2
Xfanout218 vssd1 vccd1 vccd1 vssd1 _1331_/A2 _1339_/A2 SS_sky130_fd_sc_hd__clkdlybuf4s25_1
XFILLER_113_354 vssd1 vccd1 vssd1 vccd1 SS_sky130_ef_sc_hd__decap_40_12
XFILLER_101_505 vssd1 vccd1 vssd1 vccd1 SS_sky130_ef_sc_hd__decap_40_12
X_1476_ _1476_/Q clkload6/A _1476_/D vccd1 vssd1 vccd1 vssd1 SS_sky130_fd_sc_hd__dfxtp_2
XFILLER_86_249 vssd1 vccd1 vccd1 vssd1 SS_sky130_fd_sc_hd__fill_2
XFILLER_27_305 vssd1 vccd1 vssd1 vccd1 SS_sky130_ef_sc_hd__decap_40_12
XFILLER_28_817 vssd1 vccd1 vccd1 vssd1 SS_sky130_fd_sc_hd__fill_2
XFILLER_39_165 vssd1 vccd1 vccd1 vssd1 SS_sky130_fd_sc_hd__fill_2
XFILLER_27_349 vssd1 vccd1 vssd1 vccd1 SS_sky130_ef_sc_hd__decap_40_12
XTAP_TAPCELL_ROW_38_867 vccd1 vssd1 SS_sky130_fd_sc_hd__tapvpwrvgnd_1
XFILLER_82_477 vssd1 vccd1 vccd1 vssd1 SS_sky130_fd_sc_hd__fill_8
XTAP_TAPCELL_ROW_120_2107 vccd1 vssd1 SS_sky130_fd_sc_hd__tapvpwrvgnd_1
XFILLER_24_15 vssd1 vccd1 vssd1 vccd1 SS_sky130_ef_sc_hd__decap_40_12
XFILLER_35_393 vssd1 vccd1 vssd1 vccd1 SS_sky130_ef_sc_hd__decap_40_12
XFILLER_50_363 vccd1 vssd1 vccd1 vssd1 SS_sky130_fd_sc_hd__fill_1
XPHY_EDGE_ROW_59_Left_198 vccd1 vssd1 vccd1 vssd1 SS_sky130_fd_sc_hd__decap_3
XFILLER_10_249 vssd1 vccd1 vccd1 vssd1 SS_sky130_fd_sc_hd__fill_2
XFILLER_6_209 vssd1 vccd1 vssd1 vccd1 SS_sky130_ef_sc_hd__decap_40_12
XTAP_TAPCELL_ROW_118_2069 vccd1 vssd1 SS_sky130_fd_sc_hd__tapvpwrvgnd_1
XFILLER_108_137 vssd1 vccd1 vccd1 vssd1 SS_sky130_fd_sc_hd__fill_2
XTAP_TAPCELL_ROW_131_2258 vccd1 vssd1 SS_sky130_fd_sc_hd__tapvpwrvgnd_1
XFILLER_6_6 vssd1 vccd1 vssd1 vccd1 SS_sky130_ef_sc_hd__decap_40_12
XTAP_TAPCELL_ROW_131_2269 vccd1 vssd1 SS_sky130_fd_sc_hd__tapvpwrvgnd_1
XFILLER_132_641 vssd1 vccd1 vccd1 vssd1 SS_sky130_fd_sc_hd__fill_2
XFILLER_77_205 vssd1 vccd1 vssd1 vccd1 SS_sky130_ef_sc_hd__decap_40_12
XFILLER_104_365 vssd1 vccd1 vccd1 vssd1 SS_sky130_fd_sc_hd__fill_2
XTAP_TAPCELL_ROW_113_1991 vccd1 vssd1 SS_sky130_fd_sc_hd__tapvpwrvgnd_1
XFILLER_104_376 vssd1 vccd1 vssd1 vccd1 SS_sky130_ef_sc_hd__decap_40_12
XFILLER_77_249 vssd1 vccd1 vssd1 vccd1 SS_sky130_ef_sc_hd__decap_40_12
XPHY_EDGE_ROW_130_Right_130 vccd1 vssd1 vccd1 vssd1 SS_sky130_fd_sc_hd__decap_3
XFILLER_105_51 vssd1 vccd1 vccd1 vssd1 SS_sky130_fd_sc_hd__fill_4
XFILLER_18_305 vssd1 vccd1 vccd1 vssd1 SS_sky130_fd_sc_hd__fill_2
XFILLER_46_614 vssd1 vccd1 vssd1 vccd1 SS_sky130_ef_sc_hd__decap_40_12
XFILLER_58_474 vssd1 vccd1 vccd1 vssd1 SS_sky130_fd_sc_hd__fill_2
XFILLER_58_485 vccd1 vssd1 vccd1 vssd1 SS_sky130_fd_sc_hd__fill_1
XFILLER_86_783 vssd1 vccd1 vccd1 vssd1 SS_sky130_fd_sc_hd__fill_8
XFILLER_45_113 vssd1 vccd1 vssd1 vccd1 SS_sky130_ef_sc_hd__decap_40_12
XFILLER_65_55 vccd1 vssd1 vccd1 vssd1 SS_sky130_fd_sc_hd__fill_1
XFILLER_73_433 vccd1 vssd1 vccd1 vssd1 SS_sky130_fd_sc_hd__fill_1
XFILLER_85_293 vssd1 vccd1 vssd1 vccd1 SS_sky130_ef_sc_hd__decap_40_12
XFILLER_46_669 vssd1 vccd1 vssd1 vccd1 SS_sky130_ef_sc_hd__decap_40_12
XTAP_TAPCELL_ROW_47_1009 vccd1 vssd1 SS_sky130_fd_sc_hd__tapvpwrvgnd_1
XFILLER_61_617 vssd1 vccd1 vssd1 vccd1 SS_sky130_ef_sc_hd__decap_40_12
XTAP_TAPCELL_ROW_16_539 vccd1 vssd1 SS_sky130_fd_sc_hd__tapvpwrvgnd_1
XFILLER_73_499 vssd1 vccd1 vccd1 vssd1 SS_sky130_fd_sc_hd__fill_4
XFILLER_14_533 vssd1 vccd1 vssd1 vccd1 SS_sky130_ef_sc_hd__decap_40_12
XFILLER_81_54 vssd1 vccd1 vccd1 vssd1 SS_sky130_fd_sc_hd__fill_2
XFILLER_41_385 vssd1 vccd1 vccd1 vssd1 SS_sky130_fd_sc_hd__fill_4
XFILLER_14_81 vssd1 vccd1 vccd1 vssd1 SS_sky130_fd_sc_hd__fill_2
XFILLER_10_794 vssd1 vccd1 vssd1 vccd1 SS_sky130_ef_sc_hd__decap_40_12
XTAP_TAPCELL_ROW_75_1430 vccd1 vssd1 SS_sky130_fd_sc_hd__tapvpwrvgnd_1
XFILLER_107_181 vssd1 vccd1 vssd1 vccd1 SS_sky130_ef_sc_hd__decap_40_12
XFILLER_69_706 vssd1 vccd1 vssd1 vccd1 SS_sky130_ef_sc_hd__decap_40_12
X_1330_ vccd1 vssd1 vccd1 vssd1 _1330_/X _1330_/A _1330_/B SS_sky130_fd_sc_hd__or2_2
XFILLER_123_685 vssd1 vccd1 vssd1 vccd1 SS_sky130_ef_sc_hd__decap_40_12
XFILLER_68_249 vssd1 vccd1 vccd1 vssd1 SS_sky130_fd_sc_hd__fill_2
XFILLER_122_195 vccd1 vssd1 vccd1 vssd1 SS_sky130_fd_sc_hd__fill_1
X_1261_ vssd1 vccd1 vccd1 vssd1 _1261_/A2 input36/X _1659_/D _1461_/C1 _1260_/X SS_sky130_fd_sc_hd__o211a_2
Xinput7 vssd1 vccd1 vccd1 vssd1 adc_data[4] input7/X SS_sky130_fd_sc_hd__clkdlybuf4s25_1
XFILLER_49_485 vssd1 vccd1 vssd1 vccd1 SS_sky130_ef_sc_hd__decap_40_12
XFILLER_77_783 vccd1 vssd1 vccd1 vssd1 SS_sky130_fd_sc_hd__fill_1
X_1192_ vccd1 vssd1 vccd1 vssd1 _1192_/X _1192_/A _1208_/B SS_sky130_fd_sc_hd__or2_2
XFILLER_64_433 vssd1 vccd1 vssd1 vccd1 SS_sky130_ef_sc_hd__decap_40_12
XFILLER_92_753 vssd1 vccd1 vccd1 vssd1 SS_sky130_fd_sc_hd__fill_2
XFILLER_64_477 vssd1 vccd1 vssd1 vccd1 SS_sky130_ef_sc_hd__decap_40_12
XTAP_TAPCELL_ROW_35_826 vccd1 vssd1 SS_sky130_fd_sc_hd__tapvpwrvgnd_1
XFILLER_51_105 vssd1 vccd1 vccd1 vssd1 SS_sky130_fd_sc_hd__fill_4
XTAP_TAPCELL_ROW_86_1592 vccd1 vssd1 SS_sky130_fd_sc_hd__tapvpwrvgnd_1
XFILLER_17_393 vssd1 vccd1 vssd1 vccd1 SS_sky130_ef_sc_hd__decap_40_12
XFILLER_51_149 vssd1 vccd1 vssd1 vccd1 SS_sky130_ef_sc_hd__decap_40_12
XFILLER_32_363 vccd1 vssd1 vccd1 vssd1 SS_sky130_fd_sc_hd__fill_1
XFILLER_20_525 vssd1 vccd1 vccd1 vssd1 SS_sky130_fd_sc_hd__fill_4
XFILLER_20_569 vssd1 vccd1 vssd1 vccd1 SS_sky130_ef_sc_hd__decap_40_12
X_0976_ vccd1 vssd1 vccd1 vssd1 _0976_/X _1521_/Q _1006_/B SS_sky130_fd_sc_hd__or2_2
XFILLER_118_446 vssd1 vccd1 vccd1 vssd1 SS_sky130_fd_sc_hd__fill_8
XFILLER_87_503 vccd1 vssd1 vccd1 vssd1 SS_sky130_fd_sc_hd__fill_1
XFILLER_59_205 vssd1 vccd1 vssd1 vccd1 SS_sky130_ef_sc_hd__decap_40_12
X_1528_ _1528_/Q _1752_/CLK _1528_/D vccd1 vssd1 vccd1 vssd1 SS_sky130_fd_sc_hd__dfxtp_2
XFILLER_19_15 vssd1 vccd1 vssd1 vccd1 SS_sky130_ef_sc_hd__decap_40_12
XFILLER_59_249 vssd1 vccd1 vssd1 vccd1 SS_sky130_ef_sc_hd__decap_40_12
XFILLER_87_569 vccd1 vssd1 vccd1 vssd1 SS_sky130_fd_sc_hd__fill_1
X_1459_ vssd1 vccd1 vccd1 vssd1 wire207/A input36/X _1755_/D _1459_/C1 _1458_/X SS_sky130_fd_sc_hd__o211a_2
XFILLER_101_324 vssd1 vccd1 vssd1 vccd1 SS_sky130_ef_sc_hd__decap_40_12
XFILLER_28_625 vssd1 vccd1 vssd1 vccd1 SS_sky130_ef_sc_hd__decap_40_12
XFILLER_27_113 vssd1 vccd1 vssd1 vccd1 SS_sky130_ef_sc_hd__decap_40_12
XFILLER_55_411 vccd1 vssd1 vccd1 vssd1 SS_sky130_fd_sc_hd__fill_1
XFILLER_67_293 vssd1 vccd1 vssd1 vccd1 SS_sky130_ef_sc_hd__decap_40_12
XFILLER_83_753 vssd1 vccd1 vssd1 vccd1 SS_sky130_ef_sc_hd__decap_40_12
XFILLER_16_809 vssd1 vccd1 vccd1 vssd1 SS_sky130_fd_sc_hd__fill_2
XFILLER_28_669 vssd1 vccd1 vssd1 vccd1 SS_sky130_ef_sc_hd__decap_40_12
XFILLER_43_617 vssd1 vccd1 vssd1 vccd1 SS_sky130_ef_sc_hd__decap_40_12
XPHY_EDGE_ROW_67_Left_206 vccd1 vssd1 vccd1 vssd1 SS_sky130_fd_sc_hd__decap_3
XFILLER_83_797 vssd1 vccd1 vssd1 vccd1 SS_sky130_ef_sc_hd__decap_40_12
XFILLER_35_69 vssd1 vccd1 vssd1 vccd1 SS_sky130_ef_sc_hd__decap_40_12
XFILLER_11_503 vccd1 vssd1 vccd1 vssd1 SS_sky130_fd_sc_hd__fill_1
XFILLER_51_683 vccd1 vssd1 vccd1 vssd1 SS_sky130_fd_sc_hd__fill_1
XFILLER_23_385 vssd1 vccd1 vccd1 vssd1 SS_sky130_fd_sc_hd__fill_4
XFILLER_50_193 vssd1 vccd1 vccd1 vssd1 SS_sky130_fd_sc_hd__fill_2
Xwire405 vccd1 vssd1 vssd1 vccd1 wire405/A analog_ctrl[76] SS_sky130_fd_sc_hd__buf_12
XFILLER_7_529 vssd1 vccd1 vssd1 vccd1 SS_sky130_ef_sc_hd__decap_40_12
XFILLER_51_57 vssd1 vccd1 vssd1 vccd1 SS_sky130_ef_sc_hd__decap_40_12
Xwire416 vccd1 vssd1 vssd1 vccd1 wire416/A analog_ctrl[65] SS_sky130_fd_sc_hd__buf_12
XFILLER_137_711 vccd1 vssd1 vccd1 vssd1 SS_sky130_fd_sc_hd__fill_1
XFILLER_136_265 vssd1 vccd1 vssd1 vccd1 SS_sky130_ef_sc_hd__decap_40_12
XPHY_EDGE_ROW_76_Left_215 vccd1 vssd1 vccd1 vssd1 SS_sky130_fd_sc_hd__decap_3
XFILLER_2_245 vssd1 vccd1 vccd1 vssd1 SS_sky130_fd_sc_hd__fill_4
XFILLER_4_3 vssd1 vccd1 vssd1 vccd1 SS_sky130_ef_sc_hd__decap_40_12
XTAP_TAPCELL_ROW_57_1160 vccd1 vssd1 SS_sky130_fd_sc_hd__tapvpwrvgnd_1
XFILLER_2_289 vssd1 vccd1 vssd1 vccd1 SS_sky130_ef_sc_hd__decap_40_12
XFILLER_120_622 vssd1 vccd1 vssd1 vccd1 SS_sky130_ef_sc_hd__decap_40_12
XFILLER_105_685 vssd1 vccd1 vssd1 vccd1 SS_sky130_ef_sc_hd__decap_40_12
XFILLER_116_83 vccd1 vssd1 vccd1 vssd1 SS_sky130_fd_sc_hd__fill_1
XFILLER_104_195 vccd1 vssd1 vccd1 vssd1 SS_sky130_fd_sc_hd__fill_1
XFILLER_59_783 vccd1 vssd1 vccd1 vssd1 SS_sky130_fd_sc_hd__fill_1
XFILLER_76_65 vssd1 vccd1 vssd1 vccd1 SS_sky130_ef_sc_hd__decap_40_12
XFILLER_120_699 vccd1 vssd1 vccd1 vssd1 SS_sky130_fd_sc_hd__fill_1
XFILLER_93_517 vssd1 vccd1 vssd1 vccd1 SS_sky130_ef_sc_hd__decap_40_12
XFILLER_46_433 vssd1 vccd1 vccd1 vssd1 SS_sky130_fd_sc_hd__fill_4
XFILLER_19_669 vssd1 vccd1 vccd1 vssd1 SS_sky130_fd_sc_hd__fill_2
XFILLER_46_477 vssd1 vccd1 vssd1 vccd1 SS_sky130_ef_sc_hd__decap_40_12
XPHY_EDGE_ROW_85_Left_224 vccd1 vssd1 vccd1 vssd1 SS_sky130_fd_sc_hd__decap_3
XFILLER_33_105 vssd1 vccd1 vccd1 vssd1 SS_sky130_fd_sc_hd__fill_4
XFILLER_92_53 vssd1 vccd1 vssd1 vccd1 SS_sky130_ef_sc_hd__decap_40_12
XFILLER_33_149 vssd1 vccd1 vssd1 vccd1 SS_sky130_ef_sc_hd__decap_40_12
XFILLER_61_447 vccd1 vssd1 vccd1 vssd1 SS_sky130_fd_sc_hd__fill_1
XFILLER_92_97 vssd1 vccd1 vssd1 vccd1 SS_sky130_ef_sc_hd__decap_40_12
XFILLER_14_363 vccd1 vssd1 vccd1 vssd1 SS_sky130_fd_sc_hd__fill_1
XFILLER_41_193 vssd1 vccd1 vssd1 vccd1 SS_sky130_ef_sc_hd__decap_40_12
X_0830_ vccd1 vssd1 vssd1 vccd1 _0828_/X _0829_/X _0926_/A2 _1487_/Q _1487_/D _1447_/C1
+ SS_sky130_fd_sc_hd__o221a_2
X_0761_ vccd1 vssd1 vccd1 vssd1 input4/X _0815_/B1 _1842_/A wire443/X _0761_/X SS_sky130_fd_sc_hd__a22o_2
XTAP_TAPCELL_ROW_40_895 vccd1 vssd1 SS_sky130_fd_sc_hd__tapvpwrvgnd_1
XFILLER_128_755 vccd1 vssd1 vccd1 vssd1 SS_sky130_fd_sc_hd__fill_1
XFILLER_127_221 vssd1 vccd1 vccd1 vssd1 SS_sky130_fd_sc_hd__fill_2
XFILLER_115_405 vssd1 vccd1 vssd1 vccd1 SS_sky130_ef_sc_hd__decap_40_12
XPHY_EDGE_ROW_94_Left_233 vccd1 vssd1 vccd1 vssd1 SS_sky130_fd_sc_hd__decap_3
XFILLER_115_449 vssd1 vccd1 vccd1 vssd1 SS_sky130_fd_sc_hd__fill_8
XFILLER_37_3 vssd1 vccd1 vssd1 vccd1 SS_sky130_ef_sc_hd__decap_40_12
XFILLER_69_503 vccd1 vssd1 vccd1 vssd1 SS_sky130_fd_sc_hd__fill_1
XFILLER_130_419 vccd1 vssd1 vccd1 vssd1 SS_sky130_fd_sc_hd__fill_1
X_1313_ vssd1 vccd1 vccd1 vssd1 _1319_/A2 input28/X _1684_/D _1437_/C1 _1312_/X SS_sky130_fd_sc_hd__o211a_2
XFILLER_57_709 vssd1 vccd1 vssd1 vccd1 SS_sky130_ef_sc_hd__decap_40_12
XFILLER_123_493 vssd1 vccd1 vccd1 vssd1 SS_sky130_fd_sc_hd__fill_8
XFILLER_110_121 vssd1 vccd1 vssd1 vccd1 SS_sky130_ef_sc_hd__decap_40_12
XFILLER_96_344 vssd1 vccd1 vccd1 vssd1 SS_sky130_fd_sc_hd__fill_8
X_1244_ vccd1 vssd1 vccd1 vssd1 _1244_/X _1651_/Q _1264_/B SS_sky130_fd_sc_hd__or2_2
XFILLER_110_165 vssd1 vccd1 vssd1 vccd1 SS_sky130_ef_sc_hd__decap_40_12
XFILLER_49_293 vssd1 vccd1 vssd1 vccd1 SS_sky130_ef_sc_hd__decap_40_12
Xclkbuf_2_1__f_wb_clk_i vssd1 vccd1 vssd1 vccd1 clkbuf_0_wb_clk_i/X clkload1/A SS_sky130_fd_sc_hd__clkbuf_16
XTAP_TAPCELL_ROW_88_1621 vccd1 vssd1 SS_sky130_fd_sc_hd__tapvpwrvgnd_1
XFILLER_80_701 vssd1 vccd1 vssd1 vccd1 SS_sky130_ef_sc_hd__decap_40_12
X_1175_ vssd1 vccd1 vccd1 vssd1 _1209_/A2 wire498/X _1617_/D _1431_/C1 _1174_/X SS_sky130_fd_sc_hd__o211a_2
XFILLER_25_617 vssd1 vccd1 vssd1 vccd1 SS_sky130_ef_sc_hd__decap_40_12
XFILLER_52_458 vssd1 vccd1 vssd1 vccd1 SS_sky130_ef_sc_hd__decap_40_12
XFILLER_33_661 vccd1 vssd1 vccd1 vssd1 SS_sky130_fd_sc_hd__fill_1
Xclkbuf_leaf_19_wb_clk_i _1752_/CLK clkbuf_leaf_7_wb_clk_i/A vccd1 vssd1 vssd1 vccd1
+ SS_sky130_fd_sc_hd__clkbuf_8
XFILLER_20_333 vssd1 vccd1 vssd1 vccd1 SS_sky130_ef_sc_hd__decap_40_12
XFILLER_32_193 vssd1 vccd1 vccd1 vssd1 SS_sky130_fd_sc_hd__fill_2
XFILLER_20_377 vssd1 vccd1 vssd1 vccd1 SS_sky130_ef_sc_hd__decap_40_12
XFILLER_118_221 vssd1 vccd1 vssd1 vccd1 SS_sky130_ef_sc_hd__decap_40_12
XTAP_TAPCELL_ROW_115_2028 vccd1 vssd1 SS_sky130_fd_sc_hd__tapvpwrvgnd_1
X_0959_ vssd1 vccd1 vccd1 vssd1 _0989_/A2 input47/X _1512_/D _1149_/C1 _0958_/X SS_sky130_fd_sc_hd__o211a_2
XFILLER_118_265 vssd1 vccd1 vssd1 vccd1 SS_sky130_ef_sc_hd__decap_40_12
XTAP_TAPCELL_ROW_99_1783 vccd1 vssd1 SS_sky130_fd_sc_hd__tapvpwrvgnd_1
XFILLER_134_736 vssd1 vccd1 vssd1 vccd1 SS_sky130_ef_sc_hd__decap_40_12
Xoutput130 vccd1 vssd1 wire314/A _1886_/X vccd1 vssd1 SS_sky130_fd_sc_hd__buf_4
Xoutput141 vccd1 vssd1 wire410/A _1642_/Q vccd1 vssd1 SS_sky130_fd_sc_hd__buf_4
Xoutput152 vccd1 vssd1 wire399/A _1653_/Q vccd1 vssd1 SS_sky130_fd_sc_hd__buf_4
XFILLER_0_727 vccd1 vssd1 vccd1 vssd1 SS_sky130_fd_sc_hd__fill_1
XFILLER_133_279 vccd1 vssd1 vccd1 vssd1 SS_sky130_fd_sc_hd__fill_1
Xoutput185 vccd1 vssd1 wire370/A _1497_/Q vccd1 vssd1 SS_sky130_fd_sc_hd__buf_4
Xoutput174 vccd1 vssd1 wire381/A _1487_/Q vccd1 vssd1 SS_sky130_fd_sc_hd__buf_4
Xoutput163 vccd1 vssd1 wire389/A _1663_/Q vccd1 vssd1 SS_sky130_fd_sc_hd__buf_4
Xoutput196 vccd1 vssd1 wire359/A _1478_/Q vccd1 vssd1 SS_sky130_fd_sc_hd__buf_4
XTAP_TAPCELL_ROW_110_1950 vccd1 vssd1 SS_sky130_fd_sc_hd__tapvpwrvgnd_1
XFILLER_102_633 vssd1 vccd1 vccd1 vssd1 SS_sky130_fd_sc_hd__fill_8
XFILLER_99_193 vssd1 vccd1 vssd1 vccd1 SS_sky130_ef_sc_hd__decap_40_12
XFILLER_75_517 vssd1 vccd1 vssd1 vccd1 SS_sky130_ef_sc_hd__decap_40_12
XFILLER_101_165 vssd1 vccd1 vccd1 vssd1 SS_sky130_fd_sc_hd__fill_2
XFILLER_28_433 vssd1 vccd1 vssd1 vccd1 SS_sky130_ef_sc_hd__decap_40_12
XFILLER_56_742 vssd1 vccd1 vssd1 vccd1 SS_sky130_ef_sc_hd__decap_40_12
XFILLER_83_561 vssd1 vccd1 vssd1 vccd1 SS_sky130_ef_sc_hd__decap_40_12
XFILLER_90_509 vssd1 vccd1 vssd1 vccd1 SS_sky130_ef_sc_hd__decap_40_12
XFILLER_15_105 vssd1 vccd1 vccd1 vssd1 SS_sky130_fd_sc_hd__fill_4
XFILLER_28_477 vssd1 vccd1 vssd1 vccd1 SS_sky130_ef_sc_hd__decap_40_12
XFILLER_15_149 vssd1 vccd1 vssd1 vccd1 SS_sky130_ef_sc_hd__decap_40_12
XFILLER_43_447 vccd1 vssd1 vccd1 vssd1 SS_sky130_fd_sc_hd__fill_1
XFILLER_70_233 vssd1 vccd1 vssd1 vccd1 SS_sky130_ef_sc_hd__decap_40_12
XFILLER_71_767 vssd1 vccd1 vccd1 vssd1 SS_sky130_fd_sc_hd__fill_8
XFILLER_102_41 vssd1 vccd1 vssd1 vccd1 SS_sky130_ef_sc_hd__decap_40_12
XTAP_TAPCELL_ROW_26_689 vccd1 vssd1 SS_sky130_fd_sc_hd__tapvpwrvgnd_1
XFILLER_70_277 vssd1 vccd1 vssd1 vccd1 SS_sky130_ef_sc_hd__decap_40_12
XFILLER_102_85 vssd1 vccd1 vssd1 vccd1 SS_sky130_ef_sc_hd__decap_40_12
XFILLER_8_805 vssd1 vccd1 vccd1 vssd1 SS_sky130_fd_sc_hd__fill_4
XFILLER_24_683 vssd1 vccd1 vccd1 vssd1 SS_sky130_fd_sc_hd__fill_2
XFILLER_11_333 vssd1 vccd1 vccd1 vssd1 SS_sky130_fd_sc_hd__fill_2
XFILLER_23_193 vssd1 vccd1 vssd1 vccd1 SS_sky130_ef_sc_hd__decap_40_12
XFILLER_7_337 vssd1 vccd1 vssd1 vccd1 SS_sky130_ef_sc_hd__decap_40_12
XFILLER_109_221 vssd1 vccd1 vccd1 vssd1 SS_sky130_fd_sc_hd__fill_2
Xwire279 vccd1 vssd1 vssd1 vccd1 wire279/A analog_ctrl[17] SS_sky130_fd_sc_hd__buf_12
Xwire268 vccd1 vssd1 vssd1 vccd1 wire268/A analog_ctrl[27] SS_sky130_fd_sc_hd__buf_12
XFILLER_125_714 vssd1 vccd1 vssd1 vccd1 SS_sky130_ef_sc_hd__decap_40_12
XFILLER_11_93 vssd1 vccd1 vssd1 vccd1 SS_sky130_ef_sc_hd__decap_40_12
XTAP_TAPCELL_ROW_55_1119 vccd1 vssd1 SS_sky130_fd_sc_hd__tapvpwrvgnd_1
XFILLER_125_769 vssd1 vccd1 vssd1 vccd1 SS_sky130_ef_sc_hd__decap_40_12
XFILLER_127_93 vssd1 vccd1 vssd1 vccd1 SS_sky130_ef_sc_hd__decap_40_12
XFILLER_78_377 vssd1 vccd1 vccd1 vssd1 SS_sky130_fd_sc_hd__fill_8
XFILLER_120_463 vssd1 vccd1 vssd1 vccd1 SS_sky130_ef_sc_hd__decap_40_12
XTAP_TAPCELL_ROW_6_392 vccd1 vssd1 SS_sky130_fd_sc_hd__tapvpwrvgnd_1
XFILLER_59_591 vccd1 vssd1 vccd1 vssd1 SS_sky130_fd_sc_hd__fill_1
XFILLER_47_753 vssd1 vccd1 vssd1 vccd1 SS_sky130_ef_sc_hd__decap_40_12
XFILLER_62_701 vssd1 vccd1 vssd1 vccd1 SS_sky130_ef_sc_hd__decap_40_12
XFILLER_47_797 vssd1 vccd1 vssd1 vccd1 SS_sky130_ef_sc_hd__decap_40_12
XTAP_TAPCELL_ROW_83_1540 vccd1 vssd1 SS_sky130_fd_sc_hd__tapvpwrvgnd_1
XFILLER_22_609 vssd1 vccd1 vccd1 vssd1 SS_sky130_fd_sc_hd__fill_2
XFILLER_34_469 vssd1 vccd1 vccd1 vssd1 SS_sky130_fd_sc_hd__fill_4
XTAP_TAPCELL_ROW_45_976 vccd1 vssd1 SS_sky130_fd_sc_hd__tapvpwrvgnd_1
XFILLER_61_277 vssd1 vccd1 vccd1 vssd1 SS_sky130_fd_sc_hd__fill_2
XTAP_TAPCELL_ROW_83_1551 vccd1 vssd1 SS_sky130_fd_sc_hd__tapvpwrvgnd_1
XFILLER_14_193 vssd1 vccd1 vccd1 vssd1 SS_sky130_fd_sc_hd__fill_2
X_1862_ vccd1 vssd1 _1862_/X _1862_/A vccd1 vssd1 SS_sky130_fd_sc_hd__buf_2
Xinput10 vssd1 vccd1 vccd1 vssd1 adc_data[7] input10/X SS_sky130_fd_sc_hd__clkdlybuf4s25_1
X_0813_ vccd1 vssd1 vccd1 vssd1 _1549_/Q wire424/X _1888_/A wire454/X _0813_/X SS_sky130_fd_sc_hd__a22o_2
Xinput21 vssd1 vccd1 wire501/A input21/A vccd1 vssd1 SS_sky130_fd_sc_hd__buf_1
Xinput43 vssd1 vccd1 vccd1 vssd1 input43/A input43/X SS_sky130_fd_sc_hd__clkdlybuf4s25_1
Xinput32 vssd1 vccd1 vccd1 vssd1 input32/A input32/X SS_sky130_fd_sc_hd__clkdlybuf4s25_1
XFILLER_128_585 vssd1 vccd1 vccd1 vssd1 SS_sky130_fd_sc_hd__fill_2
X_0744_ vssd1 vccd1 vssd1 vccd1 _0755_/A _0744_/X _0755_/C _0754_/D _0755_/B SS_sky130_fd_sc_hd__and4bb_2
Xhold805 hold805/X _1491_/Q vccd1 vssd1 vssd1 vccd1 SS_sky130_fd_sc_hd__dlygate4sd3_1
XFILLER_116_769 vssd1 vccd1 vssd1 vccd1 SS_sky130_ef_sc_hd__decap_40_12
XFILLER_115_279 vccd1 vssd1 vccd1 vssd1 SS_sky130_fd_sc_hd__fill_1
XFILLER_130_249 vssd1 vccd1 vccd1 vssd1 SS_sky130_fd_sc_hd__fill_2
XFILLER_57_517 vssd1 vccd1 vssd1 vccd1 SS_sky130_ef_sc_hd__decap_40_12
XFILLER_96_141 vssd1 vccd1 vssd1 vccd1 SS_sky130_ef_sc_hd__decap_40_12
XFILLER_123_18 vssd1 vccd1 vssd1 vccd1 SS_sky130_ef_sc_hd__decap_40_12
XFILLER_111_485 vssd1 vccd1 vssd1 vccd1 SS_sky130_ef_sc_hd__decap_40_12
XFILLER_97_697 vssd1 vccd1 vccd1 vssd1 SS_sky130_fd_sc_hd__fill_8
XFILLER_38_742 vssd1 vccd1 vssd1 vccd1 SS_sky130_ef_sc_hd__decap_40_12
X_1227_ vssd1 vccd1 vccd1 vssd1 _1261_/A2 wire496/X _1642_/D _1425_/C1 _1226_/X SS_sky130_fd_sc_hd__o211a_2
X_1158_ vccd1 vssd1 vccd1 vssd1 _1158_/X _1869_/A _1186_/B SS_sky130_fd_sc_hd__or2_2
XFILLER_53_701 vssd1 vccd1 vssd1 vccd1 SS_sky130_ef_sc_hd__decap_40_12
XFILLER_65_561 vssd1 vccd1 vssd1 vccd1 SS_sky130_ef_sc_hd__decap_40_12
XFILLER_25_447 vccd1 vssd1 vccd1 vssd1 SS_sky130_fd_sc_hd__fill_1
XFILLER_52_233 vssd1 vccd1 vssd1 vccd1 SS_sky130_ef_sc_hd__decap_40_12
XFILLER_53_745 vssd1 vccd1 vccd1 vssd1 SS_sky130_fd_sc_hd__fill_2
XFILLER_80_531 vccd1 vssd1 vccd1 vssd1 SS_sky130_fd_sc_hd__fill_1
XFILLER_80_553 vccd1 vssd1 vccd1 vssd1 SS_sky130_fd_sc_hd__fill_1
XFILLER_13_609 vssd1 vccd1 vccd1 vssd1 SS_sky130_fd_sc_hd__fill_4
XFILLER_40_417 vssd1 vccd1 vccd1 vssd1 SS_sky130_fd_sc_hd__fill_2
X_1089_ vssd1 vccd1 vccd1 vssd1 wire239/X input46/X _1575_/D _1151_/C1 _1088_/X SS_sky130_fd_sc_hd__o211a_2
XFILLER_52_277 vssd1 vccd1 vssd1 vccd1 SS_sky130_ef_sc_hd__decap_40_12
XTAP_TAPCELL_ROW_23_648 vccd1 vssd1 SS_sky130_fd_sc_hd__tapvpwrvgnd_1
XFILLER_20_141 vssd1 vccd1 vssd1 vccd1 SS_sky130_ef_sc_hd__decap_40_12
XFILLER_21_653 vssd1 vccd1 vssd1 vccd1 SS_sky130_ef_sc_hd__decap_40_12
XFILLER_32_15 vssd1 vccd1 vssd1 vccd1 SS_sky130_ef_sc_hd__decap_40_12
XFILLER_4_307 vccd1 vssd1 vccd1 vssd1 SS_sky130_fd_sc_hd__fill_1
XFILLER_119_541 vssd1 vccd1 vssd1 vccd1 SS_sky130_ef_sc_hd__decap_40_12
XFILLER_134_522 vssd1 vccd1 vccd1 vssd1 SS_sky130_fd_sc_hd__fill_2
XFILLER_119_585 vssd1 vccd1 vssd1 vccd1 SS_sky130_ef_sc_hd__decap_40_12
XFILLER_106_6 vssd1 vccd1 vssd1 vccd1 SS_sky130_ef_sc_hd__decap_40_12
XFILLER_121_205 vssd1 vccd1 vssd1 vccd1 SS_sky130_ef_sc_hd__decap_40_12
XFILLER_121_249 vssd1 vccd1 vssd1 vccd1 SS_sky130_ef_sc_hd__decap_40_12
XTAP_TAPCELL_ROW_128_2219 vccd1 vssd1 SS_sky130_fd_sc_hd__tapvpwrvgnd_1
XFILLER_102_452 vssd1 vccd1 vssd1 vccd1 SS_sky130_ef_sc_hd__decap_40_12
XTAP_TAPCELL_ROW_50_1049 vccd1 vssd1 SS_sky130_fd_sc_hd__tapvpwrvgnd_1
XTAP_TAPCELL_ROW_3_340 vccd1 vssd1 SS_sky130_fd_sc_hd__tapvpwrvgnd_1
XTAP_TAPCELL_ROW_3_351 vccd1 vssd1 SS_sky130_fd_sc_hd__tapvpwrvgnd_1
XFILLER_29_797 vssd1 vccd1 vssd1 vccd1 SS_sky130_ef_sc_hd__decap_40_12
XFILLER_44_701 vssd1 vccd1 vccd1 vssd1 SS_sky130_fd_sc_hd__fill_8
XFILLER_83_391 vccd1 vssd1 vccd1 vssd1 SS_sky130_fd_sc_hd__fill_1
XFILLER_16_469 vssd1 vccd1 vccd1 vssd1 SS_sky130_fd_sc_hd__fill_4
XFILLER_31_417 vssd1 vccd1 vssd1 vccd1 SS_sky130_ef_sc_hd__decap_40_12
XFILLER_43_277 vssd1 vccd1 vccd1 vssd1 SS_sky130_fd_sc_hd__fill_2
XTAP_TAPCELL_ROW_42_924 vccd1 vssd1 SS_sky130_fd_sc_hd__tapvpwrvgnd_1
XTAP_TAPCELL_ROW_42_935 vccd1 vssd1 SS_sky130_fd_sc_hd__tapvpwrvgnd_1
XTAP_TAPCELL_ROW_65_1270 vccd1 vssd1 SS_sky130_fd_sc_hd__tapvpwrvgnd_1
XTAP_TAPCELL_ROW_65_1281 vccd1 vssd1 SS_sky130_fd_sc_hd__tapvpwrvgnd_1
XFILLER_8_613 vssd1 vccd1 vssd1 vccd1 SS_sky130_ef_sc_hd__decap_40_12
XFILLER_12_697 vssd1 vccd1 vccd1 vssd1 SS_sky130_fd_sc_hd__fill_2
XFILLER_8_657 vssd1 vccd1 vssd1 vccd1 SS_sky130_ef_sc_hd__decap_40_12
XFILLER_7_167 vccd1 vssd1 vccd1 vssd1 SS_sky130_fd_sc_hd__fill_1
XFILLER_22_81 vssd1 vccd1 vccd1 vssd1 SS_sky130_fd_sc_hd__fill_2
XFILLER_4_841 vccd1 vssd1 vccd1 vssd1 SS_sky130_fd_sc_hd__fill_1
XFILLER_98_41 vssd1 vccd1 vssd1 vccd1 SS_sky130_ef_sc_hd__decap_40_12
XFILLER_98_85 vssd1 vccd1 vssd1 vccd1 SS_sky130_ef_sc_hd__decap_40_12
XFILLER_3_373 vssd1 vccd1 vssd1 vccd1 SS_sky130_ef_sc_hd__decap_40_12
XFILLER_112_249 vssd1 vccd1 vccd1 vssd1 SS_sky130_fd_sc_hd__fill_2
XFILLER_21_6 vssd1 vccd1 vssd1 vccd1 SS_sky130_ef_sc_hd__decap_40_12
XFILLER_78_141 vssd1 vccd1 vssd1 vccd1 SS_sky130_ef_sc_hd__decap_40_12
XFILLER_94_601 vssd1 vccd1 vccd1 vssd1 SS_sky130_fd_sc_hd__fill_2
XFILLER_79_697 vssd1 vccd1 vssd1 vccd1 SS_sky130_ef_sc_hd__decap_40_12
XFILLER_93_111 vccd1 vssd1 vccd1 vssd1 SS_sky130_fd_sc_hd__fill_1
XFILLER_66_347 vssd1 vccd1 vccd1 vssd1 SS_sky130_fd_sc_hd__fill_4
XFILLER_120_293 vssd1 vccd1 vccd1 vssd1 SS_sky130_fd_sc_hd__fill_2
XFILLER_81_328 vccd1 vssd1 vccd1 vssd1 SS_sky130_fd_sc_hd__fill_1
X_1012_ vccd1 vssd1 _1012_/A _1012_/X _1409_/B vccd1 vssd1 SS_sky130_fd_sc_hd__and2_2
XFILLER_34_233 vssd1 vccd1 vssd1 vccd1 SS_sky130_ef_sc_hd__decap_40_12
XFILLER_35_745 vccd1 vssd1 vccd1 vssd1 SS_sky130_fd_sc_hd__fill_1
XFILLER_62_531 vccd1 vssd1 vccd1 vssd1 SS_sky130_fd_sc_hd__fill_1
XFILLER_22_417 vssd1 vccd1 vccd1 vssd1 SS_sky130_fd_sc_hd__fill_2
XFILLER_34_277 vssd1 vccd1 vssd1 vccd1 SS_sky130_ef_sc_hd__decap_40_12
XFILLER_50_737 vssd1 vccd1 vccd1 vssd1 SS_sky130_fd_sc_hd__fill_2
XFILLER_50_748 vssd1 vccd1 vccd1 vssd1 SS_sky130_fd_sc_hd__fill_8
XTAP_TAPCELL_ROW_20_607 vccd1 vssd1 SS_sky130_fd_sc_hd__tapvpwrvgnd_1
XFILLER_8_83 vccd1 vssd1 vccd1 vssd1 SS_sky130_fd_sc_hd__fill_1
X_1845_ vccd1 vssd1 _1845_/X _1845_/A vccd1 vssd1 SS_sky130_fd_sc_hd__buf_2
Xhold602 _1432_/A _1906_/A vccd1 vssd1 vssd1 vccd1 SS_sky130_fd_sc_hd__dlygate4sd3_1
XFILLER_118_29 vssd1 vccd1 vssd1 vccd1 SS_sky130_ef_sc_hd__decap_40_12
XFILLER_118_18 vssd1 vccd1 vccd1 vssd1 SS_sky130_fd_sc_hd__fill_8
XFILLER_116_522 vssd1 vccd1 vccd1 vssd1 SS_sky130_fd_sc_hd__fill_8
XTAP_TAPCELL_ROW_96_1742 vccd1 vssd1 SS_sky130_fd_sc_hd__tapvpwrvgnd_1
Xhold635 _1610_/D _1161_/X vccd1 vssd1 vssd1 vccd1 SS_sky130_fd_sc_hd__dlygate4sd3_1
Xhold624 _0966_/A _1516_/Q vccd1 vssd1 vssd1 vccd1 SS_sky130_fd_sc_hd__dlygate4sd3_1
XFILLER_116_533 vssd1 vccd1 vssd1 vccd1 SS_sky130_ef_sc_hd__decap_40_12
Xhold613 _1420_/A _1900_/A vccd1 vssd1 vssd1 vccd1 SS_sky130_fd_sc_hd__dlygate4sd3_1
XFILLER_131_503 vccd1 vssd1 vccd1 vssd1 SS_sky130_fd_sc_hd__fill_1
Xhold657 _1074_/A _1569_/Q vccd1 vssd1 vssd1 vccd1 SS_sky130_fd_sc_hd__dlygate4sd3_1
Xhold646 input43/A wbs_dat_i[30] vccd1 vssd1 vssd1 vccd1 SS_sky130_fd_sc_hd__dlygate4sd3_1
Xhold668 input33/A wbs_dat_i[21] vccd1 vssd1 vssd1 vccd1 SS_sky130_fd_sc_hd__dlygate4sd3_1
Xhold679 _1466_/A _1759_/Q vccd1 vssd1 vssd1 vccd1 SS_sky130_fd_sc_hd__dlygate4sd3_1
XFILLER_103_205 vssd1 vccd1 vssd1 vccd1 SS_sky130_ef_sc_hd__decap_40_12
XFILLER_89_439 vssd1 vccd1 vccd1 vssd1 SS_sky130_fd_sc_hd__fill_8
XFILLER_103_249 vssd1 vccd1 vssd1 vccd1 SS_sky130_ef_sc_hd__decap_40_12
XFILLER_97_461 vssd1 vccd1 vssd1 vccd1 SS_sky130_ef_sc_hd__decap_40_12
XFILLER_27_15 vssd1 vccd1 vssd1 vccd1 SS_sky130_ef_sc_hd__decap_40_12
XFILLER_84_133 vssd1 vccd1 vccd1 vssd1 SS_sky130_fd_sc_hd__fill_4
XFILLER_111_293 vssd1 vccd1 vssd1 vccd1 SS_sky130_ef_sc_hd__decap_40_12
XFILLER_26_701 vssd1 vccd1 vccd1 vssd1 SS_sky130_fd_sc_hd__fill_8
XTAP_TAPCELL_ROW_28_718 vccd1 vssd1 SS_sky130_fd_sc_hd__tapvpwrvgnd_1
Xclkbuf_leaf_34_wb_clk_i _1748_/CLK clkload0/A vccd1 vssd1 vssd1 vccd1 SS_sky130_fd_sc_hd__clkbuf_8
XFILLER_84_177 vssd1 vccd1 vssd1 vccd1 SS_sky130_ef_sc_hd__decap_40_12
XTAP_TAPCELL_ROW_123_2138 vccd1 vssd1 SS_sky130_fd_sc_hd__tapvpwrvgnd_1
XTAP_TAPCELL_ROW_123_2149 vccd1 vssd1 SS_sky130_fd_sc_hd__tapvpwrvgnd_1
XPHY_EDGE_ROW_40_Left_179 vccd1 vssd1 vccd1 vssd1 SS_sky130_fd_sc_hd__decap_3
XFILLER_13_417 vssd1 vccd1 vssd1 vccd1 SS_sky130_ef_sc_hd__decap_40_12
XFILLER_25_277 vssd1 vccd1 vccd1 vssd1 SS_sky130_fd_sc_hd__fill_2
XFILLER_53_597 vssd1 vccd1 vccd1 vssd1 SS_sky130_fd_sc_hd__fill_8
XTAP_TAPCELL_ROW_105_1882 vccd1 vssd1 SS_sky130_fd_sc_hd__tapvpwrvgnd_1
XTAP_TAPCELL_ROW_105_1871 vccd1 vssd1 SS_sky130_fd_sc_hd__tapvpwrvgnd_1
XFILLER_43_69 vssd1 vccd1 vssd1 vccd1 SS_sky130_ef_sc_hd__decap_40_12
XFILLER_21_461 vssd1 vccd1 vssd1 vccd1 SS_sky130_ef_sc_hd__decap_40_12
XFILLER_138_113 vssd1 vccd1 vccd1 vssd1 SS_sky130_fd_sc_hd__fill_2
XTAP_TAPCELL_ROW_138_2381 vccd1 vssd1 SS_sky130_fd_sc_hd__tapvpwrvgnd_1
XTAP_TAPCELL_ROW_138_2392 vccd1 vssd1 SS_sky130_fd_sc_hd__tapvpwrvgnd_1
XTAP_TAPCELL_ROW_138_2370 vccd1 vssd1 SS_sky130_fd_sc_hd__tapvpwrvgnd_1
XFILLER_119_371 vssd1 vccd1 vssd1 vccd1 SS_sky130_ef_sc_hd__decap_40_12
XFILLER_4_137 vssd1 vccd1 vccd1 vssd1 SS_sky130_fd_sc_hd__fill_2
XFILLER_134_330 vssd1 vccd1 vccd1 vssd1 SS_sky130_fd_sc_hd__fill_2
XFILLER_119_393 vccd1 vssd1 vccd1 vssd1 SS_sky130_fd_sc_hd__fill_1
XFILLER_107_555 vssd1 vccd1 vccd1 vssd1 SS_sky130_fd_sc_hd__fill_4
XFILLER_104_3 vssd1 vccd1 vssd1 vccd1 SS_sky130_ef_sc_hd__decap_40_12
XTAP_TAPCELL_ROW_8_421 vccd1 vssd1 SS_sky130_fd_sc_hd__tapvpwrvgnd_1
XFILLER_134_352 vssd1 vccd1 vccd1 vssd1 SS_sky130_fd_sc_hd__fill_4
XFILLER_0_321 vssd1 vccd1 vssd1 vccd1 SS_sky130_ef_sc_hd__decap_40_12
XFILLER_1_833 vssd1 vccd1 vccd1 vssd1 SS_sky130_fd_sc_hd__fill_4
XFILLER_122_558 vssd1 vccd1 vssd1 vccd1 SS_sky130_ef_sc_hd__decap_40_12
XFILLER_68_77 vssd1 vccd1 vccd1 vssd1 SS_sky130_fd_sc_hd__fill_4
XFILLER_76_601 vssd1 vccd1 vccd1 vssd1 SS_sky130_fd_sc_hd__fill_8
XFILLER_0_365 vssd1 vccd1 vssd1 vccd1 SS_sky130_ef_sc_hd__decap_40_12
XFILLER_75_111 vccd1 vssd1 vccd1 vssd1 SS_sky130_fd_sc_hd__fill_1
XFILLER_76_634 vssd1 vccd1 vccd1 vssd1 SS_sky130_fd_sc_hd__fill_8
XFILLER_103_783 vccd1 vssd1 vccd1 vssd1 SS_sky130_fd_sc_hd__fill_1
XFILLER_76_645 vssd1 vccd1 vssd1 vccd1 SS_sky130_ef_sc_hd__decap_40_12
XFILLER_124_83 vccd1 vssd1 vccd1 vssd1 SS_sky130_fd_sc_hd__fill_1
XFILLER_29_561 vssd1 vccd1 vssd1 vccd1 SS_sky130_ef_sc_hd__decap_40_12
XFILLER_63_317 vssd1 vccd1 vccd1 vssd1 SS_sky130_fd_sc_hd__fill_8
XTAP_TAPCELL_ROW_67_1310 vccd1 vssd1 SS_sky130_fd_sc_hd__tapvpwrvgnd_1
XFILLER_84_65 vssd1 vccd1 vssd1 vccd1 SS_sky130_ef_sc_hd__decap_40_12
XFILLER_91_615 vccd1 vssd1 vccd1 vssd1 SS_sky130_fd_sc_hd__fill_1
XFILLER_16_233 vssd1 vccd1 vssd1 vccd1 SS_sky130_ef_sc_hd__decap_40_12
XFILLER_44_531 vccd1 vssd1 vccd1 vssd1 SS_sky130_fd_sc_hd__fill_1
XFILLER_17_81 vssd1 vccd1 vssd1 vccd1 SS_sky130_ef_sc_hd__decap_40_12
XFILLER_16_277 vssd1 vccd1 vssd1 vccd1 SS_sky130_ef_sc_hd__decap_40_12
XFILLER_31_225 vssd1 vccd1 vssd1 vccd1 SS_sky130_ef_sc_hd__decap_40_12
XFILLER_44_586 vssd1 vccd1 vccd1 vssd1 SS_sky130_fd_sc_hd__fill_2
XFILLER_8_421 vssd1 vccd1 vssd1 vccd1 SS_sky130_ef_sc_hd__decap_40_12
XFILLER_40_781 vssd1 vccd1 vccd1 vssd1 SS_sky130_fd_sc_hd__fill_8
XFILLER_129_113 vssd1 vccd1 vssd1 vccd1 SS_sky130_ef_sc_hd__decap_40_12
X_1630_ _1630_/Q _1760_/CLK _1630_/D vccd1 vssd1 vccd1 vssd1 SS_sky130_fd_sc_hd__dfxtp_2
XTAP_TAPCELL_ROW_78_1472 vccd1 vssd1 SS_sky130_fd_sc_hd__tapvpwrvgnd_1
XFILLER_125_341 vccd1 vssd1 vccd1 vssd1 SS_sky130_fd_sc_hd__fill_1
XFILLER_113_503 vccd1 vssd1 vccd1 vssd1 SS_sky130_fd_sc_hd__fill_1
X_1561_ _1561_/Q _1753_/CLK _1561_/D vccd1 vssd1 vccd1 vssd1 SS_sky130_fd_sc_hd__dfxtp_2
XFILLER_99_726 vssd1 vccd1 vccd1 vssd1 SS_sky130_fd_sc_hd__fill_2
XFILLER_3_181 vssd1 vccd1 vssd1 vccd1 SS_sky130_ef_sc_hd__decap_40_12
XFILLER_4_693 vssd1 vccd1 vccd1 vssd1 SS_sky130_fd_sc_hd__fill_4
X_1492_ _1492_/Q _1742_/CLK _1492_/D vccd1 vssd1 vccd1 vssd1 SS_sky130_fd_sc_hd__dfxtp_2
XFILLER_79_461 vccd1 vssd1 vccd1 vssd1 SS_sky130_fd_sc_hd__fill_1
XTAP_TAPCELL_ROW_91_1661 vccd1 vssd1 SS_sky130_fd_sc_hd__tapvpwrvgnd_1
XTAP_TAPCELL_ROW_91_1672 vccd1 vssd1 SS_sky130_fd_sc_hd__tapvpwrvgnd_1
XFILLER_66_133 vssd1 vccd1 vccd1 vssd1 SS_sky130_fd_sc_hd__fill_4
XFILLER_94_431 vssd1 vccd1 vssd1 vccd1 SS_sky130_ef_sc_hd__decap_40_12
XFILLER_66_177 vssd1 vccd1 vssd1 vccd1 SS_sky130_ef_sc_hd__decap_40_12
XFILLER_82_637 vssd1 vccd1 vccd1 vssd1 SS_sky130_fd_sc_hd__fill_4
XFILLER_94_464 vssd1 vccd1 vssd1 vccd1 SS_sky130_ef_sc_hd__decap_40_12
XFILLER_81_125 vssd1 vccd1 vssd1 vccd1 SS_sky130_ef_sc_hd__decap_40_12
XFILLER_23_715 vssd1 vccd1 vssd1 vccd1 SS_sky130_ef_sc_hd__decap_40_12
XFILLER_81_169 vssd1 vccd1 vssd1 vccd1 SS_sky130_ef_sc_hd__decap_40_12
XFILLER_90_692 vssd1 vccd1 vccd1 vssd1 SS_sky130_fd_sc_hd__fill_8
XFILLER_50_545 vssd1 vccd1 vccd1 vssd1 SS_sky130_fd_sc_hd__fill_4
XTAP_TAPCELL_ROW_33_798 vccd1 vssd1 SS_sky130_fd_sc_hd__tapvpwrvgnd_1
XFILLER_50_589 vssd1 vccd1 vccd1 vssd1 SS_sky130_fd_sc_hd__fill_4
XFILLER_129_39 vssd1 vccd1 vssd1 vccd1 SS_sky130_ef_sc_hd__decap_40_12
X_1828_ vccd1 vssd1 _1828_/X _1828_/A vccd1 vssd1 SS_sky130_fd_sc_hd__buf_2
XFILLER_135_105 vssd1 vccd1 vccd1 vssd1 SS_sky130_fd_sc_hd__fill_4
XFILLER_135_149 vssd1 vccd1 vssd1 vccd1 SS_sky130_ef_sc_hd__decap_40_12
XFILLER_116_330 vssd1 vccd1 vssd1 vccd1 SS_sky130_ef_sc_hd__decap_40_12
XPHY_EDGE_ROW_111_Right_111 vccd1 vssd1 vccd1 vssd1 SS_sky130_fd_sc_hd__decap_3
X_1759_ _1759_/Q _1762_/CLK _1759_/D vccd1 vssd1 vccd1 vssd1 SS_sky130_fd_sc_hd__dfxtp_2
XFILLER_89_225 vssd1 vccd1 vssd1 vccd1 SS_sky130_ef_sc_hd__decap_40_12
XFILLER_104_525 vccd1 vssd1 vccd1 vssd1 SS_sky130_fd_sc_hd__fill_1
XFILLER_58_601 vssd1 vccd1 vssd1 vccd1 SS_sky130_ef_sc_hd__decap_40_12
XFILLER_57_111 vccd1 vssd1 vccd1 vssd1 SS_sky130_fd_sc_hd__fill_1
XFILLER_98_781 vssd1 vccd1 vssd1 vccd1 SS_sky130_ef_sc_hd__decap_40_12
XFILLER_58_645 vssd1 vccd1 vssd1 vccd1 SS_sky130_ef_sc_hd__decap_40_12
XFILLER_45_317 vssd1 vccd1 vssd1 vccd1 SS_sky130_ef_sc_hd__decap_40_12
XFILLER_73_615 vccd1 vssd1 vccd1 vssd1 SS_sky130_fd_sc_hd__fill_1
XTAP_TAPCELL_ROW_107_1911 vccd1 vssd1 SS_sky130_fd_sc_hd__tapvpwrvgnd_1
XTAP_TAPCELL_ROW_107_1900 vccd1 vssd1 SS_sky130_fd_sc_hd__tapvpwrvgnd_1
XFILLER_100_786 vssd1 vccd1 vssd1 vccd1 SS_sky130_ef_sc_hd__decap_40_12
XFILLER_26_531 vccd1 vssd1 vccd1 vssd1 SS_sky130_fd_sc_hd__fill_1
XFILLER_85_497 vssd1 vccd1 vccd1 vssd1 SS_sky130_fd_sc_hd__fill_4
XTAP_TAPCELL_ROW_49_1040 vccd1 vssd1 SS_sky130_fd_sc_hd__tapvpwrvgnd_1
XFILLER_60_309 vssd1 vccd1 vssd1 vccd1 SS_sky130_ef_sc_hd__decap_40_12
XFILLER_13_225 vssd1 vccd1 vssd1 vccd1 SS_sky130_ef_sc_hd__decap_40_12
XFILLER_14_737 vssd1 vccd1 vssd1 vccd1 SS_sky130_ef_sc_hd__decap_40_12
XFILLER_53_361 vssd1 vccd1 vssd1 vccd1 SS_sky130_ef_sc_hd__decap_40_12
XFILLER_41_556 vssd1 vccd1 vccd1 vssd1 SS_sky130_fd_sc_hd__fill_4
XFILLER_110_41 vssd1 vccd1 vssd1 vccd1 SS_sky130_ef_sc_hd__decap_40_12
XFILLER_110_85 vssd1 vccd1 vssd1 vccd1 SS_sky130_ef_sc_hd__decap_40_12
XTAP_TAPCELL_ROW_11_459 vccd1 vssd1 SS_sky130_fd_sc_hd__tapvpwrvgnd_1
XFILLER_127_617 vssd1 vccd1 vccd1 vssd1 SS_sky130_fd_sc_hd__fill_4
XFILLER_123_823 vccd1 vssd1 vccd1 vssd1 SS_sky130_fd_sc_hd__fill_1
XFILLER_123_801 vccd1 vssd1 vccd1 vssd1 SS_sky130_fd_sc_hd__fill_1
XFILLER_122_311 vccd1 vssd1 vccd1 vssd1 SS_sky130_fd_sc_hd__fill_1
XFILLER_107_385 vssd1 vccd1 vccd1 vssd1 SS_sky130_fd_sc_hd__fill_4
XFILLER_1_641 vssd1 vccd1 vssd1 vccd1 SS_sky130_ef_sc_hd__decap_40_12
XFILLER_134_193 vssd1 vccd1 vccd1 vssd1 SS_sky130_fd_sc_hd__fill_2
XFILLER_122_344 vssd1 vccd1 vccd1 vssd1 SS_sky130_fd_sc_hd__fill_8
XFILLER_110_506 vssd1 vccd1 vssd1 vccd1 SS_sky130_ef_sc_hd__decap_40_12
XFILLER_1_685 vssd1 vccd1 vssd1 vccd1 SS_sky130_ef_sc_hd__decap_40_12
XTAP_TAPCELL_ROW_73_1391 vccd1 vssd1 SS_sky130_fd_sc_hd__tapvpwrvgnd_1
XFILLER_89_781 vssd1 vccd1 vccd1 vssd1 SS_sky130_fd_sc_hd__fill_2
XFILLER_122_377 vssd1 vccd1 vssd1 vccd1 SS_sky130_ef_sc_hd__decap_40_12
XFILLER_95_217 vssd1 vccd1 vccd1 vssd1 SS_sky130_fd_sc_hd__fill_4
XFILLER_0_195 vccd1 vssd1 vccd1 vssd1 SS_sky130_fd_sc_hd__fill_1
XFILLER_48_133 vssd1 vccd1 vccd1 vssd1 SS_sky130_fd_sc_hd__fill_4
XFILLER_135_93 vssd1 vccd1 vssd1 vccd1 SS_sky130_ef_sc_hd__decap_40_12
XFILLER_48_177 vssd1 vccd1 vssd1 vccd1 SS_sky130_ef_sc_hd__decap_40_12
XFILLER_76_475 vccd1 vssd1 vccd1 vssd1 SS_sky130_fd_sc_hd__fill_1
XFILLER_29_391 vccd1 vssd1 vccd1 vssd1 SS_sky130_fd_sc_hd__fill_1
XFILLER_63_125 vssd1 vccd1 vssd1 vccd1 SS_sky130_ef_sc_hd__decap_40_12
XFILLER_91_445 vssd1 vccd1 vccd1 vssd1 SS_sky130_fd_sc_hd__fill_2
XFILLER_17_553 vssd1 vccd1 vccd1 vssd1 SS_sky130_fd_sc_hd__fill_4
XFILLER_63_169 vssd1 vccd1 vssd1 vccd1 SS_sky130_ef_sc_hd__decap_40_12
XFILLER_17_597 vssd1 vccd1 vssd1 vccd1 SS_sky130_ef_sc_hd__decap_40_12
XFILLER_32_501 vssd1 vccd1 vssd1 vccd1 SS_sky130_ef_sc_hd__decap_40_12
XFILLER_44_361 vssd1 vccd1 vccd1 vssd1 SS_sky130_fd_sc_hd__fill_2
XFILLER_72_670 vssd1 vccd1 vssd1 vccd1 SS_sky130_ef_sc_hd__decap_40_12
XFILLER_32_545 vssd1 vccd1 vssd1 vccd1 SS_sky130_ef_sc_hd__decap_40_12
XFILLER_13_770 vssd1 vccd1 vssd1 vccd1 SS_sky130_ef_sc_hd__decap_40_12
X_0992_ vccd1 vssd1 vccd1 vssd1 _0992_/X _0992_/A _1008_/B SS_sky130_fd_sc_hd__or2_2
XFILLER_9_741 vssd1 vccd1 vssd1 vccd1 SS_sky130_ef_sc_hd__decap_40_12
XTAP_TAPCELL_ROW_30_746 vccd1 vssd1 SS_sky130_fd_sc_hd__tapvpwrvgnd_1
XFILLER_8_251 vccd1 vssd1 vccd1 vssd1 SS_sky130_fd_sc_hd__fill_1
XFILLER_9_785 vssd1 vccd1 vssd1 vccd1 SS_sky130_ef_sc_hd__decap_40_12
XTAP_TAPCELL_ROW_30_757 vccd1 vssd1 SS_sky130_fd_sc_hd__tapvpwrvgnd_1
XFILLER_117_105 vssd1 vccd1 vccd1 vssd1 SS_sky130_fd_sc_hd__fill_4
XFILLER_67_3 vssd1 vccd1 vssd1 vccd1 SS_sky130_ef_sc_hd__decap_40_12
XFILLER_133_609 vssd1 vccd1 vccd1 vssd1 SS_sky130_fd_sc_hd__fill_4
XFILLER_117_149 vssd1 vccd1 vssd1 vccd1 SS_sky130_ef_sc_hd__decap_40_12
XTAP_TAPCELL_ROW_93_1701 vccd1 vssd1 SS_sky130_fd_sc_hd__tapvpwrvgnd_1
X_1613_ _1873_/A clkload7/A _1613_/D vccd1 vssd1 vccd1 vssd1 SS_sky130_fd_sc_hd__dfxtp_2
XFILLER_5_51 vssd1 vccd1 vccd1 vssd1 SS_sky130_fd_sc_hd__fill_4
X_1544_ _1831_/A _1576_/CLK _1544_/D vccd1 vssd1 vccd1 vssd1 SS_sky130_fd_sc_hd__dfxtp_2
XFILLER_99_545 vssd1 vccd1 vssd1 vccd1 SS_sky130_ef_sc_hd__decap_40_12
XFILLER_87_729 vssd1 vccd1 vssd1 vccd1 SS_sky130_ef_sc_hd__decap_40_12
Xfanout208 vssd1 vccd1 vccd1 vssd1 _1472_/B _1466_/B SS_sky130_fd_sc_hd__clkdlybuf4s25_1
XFILLER_125_193 vssd1 vccd1 vssd1 vccd1 SS_sky130_ef_sc_hd__decap_40_12
XFILLER_113_366 vssd1 vccd1 vccd1 vssd1 SS_sky130_fd_sc_hd__fill_2
X_1475_ _1475_/Q clkload8/A _1475_/D vccd1 vssd1 vccd1 vssd1 SS_sky130_fd_sc_hd__dfxtp_2
XFILLER_101_517 vssd1 vccd1 vssd1 vccd1 SS_sky130_ef_sc_hd__decap_40_12
XFILLER_39_111 vccd1 vssd1 vccd1 vssd1 SS_sky130_fd_sc_hd__fill_1
XPHY_EDGE_ROW_105_Left_244 vccd1 vssd1 vccd1 vssd1 SS_sky130_fd_sc_hd__decap_3
XFILLER_27_317 vssd1 vccd1 vssd1 vccd1 SS_sky130_ef_sc_hd__decap_40_12
XFILLER_55_615 vccd1 vssd1 vccd1 vssd1 SS_sky130_fd_sc_hd__fill_1
XFILLER_67_475 vccd1 vssd1 vccd1 vssd1 SS_sky130_fd_sc_hd__fill_1
XFILLER_82_401 vssd1 vccd1 vssd1 vccd1 SS_sky130_ef_sc_hd__decap_40_12
XFILLER_95_773 vssd1 vccd1 vccd1 vssd1 SS_sky130_fd_sc_hd__fill_2
XFILLER_131_18 vssd1 vccd1 vssd1 vccd1 SS_sky130_ef_sc_hd__decap_40_12
XTAP_TAPCELL_ROW_38_868 vccd1 vssd1 SS_sky130_fd_sc_hd__tapvpwrvgnd_1
XFILLER_42_309 vssd1 vccd1 vssd1 vccd1 SS_sky130_ef_sc_hd__decap_40_12
XTAP_TAPCELL_ROW_18_570 vccd1 vssd1 SS_sky130_fd_sc_hd__tapvpwrvgnd_1
XFILLER_23_501 vssd1 vccd1 vccd1 vssd1 SS_sky130_fd_sc_hd__fill_2
XFILLER_35_361 vssd1 vccd1 vssd1 vccd1 SS_sky130_ef_sc_hd__decap_40_12
XFILLER_24_27 vccd1 vssd1 vccd1 vssd1 SS_sky130_fd_sc_hd__fill_1
XTAP_TAPCELL_ROW_102_1830 vccd1 vssd1 SS_sky130_fd_sc_hd__tapvpwrvgnd_1
XFILLER_11_729 vssd1 vccd1 vssd1 vccd1 SS_sky130_ef_sc_hd__decap_40_12
XPHY_EDGE_ROW_114_Left_253 vccd1 vssd1 vccd1 vssd1 SS_sky130_fd_sc_hd__decap_3
XFILLER_40_15 vssd1 vccd1 vssd1 vccd1 SS_sky130_ef_sc_hd__decap_40_12
XFILLER_136_425 vccd1 vssd1 vccd1 vssd1 SS_sky130_fd_sc_hd__fill_1
XFILLER_109_617 vssd1 vccd1 vssd1 vccd1 SS_sky130_ef_sc_hd__decap_40_12
XTAP_TAPCELL_ROW_131_2259 vccd1 vssd1 SS_sky130_fd_sc_hd__tapvpwrvgnd_1
XFILLER_116_193 vssd1 vccd1 vccd1 vssd1 SS_sky130_fd_sc_hd__fill_2
XFILLER_104_344 vssd1 vccd1 vssd1 vccd1 SS_sky130_ef_sc_hd__decap_40_12
XFILLER_49_57 vssd1 vccd1 vssd1 vccd1 SS_sky130_ef_sc_hd__decap_40_12
XFILLER_77_217 vssd1 vccd1 vccd1 vssd1 SS_sky130_fd_sc_hd__fill_4
XPHY_EDGE_ROW_123_Left_262 vccd1 vssd1 vccd1 vssd1 SS_sky130_fd_sc_hd__decap_3
XTAP_TAPCELL_ROW_113_1992 vccd1 vssd1 SS_sky130_fd_sc_hd__tapvpwrvgnd_1
XFILLER_104_388 vssd1 vccd1 vssd1 vccd1 SS_sky130_ef_sc_hd__decap_40_12
XFILLER_86_740 vssd1 vccd1 vccd1 vssd1 SS_sky130_fd_sc_hd__fill_8
XFILLER_46_626 vssd1 vccd1 vssd1 vccd1 SS_sky130_ef_sc_hd__decap_40_12
XFILLER_85_261 vssd1 vccd1 vssd1 vccd1 SS_sky130_ef_sc_hd__decap_40_12
XFILLER_86_762 vccd1 vssd1 vccd1 vssd1 SS_sky130_fd_sc_hd__fill_1
XFILLER_92_209 vssd1 vccd1 vssd1 vccd1 SS_sky130_ef_sc_hd__decap_40_12
XFILLER_45_125 vssd1 vccd1 vssd1 vccd1 SS_sky130_ef_sc_hd__decap_40_12
XFILLER_45_169 vssd1 vccd1 vssd1 vccd1 SS_sky130_ef_sc_hd__decap_40_12
XFILLER_14_501 vssd1 vccd1 vssd1 vccd1 SS_sky130_ef_sc_hd__decap_40_12
XFILLER_26_361 vssd1 vccd1 vccd1 vssd1 SS_sky130_fd_sc_hd__fill_2
XFILLER_61_629 vssd1 vccd1 vccd1 vssd1 SS_sky130_fd_sc_hd__fill_4
XFILLER_14_545 vssd1 vccd1 vssd1 vccd1 SS_sky130_ef_sc_hd__decap_40_12
XFILLER_60_139 vccd1 vssd1 vccd1 vssd1 SS_sky130_fd_sc_hd__fill_1
XPHY_EDGE_ROW_132_Left_271 vccd1 vssd1 vccd1 vssd1 SS_sky130_fd_sc_hd__decap_3
XFILLER_14_589 vssd1 vccd1 vssd1 vccd1 SS_sky130_ef_sc_hd__decap_40_12
XFILLER_127_425 vssd1 vccd1 vssd1 vccd1 SS_sky130_ef_sc_hd__decap_40_12
XFILLER_5_221 vssd1 vccd1 vccd1 vssd1 SS_sky130_fd_sc_hd__fill_2
XFILLER_127_447 vccd1 vssd1 vccd1 vssd1 SS_sky130_fd_sc_hd__fill_1
XFILLER_6_755 vccd1 vssd1 vccd1 vssd1 SS_sky130_fd_sc_hd__fill_1
XTAP_TAPCELL_ROW_75_1420 vccd1 vssd1 SS_sky130_fd_sc_hd__tapvpwrvgnd_1
XFILLER_30_81 vssd1 vccd1 vccd1 vssd1 SS_sky130_fd_sc_hd__fill_2
XTAP_TAPCELL_ROW_75_1431 vccd1 vssd1 SS_sky130_fd_sc_hd__tapvpwrvgnd_1
XFILLER_135_491 vssd1 vccd1 vccd1 vssd1 SS_sky130_fd_sc_hd__fill_2
XFILLER_69_718 vssd1 vccd1 vccd1 vssd1 SS_sky130_fd_sc_hd__fill_2
XFILLER_122_141 vssd1 vccd1 vssd1 vccd1 SS_sky130_ef_sc_hd__decap_40_12
XFILLER_107_193 vssd1 vccd1 vssd1 vccd1 SS_sky130_ef_sc_hd__decap_40_12
XFILLER_69_729 vssd1 vccd1 vssd1 vccd1 SS_sky130_ef_sc_hd__decap_40_12
XFILLER_123_697 vssd1 vccd1 vccd1 vssd1 SS_sky130_fd_sc_hd__fill_8
XFILLER_96_526 vssd1 vccd1 vccd1 vssd1 SS_sky130_fd_sc_hd__fill_4
XFILLER_77_751 vccd1 vssd1 vccd1 vssd1 SS_sky130_fd_sc_hd__fill_1
X_1260_ vccd1 vssd1 vccd1 vssd1 _1260_/X _1659_/Q _1264_/B SS_sky130_fd_sc_hd__or2_2
Xinput8 vssd1 vccd1 vccd1 vssd1 adc_data[5] input8/X SS_sky130_fd_sc_hd__clkdlybuf4s25_1
Xclkbuf_2_0__f_wb_clk_i vssd1 vccd1 vssd1 vccd1 clkbuf_0_wb_clk_i/X clkload0/A SS_sky130_fd_sc_hd__clkbuf_16
XFILLER_64_401 vssd1 vccd1 vssd1 vccd1 SS_sky130_ef_sc_hd__decap_40_12
X_1191_ vssd1 vccd1 vccd1 vssd1 _1195_/A2 input34/X _1625_/D _1327_/C1 _1190_/X SS_sky130_fd_sc_hd__o211a_2
XFILLER_49_497 vssd1 vccd1 vccd1 vssd1 SS_sky130_fd_sc_hd__fill_4
XFILLER_24_309 vssd1 vccd1 vssd1 vccd1 SS_sky130_ef_sc_hd__decap_40_12
XFILLER_64_445 vssd1 vccd1 vccd1 vssd1 SS_sky130_fd_sc_hd__fill_8
XFILLER_17_361 vssd1 vccd1 vssd1 vccd1 SS_sky130_ef_sc_hd__decap_40_12
XTAP_TAPCELL_ROW_35_827 vccd1 vssd1 SS_sky130_fd_sc_hd__tapvpwrvgnd_1
XFILLER_45_681 vssd1 vccd1 vccd1 vssd1 SS_sky130_fd_sc_hd__fill_2
XFILLER_64_489 vssd1 vccd1 vccd1 vssd1 SS_sky130_fd_sc_hd__fill_4
XTAP_TAPCELL_ROW_86_1593 vccd1 vssd1 SS_sky130_fd_sc_hd__tapvpwrvgnd_1
X_0975_ vssd1 vccd1 vccd1 vssd1 _0985_/A2 input24/X _1520_/D _1437_/C1 _0974_/X SS_sky130_fd_sc_hd__o211a_2
XFILLER_106_609 vccd1 vssd1 vccd1 vssd1 SS_sky130_fd_sc_hd__fill_1
XFILLER_10_29 vssd1 vccd1 vssd1 vccd1 SS_sky130_ef_sc_hd__decap_40_12
XFILLER_126_18 vssd1 vccd1 vccd1 vssd1 SS_sky130_fd_sc_hd__fill_8
XFILLER_126_29 vssd1 vccd1 vssd1 vccd1 SS_sky130_ef_sc_hd__decap_40_12
XFILLER_114_642 vssd1 vccd1 vccd1 vssd1 SS_sky130_fd_sc_hd__fill_2
X_1527_ _1527_/Q clkload3/A _1527_/D vccd1 vssd1 vccd1 vssd1 SS_sky130_fd_sc_hd__dfxtp_2
XFILLER_59_217 vssd1 vccd1 vccd1 vssd1 SS_sky130_fd_sc_hd__fill_4
XFILLER_114_697 vssd1 vccd1 vccd1 vssd1 SS_sky130_fd_sc_hd__fill_2
XFILLER_19_27 vssd1 vccd1 vssd1 vccd1 SS_sky130_ef_sc_hd__decap_40_12
XFILLER_87_559 vccd1 vssd1 vccd1 vssd1 SS_sky130_fd_sc_hd__fill_1
X_1458_ vccd1 vssd1 vccd1 vssd1 _1458_/X _1458_/A _1472_/B SS_sky130_fd_sc_hd__or2_2
XFILLER_67_261 vssd1 vccd1 vssd1 vccd1 SS_sky130_ef_sc_hd__decap_40_12
XFILLER_74_209 vssd1 vccd1 vssd1 vccd1 SS_sky130_ef_sc_hd__decap_40_12
XFILLER_27_125 vssd1 vccd1 vssd1 vccd1 SS_sky130_ef_sc_hd__decap_40_12
XFILLER_28_637 vssd1 vccd1 vccd1 vssd1 SS_sky130_fd_sc_hd__fill_4
XFILLER_83_721 vssd1 vccd1 vccd1 vssd1 SS_sky130_fd_sc_hd__fill_4
X_1389_ vssd1 vccd1 vccd1 vssd1 _1391_/A2 input34/X _1721_/D _1457_/C1 _1388_/X SS_sky130_fd_sc_hd__o211a_2
XFILLER_35_15 vssd1 vccd1 vssd1 vccd1 SS_sky130_ef_sc_hd__decap_40_12
XFILLER_55_445 vssd1 vccd1 vccd1 vssd1 SS_sky130_fd_sc_hd__fill_2
XFILLER_82_253 vssd1 vccd1 vssd1 vccd1 SS_sky130_ef_sc_hd__decap_40_12
XFILLER_83_765 vssd1 vccd1 vssd1 vccd1 SS_sky130_ef_sc_hd__decap_40_12
XFILLER_27_169 vssd1 vccd1 vssd1 vccd1 SS_sky130_ef_sc_hd__decap_40_12
XFILLER_36_681 vssd1 vccd1 vssd1 vccd1 SS_sky130_ef_sc_hd__decap_40_12
XFILLER_43_629 vssd1 vccd1 vccd1 vssd1 SS_sky130_fd_sc_hd__fill_2
XFILLER_42_139 vccd1 vssd1 vccd1 vssd1 SS_sky130_fd_sc_hd__fill_1
XFILLER_51_673 vssd1 vccd1 vccd1 vssd1 SS_sky130_fd_sc_hd__fill_8
XFILLER_51_695 vssd1 vccd1 vssd1 vccd1 SS_sky130_ef_sc_hd__decap_40_12
Xwire406 vccd1 vssd1 vssd1 vccd1 wire406/A analog_ctrl[75] SS_sky130_fd_sc_hd__buf_12
XFILLER_136_6 vssd1 vccd1 vssd1 vccd1 SS_sky130_ef_sc_hd__decap_40_12
XFILLER_11_559 vccd1 vssd1 vccd1 vssd1 SS_sky130_fd_sc_hd__fill_1
XFILLER_51_69 vssd1 vccd1 vssd1 vccd1 SS_sky130_ef_sc_hd__decap_40_12
Xwire417 vccd1 vssd1 vssd1 vccd1 wire417/A analog_ctrl[64] SS_sky130_fd_sc_hd__buf_12
XFILLER_136_211 vssd1 vccd1 vssd1 vccd1 SS_sky130_ef_sc_hd__decap_40_12
XFILLER_109_447 vccd1 vssd1 vccd1 vssd1 SS_sky130_fd_sc_hd__fill_1
XFILLER_3_725 vssd1 vccd1 vccd1 vssd1 SS_sky130_fd_sc_hd__fill_2
XFILLER_136_277 vssd1 vccd1 vssd1 vccd1 SS_sky130_ef_sc_hd__decap_40_12
XTAP_TAPCELL_ROW_57_1150 vccd1 vssd1 SS_sky130_fd_sc_hd__tapvpwrvgnd_1
XTAP_TAPCELL_ROW_57_1161 vccd1 vssd1 SS_sky130_fd_sc_hd__tapvpwrvgnd_1
XFILLER_105_697 vssd1 vccd1 vssd1 vccd1 SS_sky130_ef_sc_hd__decap_40_12
XFILLER_104_141 vssd1 vccd1 vssd1 vccd1 SS_sky130_ef_sc_hd__decap_40_12
XTAP_TAPCELL_ROW_70_1350 vccd1 vssd1 SS_sky130_fd_sc_hd__tapvpwrvgnd_1
XFILLER_120_645 vssd1 vccd1 vccd1 vssd1 SS_sky130_fd_sc_hd__fill_4
XFILLER_120_634 vssd1 vccd1 vccd1 vssd1 SS_sky130_fd_sc_hd__fill_8
XFILLER_19_615 vccd1 vssd1 vccd1 vssd1 SS_sky130_fd_sc_hd__fill_1
XFILLER_93_529 vssd1 vccd1 vssd1 vccd1 SS_sky130_ef_sc_hd__decap_40_12
XFILLER_76_77 vssd1 vccd1 vccd1 vssd1 SS_sky130_fd_sc_hd__fill_4
XFILLER_27_681 vccd1 vssd1 vccd1 vssd1 SS_sky130_fd_sc_hd__fill_1
XFILLER_46_489 vssd1 vccd1 vccd1 vssd1 SS_sky130_fd_sc_hd__fill_4
XFILLER_132_83 vccd1 vssd1 vccd1 vssd1 SS_sky130_fd_sc_hd__fill_1
XFILLER_42_640 vssd1 vccd1 vccd1 vssd1 SS_sky130_fd_sc_hd__fill_4
XFILLER_92_65 vssd1 vccd1 vssd1 vccd1 SS_sky130_ef_sc_hd__decap_40_12
XFILLER_25_81 vssd1 vccd1 vssd1 vccd1 SS_sky130_ef_sc_hd__decap_40_12
XFILLER_30_813 vccd1 vssd1 vccd1 vssd1 SS_sky130_fd_sc_hd__fill_1
XFILLER_41_161 vssd1 vccd1 vccd1 vssd1 SS_sky130_fd_sc_hd__fill_4
XFILLER_128_701 vssd1 vccd1 vssd1 vccd1 SS_sky130_ef_sc_hd__decap_40_12
XFILLER_10_581 vssd1 vccd1 vccd1 vssd1 SS_sky130_fd_sc_hd__fill_4
XTAP_TAPCELL_ROW_40_896 vccd1 vssd1 SS_sky130_fd_sc_hd__tapvpwrvgnd_1
X_0760_ vccd1 vssd1 vccd1 vssd1 _0759_/X _1892_/A wire448/A _1879_/A wire452/X _0760_/X
+ SS_sky130_fd_sc_hd__a221o_2
XFILLER_6_585 vssd1 vccd1 vccd1 vssd1 SS_sky130_fd_sc_hd__fill_2
XFILLER_51_6 vssd1 vccd1 vssd1 vccd1 SS_sky130_ef_sc_hd__decap_40_12
XFILLER_127_277 vssd1 vccd1 vccd1 vssd1 SS_sky130_fd_sc_hd__fill_2
XFILLER_115_417 vssd1 vccd1 vssd1 vccd1 SS_sky130_ef_sc_hd__decap_40_12
X_1312_ vccd1 vssd1 vccd1 vssd1 _1312_/X _1312_/A _1318_/B SS_sky130_fd_sc_hd__or2_2
XFILLER_69_559 vccd1 vssd1 vccd1 vssd1 SS_sky130_fd_sc_hd__fill_1
XFILLER_2_41 vssd1 vccd1 vssd1 vccd1 SS_sky130_ef_sc_hd__decap_40_12
XFILLER_56_209 vssd1 vccd1 vssd1 vccd1 SS_sky130_ef_sc_hd__decap_40_12
XFILLER_84_507 vccd1 vssd1 vccd1 vssd1 SS_sky130_fd_sc_hd__fill_1
X_1243_ vssd1 vccd1 vccd1 vssd1 _1261_/A2 input26/X _1650_/D _1381_/C1 _1242_/X SS_sky130_fd_sc_hd__o211a_2
XFILLER_110_133 vssd1 vccd1 vccd1 vssd1 SS_sky130_fd_sc_hd__fill_4
XFILLER_2_85 vssd1 vccd1 vssd1 vccd1 SS_sky130_ef_sc_hd__decap_40_12
XFILLER_49_261 vssd1 vccd1 vssd1 vccd1 SS_sky130_ef_sc_hd__decap_40_12
XFILLER_65_721 vssd1 vccd1 vccd1 vssd1 SS_sky130_fd_sc_hd__fill_4
XTAP_TAPCELL_ROW_88_1622 vccd1 vssd1 SS_sky130_fd_sc_hd__tapvpwrvgnd_1
XFILLER_110_177 vssd1 vccd1 vssd1 vccd1 SS_sky130_ef_sc_hd__decap_40_12
XFILLER_37_445 vssd1 vccd1 vccd1 vssd1 SS_sky130_fd_sc_hd__fill_2
X_1174_ vccd1 vssd1 vccd1 vssd1 _1174_/X _1877_/A _1208_/B SS_sky130_fd_sc_hd__or2_2
XFILLER_18_681 vssd1 vccd1 vssd1 vccd1 SS_sky130_ef_sc_hd__decap_40_12
XFILLER_25_629 vssd1 vccd1 vccd1 vssd1 SS_sky130_fd_sc_hd__fill_8
XFILLER_64_253 vssd1 vccd1 vssd1 vccd1 SS_sky130_ef_sc_hd__decap_40_12
XFILLER_65_787 vccd1 vssd1 vccd1 vssd1 SS_sky130_fd_sc_hd__fill_1
XFILLER_80_713 vssd1 vccd1 vssd1 vccd1 SS_sky130_ef_sc_hd__decap_40_12
XFILLER_24_139 vccd1 vssd1 vccd1 vssd1 SS_sky130_fd_sc_hd__fill_1
XFILLER_80_757 vssd1 vccd1 vssd1 vccd1 SS_sky130_ef_sc_hd__decap_40_12
XFILLER_21_813 vccd1 vssd1 vccd1 vssd1 SS_sky130_fd_sc_hd__fill_1
XFILLER_33_673 vssd1 vccd1 vssd1 vccd1 SS_sky130_ef_sc_hd__decap_40_12
XFILLER_20_301 vssd1 vccd1 vccd1 vssd1 SS_sky130_fd_sc_hd__fill_4
XFILLER_20_345 vssd1 vccd1 vssd1 vccd1 SS_sky130_ef_sc_hd__decap_40_12
XFILLER_20_389 vssd1 vccd1 vssd1 vccd1 SS_sky130_ef_sc_hd__decap_40_12
X_0958_ vccd1 vssd1 vccd1 vssd1 _0958_/X _1838_/A _0988_/B SS_sky130_fd_sc_hd__or2_2
XTAP_TAPCELL_ROW_115_2018 vccd1 vssd1 SS_sky130_fd_sc_hd__tapvpwrvgnd_1
XFILLER_118_233 vssd1 vccd1 vssd1 vccd1 SS_sky130_ef_sc_hd__decap_40_12
XTAP_TAPCELL_ROW_115_2029 vccd1 vssd1 SS_sky130_fd_sc_hd__tapvpwrvgnd_1
XTAP_TAPCELL_ROW_99_1784 vccd1 vssd1 SS_sky130_fd_sc_hd__tapvpwrvgnd_1
XFILLER_133_225 vssd1 vccd1 vssd1 vccd1 SS_sky130_ef_sc_hd__decap_40_12
XFILLER_134_748 vssd1 vccd1 vccd1 vssd1 SS_sky130_fd_sc_hd__fill_2
XFILLER_118_299 vccd1 vssd1 vccd1 vssd1 SS_sky130_fd_sc_hd__fill_1
XFILLER_118_277 vssd1 vccd1 vssd1 vccd1 SS_sky130_ef_sc_hd__decap_40_12
X_0889_ vssd1 vccd1 vccd1 vssd1 _0889_/B _0889_/C _0943_/A _0889_/X SS_sky130_fd_sc_hd__or3_2
Xoutput120 vccd1 vssd1 wire324/A _1877_/X vccd1 vssd1 SS_sky130_fd_sc_hd__buf_4
Xoutput131 vccd1 vssd1 wire313/A _1887_/X vccd1 vssd1 SS_sky130_fd_sc_hd__buf_4
Xoutput142 vccd1 vssd1 wire409/A _1643_/Q vccd1 vssd1 SS_sky130_fd_sc_hd__buf_4
XFILLER_88_813 vssd1 vccd1 vccd1 vssd1 SS_sky130_fd_sc_hd__fill_4
Xoutput175 vccd1 vssd1 wire380/A _1488_/Q vccd1 vssd1 SS_sky130_fd_sc_hd__buf_4
Xoutput186 vccd1 vssd1 wire369/A _1498_/Q vccd1 vssd1 SS_sky130_fd_sc_hd__buf_4
Xoutput164 vccd1 vssd1 wire388/A _1664_/Q vccd1 vssd1 SS_sky130_fd_sc_hd__buf_4
XFILLER_102_601 vssd1 vccd1 vssd1 vccd1 SS_sky130_ef_sc_hd__decap_40_12
XFILLER_99_161 vssd1 vccd1 vccd1 vssd1 SS_sky130_fd_sc_hd__fill_4
Xoutput153 vccd1 vssd1 wire398/A _1654_/Q vccd1 vssd1 SS_sky130_fd_sc_hd__buf_4
Xoutput197 vccd1 vssd1 wire358/A _1479_/Q vccd1 vssd1 SS_sky130_fd_sc_hd__buf_4
XTAP_TAPCELL_ROW_110_1951 vccd1 vssd1 SS_sky130_fd_sc_hd__tapvpwrvgnd_1
XFILLER_102_645 vssd1 vccd1 vssd1 vccd1 SS_sky130_ef_sc_hd__decap_40_12
XFILLER_101_111 vccd1 vssd1 vccd1 vssd1 SS_sky130_fd_sc_hd__fill_1
XFILLER_28_401 vssd1 vccd1 vssd1 vccd1 SS_sky130_ef_sc_hd__decap_40_12
XTAP_TAPCELL_ROW_52_1080 vccd1 vssd1 SS_sky130_fd_sc_hd__tapvpwrvgnd_1
XFILLER_68_581 vssd1 vccd1 vccd1 vssd1 SS_sky130_fd_sc_hd__fill_4
XFILLER_75_529 vssd1 vccd1 vssd1 vccd1 SS_sky130_ef_sc_hd__decap_40_12
XFILLER_87_389 vssd1 vccd1 vccd1 vssd1 SS_sky130_fd_sc_hd__fill_2
XFILLER_28_445 vssd1 vccd1 vssd1 vccd1 SS_sky130_ef_sc_hd__decap_40_12
XFILLER_56_754 vssd1 vccd1 vccd1 vssd1 SS_sky130_fd_sc_hd__fill_2
XFILLER_28_489 vssd1 vccd1 vssd1 vccd1 SS_sky130_ef_sc_hd__decap_40_12
XFILLER_83_573 vssd1 vccd1 vssd1 vccd1 SS_sky130_ef_sc_hd__decap_40_12
XFILLER_70_245 vssd1 vccd1 vccd1 vssd1 SS_sky130_fd_sc_hd__fill_4
XFILLER_71_746 vssd1 vccd1 vssd1 vccd1 SS_sky130_ef_sc_hd__decap_40_12
XFILLER_102_53 vssd1 vccd1 vssd1 vccd1 SS_sky130_ef_sc_hd__decap_40_12
XFILLER_12_802 vssd1 vccd1 vccd1 vssd1 SS_sky130_fd_sc_hd__fill_8
XFILLER_12_813 vssd1 vccd1 vccd1 vssd1 SS_sky130_fd_sc_hd__fill_4
XFILLER_30_109 vssd1 vccd1 vssd1 vccd1 SS_sky130_ef_sc_hd__decap_40_12
XFILLER_102_97 vssd1 vccd1 vssd1 vccd1 SS_sky130_ef_sc_hd__decap_40_12
XFILLER_23_161 vssd1 vccd1 vccd1 vssd1 SS_sky130_fd_sc_hd__fill_4
XFILLER_70_289 vssd1 vccd1 vssd1 vccd1 SS_sky130_ef_sc_hd__decap_40_12
XFILLER_7_305 vssd1 vccd1 vssd1 vccd1 SS_sky130_ef_sc_hd__decap_40_12
XFILLER_8_817 vssd1 vccd1 vccd1 vssd1 SS_sky130_fd_sc_hd__fill_2
XFILLER_134_3 vssd1 vccd1 vssd1 vccd1 SS_sky130_ef_sc_hd__decap_40_12
XFILLER_11_389 vssd1 vccd1 vccd1 vssd1 SS_sky130_fd_sc_hd__fill_2
Xwire225 vccd1 vssd1 _1318_/B _1330_/B vccd1 vssd1 SS_sky130_fd_sc_hd__buf_4
XFILLER_7_349 vssd1 vccd1 vssd1 vccd1 SS_sky130_ef_sc_hd__decap_40_12
Xwire269 vccd1 vssd1 vssd1 vccd1 wire269/A analog_ctrl[26] SS_sky130_fd_sc_hd__buf_12
XFILLER_125_726 vssd1 vccd1 vccd1 vssd1 SS_sky130_fd_sc_hd__fill_2
XFILLER_109_277 vssd1 vccd1 vccd1 vssd1 SS_sky130_fd_sc_hd__fill_2
XFILLER_78_301 vssd1 vccd1 vccd1 vssd1 SS_sky130_fd_sc_hd__fill_4
Xload_slew219 vccd1 vssd1 _1337_/A2 _1339_/A2 vccd1 vssd1 SS_sky130_fd_sc_hd__buf_6
XFILLER_105_461 vssd1 vccd1 vssd1 vccd1 SS_sky130_ef_sc_hd__decap_40_12
XFILLER_97_109 vssd1 vccd1 vccd1 vssd1 SS_sky130_fd_sc_hd__fill_2
XFILLER_38_209 vssd1 vccd1 vssd1 vccd1 SS_sky130_ef_sc_hd__decap_40_12
XTAP_TAPCELL_ROW_6_393 vccd1 vssd1 SS_sky130_fd_sc_hd__tapvpwrvgnd_1
XFILLER_47_721 vssd1 vccd1 vccd1 vssd1 SS_sky130_fd_sc_hd__fill_4
XFILLER_120_475 vccd1 vssd1 vccd1 vssd1 SS_sky130_fd_sc_hd__fill_1
XFILLER_19_445 vssd1 vccd1 vccd1 vssd1 SS_sky130_fd_sc_hd__fill_2
XFILLER_47_765 vssd1 vccd1 vssd1 vccd1 SS_sky130_ef_sc_hd__decap_40_12
XFILLER_46_253 vssd1 vccd1 vssd1 vccd1 SS_sky130_ef_sc_hd__decap_40_12
XFILLER_62_713 vssd1 vccd1 vssd1 vccd1 SS_sky130_ef_sc_hd__decap_40_12
XFILLER_61_223 vccd1 vssd1 vccd1 vssd1 SS_sky130_fd_sc_hd__fill_1
XFILLER_62_757 vssd1 vccd1 vssd1 vccd1 SS_sky130_ef_sc_hd__decap_40_12
XFILLER_74_595 vssd1 vccd1 vssd1 vccd1 SS_sky130_ef_sc_hd__decap_40_12
XFILLER_15_673 vssd1 vccd1 vssd1 vccd1 SS_sky130_ef_sc_hd__decap_40_12
XFILLER_21_109 vssd1 vccd1 vccd1 vssd1 SS_sky130_fd_sc_hd__fill_2
XTAP_TAPCELL_ROW_45_977 vccd1 vssd1 SS_sky130_fd_sc_hd__tapvpwrvgnd_1
XTAP_TAPCELL_ROW_83_1541 vccd1 vssd1 SS_sky130_fd_sc_hd__tapvpwrvgnd_1
XTAP_TAPCELL_ROW_83_1552 vccd1 vssd1 SS_sky130_fd_sc_hd__tapvpwrvgnd_1
XFILLER_70_790 vssd1 vccd1 vssd1 vccd1 SS_sky130_ef_sc_hd__decap_40_12
X_1861_ vccd1 vssd1 _1861_/X _1861_/A vccd1 vssd1 SS_sky130_fd_sc_hd__buf_2
Xinput11 vssd1 vccd1 vccd1 vssd1 adc_data[8] input11/X SS_sky130_fd_sc_hd__clkdlybuf4s25_1
XFILLER_30_687 vssd1 vccd1 vssd1 vccd1 SS_sky130_ef_sc_hd__decap_40_12
X_0812_ vccd1 vssd1 vssd1 vccd1 _0808_/X _0811_/X _0878_/A2 _1484_/Q _1484_/D _1387_/C1
+ SS_sky130_fd_sc_hd__o221a_2
Xinput22 vssd1 vccd1 wire500/A input22/A vccd1 vssd1 SS_sky130_fd_sc_hd__buf_1
Xinput33 vssd1 vccd1 vccd1 vssd1 input33/A input33/X SS_sky130_fd_sc_hd__clkdlybuf4s25_1
Xinput44 vssd1 vccd1 vccd1 vssd1 input44/A input44/X SS_sky130_fd_sc_hd__clkdlybuf4s25_1
X_0743_ vssd1 vccd1 vssd1 vccd1 wire454/X _1344_/A _0742_/X _0743_/X SS_sky130_fd_sc_hd__a21o_2
Xhold806 hold806/X _1489_/Q vccd1 vssd1 vssd1 vccd1 SS_sky130_fd_sc_hd__dlygate4sd3_1
XFILLER_115_225 vssd1 vccd1 vssd1 vccd1 SS_sky130_ef_sc_hd__decap_40_12
XFILLER_88_109 vssd1 vccd1 vssd1 vccd1 SS_sky130_ef_sc_hd__decap_40_12
XFILLER_131_729 vssd1 vccd1 vssd1 vccd1 SS_sky130_ef_sc_hd__decap_40_12
XFILLER_124_781 vssd1 vccd1 vssd1 vccd1 SS_sky130_ef_sc_hd__decap_40_12
XFILLER_69_334 vssd1 vccd1 vccd1 vssd1 SS_sky130_fd_sc_hd__fill_2
XFILLER_85_816 vssd1 vccd1 vccd1 vssd1 SS_sky130_fd_sc_hd__fill_2
XFILLER_97_654 vssd1 vccd1 vssd1 vccd1 SS_sky130_ef_sc_hd__decap_40_12
XFILLER_96_153 vssd1 vccd1 vssd1 vccd1 SS_sky130_ef_sc_hd__decap_40_12
XFILLER_57_529 vssd1 vccd1 vssd1 vccd1 SS_sky130_ef_sc_hd__decap_40_12
XFILLER_69_389 vssd1 vccd1 vccd1 vssd1 SS_sky130_fd_sc_hd__fill_2
XFILLER_84_315 vssd1 vccd1 vssd1 vccd1 SS_sky130_ef_sc_hd__decap_40_12
XFILLER_111_497 vssd1 vccd1 vccd1 vssd1 SS_sky130_fd_sc_hd__fill_4
XFILLER_96_197 vssd1 vccd1 vssd1 vccd1 SS_sky130_ef_sc_hd__decap_40_12
XFILLER_38_754 vssd1 vccd1 vccd1 vssd1 SS_sky130_fd_sc_hd__fill_2
X_1226_ vccd1 vssd1 vccd1 vssd1 _1226_/X _1642_/Q _1264_/B SS_sky130_fd_sc_hd__or2_2
X_1157_ vssd1 vccd1 vccd1 vssd1 wire233/X input47/X _1608_/D _1165_/C1 _1156_/X SS_sky130_fd_sc_hd__o211a_2
XFILLER_53_713 vssd1 vccd1 vssd1 vccd1 SS_sky130_ef_sc_hd__decap_40_12
XFILLER_65_573 vssd1 vccd1 vssd1 vccd1 SS_sky130_ef_sc_hd__decap_40_12
XTAP_TAPCELL_ROW_125_2180 vccd1 vssd1 SS_sky130_fd_sc_hd__tapvpwrvgnd_1
XFILLER_12_109 vssd1 vccd1 vssd1 vccd1 SS_sky130_ef_sc_hd__decap_40_12
X_1088_ vccd1 vssd1 vccd1 vssd1 _1088_/X _1845_/A _1116_/B SS_sky130_fd_sc_hd__or2_2
XFILLER_52_245 vssd1 vccd1 vccd1 vssd1 SS_sky130_fd_sc_hd__fill_4
XTAP_TAPCELL_ROW_23_638 vccd1 vssd1 SS_sky130_fd_sc_hd__tapvpwrvgnd_1
XFILLER_52_289 vssd1 vccd1 vssd1 vccd1 SS_sky130_ef_sc_hd__decap_40_12
XFILLER_80_587 vccd1 vssd1 vccd1 vssd1 SS_sky130_fd_sc_hd__fill_1
XFILLER_21_665 vssd1 vccd1 vccd1 vssd1 SS_sky130_fd_sc_hd__fill_4
XTAP_TAPCELL_ROW_23_649 vccd1 vssd1 SS_sky130_fd_sc_hd__tapvpwrvgnd_1
XFILLER_32_27 vccd1 vssd1 vccd1 vssd1 SS_sky130_fd_sc_hd__fill_1
XFILLER_20_153 vssd1 vccd1 vssd1 vccd1 SS_sky130_ef_sc_hd__decap_40_12
XFILLER_5_809 vssd1 vccd1 vssd1 vccd1 SS_sky130_ef_sc_hd__decap_40_12
XFILLER_20_197 vssd1 vccd1 vssd1 vccd1 SS_sky130_ef_sc_hd__decap_40_12
XFILLER_119_553 vssd1 vccd1 vccd1 vssd1 SS_sky130_fd_sc_hd__fill_4
XFILLER_119_597 vssd1 vccd1 vssd1 vccd1 SS_sky130_ef_sc_hd__decap_40_12
XFILLER_107_737 vccd1 vssd1 vccd1 vssd1 SS_sky130_fd_sc_hd__fill_1
XFILLER_0_503 vccd1 vssd1 vccd1 vssd1 SS_sky130_fd_sc_hd__fill_1
XFILLER_79_109 vssd1 vccd1 vccd1 vssd1 SS_sky130_fd_sc_hd__fill_2
XFILLER_121_217 vssd1 vccd1 vccd1 vssd1 SS_sky130_fd_sc_hd__fill_4
XFILLER_88_632 vssd1 vccd1 vssd1 vccd1 SS_sky130_ef_sc_hd__decap_40_12
XFILLER_115_781 vssd1 vccd1 vccd1 vssd1 SS_sky130_fd_sc_hd__fill_2
XFILLER_130_751 vssd1 vccd1 vccd1 vssd1 SS_sky130_fd_sc_hd__fill_4
XFILLER_102_464 vssd1 vccd1 vccd1 vssd1 SS_sky130_fd_sc_hd__fill_4
XFILLER_48_529 vssd1 vccd1 vccd1 vssd1 SS_sky130_fd_sc_hd__fill_2
XFILLER_57_57 vssd1 vccd1 vssd1 vccd1 SS_sky130_ef_sc_hd__decap_40_12
XFILLER_75_337 vssd1 vccd1 vssd1 vccd1 SS_sky130_ef_sc_hd__decap_40_12
XFILLER_102_486 vssd1 vccd1 vssd1 vccd1 SS_sky130_ef_sc_hd__decap_40_12
XTAP_TAPCELL_ROW_3_341 vccd1 vssd1 SS_sky130_fd_sc_hd__tapvpwrvgnd_1
XTAP_TAPCELL_ROW_3_352 vccd1 vssd1 SS_sky130_fd_sc_hd__tapvpwrvgnd_1
XFILLER_113_30 vssd1 vccd1 vssd1 vccd1 SS_sky130_ef_sc_hd__decap_40_12
XFILLER_28_253 vssd1 vccd1 vssd1 vccd1 SS_sky130_ef_sc_hd__decap_40_12
XFILLER_90_307 vccd1 vssd1 vccd1 vssd1 SS_sky130_fd_sc_hd__fill_1
XFILLER_90_329 vccd1 vssd1 vccd1 vssd1 SS_sky130_fd_sc_hd__fill_1
XFILLER_43_223 vccd1 vssd1 vccd1 vssd1 SS_sky130_fd_sc_hd__fill_1
XFILLER_44_757 vssd1 vccd1 vssd1 vccd1 SS_sky130_ef_sc_hd__decap_40_12
XFILLER_71_521 vssd1 vccd1 vccd1 vssd1 SS_sky130_fd_sc_hd__fill_2
XFILLER_31_429 vssd1 vccd1 vssd1 vccd1 SS_sky130_ef_sc_hd__decap_40_12
XTAP_TAPCELL_ROW_42_925 vccd1 vssd1 SS_sky130_fd_sc_hd__tapvpwrvgnd_1
XTAP_TAPCELL_ROW_42_936 vccd1 vssd1 SS_sky130_fd_sc_hd__tapvpwrvgnd_1
XTAP_TAPCELL_ROW_65_1271 vccd1 vssd1 SS_sky130_fd_sc_hd__tapvpwrvgnd_1
XTAP_TAPCELL_ROW_65_1282 vccd1 vssd1 SS_sky130_fd_sc_hd__tapvpwrvgnd_1
XPHY_EDGE_ROW_125_Right_125 vccd1 vssd1 vccd1 vssd1 SS_sky130_fd_sc_hd__decap_3
XFILLER_12_643 vccd1 vssd1 vccd1 vssd1 SS_sky130_fd_sc_hd__fill_1
XFILLER_7_113 vssd1 vccd1 vssd1 vccd1 SS_sky130_ef_sc_hd__decap_40_12
XFILLER_8_625 vssd1 vccd1 vssd1 vccd1 SS_sky130_ef_sc_hd__decap_40_12
XFILLER_8_669 vssd1 vccd1 vssd1 vccd1 SS_sky130_ef_sc_hd__decap_40_12
Xclkbuf_leaf_4_wb_clk_i _1747_/CLK clkbuf_leaf_9_wb_clk_i/A vccd1 vssd1 vssd1 vccd1
+ SS_sky130_fd_sc_hd__clkbuf_8
XFILLER_98_53 vssd1 vccd1 vssd1 vccd1 SS_sky130_ef_sc_hd__decap_40_12
XFILLER_113_729 vssd1 vccd1 vccd1 vssd1 SS_sky130_fd_sc_hd__fill_2
XFILLER_3_385 vssd1 vccd1 vccd1 vssd1 SS_sky130_fd_sc_hd__fill_4
XFILLER_106_792 vssd1 vccd1 vssd1 vccd1 SS_sky130_ef_sc_hd__decap_40_12
XFILLER_106_781 vssd1 vccd1 vccd1 vssd1 SS_sky130_fd_sc_hd__fill_4
XFILLER_98_97 vssd1 vccd1 vssd1 vccd1 SS_sky130_ef_sc_hd__decap_40_12
XFILLER_78_153 vssd1 vccd1 vssd1 vccd1 SS_sky130_ef_sc_hd__decap_40_12
XFILLER_94_613 vssd1 vccd1 vssd1 vccd1 SS_sky130_ef_sc_hd__decap_40_12
XFILLER_78_197 vssd1 vccd1 vssd1 vccd1 SS_sky130_ef_sc_hd__decap_40_12
XFILLER_47_551 vssd1 vccd1 vccd1 vssd1 SS_sky130_fd_sc_hd__fill_2
XFILLER_81_318 vssd1 vccd1 vccd1 vssd1 SS_sky130_fd_sc_hd__fill_8
X_1011_ vssd1 vccd1 vccd1 vssd1 _0947_/Y input44/X _1538_/D _1473_/C1 _1010_/X SS_sky130_fd_sc_hd__o211a_2
XFILLER_93_167 vccd1 vssd1 vccd1 vssd1 SS_sky130_fd_sc_hd__fill_1
XFILLER_34_245 vssd1 vccd1 vccd1 vssd1 SS_sky130_fd_sc_hd__fill_4
XFILLER_50_705 vssd1 vccd1 vccd1 vssd1 SS_sky130_fd_sc_hd__fill_2
XFILLER_34_289 vssd1 vccd1 vssd1 vccd1 SS_sky130_ef_sc_hd__decap_40_12
XFILLER_62_598 vccd1 vssd1 vccd1 vssd1 SS_sky130_fd_sc_hd__fill_1
XFILLER_97_3 vssd1 vccd1 vssd1 vccd1 SS_sky130_ef_sc_hd__decap_40_12
XFILLER_30_473 vssd1 vccd1 vccd1 vssd1 SS_sky130_fd_sc_hd__fill_2
X_1844_ vccd1 vssd1 _1844_/X _1844_/A vccd1 vssd1 SS_sky130_fd_sc_hd__buf_2
Xhold603 _1366_/A _1710_/Q vccd1 vssd1 vssd1 vccd1 SS_sky130_fd_sc_hd__dlygate4sd3_1
XTAP_TAPCELL_ROW_96_1743 vccd1 vssd1 SS_sky130_fd_sc_hd__tapvpwrvgnd_1
Xhold614 _1082_/A _1842_/A vccd1 vssd1 vssd1 vccd1 SS_sky130_fd_sc_hd__dlygate4sd3_1
Xhold636 _0962_/A _1837_/A vccd1 vssd1 vssd1 vccd1 SS_sky130_fd_sc_hd__dlygate4sd3_1
Xhold625 _1100_/A _1855_/A vccd1 vssd1 vssd1 vccd1 SS_sky130_fd_sc_hd__dlygate4sd3_1
XFILLER_128_394 vssd1 vccd1 vccd1 vssd1 SS_sky130_fd_sc_hd__fill_4
XFILLER_116_545 vssd1 vccd1 vssd1 vccd1 SS_sky130_ef_sc_hd__decap_40_12
Xhold647 _1729_/D _1405_/X vccd1 vssd1 vssd1 vccd1 SS_sky130_fd_sc_hd__dlygate4sd3_1
Xhold658 _1010_/A _1538_/Q vccd1 vssd1 vssd1 vccd1 SS_sky130_fd_sc_hd__dlygate4sd3_1
XFILLER_116_589 vssd1 vccd1 vssd1 vccd1 SS_sky130_ef_sc_hd__decap_40_12
Xhold669 _1752_/D _1453_/X vccd1 vssd1 vssd1 vccd1 SS_sky130_fd_sc_hd__dlygate4sd3_1
XFILLER_103_217 vssd1 vccd1 vccd1 vssd1 SS_sky130_fd_sc_hd__fill_4
XFILLER_85_602 vssd1 vccd1 vssd1 vccd1 SS_sky130_ef_sc_hd__decap_40_12
XFILLER_134_29 vssd1 vccd1 vccd1 vssd1 SS_sky130_fd_sc_hd__fill_4
XFILLER_112_751 vssd1 vccd1 vccd1 vssd1 SS_sky130_fd_sc_hd__fill_4
XFILLER_111_261 vssd1 vccd1 vssd1 vccd1 SS_sky130_ef_sc_hd__decap_40_12
XFILLER_97_473 vssd1 vccd1 vssd1 vccd1 SS_sky130_ef_sc_hd__decap_40_12
XFILLER_27_27 vssd1 vccd1 vssd1 vccd1 SS_sky130_ef_sc_hd__decap_40_12
XFILLER_57_337 vssd1 vccd1 vssd1 vccd1 SS_sky130_ef_sc_hd__decap_40_12
XTAP_TAPCELL_ROW_0_300 vccd1 vssd1 SS_sky130_fd_sc_hd__tapvpwrvgnd_1
XTAP_TAPCELL_ROW_28_719 vccd1 vssd1 SS_sky130_fd_sc_hd__tapvpwrvgnd_1
XFILLER_72_307 vccd1 vssd1 vccd1 vssd1 SS_sky130_fd_sc_hd__fill_1
XFILLER_72_329 vssd1 vccd1 vccd1 vssd1 SS_sky130_fd_sc_hd__fill_2
X_1209_ vssd1 vccd1 vccd1 vssd1 _1209_/A2 input44/X _1634_/D _1473_/C1 _1208_/X SS_sky130_fd_sc_hd__o211a_2
XFILLER_25_223 vccd1 vssd1 vccd1 vssd1 SS_sky130_fd_sc_hd__fill_1
XFILLER_26_757 vssd1 vccd1 vssd1 vccd1 SS_sky130_ef_sc_hd__decap_40_12
XFILLER_81_841 vccd1 vssd1 vccd1 vssd1 SS_sky130_fd_sc_hd__fill_1
XFILLER_84_189 vssd1 vccd1 vccd1 vssd1 SS_sky130_fd_sc_hd__fill_4
XTAP_TAPCELL_ROW_123_2139 vccd1 vssd1 SS_sky130_fd_sc_hd__tapvpwrvgnd_1
XFILLER_13_429 vssd1 vccd1 vssd1 vccd1 SS_sky130_ef_sc_hd__decap_40_12
XFILLER_41_727 vccd1 vssd1 vccd1 vssd1 SS_sky130_fd_sc_hd__fill_1
XFILLER_41_749 vssd1 vccd1 vccd1 vssd1 SS_sky130_fd_sc_hd__fill_8
XFILLER_80_362 vssd1 vccd1 vccd1 vssd1 SS_sky130_fd_sc_hd__fill_2
XTAP_TAPCELL_ROW_105_1872 vccd1 vssd1 SS_sky130_fd_sc_hd__tapvpwrvgnd_1
XFILLER_34_790 vssd1 vccd1 vccd1 vssd1 SS_sky130_fd_sc_hd__fill_2
XFILLER_21_473 vssd1 vccd1 vssd1 vccd1 SS_sky130_ef_sc_hd__decap_40_12
XTAP_TAPCELL_ROW_138_2382 vccd1 vssd1 SS_sky130_fd_sc_hd__tapvpwrvgnd_1
XTAP_TAPCELL_ROW_138_2371 vccd1 vssd1 SS_sky130_fd_sc_hd__tapvpwrvgnd_1
XFILLER_126_309 vssd1 vccd1 vssd1 vccd1 SS_sky130_ef_sc_hd__decap_40_12
XFILLER_5_617 vssd1 vccd1 vssd1 vccd1 SS_sky130_ef_sc_hd__decap_40_12
XFILLER_119_383 vssd1 vccd1 vccd1 vssd1 SS_sky130_fd_sc_hd__fill_2
XFILLER_134_375 vccd1 vssd1 vccd1 vssd1 SS_sky130_fd_sc_hd__fill_1
XFILLER_108_41 vssd1 vccd1 vssd1 vccd1 SS_sky130_ef_sc_hd__decap_40_12
XTAP_TAPCELL_ROW_8_422 vccd1 vssd1 SS_sky130_fd_sc_hd__tapvpwrvgnd_1
XFILLER_108_85 vssd1 vccd1 vssd1 vccd1 SS_sky130_ef_sc_hd__decap_40_12
XFILLER_0_333 vssd1 vccd1 vccd1 vssd1 SS_sky130_fd_sc_hd__fill_2
XFILLER_0_355 vccd1 vssd1 vccd1 vssd1 SS_sky130_fd_sc_hd__fill_1
XFILLER_0_377 vssd1 vccd1 vssd1 vccd1 SS_sky130_ef_sc_hd__decap_40_12
XFILLER_88_473 vssd1 vccd1 vccd1 vssd1 SS_sky130_fd_sc_hd__fill_2
XFILLER_76_657 vccd1 vssd1 vccd1 vssd1 SS_sky130_fd_sc_hd__fill_1
XFILLER_29_573 vssd1 vccd1 vssd1 vccd1 SS_sky130_ef_sc_hd__decap_40_12
XTAP_TAPCELL_ROW_67_1300 vccd1 vssd1 SS_sky130_fd_sc_hd__tapvpwrvgnd_1
XFILLER_75_167 vccd1 vssd1 vccd1 vssd1 SS_sky130_fd_sc_hd__fill_1
XTAP_TAPCELL_ROW_67_1311 vccd1 vssd1 SS_sky130_fd_sc_hd__tapvpwrvgnd_1
XFILLER_84_77 vssd1 vccd1 vccd1 vssd1 SS_sky130_fd_sc_hd__fill_4
XFILLER_90_137 vssd1 vccd1 vccd1 vssd1 SS_sky130_fd_sc_hd__fill_2
XFILLER_16_245 vssd1 vccd1 vccd1 vssd1 SS_sky130_fd_sc_hd__fill_4
XFILLER_17_757 vccd1 vssd1 vccd1 vssd1 SS_sky130_fd_sc_hd__fill_1
XFILLER_32_705 vssd1 vccd1 vccd1 vssd1 SS_sky130_fd_sc_hd__fill_2
XFILLER_16_289 vssd1 vccd1 vssd1 vccd1 SS_sky130_ef_sc_hd__decap_40_12
XFILLER_17_93 vssd1 vccd1 vssd1 vccd1 SS_sky130_ef_sc_hd__decap_40_12
XTAP_TAPCELL_ROW_80_1500 vccd1 vssd1 SS_sky130_fd_sc_hd__tapvpwrvgnd_1
XFILLER_31_237 vssd1 vccd1 vssd1 vccd1 SS_sky130_ef_sc_hd__decap_40_12
XFILLER_12_473 vssd1 vccd1 vccd1 vssd1 SS_sky130_fd_sc_hd__fill_2
XFILLER_129_125 vssd1 vccd1 vssd1 vccd1 SS_sky130_ef_sc_hd__decap_40_12
XFILLER_8_433 vssd1 vccd1 vssd1 vccd1 SS_sky130_ef_sc_hd__decap_40_12
XFILLER_33_81 vssd1 vccd1 vssd1 vccd1 SS_sky130_ef_sc_hd__decap_40_12
XFILLER_8_477 vssd1 vccd1 vssd1 vccd1 SS_sky130_ef_sc_hd__decap_40_12
XFILLER_129_169 vssd1 vccd1 vssd1 vccd1 SS_sky130_ef_sc_hd__decap_40_12
XTAP_TAPCELL_ROW_78_1473 vccd1 vssd1 SS_sky130_fd_sc_hd__tapvpwrvgnd_1
X_1560_ _1560_/Q _1752_/CLK _1560_/D vccd1 vssd1 vccd1 vssd1 SS_sky130_fd_sc_hd__dfxtp_2
XFILLER_125_397 vccd1 vssd1 vccd1 vssd1 SS_sky130_fd_sc_hd__fill_1
X_1491_ _1491_/Q _1747_/CLK _1491_/D vccd1 vssd1 vccd1 vssd1 SS_sky130_fd_sc_hd__dfxtp_2
XFILLER_3_193 vssd1 vccd1 vssd1 vccd1 SS_sky130_ef_sc_hd__decap_40_12
XTAP_TAPCELL_ROW_91_1662 vccd1 vssd1 SS_sky130_fd_sc_hd__tapvpwrvgnd_1
XFILLER_67_613 vssd1 vccd1 vccd1 vssd1 SS_sky130_fd_sc_hd__fill_2
XFILLER_100_209 vssd1 vccd1 vssd1 vccd1 SS_sky130_ef_sc_hd__decap_40_12
XFILLER_12_3 vssd1 vccd1 vssd1 vccd1 SS_sky130_ef_sc_hd__decap_40_12
XFILLER_39_337 vssd1 vccd1 vssd1 vccd1 SS_sky130_ef_sc_hd__decap_40_12
XFILLER_94_443 vssd1 vccd1 vssd1 vccd1 SS_sky130_ef_sc_hd__decap_40_12
XFILLER_54_307 vccd1 vssd1 vccd1 vssd1 SS_sky130_fd_sc_hd__fill_1
XFILLER_63_841 vccd1 vssd1 vccd1 vssd1 SS_sky130_fd_sc_hd__fill_1
XFILLER_66_189 vssd1 vccd1 vccd1 vssd1 SS_sky130_fd_sc_hd__fill_4
XFILLER_81_137 vssd1 vccd1 vssd1 vccd1 SS_sky130_ef_sc_hd__decap_40_12
XFILLER_23_727 vccd1 vssd1 vccd1 vssd1 SS_sky130_fd_sc_hd__fill_1
XFILLER_90_671 vccd1 vssd1 vccd1 vssd1 SS_sky130_fd_sc_hd__fill_1
XFILLER_13_18 vssd1 vccd1 vssd1 vccd1 SS_sky130_ef_sc_hd__decap_40_12
XTAP_TAPCELL_ROW_33_788 vccd1 vssd1 SS_sky130_fd_sc_hd__tapvpwrvgnd_1
XFILLER_31_782 vssd1 vccd1 vccd1 vssd1 SS_sky130_fd_sc_hd__fill_2
XTAP_TAPCELL_ROW_33_799 vccd1 vssd1 SS_sky130_fd_sc_hd__tapvpwrvgnd_1
X_1827_ vccd1 vssd1 _1827_/X _1827_/A vccd1 vssd1 SS_sky130_fd_sc_hd__buf_2
XTAP_TAPCELL_ROW_13_490 vccd1 vssd1 SS_sky130_fd_sc_hd__tapvpwrvgnd_1
XFILLER_108_309 vssd1 vccd1 vssd1 vccd1 SS_sky130_ef_sc_hd__decap_40_12
X_1758_ _1758_/Q _1758_/CLK _1758_/D vccd1 vssd1 vccd1 vssd1 SS_sky130_fd_sc_hd__dfxtp_2
XTAP_TAPCELL_ROW_133_2290 vccd1 vssd1 SS_sky130_fd_sc_hd__tapvpwrvgnd_1
XFILLER_132_813 vssd1 vccd1 vccd1 vssd1 SS_sky130_fd_sc_hd__fill_4
XFILLER_116_342 vssd1 vccd1 vssd1 vccd1 SS_sky130_ef_sc_hd__decap_40_12
XFILLER_89_237 vssd1 vccd1 vssd1 vccd1 SS_sky130_ef_sc_hd__decap_40_12
X_1689_ _1689_/Q _1754_/CLK _1689_/D vccd1 vssd1 vccd1 vssd1 SS_sky130_fd_sc_hd__dfxtp_2
XFILLER_38_26 vssd1 vccd1 vccd1 vssd1 SS_sky130_fd_sc_hd__fill_2
XFILLER_58_613 vssd1 vccd1 vssd1 vccd1 SS_sky130_ef_sc_hd__decap_40_12
XFILLER_131_389 vssd1 vccd1 vccd1 vssd1 SS_sky130_fd_sc_hd__fill_2
XFILLER_98_793 vssd1 vccd1 vccd1 vssd1 SS_sky130_fd_sc_hd__fill_4
XFILLER_58_657 vssd1 vccd1 vssd1 vccd1 SS_sky130_ef_sc_hd__decap_40_12
XFILLER_97_281 vssd1 vccd1 vssd1 vccd1 SS_sky130_ef_sc_hd__decap_40_12
XFILLER_57_167 vccd1 vssd1 vccd1 vssd1 SS_sky130_fd_sc_hd__fill_1
XTAP_TAPCELL_ROW_107_1901 vccd1 vssd1 SS_sky130_fd_sc_hd__tapvpwrvgnd_1
XFILLER_45_329 vssd1 vccd1 vccd1 vssd1 SS_sky130_fd_sc_hd__fill_4
XFILLER_72_137 vssd1 vccd1 vccd1 vssd1 SS_sky130_fd_sc_hd__fill_2
XTAP_TAPCELL_ROW_107_1912 vccd1 vssd1 SS_sky130_fd_sc_hd__tapvpwrvgnd_1
XFILLER_100_798 vssd1 vccd1 vccd1 vssd1 SS_sky130_fd_sc_hd__fill_4
XTAP_TAPCELL_ROW_49_1030 vccd1 vssd1 SS_sky130_fd_sc_hd__tapvpwrvgnd_1
XTAP_TAPCELL_ROW_49_1041 vccd1 vssd1 SS_sky130_fd_sc_hd__tapvpwrvgnd_1
XFILLER_26_587 vccd1 vssd1 vccd1 vssd1 SS_sky130_fd_sc_hd__fill_1
XFILLER_53_373 vssd1 vccd1 vssd1 vccd1 SS_sky130_ef_sc_hd__decap_40_12
XFILLER_81_671 vccd1 vssd1 vccd1 vssd1 SS_sky130_fd_sc_hd__fill_1
XFILLER_13_237 vssd1 vccd1 vssd1 vccd1 SS_sky130_ef_sc_hd__decap_40_12
XFILLER_14_749 vssd1 vccd1 vccd1 vssd1 SS_sky130_fd_sc_hd__fill_4
XTAP_TAPCELL_ROW_62_1230 vccd1 vssd1 SS_sky130_fd_sc_hd__tapvpwrvgnd_1
XFILLER_110_53 vssd1 vccd1 vssd1 vccd1 SS_sky130_ef_sc_hd__decap_40_12
XFILLER_21_281 vssd1 vccd1 vssd1 vccd1 SS_sky130_ef_sc_hd__decap_40_12
XFILLER_110_97 vssd1 vccd1 vssd1 vccd1 SS_sky130_ef_sc_hd__decap_40_12
XFILLER_5_447 vccd1 vssd1 vccd1 vssd1 SS_sky130_fd_sc_hd__fill_1
XFILLER_126_139 vccd1 vssd1 vccd1 vssd1 SS_sky130_fd_sc_hd__fill_1
XFILLER_119_51 vssd1 vccd1 vccd1 vssd1 SS_sky130_fd_sc_hd__fill_4
XFILLER_135_673 vssd1 vccd1 vssd1 vccd1 SS_sky130_ef_sc_hd__decap_40_12
XFILLER_79_55 vccd1 vssd1 vccd1 vssd1 SS_sky130_fd_sc_hd__fill_1
XFILLER_1_653 vssd1 vccd1 vssd1 vccd1 SS_sky130_ef_sc_hd__decap_40_12
XFILLER_0_141 vssd1 vccd1 vssd1 vccd1 SS_sky130_ef_sc_hd__decap_40_12
XTAP_TAPCELL_ROW_73_1392 vccd1 vssd1 SS_sky130_fd_sc_hd__tapvpwrvgnd_1
XFILLER_122_389 vssd1 vccd1 vssd1 vccd1 SS_sky130_ef_sc_hd__decap_40_12
XFILLER_110_518 vssd1 vccd1 vssd1 vccd1 SS_sky130_ef_sc_hd__decap_40_12
XFILLER_1_697 vssd1 vccd1 vssd1 vccd1 SS_sky130_ef_sc_hd__decap_40_12
XFILLER_76_421 vssd1 vccd1 vssd1 vccd1 SS_sky130_ef_sc_hd__decap_40_12
XFILLER_36_307 vccd1 vssd1 vccd1 vssd1 SS_sky130_fd_sc_hd__fill_1
XFILLER_28_81 vssd1 vccd1 vccd1 vssd1 SS_sky130_fd_sc_hd__fill_2
XFILLER_48_189 vssd1 vccd1 vccd1 vssd1 SS_sky130_fd_sc_hd__fill_4
XFILLER_63_137 vssd1 vccd1 vssd1 vccd1 SS_sky130_ef_sc_hd__decap_40_12
XFILLER_45_841 vccd1 vssd1 vccd1 vssd1 SS_sky130_fd_sc_hd__fill_1
XFILLER_32_513 vssd1 vccd1 vssd1 vccd1 SS_sky130_ef_sc_hd__decap_40_12
XFILLER_60_811 vccd1 vssd1 vccd1 vssd1 SS_sky130_fd_sc_hd__fill_1
XFILLER_72_682 vssd1 vccd1 vssd1 vccd1 SS_sky130_ef_sc_hd__decap_40_12
XFILLER_32_557 vssd1 vccd1 vssd1 vccd1 SS_sky130_ef_sc_hd__decap_40_12
XFILLER_71_181 vssd1 vccd1 vssd1 vccd1 SS_sky130_ef_sc_hd__decap_40_12
XFILLER_32_579 vccd1 vssd1 vccd1 vssd1 SS_sky130_fd_sc_hd__fill_1
X_0991_ vssd1 vccd1 vccd1 vssd1 wire253/X input33/X _1528_/D _1451_/C1 _0990_/X SS_sky130_fd_sc_hd__o211a_2
XFILLER_9_753 vssd1 vccd1 vssd1 vccd1 SS_sky130_ef_sc_hd__decap_40_12
XFILLER_13_782 vssd1 vccd1 vccd1 vssd1 SS_sky130_fd_sc_hd__fill_2
XFILLER_13_793 vssd1 vccd1 vssd1 vccd1 SS_sky130_ef_sc_hd__decap_40_12
XTAP_TAPCELL_ROW_30_747 vccd1 vssd1 SS_sky130_fd_sc_hd__tapvpwrvgnd_1
XFILLER_81_6 vssd1 vccd1 vssd1 vccd1 SS_sky130_ef_sc_hd__decap_40_12
XFILLER_9_797 vssd1 vccd1 vssd1 vccd1 SS_sky130_ef_sc_hd__decap_40_12
X_1612_ _1872_/A clkload9/A _1612_/D vccd1 vssd1 vccd1 vssd1 SS_sky130_fd_sc_hd__dfxtp_2
XTAP_TAPCELL_ROW_93_1702 vccd1 vssd1 SS_sky130_fd_sc_hd__tapvpwrvgnd_1
XFILLER_132_109 vssd1 vccd1 vssd1 vccd1 SS_sky130_ef_sc_hd__decap_40_12
XFILLER_126_651 vccd1 vssd1 vccd1 vssd1 SS_sky130_fd_sc_hd__fill_1
X_1543_ _1830_/A _1608_/CLK _1543_/D vccd1 vssd1 vccd1 vssd1 SS_sky130_fd_sc_hd__dfxtp_2
XFILLER_125_161 vssd1 vccd1 vccd1 vssd1 SS_sky130_fd_sc_hd__fill_4
XFILLER_114_835 vccd1 vssd1 vccd1 vssd1 SS_sky130_fd_sc_hd__fill_1
Xfanout209 vssd1 vccd1 vccd1 vssd1 _1468_/B _1472_/B SS_sky130_fd_sc_hd__clkdlybuf4s25_1
X_1474_ _1474_/Q _1754_/CLK _1474_/D vccd1 vssd1 vccd1 vssd1 SS_sky130_fd_sc_hd__dfxtp_2
XFILLER_99_557 vssd1 vccd1 vccd1 vssd1 SS_sky130_fd_sc_hd__fill_2
XFILLER_101_529 vssd1 vccd1 vssd1 vccd1 SS_sky130_ef_sc_hd__decap_40_12
XFILLER_79_281 vssd1 vccd1 vssd1 vccd1 SS_sky130_ef_sc_hd__decap_40_12
XFILLER_95_741 vssd1 vccd1 vssd1 vccd1 SS_sky130_ef_sc_hd__decap_40_12
XFILLER_28_819 vccd1 vssd1 vccd1 vssd1 SS_sky130_fd_sc_hd__fill_1
XFILLER_39_167 vccd1 vssd1 vccd1 vssd1 SS_sky130_fd_sc_hd__fill_1
XFILLER_94_251 vccd1 vssd1 vccd1 vssd1 SS_sky130_fd_sc_hd__fill_1
XFILLER_27_329 vssd1 vccd1 vccd1 vssd1 SS_sky130_fd_sc_hd__fill_4
XFILLER_55_638 vssd1 vccd1 vssd1 vccd1 SS_sky130_ef_sc_hd__decap_40_12
XFILLER_82_413 vssd1 vccd1 vccd1 vssd1 SS_sky130_fd_sc_hd__fill_4
XTAP_TAPCELL_ROW_38_869 vccd1 vssd1 SS_sky130_fd_sc_hd__tapvpwrvgnd_1
XFILLER_54_137 vssd1 vccd1 vccd1 vssd1 SS_sky130_fd_sc_hd__fill_2
XTAP_TAPCELL_ROW_18_571 vccd1 vssd1 SS_sky130_fd_sc_hd__tapvpwrvgnd_1
XFILLER_35_373 vssd1 vccd1 vssd1 vccd1 SS_sky130_ef_sc_hd__decap_40_12
XFILLER_23_557 vssd1 vccd1 vccd1 vssd1 SS_sky130_fd_sc_hd__fill_2
XFILLER_50_321 vssd1 vccd1 vssd1 vccd1 SS_sky130_ef_sc_hd__decap_40_12
XTAP_TAPCELL_ROW_102_1831 vccd1 vssd1 SS_sky130_fd_sc_hd__tapvpwrvgnd_1
XFILLER_50_365 vssd1 vccd1 vssd1 vccd1 SS_sky130_ef_sc_hd__decap_40_12
XFILLER_40_27 vccd1 vssd1 vccd1 vssd1 SS_sky130_fd_sc_hd__fill_1
XTAP_TAPCELL_ROW_135_2330 vccd1 vssd1 SS_sky130_fd_sc_hd__tapvpwrvgnd_1
XFILLER_136_404 vssd1 vccd1 vccd1 vssd1 SS_sky130_fd_sc_hd__fill_4
XFILLER_109_629 vssd1 vccd1 vssd1 vccd1 SS_sky130_ef_sc_hd__decap_40_12
XFILLER_108_139 vccd1 vssd1 vccd1 vssd1 SS_sky130_fd_sc_hd__fill_1
XFILLER_123_109 vssd1 vccd1 vccd1 vssd1 SS_sky130_fd_sc_hd__fill_2
XFILLER_105_813 vccd1 vssd1 vccd1 vssd1 SS_sky130_fd_sc_hd__fill_1
XFILLER_2_417 vssd1 vccd1 vccd1 vssd1 SS_sky130_fd_sc_hd__fill_2
XFILLER_117_673 vccd1 vssd1 vccd1 vssd1 SS_sky130_fd_sc_hd__fill_1
XFILLER_104_301 vssd1 vccd1 vccd1 vssd1 SS_sky130_fd_sc_hd__fill_4
XFILLER_132_643 vccd1 vssd1 vccd1 vssd1 SS_sky130_fd_sc_hd__fill_1
XFILLER_132_665 vssd1 vccd1 vccd1 vssd1 SS_sky130_fd_sc_hd__fill_2
XFILLER_120_805 vccd1 vssd1 vccd1 vssd1 SS_sky130_fd_sc_hd__fill_1
XFILLER_104_356 vssd1 vccd1 vccd1 vssd1 SS_sky130_fd_sc_hd__fill_8
XFILLER_49_69 vssd1 vccd1 vssd1 vccd1 SS_sky130_ef_sc_hd__decap_40_12
XTAP_TAPCELL_ROW_113_1993 vccd1 vssd1 SS_sky130_fd_sc_hd__tapvpwrvgnd_1
XFILLER_104_367 vccd1 vssd1 vccd1 vssd1 SS_sky130_fd_sc_hd__fill_1
XFILLER_58_421 vssd1 vccd1 vssd1 vccd1 SS_sky130_ef_sc_hd__decap_40_12
XFILLER_18_307 vccd1 vssd1 vccd1 vssd1 SS_sky130_fd_sc_hd__fill_1
XFILLER_39_690 vccd1 vssd1 vccd1 vssd1 SS_sky130_fd_sc_hd__fill_1
XFILLER_46_638 vssd1 vccd1 vccd1 vssd1 SS_sky130_fd_sc_hd__fill_4
XFILLER_65_57 vssd1 vccd1 vssd1 vccd1 SS_sky130_ef_sc_hd__decap_40_12
XFILLER_85_273 vssd1 vccd1 vccd1 vssd1 SS_sky130_fd_sc_hd__fill_4
XFILLER_27_841 vccd1 vssd1 vccd1 vssd1 SS_sky130_fd_sc_hd__fill_1
XFILLER_45_137 vssd1 vccd1 vssd1 vccd1 SS_sky130_ef_sc_hd__decap_40_12
XFILLER_73_446 vssd1 vccd1 vccd1 vssd1 SS_sky130_fd_sc_hd__fill_2
XFILLER_14_513 vssd1 vccd1 vssd1 vccd1 SS_sky130_ef_sc_hd__decap_40_12
XFILLER_42_811 vccd1 vssd1 vccd1 vssd1 SS_sky130_fd_sc_hd__fill_1
XFILLER_121_30 vssd1 vccd1 vssd1 vccd1 SS_sky130_ef_sc_hd__decap_40_12
XFILLER_14_557 vssd1 vccd1 vssd1 vccd1 SS_sky130_ef_sc_hd__decap_40_12
XFILLER_53_181 vssd1 vccd1 vssd1 vccd1 SS_sky130_ef_sc_hd__decap_40_12
XFILLER_6_701 vssd1 vccd1 vssd1 vccd1 SS_sky130_ef_sc_hd__decap_40_12
XFILLER_14_83 vccd1 vssd1 vccd1 vssd1 SS_sky130_fd_sc_hd__fill_1
XFILLER_127_437 vssd1 vccd1 vccd1 vssd1 SS_sky130_fd_sc_hd__fill_8
XFILLER_5_277 vssd1 vccd1 vccd1 vssd1 SS_sky130_fd_sc_hd__fill_2
XTAP_TAPCELL_ROW_75_1421 vccd1 vssd1 SS_sky130_fd_sc_hd__tapvpwrvgnd_1
XTAP_TAPCELL_ROW_75_1432 vccd1 vssd1 SS_sky130_fd_sc_hd__tapvpwrvgnd_1
XFILLER_123_621 vssd1 vccd1 vccd1 vssd1 SS_sky130_fd_sc_hd__fill_2
XFILLER_114_109 vssd1 vccd1 vssd1 vccd1 SS_sky130_ef_sc_hd__decap_40_12
XFILLER_107_161 vssd1 vccd1 vccd1 vssd1 SS_sky130_fd_sc_hd__fill_4
XFILLER_123_632 vssd1 vccd1 vssd1 vccd1 SS_sky130_ef_sc_hd__decap_40_12
XFILLER_1_461 vssd1 vccd1 vssd1 vccd1 SS_sky130_ef_sc_hd__decap_40_12
XFILLER_122_153 vssd1 vccd1 vssd1 vccd1 SS_sky130_ef_sc_hd__decap_40_12
XFILLER_77_741 vssd1 vccd1 vccd1 vssd1 SS_sky130_fd_sc_hd__fill_8
XFILLER_122_197 vssd1 vccd1 vssd1 vccd1 SS_sky130_ef_sc_hd__decap_40_12
XFILLER_76_251 vccd1 vssd1 vccd1 vssd1 SS_sky130_fd_sc_hd__fill_1
XFILLER_77_785 vssd1 vccd1 vssd1 vccd1 SS_sky130_ef_sc_hd__decap_40_12
X_1190_ vccd1 vssd1 vccd1 vssd1 _1190_/X _1190_/A _1208_/B SS_sky130_fd_sc_hd__or2_2
Xinput9 vssd1 vccd1 vccd1 vssd1 adc_data[6] input9/X SS_sky130_fd_sc_hd__clkdlybuf4s25_1
XFILLER_64_413 vssd1 vccd1 vccd1 vssd1 SS_sky130_fd_sc_hd__fill_4
XFILLER_92_733 vssd1 vccd1 vccd1 vssd1 SS_sky130_fd_sc_hd__fill_2
XFILLER_36_137 vssd1 vccd1 vccd1 vssd1 SS_sky130_fd_sc_hd__fill_2
XFILLER_91_221 vssd1 vccd1 vccd1 vssd1 SS_sky130_fd_sc_hd__fill_2
XFILLER_92_755 vccd1 vssd1 vccd1 vssd1 SS_sky130_fd_sc_hd__fill_1
XFILLER_17_373 vssd1 vccd1 vssd1 vccd1 SS_sky130_ef_sc_hd__decap_40_12
XTAP_TAPCELL_ROW_35_828 vccd1 vssd1 SS_sky130_fd_sc_hd__tapvpwrvgnd_1
XFILLER_45_671 vccd1 vssd1 vccd1 vssd1 SS_sky130_fd_sc_hd__fill_1
XTAP_TAPCELL_ROW_86_1583 vccd1 vssd1 SS_sky130_fd_sc_hd__tapvpwrvgnd_1
XFILLER_32_321 vssd1 vccd1 vssd1 vccd1 SS_sky130_ef_sc_hd__decap_40_12
XTAP_TAPCELL_ROW_86_1594 vccd1 vssd1 SS_sky130_fd_sc_hd__tapvpwrvgnd_1
XTAP_TAPCELL_ROW_15_530 vccd1 vssd1 SS_sky130_fd_sc_hd__tapvpwrvgnd_1
XFILLER_32_365 vssd1 vccd1 vssd1 vccd1 SS_sky130_ef_sc_hd__decap_40_12
XFILLER_9_561 vssd1 vccd1 vssd1 vccd1 SS_sky130_ef_sc_hd__decap_40_12
X_0974_ vccd1 vssd1 vccd1 vssd1 _0974_/X _0974_/A _0984_/B SS_sky130_fd_sc_hd__or2_2
XTAP_TAPCELL_ROW_117_2060 vccd1 vssd1 SS_sky130_fd_sc_hd__tapvpwrvgnd_1
XFILLER_105_109 vssd1 vccd1 vccd1 vssd1 SS_sky130_fd_sc_hd__fill_2
X_1526_ _1526_/Q _1686_/CLK _1526_/D vccd1 vssd1 vccd1 vssd1 SS_sky130_fd_sc_hd__dfxtp_2
XFILLER_87_505 vssd1 vccd1 vccd1 vssd1 SS_sky130_fd_sc_hd__fill_4
XFILLER_99_376 vssd1 vccd1 vssd1 vccd1 SS_sky130_ef_sc_hd__decap_40_12
X_1457_ vssd1 vccd1 vccd1 vssd1 wire207/A input35/X _1754_/D _1457_/C1 _1456_/X SS_sky130_fd_sc_hd__o211a_2
XFILLER_101_337 vssd1 vccd1 vssd1 vccd1 SS_sky130_ef_sc_hd__decap_40_12
XFILLER_19_39 vssd1 vccd1 vssd1 vccd1 SS_sky130_ef_sc_hd__decap_40_12
X_1388_ vccd1 vssd1 vccd1 vssd1 _1388_/X _1388_/A _1396_/B SS_sky130_fd_sc_hd__or2_2
XFILLER_67_273 vssd1 vccd1 vccd1 vssd1 SS_sky130_fd_sc_hd__fill_4
XFILLER_95_593 vccd1 vssd1 vccd1 vssd1 SS_sky130_fd_sc_hd__fill_1
XFILLER_27_137 vssd1 vccd1 vssd1 vccd1 SS_sky130_ef_sc_hd__decap_40_12
XFILLER_82_221 vssd1 vccd1 vssd1 vccd1 SS_sky130_ef_sc_hd__decap_40_12
XFILLER_83_777 vssd1 vccd1 vccd1 vssd1 SS_sky130_fd_sc_hd__fill_4
XFILLER_24_811 vccd1 vssd1 vccd1 vssd1 SS_sky130_fd_sc_hd__fill_1
XFILLER_35_27 vssd1 vccd1 vssd1 vccd1 SS_sky130_ef_sc_hd__decap_40_12
XFILLER_82_265 vssd1 vccd1 vssd1 vccd1 SS_sky130_ef_sc_hd__decap_40_12
XFILLER_35_181 vssd1 vccd1 vssd1 vccd1 SS_sky130_ef_sc_hd__decap_40_12
XFILLER_36_693 vssd1 vccd1 vccd1 vssd1 SS_sky130_fd_sc_hd__fill_4
XFILLER_11_505 vssd1 vccd1 vssd1 vccd1 SS_sky130_ef_sc_hd__decap_40_12
XFILLER_50_195 vccd1 vssd1 vccd1 vssd1 SS_sky130_fd_sc_hd__fill_1
Xwire407 vccd1 vssd1 vssd1 vccd1 wire407/A analog_ctrl[74] SS_sky130_fd_sc_hd__buf_12
XFILLER_136_201 vssd1 vccd1 vccd1 vssd1 SS_sky130_fd_sc_hd__fill_2
XFILLER_136_223 vssd1 vccd1 vssd1 vccd1 SS_sky130_ef_sc_hd__decap_40_12
XFILLER_137_779 vssd1 vccd1 vccd1 vssd1 SS_sky130_fd_sc_hd__fill_4
XFILLER_136_289 vssd1 vccd1 vssd1 vccd1 SS_sky130_ef_sc_hd__decap_40_12
XFILLER_105_621 vssd1 vccd1 vccd1 vssd1 SS_sky130_fd_sc_hd__fill_2
XTAP_TAPCELL_ROW_57_1151 vccd1 vssd1 SS_sky130_fd_sc_hd__tapvpwrvgnd_1
XTAP_TAPCELL_ROW_57_1162 vccd1 vssd1 SS_sky130_fd_sc_hd__tapvpwrvgnd_1
XFILLER_105_632 vssd1 vccd1 vssd1 vccd1 SS_sky130_ef_sc_hd__decap_40_12
XFILLER_78_505 vssd1 vccd1 vccd1 vssd1 SS_sky130_fd_sc_hd__fill_2
XFILLER_78_516 vssd1 vccd1 vssd1 vccd1 SS_sky130_ef_sc_hd__decap_40_12
XFILLER_116_41 vssd1 vccd1 vssd1 vccd1 SS_sky130_ef_sc_hd__decap_40_12
XFILLER_104_153 vssd1 vccd1 vssd1 vccd1 SS_sky130_ef_sc_hd__decap_40_12
XFILLER_59_741 vssd1 vccd1 vssd1 vccd1 SS_sky130_ef_sc_hd__decap_40_12
XFILLER_132_495 vssd1 vccd1 vssd1 vccd1 SS_sky130_ef_sc_hd__decap_40_12
XFILLER_116_85 vssd1 vccd1 vssd1 vccd1 SS_sky130_ef_sc_hd__decap_40_12
XFILLER_104_197 vssd1 vccd1 vssd1 vccd1 SS_sky130_ef_sc_hd__decap_40_12
XFILLER_58_251 vccd1 vssd1 vccd1 vssd1 SS_sky130_fd_sc_hd__fill_1
XTAP_TAPCELL_ROW_70_1351 vccd1 vssd1 SS_sky130_fd_sc_hd__tapvpwrvgnd_1
XFILLER_59_785 vssd1 vccd1 vssd1 vccd1 SS_sky130_ef_sc_hd__decap_40_12
XFILLER_18_137 vssd1 vccd1 vccd1 vssd1 SS_sky130_fd_sc_hd__fill_2
XFILLER_73_221 vssd1 vccd1 vccd1 vssd1 SS_sky130_fd_sc_hd__fill_2
XFILLER_74_755 vccd1 vssd1 vccd1 vssd1 SS_sky130_fd_sc_hd__fill_1
XFILLER_27_671 vccd1 vssd1 vccd1 vssd1 SS_sky130_fd_sc_hd__fill_1
XFILLER_14_321 vssd1 vccd1 vssd1 vccd1 SS_sky130_ef_sc_hd__decap_40_12
XFILLER_61_449 vssd1 vccd1 vccd1 vssd1 SS_sky130_fd_sc_hd__fill_4
XFILLER_92_77 vssd1 vccd1 vccd1 vssd1 SS_sky130_fd_sc_hd__fill_4
XFILLER_14_365 vssd1 vccd1 vssd1 vccd1 SS_sky130_ef_sc_hd__decap_40_12
XFILLER_25_93 vssd1 vccd1 vssd1 vccd1 SS_sky130_ef_sc_hd__decap_40_12
XFILLER_128_713 vssd1 vccd1 vssd1 vccd1 SS_sky130_ef_sc_hd__decap_40_12
XTAP_TAPCELL_ROW_40_897 vccd1 vssd1 SS_sky130_fd_sc_hd__tapvpwrvgnd_1
XFILLER_128_757 vssd1 vccd1 vssd1 vccd1 SS_sky130_ef_sc_hd__decap_40_12
XFILLER_127_223 vccd1 vssd1 vccd1 vssd1 SS_sky130_fd_sc_hd__fill_1
XFILLER_6_531 vccd1 vssd1 vccd1 vssd1 SS_sky130_fd_sc_hd__fill_1
XFILLER_41_81 vssd1 vccd1 vssd1 vccd1 SS_sky130_ef_sc_hd__decap_40_12
XFILLER_115_429 vssd1 vccd1 vssd1 vccd1 SS_sky130_ef_sc_hd__decap_40_12
XFILLER_69_505 vssd1 vccd1 vssd1 vccd1 SS_sky130_ef_sc_hd__decap_40_12
XFILLER_2_781 vssd1 vccd1 vssd1 vccd1 SS_sky130_ef_sc_hd__decap_40_12
X_1311_ vssd1 vccd1 vccd1 vssd1 _1319_/A2 input27/X _1683_/D _1441_/C1 _1310_/X SS_sky130_fd_sc_hd__o211a_2
XFILLER_2_53 vssd1 vccd1 vssd1 vccd1 SS_sky130_ef_sc_hd__decap_40_12
XPHY_EDGE_ROW_10_Right_10 vccd1 vssd1 vccd1 vssd1 SS_sky130_fd_sc_hd__decap_3
X_1242_ vccd1 vssd1 vccd1 vssd1 _1242_/X _1650_/Q _1264_/B SS_sky130_fd_sc_hd__or2_2
XFILLER_49_273 vssd1 vccd1 vccd1 vssd1 SS_sky130_fd_sc_hd__fill_4
XTAP_TAPCELL_ROW_88_1623 vccd1 vssd1 SS_sky130_fd_sc_hd__tapvpwrvgnd_1
XFILLER_110_189 vssd1 vccd1 vccd1 vssd1 SS_sky130_fd_sc_hd__fill_4
XFILLER_2_97 vssd1 vccd1 vssd1 vccd1 SS_sky130_ef_sc_hd__decap_40_12
X_1173_ vssd1 vccd1 vccd1 vssd1 wire233/A input24/X _1616_/D _1445_/C1 _1172_/X SS_sky130_fd_sc_hd__o211a_2
XFILLER_64_221 vssd1 vccd1 vssd1 vccd1 SS_sky130_ef_sc_hd__decap_40_12
XFILLER_64_265 vssd1 vccd1 vssd1 vccd1 SS_sky130_ef_sc_hd__decap_40_12
XFILLER_80_725 vssd1 vccd1 vssd1 vccd1 SS_sky130_ef_sc_hd__decap_40_12
XFILLER_92_585 vssd1 vccd1 vccd1 vssd1 SS_sky130_fd_sc_hd__fill_2
XFILLER_17_181 vssd1 vccd1 vssd1 vccd1 SS_sky130_ef_sc_hd__decap_40_12
XFILLER_18_693 vssd1 vccd1 vccd1 vssd1 SS_sky130_fd_sc_hd__fill_4
XFILLER_52_449 vccd1 vssd1 vccd1 vssd1 SS_sky130_fd_sc_hd__fill_1
XFILLER_80_769 vssd1 vccd1 vssd1 vccd1 SS_sky130_ef_sc_hd__decap_40_12
XFILLER_33_641 vssd1 vccd1 vssd1 vccd1 SS_sky130_ef_sc_hd__decap_40_12
XFILLER_33_685 vssd1 vccd1 vccd1 vssd1 SS_sky130_fd_sc_hd__fill_8
XFILLER_20_357 vssd1 vccd1 vccd1 vssd1 SS_sky130_fd_sc_hd__fill_4
XFILLER_32_195 vccd1 vssd1 vccd1 vssd1 SS_sky130_fd_sc_hd__fill_1
XFILLER_60_493 vssd1 vccd1 vccd1 vssd1 SS_sky130_fd_sc_hd__fill_2
XFILLER_21_18 vssd1 vccd1 vssd1 vccd1 SS_sky130_ef_sc_hd__decap_40_12
X_0957_ vssd1 vccd1 vccd1 vssd1 _0989_/A2 input46/X _1511_/D _1165_/C1 _0956_/X SS_sky130_fd_sc_hd__o211a_2
XTAP_TAPCELL_ROW_115_2019 vccd1 vssd1 SS_sky130_fd_sc_hd__tapvpwrvgnd_1
XFILLER_9_391 vccd1 vssd1 vccd1 vssd1 SS_sky130_fd_sc_hd__fill_1
XFILLER_118_245 vssd1 vccd1 vccd1 vssd1 SS_sky130_fd_sc_hd__fill_4
XTAP_TAPCELL_ROW_99_1785 vccd1 vssd1 SS_sky130_fd_sc_hd__tapvpwrvgnd_1
Xoutput110 vccd1 vssd1 wire334/A _1868_/X vccd1 vssd1 SS_sky130_fd_sc_hd__buf_4
XFILLER_118_289 vssd1 vccd1 vccd1 vssd1 SS_sky130_fd_sc_hd__fill_8
X_0888_ vccd1 vssd1 vccd1 vssd1 _1529_/Q _0947_/A _1689_/Q _0891_/B1 _0889_/C SS_sky130_fd_sc_hd__a22o_2
Xclkbuf_leaf_28_wb_clk_i _1573_/CLK clkload1/A vccd1 vssd1 vssd1 vccd1 SS_sky130_fd_sc_hd__clkbuf_8
Xoutput121 vccd1 vssd1 wire323/A _1878_/X vccd1 vssd1 SS_sky130_fd_sc_hd__buf_4
Xoutput132 vccd1 vssd1 wire312/A _1888_/X vccd1 vssd1 SS_sky130_fd_sc_hd__buf_4
Xoutput143 vccd1 vssd1 wire408/A _1644_/Q vccd1 vssd1 SS_sky130_fd_sc_hd__buf_4
XFILLER_133_237 vssd1 vccd1 vssd1 vccd1 SS_sky130_ef_sc_hd__decap_40_12
XFILLER_0_729 vssd1 vccd1 vssd1 vccd1 SS_sky130_ef_sc_hd__decap_40_12
Xoutput176 vccd1 vssd1 wire379/A _1489_/Q vccd1 vssd1 SS_sky130_fd_sc_hd__buf_4
XFILLER_114_473 vssd1 vccd1 vccd1 vssd1 SS_sky130_fd_sc_hd__fill_2
Xoutput165 vccd1 vssd1 wire387/A _1665_/Q vccd1 vssd1 SS_sky130_fd_sc_hd__buf_4
XFILLER_102_613 vssd1 vccd1 vccd1 vssd1 SS_sky130_fd_sc_hd__fill_2
Xoutput154 vccd1 vssd1 wire397/A _1655_/Q vccd1 vssd1 SS_sky130_fd_sc_hd__buf_4
X_1509_ _1833_/A _1573_/CLK _1509_/D vccd1 vssd1 vccd1 vssd1 SS_sky130_fd_sc_hd__dfxtp_2
XFILLER_87_335 vccd1 vssd1 vccd1 vssd1 SS_sky130_fd_sc_hd__fill_1
Xoutput198 vccd1 vssd1 wire357/A _1480_/Q vccd1 vssd1 SS_sky130_fd_sc_hd__buf_4
Xoutput187 vccd1 vssd1 wire368/A _1499_/Q vccd1 vssd1 SS_sky130_fd_sc_hd__buf_4
XTAP_TAPCELL_ROW_110_1952 vccd1 vssd1 SS_sky130_fd_sc_hd__tapvpwrvgnd_1
XFILLER_102_657 vssd1 vccd1 vssd1 vccd1 SS_sky130_ef_sc_hd__decap_40_12
XFILLER_28_413 vssd1 vccd1 vccd1 vssd1 SS_sky130_fd_sc_hd__fill_4
XTAP_TAPCELL_ROW_52_1081 vccd1 vssd1 SS_sky130_fd_sc_hd__tapvpwrvgnd_1
XFILLER_101_167 vccd1 vssd1 vccd1 vssd1 SS_sky130_fd_sc_hd__fill_1
XFILLER_28_457 vssd1 vccd1 vssd1 vccd1 SS_sky130_ef_sc_hd__decap_40_12
XFILLER_46_26 vssd1 vccd1 vccd1 vssd1 SS_sky130_fd_sc_hd__fill_2
XFILLER_55_221 vssd1 vccd1 vccd1 vssd1 SS_sky130_fd_sc_hd__fill_2
XPHY_EDGE_ROW_106_Right_106 vccd1 vssd1 vccd1 vssd1 SS_sky130_fd_sc_hd__decap_3
XFILLER_95_390 vssd1 vccd1 vccd1 vssd1 SS_sky130_fd_sc_hd__fill_2
XFILLER_43_405 vssd1 vccd1 vssd1 vccd1 SS_sky130_ef_sc_hd__decap_40_12
XFILLER_83_585 vssd1 vccd1 vssd1 vccd1 SS_sky130_ef_sc_hd__decap_40_12
XFILLER_43_427 vssd1 vccd1 vssd1 vccd1 SS_sky130_ef_sc_hd__decap_40_12
XFILLER_43_449 vssd1 vccd1 vssd1 vccd1 SS_sky130_ef_sc_hd__decap_40_12
XFILLER_71_758 vssd1 vccd1 vccd1 vssd1 SS_sky130_fd_sc_hd__fill_2
XFILLER_102_65 vssd1 vccd1 vssd1 vccd1 SS_sky130_ef_sc_hd__decap_40_12
XFILLER_24_696 vssd1 vccd1 vccd1 vssd1 SS_sky130_fd_sc_hd__fill_4
XFILLER_11_335 vccd1 vssd1 vccd1 vssd1 SS_sky130_fd_sc_hd__fill_1
XFILLER_7_317 vssd1 vccd1 vssd1 vccd1 SS_sky130_ef_sc_hd__decap_40_12
XFILLER_137_521 vssd1 vccd1 vccd1 vssd1 SS_sky130_fd_sc_hd__fill_2
XFILLER_127_3 vssd1 vccd1 vssd1 vccd1 SS_sky130_ef_sc_hd__decap_40_12
XFILLER_109_223 vccd1 vssd1 vccd1 vssd1 SS_sky130_fd_sc_hd__fill_1
XFILLER_3_501 vssd1 vccd1 vccd1 vssd1 SS_sky130_fd_sc_hd__fill_2
XFILLER_127_51 vssd1 vccd1 vccd1 vssd1 SS_sky130_fd_sc_hd__fill_4
XFILLER_118_790 vssd1 vccd1 vssd1 vccd1 SS_sky130_ef_sc_hd__decap_40_12
XFILLER_87_55 vccd1 vssd1 vccd1 vssd1 SS_sky130_fd_sc_hd__fill_1
XFILLER_133_782 vssd1 vccd1 vccd1 vssd1 SS_sky130_fd_sc_hd__fill_2
XFILLER_120_421 vssd1 vccd1 vccd1 vssd1 SS_sky130_fd_sc_hd__fill_8
XFILLER_105_473 vssd1 vccd1 vssd1 vccd1 SS_sky130_ef_sc_hd__decap_40_12
XFILLER_94_817 vccd1 vssd1 vccd1 vssd1 SS_sky130_fd_sc_hd__fill_1
XTAP_TAPCELL_ROW_6_383 vccd1 vssd1 SS_sky130_fd_sc_hd__tapvpwrvgnd_1
XTAP_TAPCELL_ROW_6_394 vccd1 vssd1 SS_sky130_fd_sc_hd__tapvpwrvgnd_1
XFILLER_93_305 vssd1 vccd1 vssd1 vccd1 SS_sky130_ef_sc_hd__decap_40_12
XFILLER_46_221 vssd1 vccd1 vssd1 vccd1 SS_sky130_ef_sc_hd__decap_40_12
XFILLER_46_265 vssd1 vccd1 vssd1 vccd1 SS_sky130_ef_sc_hd__decap_40_12
XFILLER_47_777 vssd1 vccd1 vccd1 vssd1 SS_sky130_fd_sc_hd__fill_4
XFILLER_62_725 vssd1 vccd1 vssd1 vccd1 SS_sky130_ef_sc_hd__decap_40_12
XFILLER_36_81 vssd1 vccd1 vccd1 vssd1 SS_sky130_fd_sc_hd__fill_2
XFILLER_15_641 vssd1 vccd1 vssd1 vccd1 SS_sky130_ef_sc_hd__decap_40_12
XTAP_TAPCELL_ROW_45_978 vccd1 vssd1 SS_sky130_fd_sc_hd__tapvpwrvgnd_1
XFILLER_62_769 vssd1 vccd1 vssd1 vccd1 SS_sky130_ef_sc_hd__decap_40_12
XTAP_TAPCELL_ROW_83_1542 vccd1 vssd1 SS_sky130_fd_sc_hd__tapvpwrvgnd_1
XFILLER_15_685 vssd1 vccd1 vssd1 vccd1 SS_sky130_ef_sc_hd__decap_40_12
XFILLER_61_279 vccd1 vssd1 vccd1 vssd1 SS_sky130_fd_sc_hd__fill_1
XFILLER_14_195 vccd1 vssd1 vccd1 vssd1 SS_sky130_fd_sc_hd__fill_1
XTAP_TAPCELL_ROW_25_680 vccd1 vssd1 SS_sky130_fd_sc_hd__tapvpwrvgnd_1
XFILLER_42_493 vssd1 vccd1 vccd1 vssd1 SS_sky130_fd_sc_hd__fill_2
X_1860_ vccd1 vssd1 _1860_/X _1860_/A vccd1 vssd1 SS_sky130_fd_sc_hd__buf_2
Xinput12 vssd1 vccd1 vccd1 vssd1 adc_data[9] input12/X SS_sky130_fd_sc_hd__clkdlybuf4s25_1
XFILLER_30_677 vssd1 vccd1 vccd1 vssd1 SS_sky130_fd_sc_hd__fill_2
XFILLER_30_699 vccd1 vssd1 vccd1 vssd1 SS_sky130_fd_sc_hd__fill_1
X_0811_ vssd1 vccd1 vssd1 vccd1 wire435/X _1904_/A _0865_/B1 _0809_/X _0811_/X _0810_/X
+ SS_sky130_fd_sc_hd__a2111o_2
X_0742_ vccd1 vssd1 vccd1 vssd1 _1841_/A wire443/A _1891_/A wire448/X _0742_/X SS_sky130_fd_sc_hd__a22o_2
Xinput23 vssd1 vccd1 wire499/A input23/A vccd1 vssd1 SS_sky130_fd_sc_hd__buf_1
Xinput34 vssd1 vccd1 vccd1 vssd1 input34/A input34/X SS_sky130_fd_sc_hd__clkdlybuf4s25_1
Xinput45 vccd1 vssd1 input45/X input45/A vccd1 vssd1 SS_sky130_fd_sc_hd__buf_2
XFILLER_6_361 vssd1 vccd1 vccd1 vssd1 SS_sky130_fd_sc_hd__fill_2
XFILLER_128_587 vccd1 vssd1 vccd1 vssd1 SS_sky130_fd_sc_hd__fill_1
Xhold807 hold807/X _1498_/Q vccd1 vssd1 vssd1 vccd1 SS_sky130_fd_sc_hd__dlygate4sd3_1
XFILLER_115_237 vssd1 vccd1 vssd1 vccd1 SS_sky130_ef_sc_hd__decap_40_12
XFILLER_42_3 vssd1 vccd1 vssd1 vccd1 SS_sky130_ef_sc_hd__decap_40_12
XFILLER_124_793 vssd1 vccd1 vssd1 vccd1 SS_sky130_ef_sc_hd__decap_40_12
XFILLER_123_281 vssd1 vccd1 vssd1 vccd1 SS_sky130_ef_sc_hd__decap_40_12
XFILLER_111_421 vccd1 vssd1 vccd1 vssd1 SS_sky130_fd_sc_hd__fill_1
XFILLER_96_121 vssd1 vccd1 vssd1 vccd1 SS_sky130_ef_sc_hd__decap_40_12
XFILLER_97_666 vssd1 vccd1 vccd1 vssd1 SS_sky130_fd_sc_hd__fill_4
XFILLER_84_305 vssd1 vccd1 vccd1 vssd1 SS_sky130_fd_sc_hd__fill_2
XFILLER_84_327 vssd1 vccd1 vssd1 vccd1 SS_sky130_ef_sc_hd__decap_40_12
XFILLER_96_165 vssd1 vccd1 vssd1 vccd1 SS_sky130_ef_sc_hd__decap_40_12
XFILLER_37_221 vssd1 vccd1 vccd1 vssd1 SS_sky130_fd_sc_hd__fill_2
X_1225_ vssd1 vccd1 vccd1 vssd1 _1267_/A2 wire497/X _1641_/D _1423_/C1 _1224_/X SS_sky130_fd_sc_hd__o211a_2
XFILLER_25_405 vssd1 vccd1 vssd1 vccd1 SS_sky130_ef_sc_hd__decap_40_12
X_1156_ vccd1 vssd1 vccd1 vssd1 _1156_/X _1156_/A _1186_/B SS_sky130_fd_sc_hd__or2_2
XFILLER_53_725 vssd1 vccd1 vccd1 vssd1 SS_sky130_fd_sc_hd__fill_2
XTAP_TAPCELL_ROW_125_2170 vccd1 vssd1 SS_sky130_fd_sc_hd__tapvpwrvgnd_1
XFILLER_16_18 vssd1 vccd1 vccd1 vssd1 SS_sky130_fd_sc_hd__fill_8
XFILLER_16_29 vssd1 vccd1 vssd1 vccd1 SS_sky130_ef_sc_hd__decap_40_12
XFILLER_25_449 vssd1 vccd1 vssd1 vccd1 SS_sky130_ef_sc_hd__decap_40_12
XFILLER_80_533 vssd1 vccd1 vssd1 vccd1 SS_sky130_ef_sc_hd__decap_40_12
XTAP_TAPCELL_ROW_125_2181 vccd1 vssd1 SS_sky130_fd_sc_hd__tapvpwrvgnd_1
X_1087_ vssd1 vccd1 vccd1 vssd1 wire239/X input45/X _1574_/D _1149_/C1 _1086_/X SS_sky130_fd_sc_hd__o211a_2
XTAP_TAPCELL_ROW_23_639 vccd1 vssd1 SS_sky130_fd_sc_hd__tapvpwrvgnd_1
XFILLER_40_419 vccd1 vssd1 vccd1 vssd1 SS_sky130_fd_sc_hd__fill_1
XFILLER_20_121 vssd1 vccd1 vssd1 vccd1 SS_sky130_ef_sc_hd__decap_40_12
XFILLER_138_307 vccd1 vssd1 vccd1 vssd1 SS_sky130_fd_sc_hd__fill_1
XFILLER_20_165 vssd1 vccd1 vssd1 vccd1 SS_sky130_ef_sc_hd__decap_40_12
XFILLER_4_309 vssd1 vccd1 vssd1 vccd1 SS_sky130_ef_sc_hd__decap_40_12
XFILLER_134_546 vssd1 vccd1 vssd1 vccd1 SS_sky130_ef_sc_hd__decap_40_12
XTAP_TAPCELL_ROW_54_1110 vccd1 vssd1 SS_sky130_fd_sc_hd__tapvpwrvgnd_1
XFILLER_102_421 vssd1 vccd1 vccd1 vssd1 SS_sky130_fd_sc_hd__fill_2
XFILLER_76_817 vccd1 vssd1 vccd1 vssd1 SS_sky130_fd_sc_hd__fill_1
XFILLER_57_69 vssd1 vccd1 vssd1 vccd1 SS_sky130_ef_sc_hd__decap_40_12
XFILLER_75_305 vssd1 vccd1 vssd1 vccd1 SS_sky130_ef_sc_hd__decap_40_12
XFILLER_87_165 vssd1 vccd1 vccd1 vssd1 SS_sky130_fd_sc_hd__fill_2
XFILLER_88_699 vccd1 vssd1 vccd1 vssd1 SS_sky130_fd_sc_hd__fill_1
XTAP_TAPCELL_ROW_3_342 vccd1 vssd1 SS_sky130_fd_sc_hd__tapvpwrvgnd_1
XFILLER_28_221 vssd1 vccd1 vssd1 vccd1 SS_sky130_ef_sc_hd__decap_40_12
XFILLER_75_349 vssd1 vccd1 vssd1 vccd1 SS_sky130_ef_sc_hd__decap_40_12
XFILLER_102_498 vssd1 vccd1 vssd1 vccd1 SS_sky130_ef_sc_hd__decap_40_12
XFILLER_28_265 vssd1 vccd1 vssd1 vccd1 SS_sky130_ef_sc_hd__decap_40_12
XFILLER_113_42 vssd1 vccd1 vssd1 vccd1 SS_sky130_ef_sc_hd__decap_40_12
XFILLER_83_393 vssd1 vccd1 vssd1 vccd1 SS_sky130_ef_sc_hd__decap_40_12
XFILLER_44_769 vssd1 vccd1 vssd1 vccd1 SS_sky130_ef_sc_hd__decap_40_12
XFILLER_73_57 vssd1 vccd1 vssd1 vccd1 SS_sky130_ef_sc_hd__decap_40_12
XTAP_TAPCELL_ROW_42_926 vccd1 vssd1 SS_sky130_fd_sc_hd__tapvpwrvgnd_1
XTAP_TAPCELL_ROW_42_937 vccd1 vssd1 SS_sky130_fd_sc_hd__tapvpwrvgnd_1
XFILLER_43_279 vccd1 vssd1 vccd1 vssd1 SS_sky130_fd_sc_hd__fill_1
XTAP_TAPCELL_ROW_65_1272 vccd1 vssd1 SS_sky130_fd_sc_hd__tapvpwrvgnd_1
XFILLER_8_637 vssd1 vccd1 vccd1 vssd1 SS_sky130_fd_sc_hd__fill_4
XFILLER_11_165 vssd1 vccd1 vccd1 vssd1 SS_sky130_fd_sc_hd__fill_2
XFILLER_7_125 vssd1 vccd1 vssd1 vccd1 SS_sky130_ef_sc_hd__decap_40_12
XFILLER_12_699 vccd1 vssd1 vccd1 vssd1 SS_sky130_fd_sc_hd__fill_1
XFILLER_138_841 vccd1 vssd1 vccd1 vssd1 SS_sky130_fd_sc_hd__fill_1
XFILLER_7_169 vssd1 vccd1 vssd1 vccd1 SS_sky130_ef_sc_hd__decap_40_12
XFILLER_22_83 vccd1 vssd1 vccd1 vssd1 SS_sky130_fd_sc_hd__fill_1
XFILLER_137_351 vssd1 vccd1 vccd1 vssd1 SS_sky130_fd_sc_hd__fill_4
XFILLER_125_502 vssd1 vccd1 vccd1 vssd1 SS_sky130_fd_sc_hd__fill_2
XFILLER_138_83 vccd1 vssd1 vccd1 vssd1 SS_sky130_fd_sc_hd__fill_1
XFILLER_125_557 vssd1 vccd1 vccd1 vssd1 SS_sky130_fd_sc_hd__fill_2
XFILLER_98_419 vccd1 vssd1 vccd1 vssd1 SS_sky130_fd_sc_hd__fill_1
XFILLER_98_65 vssd1 vccd1 vssd1 vccd1 SS_sky130_ef_sc_hd__decap_40_12
XFILLER_67_817 vssd1 vccd1 vccd1 vssd1 SS_sky130_fd_sc_hd__fill_2
XFILLER_78_121 vssd1 vccd1 vssd1 vccd1 SS_sky130_ef_sc_hd__decap_40_12
XFILLER_121_741 vssd1 vccd1 vccd1 vssd1 SS_sky130_fd_sc_hd__fill_4
XFILLER_105_281 vssd1 vccd1 vssd1 vccd1 SS_sky130_ef_sc_hd__decap_40_12
XFILLER_94_603 vccd1 vssd1 vccd1 vssd1 SS_sky130_fd_sc_hd__fill_1
XFILLER_66_305 vssd1 vccd1 vccd1 vssd1 SS_sky130_fd_sc_hd__fill_2
XFILLER_78_165 vssd1 vccd1 vssd1 vccd1 SS_sky130_ef_sc_hd__decap_40_12
XFILLER_121_785 vssd1 vccd1 vssd1 vccd1 SS_sky130_ef_sc_hd__decap_40_12
XFILLER_120_251 vccd1 vssd1 vccd1 vssd1 SS_sky130_fd_sc_hd__fill_1
XFILLER_94_625 vssd1 vccd1 vccd1 vssd1 SS_sky130_fd_sc_hd__fill_4
XFILLER_93_113 vssd1 vccd1 vssd1 vccd1 SS_sky130_ef_sc_hd__decap_40_12
XFILLER_19_221 vssd1 vccd1 vccd1 vssd1 SS_sky130_fd_sc_hd__fill_2
XFILLER_59_390 vssd1 vccd1 vccd1 vssd1 SS_sky130_fd_sc_hd__fill_2
X_1010_ vccd1 vssd1 vccd1 vssd1 _1010_/X _1010_/A _1010_/B SS_sky130_fd_sc_hd__or2_2
XFILLER_62_533 vssd1 vccd1 vccd1 vssd1 SS_sky130_fd_sc_hd__fill_8
XFILLER_74_393 vssd1 vccd1 vccd1 vssd1 SS_sky130_fd_sc_hd__fill_2
XFILLER_22_419 vccd1 vssd1 vccd1 vssd1 SS_sky130_fd_sc_hd__fill_1
XFILLER_50_739 vccd1 vssd1 vccd1 vssd1 SS_sky130_fd_sc_hd__fill_1
XFILLER_8_41 vssd1 vccd1 vssd1 vccd1 SS_sky130_ef_sc_hd__decap_40_12
XFILLER_8_85 vssd1 vccd1 vssd1 vccd1 SS_sky130_ef_sc_hd__decap_40_12
X_1843_ vccd1 vssd1 _1843_/X _1843_/A vccd1 vssd1 SS_sky130_fd_sc_hd__buf_2
XFILLER_128_340 vssd1 vccd1 vssd1 vccd1 SS_sky130_ef_sc_hd__decap_40_12
XFILLER_129_841 vccd1 vssd1 vccd1 vssd1 SS_sky130_fd_sc_hd__fill_1
XTAP_TAPCELL_ROW_96_1744 vccd1 vssd1 SS_sky130_fd_sc_hd__tapvpwrvgnd_1
XTAP_TAPCELL_ROW_96_1733 vccd1 vssd1 SS_sky130_fd_sc_hd__tapvpwrvgnd_1
Xhold604 _1036_/A _1550_/Q vccd1 vssd1 vssd1 vccd1 SS_sky130_fd_sc_hd__dlygate4sd3_1
Xhold626 _1364_/A _1888_/A vccd1 vssd1 vssd1 vccd1 SS_sky130_fd_sc_hd__dlygate4sd3_1
Xhold615 _1240_/A _1649_/Q vccd1 vssd1 vssd1 vccd1 SS_sky130_fd_sc_hd__dlygate4sd3_1
Xhold637 _1358_/A _1885_/A vccd1 vssd1 vssd1 vccd1 SS_sky130_fd_sc_hd__dlygate4sd3_1
Xhold659 _1340_/A _1698_/Q vccd1 vssd1 vssd1 vccd1 SS_sky130_fd_sc_hd__dlygate4sd3_1
XFILLER_131_505 vssd1 vccd1 vssd1 vccd1 SS_sky130_ef_sc_hd__decap_40_12
Xhold648 _1208_/A _1634_/Q vccd1 vssd1 vssd1 vccd1 SS_sky130_fd_sc_hd__dlygate4sd3_1
XFILLER_116_557 vssd1 vccd1 vssd1 vccd1 SS_sky130_ef_sc_hd__decap_40_12
XFILLER_58_817 vssd1 vccd1 vccd1 vssd1 SS_sky130_fd_sc_hd__fill_2
XFILLER_97_441 vssd1 vccd1 vccd1 vssd1 SS_sky130_fd_sc_hd__fill_4
XFILLER_57_305 vssd1 vccd1 vssd1 vccd1 SS_sky130_ef_sc_hd__decap_40_12
XFILLER_69_165 vssd1 vccd1 vccd1 vssd1 SS_sky130_fd_sc_hd__fill_2
XFILLER_85_614 vssd1 vccd1 vccd1 vssd1 SS_sky130_fd_sc_hd__fill_2
XTAP_TAPCELL_ROW_127_2210 vccd1 vssd1 SS_sky130_fd_sc_hd__tapvpwrvgnd_1
XFILLER_111_273 vssd1 vccd1 vccd1 vssd1 SS_sky130_fd_sc_hd__fill_4
XFILLER_97_485 vssd1 vccd1 vssd1 vccd1 SS_sky130_ef_sc_hd__decap_40_12
XFILLER_73_809 vssd1 vccd1 vssd1 vccd1 SS_sky130_ef_sc_hd__decap_40_12
XFILLER_85_669 vssd1 vccd1 vccd1 vssd1 SS_sky130_fd_sc_hd__fill_2
XTAP_TAPCELL_ROW_0_301 vccd1 vssd1 SS_sky130_fd_sc_hd__tapvpwrvgnd_1
XFILLER_27_39 vssd1 vccd1 vssd1 vccd1 SS_sky130_ef_sc_hd__decap_40_12
XFILLER_26_714 vssd1 vccd1 vccd1 vssd1 SS_sky130_fd_sc_hd__fill_4
X_1208_ vccd1 vssd1 vccd1 vssd1 _1208_/X _1208_/A _1208_/B SS_sky130_fd_sc_hd__or2_2
XFILLER_53_522 vssd1 vccd1 vssd1 vccd1 SS_sky130_ef_sc_hd__decap_40_12
XFILLER_65_393 vssd1 vccd1 vssd1 vccd1 SS_sky130_ef_sc_hd__decap_40_12
XFILLER_26_769 vssd1 vccd1 vssd1 vccd1 SS_sky130_ef_sc_hd__decap_40_12
X_1139_ vssd1 vccd1 vccd1 vssd1 _1141_/A2 input41/X _1600_/D _1403_/C1 _1138_/X SS_sky130_fd_sc_hd__o211a_2
XFILLER_25_279 vccd1 vssd1 vccd1 vssd1 SS_sky130_fd_sc_hd__fill_1
XTAP_TAPCELL_ROW_105_1873 vccd1 vssd1 SS_sky130_fd_sc_hd__tapvpwrvgnd_1
XFILLER_40_249 vssd1 vccd1 vccd1 vssd1 SS_sky130_fd_sc_hd__fill_2
XFILLER_21_441 vssd1 vccd1 vccd1 vssd1 SS_sky130_fd_sc_hd__fill_4
XFILLER_21_485 vssd1 vccd1 vssd1 vccd1 SS_sky130_ef_sc_hd__decap_40_12
XTAP_TAPCELL_ROW_138_2383 vccd1 vssd1 SS_sky130_fd_sc_hd__tapvpwrvgnd_1
XTAP_TAPCELL_ROW_138_2372 vccd1 vssd1 SS_sky130_fd_sc_hd__tapvpwrvgnd_1
XFILLER_138_137 vssd1 vccd1 vccd1 vssd1 SS_sky130_fd_sc_hd__fill_2
XFILLER_5_629 vssd1 vccd1 vssd1 vccd1 SS_sky130_ef_sc_hd__decap_40_12
XFILLER_107_513 vccd1 vssd1 vccd1 vssd1 SS_sky130_fd_sc_hd__fill_1
XFILLER_4_139 vccd1 vssd1 vccd1 vssd1 SS_sky130_fd_sc_hd__fill_1
XFILLER_134_321 vccd1 vssd1 vccd1 vssd1 SS_sky130_fd_sc_hd__fill_1
XFILLER_111_6 vssd1 vccd1 vssd1 vccd1 SS_sky130_ef_sc_hd__decap_40_12
XFILLER_134_365 vccd1 vssd1 vccd1 vssd1 SS_sky130_fd_sc_hd__fill_1
XFILLER_108_53 vssd1 vccd1 vssd1 vccd1 SS_sky130_ef_sc_hd__decap_40_12
XTAP_TAPCELL_ROW_8_423 vccd1 vssd1 SS_sky130_fd_sc_hd__tapvpwrvgnd_1
XFILLER_108_97 vssd1 vccd1 vssd1 vccd1 SS_sky130_ef_sc_hd__decap_40_12
XFILLER_103_741 vssd1 vccd1 vssd1 vccd1 SS_sky130_ef_sc_hd__decap_40_12
XFILLER_0_389 vssd1 vccd1 vccd1 vssd1 SS_sky130_fd_sc_hd__fill_2
XFILLER_48_305 vssd1 vccd1 vccd1 vssd1 SS_sky130_fd_sc_hd__fill_2
XFILLER_103_785 vssd1 vccd1 vssd1 vccd1 SS_sky130_ef_sc_hd__decap_40_12
XFILLER_102_251 vccd1 vssd1 vccd1 vssd1 SS_sky130_fd_sc_hd__fill_1
XFILLER_75_113 vssd1 vccd1 vssd1 vccd1 SS_sky130_ef_sc_hd__decap_40_12
XFILLER_124_41 vssd1 vccd1 vssd1 vccd1 SS_sky130_ef_sc_hd__decap_40_12
XFILLER_29_541 vssd1 vccd1 vssd1 vccd1 SS_sky130_ef_sc_hd__decap_40_12
XTAP_TAPCELL_ROW_67_1301 vccd1 vssd1 SS_sky130_fd_sc_hd__tapvpwrvgnd_1
XFILLER_124_85 vssd1 vccd1 vssd1 vccd1 SS_sky130_ef_sc_hd__decap_40_12
XFILLER_91_617 vssd1 vccd1 vssd1 vccd1 SS_sky130_ef_sc_hd__decap_40_12
XFILLER_17_725 vssd1 vccd1 vccd1 vssd1 SS_sky130_fd_sc_hd__fill_2
XFILLER_29_585 vssd1 vccd1 vssd1 vccd1 SS_sky130_ef_sc_hd__decap_40_12
XFILLER_44_511 vssd1 vccd1 vssd1 vccd1 SS_sky130_ef_sc_hd__decap_40_12
XFILLER_44_533 vssd1 vccd1 vssd1 vccd1 SS_sky130_ef_sc_hd__decap_40_12
XTAP_TAPCELL_ROW_67_1312 vccd1 vssd1 SS_sky130_fd_sc_hd__tapvpwrvgnd_1
XFILLER_31_205 vssd1 vccd1 vssd1 vccd1 SS_sky130_ef_sc_hd__decap_40_12
XFILLER_44_577 vccd1 vssd1 vccd1 vssd1 SS_sky130_fd_sc_hd__fill_1
XTAP_TAPCELL_ROW_80_1501 vccd1 vssd1 SS_sky130_fd_sc_hd__tapvpwrvgnd_1
XFILLER_31_249 vssd1 vccd1 vssd1 vccd1 SS_sky130_ef_sc_hd__decap_40_12
XFILLER_8_401 vssd1 vccd1 vssd1 vccd1 SS_sky130_ef_sc_hd__decap_40_12
XFILLER_8_445 vssd1 vccd1 vssd1 vccd1 SS_sky130_ef_sc_hd__decap_40_12
XFILLER_33_93 vssd1 vccd1 vssd1 vccd1 SS_sky130_ef_sc_hd__decap_40_12
XFILLER_129_137 vssd1 vccd1 vssd1 vccd1 SS_sky130_ef_sc_hd__decap_40_12
XFILLER_8_489 vssd1 vccd1 vssd1 vccd1 SS_sky130_ef_sc_hd__decap_40_12
XFILLER_138_671 vccd1 vssd1 vccd1 vssd1 SS_sky130_fd_sc_hd__fill_1
XTAP_TAPCELL_ROW_78_1463 vccd1 vssd1 SS_sky130_fd_sc_hd__tapvpwrvgnd_1
XTAP_TAPCELL_ROW_78_1474 vccd1 vssd1 SS_sky130_fd_sc_hd__tapvpwrvgnd_1
XFILLER_125_354 vssd1 vccd1 vssd1 vccd1 SS_sky130_ef_sc_hd__decap_40_12
XFILLER_113_505 vssd1 vccd1 vccd1 vssd1 SS_sky130_fd_sc_hd__fill_8
XFILLER_3_161 vssd1 vccd1 vccd1 vssd1 SS_sky130_fd_sc_hd__fill_4
X_1490_ _1490_/Q _1717_/CLK _1490_/D vccd1 vssd1 vccd1 vssd1 SS_sky130_fd_sc_hd__dfxtp_2
XTAP_TAPCELL_ROW_91_1663 vccd1 vssd1 SS_sky130_fd_sc_hd__tapvpwrvgnd_1
XFILLER_98_249 vssd1 vccd1 vccd1 vssd1 SS_sky130_fd_sc_hd__fill_2
XFILLER_39_305 vssd1 vccd1 vssd1 vccd1 SS_sky130_ef_sc_hd__decap_40_12
XFILLER_39_349 vssd1 vccd1 vssd1 vccd1 SS_sky130_ef_sc_hd__decap_40_12
XFILLER_55_809 vssd1 vccd1 vccd1 vssd1 SS_sky130_fd_sc_hd__fill_8
XFILLER_94_477 vssd1 vccd1 vssd1 vccd1 SS_sky130_ef_sc_hd__decap_40_12
XFILLER_94_455 vccd1 vssd1 vccd1 vssd1 SS_sky130_fd_sc_hd__fill_1
XFILLER_63_820 vssd1 vccd1 vccd1 vssd1 SS_sky130_fd_sc_hd__fill_4
XFILLER_81_105 vssd1 vccd1 vccd1 vssd1 SS_sky130_fd_sc_hd__fill_4
XFILLER_47_393 vssd1 vccd1 vccd1 vssd1 SS_sky130_fd_sc_hd__fill_4
XFILLER_81_149 vssd1 vccd1 vssd1 vccd1 SS_sky130_ef_sc_hd__decap_40_12
XPHY_EDGE_ROW_8_Right_8 vccd1 vssd1 vccd1 vssd1 SS_sky130_fd_sc_hd__decap_3
XFILLER_35_599 vssd1 vccd1 vssd1 vccd1 SS_sky130_ef_sc_hd__decap_40_12
XFILLER_62_363 vccd1 vssd1 vccd1 vssd1 SS_sky130_fd_sc_hd__fill_1
XFILLER_22_249 vssd1 vccd1 vccd1 vssd1 SS_sky130_fd_sc_hd__fill_2
XFILLER_50_558 vssd1 vccd1 vccd1 vssd1 SS_sky130_fd_sc_hd__fill_2
XTAP_TAPCELL_ROW_33_789 vccd1 vssd1 SS_sky130_fd_sc_hd__tapvpwrvgnd_1
XFILLER_50_569 vssd1 vccd1 vssd1 vccd1 SS_sky130_ef_sc_hd__decap_40_12
X_1826_ vccd1 vssd1 _1826_/X _1826_/A vccd1 vssd1 SS_sky130_fd_sc_hd__buf_2
XTAP_TAPCELL_ROW_13_491 vccd1 vssd1 SS_sky130_fd_sc_hd__tapvpwrvgnd_1
XFILLER_129_671 vccd1 vssd1 vccd1 vssd1 SS_sky130_fd_sc_hd__fill_1
X_1757_ _1757_/Q _1758_/CLK _1757_/D vccd1 vssd1 vccd1 vssd1 SS_sky130_fd_sc_hd__dfxtp_2
XFILLER_116_365 vssd1 vccd1 vssd1 vccd1 SS_sky130_ef_sc_hd__decap_40_12
XFILLER_116_354 vssd1 vccd1 vccd1 vssd1 SS_sky130_fd_sc_hd__fill_8
XFILLER_1_109 vssd1 vccd1 vccd1 vssd1 SS_sky130_fd_sc_hd__fill_2
XFILLER_89_205 vssd1 vccd1 vssd1 vccd1 SS_sky130_ef_sc_hd__decap_40_12
XTAP_TAPCELL_ROW_133_2291 vccd1 vssd1 SS_sky130_fd_sc_hd__tapvpwrvgnd_1
X_1688_ _1688_/Q _1724_/CLK _1688_/D vccd1 vssd1 vccd1 vssd1 SS_sky130_fd_sc_hd__dfxtp_2
XPHY_EDGE_ROW_39_Right_39 vccd1 vssd1 vccd1 vssd1 SS_sky130_fd_sc_hd__decap_3
XFILLER_89_249 vssd1 vccd1 vssd1 vccd1 SS_sky130_ef_sc_hd__decap_40_12
XFILLER_58_625 vssd1 vccd1 vccd1 vssd1 SS_sky130_fd_sc_hd__fill_8
XFILLER_57_113 vssd1 vccd1 vssd1 vccd1 SS_sky130_ef_sc_hd__decap_40_12
XFILLER_100_722 vssd1 vccd1 vssd1 vccd1 SS_sky130_ef_sc_hd__decap_40_12
XFILLER_97_293 vssd1 vccd1 vccd1 vssd1 SS_sky130_fd_sc_hd__fill_4
XFILLER_58_669 vssd1 vccd1 vssd1 vccd1 SS_sky130_ef_sc_hd__decap_40_12
XFILLER_73_617 vssd1 vccd1 vssd1 vccd1 SS_sky130_ef_sc_hd__decap_40_12
XTAP_TAPCELL_ROW_107_1902 vccd1 vssd1 SS_sky130_fd_sc_hd__tapvpwrvgnd_1
XFILLER_26_533 vssd1 vccd1 vssd1 vccd1 SS_sky130_ef_sc_hd__decap_40_12
XTAP_TAPCELL_ROW_49_1031 vccd1 vssd1 SS_sky130_fd_sc_hd__tapvpwrvgnd_1
XTAP_TAPCELL_ROW_49_1042 vccd1 vssd1 SS_sky130_fd_sc_hd__tapvpwrvgnd_1
XFILLER_54_15 vssd1 vccd1 vssd1 vccd1 SS_sky130_ef_sc_hd__decap_40_12
XFILLER_13_205 vssd1 vccd1 vssd1 vccd1 SS_sky130_ef_sc_hd__decap_40_12
XFILLER_41_503 vccd1 vssd1 vccd1 vssd1 SS_sky130_fd_sc_hd__fill_1
XFILLER_13_249 vssd1 vccd1 vssd1 vccd1 SS_sky130_ef_sc_hd__decap_40_12
XPHY_EDGE_ROW_48_Right_48 vccd1 vssd1 vccd1 vssd1 SS_sky130_fd_sc_hd__decap_3
XFILLER_53_385 vssd1 vccd1 vccd1 vssd1 SS_sky130_fd_sc_hd__fill_4
XTAP_TAPCELL_ROW_62_1231 vccd1 vssd1 SS_sky130_fd_sc_hd__tapvpwrvgnd_1
XFILLER_80_193 vssd1 vccd1 vccd1 vssd1 SS_sky130_fd_sc_hd__fill_2
XFILLER_110_65 vssd1 vccd1 vssd1 vccd1 SS_sky130_ef_sc_hd__decap_40_12
XFILLER_21_293 vssd1 vccd1 vssd1 vccd1 SS_sky130_ef_sc_hd__decap_40_12
XFILLER_108_800 vssd1 vccd1 vssd1 vccd1 SS_sky130_ef_sc_hd__decap_40_12
XFILLER_119_181 vssd1 vccd1 vssd1 vccd1 SS_sky130_ef_sc_hd__decap_40_12
XPHY_EDGE_ROW_57_Right_57 vccd1 vssd1 vccd1 vssd1 SS_sky130_fd_sc_hd__decap_3
XFILLER_135_685 vssd1 vccd1 vssd1 vccd1 SS_sky130_ef_sc_hd__decap_40_12
XFILLER_134_195 vccd1 vssd1 vccd1 vssd1 SS_sky130_fd_sc_hd__fill_1
XFILLER_0_153 vssd1 vccd1 vccd1 vssd1 SS_sky130_fd_sc_hd__fill_4
XFILLER_1_665 vssd1 vccd1 vccd1 vssd1 SS_sky130_fd_sc_hd__fill_4
XFILLER_49_625 vssd1 vccd1 vssd1 vccd1 SS_sky130_ef_sc_hd__decap_40_12
XTAP_TAPCELL_ROW_73_1393 vccd1 vssd1 SS_sky130_fd_sc_hd__tapvpwrvgnd_1
XFILLER_89_783 vccd1 vssd1 vccd1 vssd1 SS_sky130_fd_sc_hd__fill_1
XFILLER_135_51 vssd1 vccd1 vccd1 vssd1 SS_sky130_fd_sc_hd__fill_4
XFILLER_0_197 vssd1 vccd1 vssd1 vccd1 SS_sky130_ef_sc_hd__decap_40_12
XFILLER_76_433 vssd1 vccd1 vssd1 vccd1 SS_sky130_ef_sc_hd__decap_40_12
XFILLER_95_55 vccd1 vssd1 vccd1 vssd1 SS_sky130_fd_sc_hd__fill_1
XFILLER_64_606 vssd1 vccd1 vssd1 vccd1 SS_sky130_ef_sc_hd__decap_40_12
XFILLER_76_477 vssd1 vccd1 vssd1 vccd1 SS_sky130_ef_sc_hd__decap_40_12
XFILLER_63_105 vssd1 vccd1 vccd1 vssd1 SS_sky130_fd_sc_hd__fill_4
XFILLER_29_393 vssd1 vccd1 vssd1 vccd1 SS_sky130_ef_sc_hd__decap_40_12
XFILLER_63_149 vssd1 vccd1 vssd1 vccd1 SS_sky130_ef_sc_hd__decap_40_12
XFILLER_91_447 vccd1 vssd1 vccd1 vssd1 SS_sky130_fd_sc_hd__fill_1
XFILLER_44_363 vccd1 vssd1 vccd1 vssd1 SS_sky130_fd_sc_hd__fill_1
XFILLER_60_801 vssd1 vccd1 vccd1 vssd1 SS_sky130_fd_sc_hd__fill_8
XPHY_EDGE_ROW_66_Right_66 vccd1 vssd1 vccd1 vssd1 SS_sky130_fd_sc_hd__decap_3
XFILLER_32_525 vssd1 vccd1 vccd1 vssd1 SS_sky130_fd_sc_hd__fill_4
XFILLER_71_193 vssd1 vccd1 vssd1 vccd1 SS_sky130_ef_sc_hd__decap_40_12
XFILLER_72_694 vssd1 vccd1 vccd1 vssd1 SS_sky130_fd_sc_hd__fill_4
XFILLER_32_569 vssd1 vccd1 vccd1 vssd1 SS_sky130_fd_sc_hd__fill_8
XFILLER_44_81 vssd1 vccd1 vccd1 vssd1 SS_sky130_fd_sc_hd__fill_2
X_0990_ vccd1 vssd1 vccd1 vssd1 _0990_/X _0990_/A _1006_/B SS_sky130_fd_sc_hd__or2_2
XFILLER_9_721 vssd1 vccd1 vccd1 vssd1 SS_sky130_fd_sc_hd__fill_4
XFILLER_8_253 vssd1 vccd1 vssd1 vccd1 SS_sky130_ef_sc_hd__decap_40_12
XFILLER_9_765 vssd1 vccd1 vssd1 vccd1 SS_sky130_ef_sc_hd__decap_40_12
XTAP_TAPCELL_ROW_30_748 vccd1 vssd1 SS_sky130_fd_sc_hd__tapvpwrvgnd_1
XTAP_TAPCELL_ROW_10_450 vccd1 vssd1 SS_sky130_fd_sc_hd__tapvpwrvgnd_1
X_1611_ _1871_/A _1742_/CLK _1611_/D vccd1 vssd1 vccd1 vssd1 SS_sky130_fd_sc_hd__dfxtp_2
XPHY_EDGE_ROW_75_Right_75 vccd1 vssd1 vccd1 vssd1 SS_sky130_fd_sc_hd__decap_3
XFILLER_114_803 vssd1 vccd1 vccd1 vssd1 SS_sky130_fd_sc_hd__fill_8
X_1542_ _1829_/A _1573_/CLK _1542_/D vccd1 vssd1 vccd1 vssd1 SS_sky130_fd_sc_hd__dfxtp_2
XFILLER_126_674 vssd1 vccd1 vssd1 vccd1 SS_sky130_ef_sc_hd__decap_40_12
X_1473_ vssd1 vccd1 vccd1 vssd1 wire207/A input44/X _1762_/D _1473_/C1 _1472_/X SS_sky130_fd_sc_hd__o211a_2
XFILLER_39_113 vssd1 vccd1 vssd1 vccd1 SS_sky130_ef_sc_hd__decap_40_12
XFILLER_79_293 vssd1 vccd1 vssd1 vccd1 SS_sky130_ef_sc_hd__decap_40_12
XFILLER_28_809 vssd1 vccd1 vccd1 vssd1 SS_sky130_fd_sc_hd__fill_2
XFILLER_55_617 vssd1 vccd1 vssd1 vccd1 SS_sky130_ef_sc_hd__decap_40_12
XFILLER_121_390 vssd1 vccd1 vccd1 vssd1 SS_sky130_fd_sc_hd__fill_2
XFILLER_95_775 vccd1 vssd1 vccd1 vssd1 SS_sky130_fd_sc_hd__fill_1
XFILLER_95_753 vssd1 vccd1 vssd1 vccd1 SS_sky130_ef_sc_hd__decap_40_12
XPHY_EDGE_ROW_19_Left_158 vccd1 vssd1 vccd1 vssd1 SS_sky130_fd_sc_hd__decap_3
XPHY_EDGE_ROW_84_Right_84 vccd1 vssd1 vccd1 vssd1 SS_sky130_fd_sc_hd__decap_3
XFILLER_23_503 vccd1 vssd1 vccd1 vssd1 SS_sky130_fd_sc_hd__fill_1
XTAP_TAPCELL_ROW_18_572 vccd1 vssd1 SS_sky130_fd_sc_hd__tapvpwrvgnd_1
XFILLER_24_29 vssd1 vccd1 vssd1 vccd1 SS_sky130_ef_sc_hd__decap_40_12
XFILLER_35_385 vssd1 vccd1 vccd1 vssd1 SS_sky130_fd_sc_hd__fill_4
XFILLER_50_333 vssd1 vccd1 vssd1 vccd1 SS_sky130_ef_sc_hd__decap_40_12
XFILLER_62_193 vssd1 vccd1 vccd1 vssd1 SS_sky130_fd_sc_hd__fill_2
XTAP_TAPCELL_ROW_102_1832 vccd1 vssd1 SS_sky130_fd_sc_hd__tapvpwrvgnd_1
XFILLER_11_709 vssd1 vccd1 vssd1 vccd1 SS_sky130_ef_sc_hd__decap_40_12
XFILLER_50_377 vssd1 vccd1 vssd1 vccd1 SS_sky130_ef_sc_hd__decap_40_12
XTAP_TAPCELL_ROW_135_2320 vccd1 vssd1 SS_sky130_fd_sc_hd__tapvpwrvgnd_1
XTAP_TAPCELL_ROW_135_2331 vccd1 vssd1 SS_sky130_fd_sc_hd__tapvpwrvgnd_1
XPHY_EDGE_ROW_28_Left_167 vccd1 vssd1 vccd1 vssd1 SS_sky130_fd_sc_hd__decap_3
XPHY_EDGE_ROW_93_Right_93 vccd1 vssd1 vccd1 vssd1 SS_sky130_fd_sc_hd__decap_3
XFILLER_49_15 vssd1 vccd1 vssd1 vccd1 SS_sky130_ef_sc_hd__decap_40_12
XFILLER_116_195 vccd1 vssd1 vccd1 vssd1 SS_sky130_fd_sc_hd__fill_1
XFILLER_131_165 vssd1 vccd1 vccd1 vssd1 SS_sky130_fd_sc_hd__fill_2
XFILLER_132_699 vccd1 vssd1 vccd1 vssd1 SS_sky130_fd_sc_hd__fill_1
XFILLER_120_817 vccd1 vssd1 vccd1 vssd1 SS_sky130_fd_sc_hd__fill_1
XTAP_TAPCELL_ROW_113_1994 vccd1 vssd1 SS_sky130_fd_sc_hd__tapvpwrvgnd_1
XFILLER_58_433 vssd1 vccd1 vccd1 vssd1 SS_sky130_fd_sc_hd__fill_8
XPHY_EDGE_ROW_37_Left_176 vccd1 vssd1 vccd1 vssd1 SS_sky130_fd_sc_hd__decap_3
XFILLER_100_541 vssd1 vccd1 vssd1 vccd1 SS_sky130_ef_sc_hd__decap_40_12
XFILLER_45_105 vssd1 vccd1 vccd1 vssd1 SS_sky130_fd_sc_hd__fill_4
XFILLER_58_477 vssd1 vccd1 vccd1 vssd1 SS_sky130_fd_sc_hd__fill_8
XFILLER_86_797 vssd1 vccd1 vssd1 vccd1 SS_sky130_ef_sc_hd__decap_40_12
XFILLER_100_585 vssd1 vccd1 vccd1 vssd1 SS_sky130_fd_sc_hd__fill_2
XFILLER_45_149 vssd1 vccd1 vssd1 vccd1 SS_sky130_ef_sc_hd__decap_40_12
XFILLER_65_69 vssd1 vccd1 vssd1 vccd1 SS_sky130_ef_sc_hd__decap_40_12
XFILLER_26_363 vccd1 vssd1 vccd1 vssd1 SS_sky130_fd_sc_hd__fill_1
XFILLER_54_683 vssd1 vccd1 vssd1 vccd1 SS_sky130_ef_sc_hd__decap_40_12
XFILLER_121_42 vssd1 vccd1 vssd1 vccd1 SS_sky130_ef_sc_hd__decap_40_12
XFILLER_14_525 vssd1 vccd1 vccd1 vssd1 SS_sky130_fd_sc_hd__fill_4
XFILLER_41_333 vssd1 vccd1 vccd1 vssd1 SS_sky130_fd_sc_hd__fill_2
XFILLER_53_193 vssd1 vccd1 vssd1 vccd1 SS_sky130_ef_sc_hd__decap_40_12
XFILLER_14_569 vssd1 vccd1 vssd1 vccd1 SS_sky130_ef_sc_hd__decap_40_12
XFILLER_81_57 vssd1 vccd1 vssd1 vccd1 SS_sky130_ef_sc_hd__decap_40_12
XFILLER_10_753 vssd1 vccd1 vccd1 vssd1 SS_sky130_fd_sc_hd__fill_2
XPHY_EDGE_ROW_46_Left_185 vccd1 vssd1 vccd1 vssd1 SS_sky130_fd_sc_hd__decap_3
XFILLER_6_713 vssd1 vccd1 vssd1 vccd1 SS_sky130_ef_sc_hd__decap_40_12
XFILLER_127_449 vssd1 vccd1 vssd1 vccd1 SS_sky130_ef_sc_hd__decap_40_12
XFILLER_5_223 vccd1 vssd1 vccd1 vssd1 SS_sky130_fd_sc_hd__fill_1
XFILLER_6_757 vssd1 vccd1 vssd1 vccd1 SS_sky130_ef_sc_hd__decap_40_12
XFILLER_108_641 vssd1 vccd1 vccd1 vssd1 SS_sky130_fd_sc_hd__fill_2
XFILLER_30_83 vccd1 vssd1 vccd1 vssd1 SS_sky130_fd_sc_hd__fill_1
XTAP_TAPCELL_ROW_75_1422 vccd1 vssd1 SS_sky130_fd_sc_hd__tapvpwrvgnd_1
XFILLER_108_685 vssd1 vccd1 vssd1 vccd1 SS_sky130_ef_sc_hd__decap_40_12
XFILLER_123_644 vssd1 vccd1 vssd1 vccd1 SS_sky130_ef_sc_hd__decap_40_12
XFILLER_122_121 vssd1 vccd1 vssd1 vccd1 SS_sky130_ef_sc_hd__decap_40_12
XFILLER_122_165 vssd1 vccd1 vssd1 vccd1 SS_sky130_ef_sc_hd__decap_40_12
XFILLER_111_828 vssd1 vccd1 vccd1 vssd1 SS_sky130_fd_sc_hd__fill_2
XFILLER_110_305 vssd1 vccd1 vccd1 vssd1 SS_sky130_fd_sc_hd__fill_2
XFILLER_1_473 vssd1 vccd1 vssd1 vccd1 SS_sky130_ef_sc_hd__decap_40_12
XFILLER_49_433 vccd1 vssd1 vccd1 vssd1 SS_sky130_fd_sc_hd__fill_1
XPHY_EDGE_ROW_55_Left_194 vccd1 vssd1 vccd1 vssd1 SS_sky130_fd_sc_hd__decap_3
XFILLER_89_591 vssd1 vccd1 vssd1 vccd1 SS_sky130_ef_sc_hd__decap_40_12
XFILLER_39_81 vssd1 vccd1 vssd1 vccd1 SS_sky130_ef_sc_hd__decap_40_12
XFILLER_92_701 vssd1 vccd1 vssd1 vccd1 SS_sky130_ef_sc_hd__decap_40_12
XFILLER_37_628 vssd1 vccd1 vssd1 vccd1 SS_sky130_ef_sc_hd__decap_40_12
XFILLER_77_797 vssd1 vccd1 vccd1 vssd1 SS_sky130_fd_sc_hd__fill_8
XFILLER_64_458 vssd1 vccd1 vssd1 vccd1 SS_sky130_ef_sc_hd__decap_40_12
XTAP_TAPCELL_ROW_35_818 vccd1 vssd1 SS_sky130_fd_sc_hd__tapvpwrvgnd_1
XTAP_TAPCELL_ROW_35_829 vccd1 vssd1 SS_sky130_fd_sc_hd__tapvpwrvgnd_1
XFILLER_91_277 vssd1 vccd1 vccd1 vssd1 SS_sky130_fd_sc_hd__fill_2
XTAP_TAPCELL_ROW_15_520 vccd1 vssd1 SS_sky130_fd_sc_hd__tapvpwrvgnd_1
XFILLER_17_385 vssd1 vccd1 vccd1 vssd1 SS_sky130_fd_sc_hd__fill_4
XFILLER_45_683 vccd1 vssd1 vccd1 vssd1 SS_sky130_fd_sc_hd__fill_1
XTAP_TAPCELL_ROW_86_1584 vccd1 vssd1 SS_sky130_fd_sc_hd__tapvpwrvgnd_1
XTAP_TAPCELL_ROW_86_1595 vccd1 vssd1 SS_sky130_fd_sc_hd__tapvpwrvgnd_1
XTAP_TAPCELL_ROW_15_531 vccd1 vssd1 SS_sky130_fd_sc_hd__tapvpwrvgnd_1
XFILLER_32_333 vssd1 vccd1 vssd1 vccd1 SS_sky130_ef_sc_hd__decap_40_12
XFILLER_44_193 vssd1 vccd1 vccd1 vssd1 SS_sky130_fd_sc_hd__fill_2
XFILLER_32_377 vssd1 vccd1 vssd1 vccd1 SS_sky130_ef_sc_hd__decap_40_12
X_0973_ vssd1 vccd1 vccd1 vssd1 wire253/X wire499/X _1519_/D _1451_/C1 _0972_/X SS_sky130_fd_sc_hd__o211a_2
XFILLER_9_573 vssd1 vccd1 vssd1 vccd1 SS_sky130_ef_sc_hd__decap_40_12
XFILLER_72_3 vssd1 vccd1 vssd1 vccd1 SS_sky130_ef_sc_hd__decap_40_12
XTAP_TAPCELL_ROW_117_2050 vccd1 vssd1 SS_sky130_fd_sc_hd__tapvpwrvgnd_1
XTAP_TAPCELL_ROW_117_2061 vccd1 vssd1 SS_sky130_fd_sc_hd__tapvpwrvgnd_1
X_1525_ _1525_/Q clkload2/A _1525_/D vccd1 vssd1 vccd1 vssd1 SS_sky130_fd_sc_hd__dfxtp_2
XTAP_TAPCELL_ROW_130_2250 vccd1 vssd1 SS_sky130_fd_sc_hd__tapvpwrvgnd_1
XFILLER_99_333 vssd1 vccd1 vccd1 vssd1 SS_sky130_fd_sc_hd__fill_2
XFILLER_113_165 vssd1 vccd1 vccd1 vssd1 SS_sky130_fd_sc_hd__fill_2
XFILLER_101_305 vssd1 vccd1 vssd1 vccd1 SS_sky130_ef_sc_hd__decap_40_12
XFILLER_99_388 vssd1 vccd1 vccd1 vssd1 SS_sky130_fd_sc_hd__fill_4
X_1456_ vccd1 vssd1 vccd1 vssd1 _1456_/X _1456_/A _1472_/B SS_sky130_fd_sc_hd__or2_2
XFILLER_114_699 vccd1 vssd1 vccd1 vssd1 SS_sky130_fd_sc_hd__fill_1
XFILLER_68_753 vssd1 vccd1 vccd1 vssd1 SS_sky130_fd_sc_hd__fill_2
X_1387_ vssd1 vccd1 vccd1 vssd1 _1405_/A2 input33/X _1720_/D _1387_/C1 _1386_/X SS_sky130_fd_sc_hd__o211a_2
XFILLER_101_349 vssd1 vccd1 vssd1 vccd1 SS_sky130_ef_sc_hd__decap_40_12
XFILLER_95_561 vssd1 vccd1 vccd1 vssd1 SS_sky130_fd_sc_hd__fill_2
XFILLER_27_105 vssd1 vccd1 vccd1 vssd1 SS_sky130_fd_sc_hd__fill_4
XFILLER_55_425 vssd1 vccd1 vssd1 vccd1 SS_sky130_ef_sc_hd__decap_40_12
XFILLER_27_149 vssd1 vccd1 vssd1 vccd1 SS_sky130_ef_sc_hd__decap_40_12
XFILLER_55_447 vccd1 vssd1 vccd1 vssd1 SS_sky130_fd_sc_hd__fill_1
XFILLER_82_233 vssd1 vccd1 vssd1 vccd1 SS_sky130_ef_sc_hd__decap_40_12
XFILLER_35_39 vssd1 vccd1 vssd1 vccd1 SS_sky130_ef_sc_hd__decap_40_12
XFILLER_82_277 vssd1 vccd1 vssd1 vccd1 SS_sky130_ef_sc_hd__decap_40_12
XFILLER_23_333 vssd1 vccd1 vccd1 vssd1 SS_sky130_fd_sc_hd__fill_2
XFILLER_35_193 vssd1 vccd1 vssd1 vccd1 SS_sky130_ef_sc_hd__decap_40_12
XFILLER_50_141 vssd1 vccd1 vssd1 vccd1 SS_sky130_ef_sc_hd__decap_40_12
XFILLER_51_653 vssd1 vccd1 vccd1 vssd1 SS_sky130_fd_sc_hd__fill_4
XFILLER_11_517 vssd1 vccd1 vssd1 vccd1 SS_sky130_ef_sc_hd__decap_40_12
Xwire408 vccd1 vssd1 vssd1 vccd1 wire408/A analog_ctrl[73] SS_sky130_fd_sc_hd__buf_12
XFILLER_109_405 vssd1 vccd1 vccd1 vssd1 SS_sky130_fd_sc_hd__fill_8
XFILLER_136_235 vssd1 vccd1 vssd1 vccd1 SS_sky130_ef_sc_hd__decap_40_12
XFILLER_109_449 vssd1 vccd1 vssd1 vccd1 SS_sky130_ef_sc_hd__decap_40_12
XFILLER_3_727 vccd1 vssd1 vccd1 vssd1 SS_sky130_fd_sc_hd__fill_1
XTAP_TAPCELL_ROW_57_1152 vccd1 vssd1 SS_sky130_fd_sc_hd__tapvpwrvgnd_1
XFILLER_105_644 vssd1 vccd1 vssd1 vccd1 SS_sky130_ef_sc_hd__decap_40_12
XFILLER_104_121 vssd1 vccd1 vssd1 vccd1 SS_sky130_ef_sc_hd__decap_40_12
XFILLER_78_528 vssd1 vccd1 vccd1 vssd1 SS_sky130_fd_sc_hd__fill_4
XFILLER_132_474 vssd1 vccd1 vccd1 vssd1 SS_sky130_fd_sc_hd__fill_2
XFILLER_104_165 vssd1 vccd1 vssd1 vccd1 SS_sky130_ef_sc_hd__decap_40_12
XFILLER_59_720 vssd1 vccd1 vccd1 vssd1 SS_sky130_fd_sc_hd__fill_8
XFILLER_116_53 vssd1 vccd1 vssd1 vccd1 SS_sky130_ef_sc_hd__decap_40_12
XFILLER_59_753 vssd1 vccd1 vssd1 vccd1 SS_sky130_ef_sc_hd__decap_40_12
XTAP_TAPCELL_ROW_70_1352 vccd1 vssd1 SS_sky130_fd_sc_hd__tapvpwrvgnd_1
XFILLER_116_97 vssd1 vccd1 vssd1 vccd1 SS_sky130_ef_sc_hd__decap_40_12
XFILLER_19_617 vssd1 vccd1 vssd1 vccd1 SS_sky130_ef_sc_hd__decap_40_12
XFILLER_59_797 vssd1 vccd1 vssd1 vccd1 SS_sky130_ef_sc_hd__decap_40_12
XFILLER_74_701 vssd1 vccd1 vccd1 vssd1 SS_sky130_fd_sc_hd__fill_4
XFILLER_132_41 vssd1 vccd1 vssd1 vccd1 SS_sky130_ef_sc_hd__decap_40_12
XFILLER_73_277 vssd1 vccd1 vccd1 vssd1 SS_sky130_fd_sc_hd__fill_2
XFILLER_132_85 vssd1 vccd1 vssd1 vccd1 SS_sky130_ef_sc_hd__decap_40_12
XFILLER_42_631 vccd1 vssd1 vccd1 vssd1 SS_sky130_fd_sc_hd__fill_1
XFILLER_54_491 vccd1 vssd1 vccd1 vssd1 SS_sky130_fd_sc_hd__fill_1
XFILLER_14_333 vssd1 vccd1 vssd1 vccd1 SS_sky130_ef_sc_hd__decap_40_12
XFILLER_26_193 vssd1 vccd1 vccd1 vssd1 SS_sky130_fd_sc_hd__fill_2
XFILLER_14_377 vssd1 vccd1 vssd1 vccd1 SS_sky130_ef_sc_hd__decap_40_12
XFILLER_128_725 vssd1 vccd1 vccd1 vssd1 SS_sky130_fd_sc_hd__fill_4
XTAP_TAPCELL_ROW_40_898 vccd1 vssd1 SS_sky130_fd_sc_hd__tapvpwrvgnd_1
XFILLER_41_93 vssd1 vccd1 vssd1 vccd1 SS_sky130_ef_sc_hd__decap_40_12
XFILLER_128_769 vssd1 vccd1 vssd1 vccd1 SS_sky130_ef_sc_hd__decap_40_12
XFILLER_6_587 vccd1 vssd1 vccd1 vssd1 SS_sky130_fd_sc_hd__fill_1
XFILLER_127_279 vccd1 vssd1 vccd1 vssd1 SS_sky130_fd_sc_hd__fill_1
XPHY_EDGE_ROW_63_Left_202 vccd1 vssd1 vccd1 vssd1 SS_sky130_fd_sc_hd__decap_3
XFILLER_69_517 vssd1 vccd1 vssd1 vccd1 SS_sky130_ef_sc_hd__decap_40_12
XFILLER_123_441 vssd1 vccd1 vccd1 vssd1 SS_sky130_fd_sc_hd__fill_2
XFILLER_2_793 vssd1 vccd1 vssd1 vccd1 SS_sky130_ef_sc_hd__decap_40_12
X_1310_ vccd1 vssd1 vccd1 vssd1 _1310_/X _1310_/A _1318_/B SS_sky130_fd_sc_hd__or2_2
XFILLER_1_281 vssd1 vccd1 vssd1 vccd1 SS_sky130_ef_sc_hd__decap_40_12
X_1241_ vssd1 vccd1 vccd1 vssd1 _1273_/A2 wire498/X _1649_/D _1439_/C1 _1240_/X SS_sky130_fd_sc_hd__o211a_2
XFILLER_96_369 vccd1 vssd1 vccd1 vssd1 SS_sky130_fd_sc_hd__fill_1
XFILLER_2_65 vssd1 vccd1 vssd1 vccd1 SS_sky130_ef_sc_hd__decap_40_12
X_1172_ vccd1 vssd1 vccd1 vssd1 _1172_/X _1172_/A _1186_/B SS_sky130_fd_sc_hd__or2_2
XFILLER_77_561 vssd1 vccd1 vssd1 vccd1 SS_sky130_ef_sc_hd__decap_40_12
XTAP_TAPCELL_ROW_88_1613 vccd1 vssd1 SS_sky130_fd_sc_hd__tapvpwrvgnd_1
XTAP_TAPCELL_ROW_88_1624 vccd1 vssd1 SS_sky130_fd_sc_hd__tapvpwrvgnd_1
XFILLER_37_447 vccd1 vssd1 vccd1 vssd1 SS_sky130_fd_sc_hd__fill_1
XFILLER_64_233 vssd1 vccd1 vssd1 vccd1 SS_sky130_ef_sc_hd__decap_40_12
XFILLER_92_531 vccd1 vssd1 vccd1 vssd1 SS_sky130_fd_sc_hd__fill_1
XFILLER_25_609 vssd1 vccd1 vccd1 vssd1 SS_sky130_fd_sc_hd__fill_4
XFILLER_52_417 vssd1 vccd1 vccd1 vssd1 SS_sky130_fd_sc_hd__fill_2
XFILLER_64_277 vssd1 vccd1 vssd1 vccd1 SS_sky130_ef_sc_hd__decap_40_12
XPHY_EDGE_ROW_72_Left_211 vccd1 vssd1 vccd1 vssd1 SS_sky130_fd_sc_hd__decap_3
XFILLER_80_737 vssd1 vccd1 vssd1 vccd1 SS_sky130_ef_sc_hd__decap_40_12
XFILLER_92_597 vccd1 vssd1 vccd1 vssd1 SS_sky130_fd_sc_hd__fill_1
XFILLER_17_193 vssd1 vccd1 vssd1 vccd1 SS_sky130_ef_sc_hd__decap_40_12
XFILLER_32_141 vssd1 vccd1 vssd1 vccd1 SS_sky130_ef_sc_hd__decap_40_12
XFILLER_33_653 vssd1 vccd1 vccd1 vssd1 SS_sky130_fd_sc_hd__fill_8
X_0956_ vccd1 vssd1 vccd1 vssd1 _0956_/X _1840_/A _0988_/B SS_sky130_fd_sc_hd__or2_2
XFILLER_119_725 vssd1 vccd1 vccd1 vssd1 SS_sky130_fd_sc_hd__fill_2
XTAP_TAPCELL_ROW_99_1786 vccd1 vssd1 SS_sky130_fd_sc_hd__tapvpwrvgnd_1
Xoutput100 vccd1 vssd1 wire344/A _1859_/X vccd1 vssd1 SS_sky130_fd_sc_hd__buf_4
XFILLER_133_205 vssd1 vccd1 vssd1 vccd1 SS_sky130_ef_sc_hd__decap_40_12
X_0887_ vccd1 vssd1 vccd1 vssd1 _0886_/X _1058_/A _1013_/A _1124_/A wire445/X _0887_/X
+ SS_sky130_fd_sc_hd__a221o_2
XFILLER_106_419 vccd1 vssd1 vccd1 vssd1 SS_sky130_fd_sc_hd__fill_1
Xoutput111 vccd1 vssd1 wire333/A _1869_/X vccd1 vssd1 SS_sky130_fd_sc_hd__buf_4
Xoutput122 vccd1 vssd1 wire322/A _1879_/X vccd1 vssd1 SS_sky130_fd_sc_hd__buf_4
Xoutput133 vccd1 vssd1 wire417/A _1635_/Q vccd1 vssd1 SS_sky130_fd_sc_hd__buf_4
XPHY_EDGE_ROW_81_Left_220 vccd1 vssd1 vccd1 vssd1 SS_sky130_fd_sc_hd__decap_3
XFILLER_133_249 vssd1 vccd1 vssd1 vccd1 SS_sky130_ef_sc_hd__decap_40_12
Xoutput144 vccd1 vssd1 wire407/A _1645_/Q vccd1 vssd1 SS_sky130_fd_sc_hd__buf_4
Xoutput177 vccd1 vssd1 wire378/A _1490_/Q vccd1 vssd1 SS_sky130_fd_sc_hd__buf_4
Xoutput166 vccd1 vssd1 wire386/A _1666_/Q vccd1 vssd1 SS_sky130_fd_sc_hd__buf_4
Xoutput155 vccd1 vssd1 wire396/A _1656_/Q vccd1 vssd1 SS_sky130_fd_sc_hd__buf_4
X_1508_ _1836_/A _1576_/CLK _1508_/D vccd1 vssd1 vccd1 vssd1 SS_sky130_fd_sc_hd__dfxtp_2
Xoutput199 vccd1 vssd1 wire356/A _1481_/Q vccd1 vssd1 SS_sky130_fd_sc_hd__buf_4
Xoutput188 vccd1 vssd1 wire367/A _1500_/Q vccd1 vssd1 SS_sky130_fd_sc_hd__buf_4
XFILLER_101_113 vssd1 vccd1 vssd1 vccd1 SS_sky130_ef_sc_hd__decap_40_12
XFILLER_87_369 vssd1 vccd1 vccd1 vssd1 SS_sky130_fd_sc_hd__fill_2
XTAP_TAPCELL_ROW_110_1953 vccd1 vssd1 SS_sky130_fd_sc_hd__tapvpwrvgnd_1
XFILLER_102_669 vssd1 vccd1 vccd1 vssd1 SS_sky130_fd_sc_hd__fill_4
X_1439_ vssd1 vccd1 vccd1 vssd1 _1439_/A2 wire498/X _1745_/D _1439_/C1 _1438_/X SS_sky130_fd_sc_hd__o211a_2
XTAP_TAPCELL_ROW_52_1082 vccd1 vssd1 SS_sky130_fd_sc_hd__tapvpwrvgnd_1
XFILLER_56_701 vssd1 vccd1 vssd1 vccd1 SS_sky130_ef_sc_hd__decap_40_12
XFILLER_28_469 vssd1 vccd1 vccd1 vssd1 SS_sky130_fd_sc_hd__fill_4
XFILLER_43_417 vssd1 vccd1 vccd1 vssd1 SS_sky130_fd_sc_hd__fill_4
XFILLER_55_277 vssd1 vccd1 vccd1 vssd1 SS_sky130_fd_sc_hd__fill_2
XFILLER_71_704 vssd1 vccd1 vssd1 vccd1 SS_sky130_ef_sc_hd__decap_40_12
XFILLER_43_439 vssd1 vccd1 vccd1 vssd1 SS_sky130_fd_sc_hd__fill_8
XFILLER_71_737 vccd1 vssd1 vccd1 vssd1 SS_sky130_fd_sc_hd__fill_1
XFILLER_83_597 vssd1 vccd1 vssd1 vccd1 SS_sky130_ef_sc_hd__decap_40_12
XFILLER_24_653 vccd1 vssd1 vccd1 vssd1 SS_sky130_fd_sc_hd__fill_1
XFILLER_62_15 vssd1 vccd1 vssd1 vccd1 SS_sky130_ef_sc_hd__decap_40_12
XFILLER_102_77 vssd1 vccd1 vccd1 vssd1 SS_sky130_fd_sc_hd__fill_4
XFILLER_51_461 vssd1 vccd1 vssd1 vccd1 SS_sky130_ef_sc_hd__decap_40_12
XFILLER_8_819 vccd1 vssd1 vccd1 vssd1 SS_sky130_fd_sc_hd__fill_1
XFILLER_7_329 vssd1 vccd1 vccd1 vssd1 SS_sky130_fd_sc_hd__fill_4
XFILLER_11_30 vssd1 vccd1 vssd1 vccd1 SS_sky130_ef_sc_hd__decap_40_12
XFILLER_109_279 vccd1 vssd1 vccd1 vssd1 SS_sky130_fd_sc_hd__fill_1
XFILLER_124_249 vssd1 vccd1 vccd1 vssd1 SS_sky130_fd_sc_hd__fill_2
XFILLER_2_3 vssd1 vccd1 vssd1 vccd1 SS_sky130_ef_sc_hd__decap_40_12
XFILLER_3_557 vssd1 vccd1 vccd1 vssd1 SS_sky130_fd_sc_hd__fill_2
XFILLER_105_485 vssd1 vccd1 vssd1 vccd1 SS_sky130_ef_sc_hd__decap_40_12
XFILLER_94_807 vccd1 vssd1 vccd1 vssd1 SS_sky130_fd_sc_hd__fill_1
XTAP_TAPCELL_ROW_6_384 vccd1 vssd1 SS_sky130_fd_sc_hd__tapvpwrvgnd_1
XTAP_TAPCELL_ROW_6_395 vccd1 vssd1 SS_sky130_fd_sc_hd__tapvpwrvgnd_1
XFILLER_59_561 vssd1 vccd1 vssd1 vccd1 SS_sky130_ef_sc_hd__decap_40_12
XFILLER_120_477 vssd1 vccd1 vssd1 vccd1 SS_sky130_ef_sc_hd__decap_40_12
XFILLER_93_317 vssd1 vccd1 vssd1 vccd1 SS_sky130_ef_sc_hd__decap_40_12
XFILLER_19_447 vccd1 vssd1 vccd1 vssd1 SS_sky130_fd_sc_hd__fill_1
XFILLER_46_233 vssd1 vccd1 vssd1 vccd1 SS_sky130_ef_sc_hd__decap_40_12
XFILLER_74_520 vssd1 vccd1 vccd1 vssd1 SS_sky130_fd_sc_hd__fill_2
XFILLER_74_531 vccd1 vssd1 vccd1 vssd1 SS_sky130_fd_sc_hd__fill_1
XFILLER_34_417 vssd1 vccd1 vccd1 vssd1 SS_sky130_fd_sc_hd__fill_2
XFILLER_46_277 vssd1 vccd1 vssd1 vccd1 SS_sky130_ef_sc_hd__decap_40_12
XFILLER_61_225 vssd1 vccd1 vssd1 vccd1 SS_sky130_ef_sc_hd__decap_40_12
XFILLER_62_737 vssd1 vccd1 vssd1 vccd1 SS_sky130_ef_sc_hd__decap_40_12
XFILLER_74_586 vssd1 vccd1 vccd1 vssd1 SS_sky130_fd_sc_hd__fill_2
XFILLER_15_653 vssd1 vccd1 vssd1 vccd1 SS_sky130_ef_sc_hd__decap_40_12
XTAP_TAPCELL_ROW_45_968 vccd1 vssd1 SS_sky130_fd_sc_hd__tapvpwrvgnd_1
XTAP_TAPCELL_ROW_45_979 vccd1 vssd1 SS_sky130_fd_sc_hd__tapvpwrvgnd_1
XTAP_TAPCELL_ROW_83_1543 vccd1 vssd1 SS_sky130_fd_sc_hd__tapvpwrvgnd_1
XFILLER_14_141 vssd1 vccd1 vssd1 vccd1 SS_sky130_ef_sc_hd__decap_40_12
XFILLER_15_697 vssd1 vccd1 vssd1 vccd1 SS_sky130_ef_sc_hd__decap_40_12
XTAP_TAPCELL_ROW_25_670 vccd1 vssd1 SS_sky130_fd_sc_hd__tapvpwrvgnd_1
XFILLER_30_601 vssd1 vccd1 vssd1 vccd1 SS_sky130_ef_sc_hd__decap_40_12
XFILLER_42_461 vssd1 vccd1 vssd1 vccd1 SS_sky130_ef_sc_hd__decap_40_12
XTAP_TAPCELL_ROW_25_681 vccd1 vssd1 SS_sky130_fd_sc_hd__tapvpwrvgnd_1
XFILLER_30_645 vssd1 vccd1 vssd1 vccd1 SS_sky130_ef_sc_hd__decap_40_12
Xinput13 vssd1 vccd1 vccd1 vssd1 adc_eof input13/X SS_sky130_fd_sc_hd__clkdlybuf4s25_1
XFILLER_52_81 vssd1 vccd1 vccd1 vssd1 SS_sky130_fd_sc_hd__fill_2
X_0810_ vccd1 vssd1 vccd1 vssd1 _1516_/Q _0930_/B1 _1644_/Q _0894_/B1 _0810_/X SS_sky130_fd_sc_hd__a22o_2
XFILLER_7_841 vccd1 vssd1 vccd1 vssd1 SS_sky130_fd_sc_hd__fill_1
XFILLER_128_533 vssd1 vccd1 vssd1 vccd1 SS_sky130_ef_sc_hd__decap_40_12
X_0741_ vssd1 vccd1 vssd1 vccd1 _0755_/A _0754_/D _0755_/B _0741_/Y _0755_/C SS_sky130_fd_sc_hd__nor4b_2
Xinput46 vccd1 vssd1 input46/X input46/A vccd1 vssd1 SS_sky130_fd_sc_hd__buf_2
Xinput35 vssd1 vccd1 vccd1 vssd1 input35/A input35/X SS_sky130_fd_sc_hd__clkdlybuf4s25_1
Xinput24 vssd1 vccd1 vccd1 vssd1 input24/A input24/X SS_sky130_fd_sc_hd__clkdlybuf4s25_1
Xhold808 hold808/X _1495_/Q vccd1 vssd1 vssd1 vccd1 SS_sky130_fd_sc_hd__dlygate4sd3_1
XFILLER_115_205 vssd1 vccd1 vssd1 vccd1 SS_sky130_ef_sc_hd__decap_40_12
XFILLER_115_249 vssd1 vccd1 vssd1 vccd1 SS_sky130_ef_sc_hd__decap_40_12
XFILLER_35_3 vssd1 vccd1 vssd1 vccd1 SS_sky130_ef_sc_hd__decap_40_12
XFILLER_123_293 vssd1 vccd1 vssd1 vccd1 SS_sky130_ef_sc_hd__decap_40_12
XFILLER_96_133 vssd1 vccd1 vccd1 vssd1 SS_sky130_fd_sc_hd__fill_4
XFILLER_38_701 vssd1 vccd1 vssd1 vccd1 SS_sky130_ef_sc_hd__decap_40_12
XFILLER_96_177 vssd1 vccd1 vssd1 vccd1 SS_sky130_ef_sc_hd__decap_40_12
X_1224_ vccd1 vssd1 vccd1 vssd1 _1224_/X _1641_/Q _1272_/B SS_sky130_fd_sc_hd__or2_2
XFILLER_77_391 vccd1 vssd1 vccd1 vssd1 SS_sky130_fd_sc_hd__fill_1
XFILLER_84_339 vssd1 vccd1 vssd1 vccd1 SS_sky130_ef_sc_hd__decap_40_12
X_1155_ vssd1 vccd1 vccd1 vssd1 wire233/X input46/X _1607_/D _1165_/C1 _1154_/X SS_sky130_fd_sc_hd__o211a_2
XFILLER_80_501 vssd1 vccd1 vssd1 vccd1 SS_sky130_ef_sc_hd__decap_40_12
XFILLER_92_361 vssd1 vccd1 vccd1 vssd1 SS_sky130_fd_sc_hd__fill_2
XFILLER_25_417 vssd1 vccd1 vssd1 vccd1 SS_sky130_ef_sc_hd__decap_40_12
X_1086_ vccd1 vssd1 vccd1 vssd1 _1086_/X _1844_/A _1116_/B SS_sky130_fd_sc_hd__or2_2
XFILLER_37_277 vssd1 vccd1 vccd1 vssd1 SS_sky130_fd_sc_hd__fill_2
XTAP_TAPCELL_ROW_125_2182 vccd1 vssd1 SS_sky130_fd_sc_hd__tapvpwrvgnd_1
XTAP_TAPCELL_ROW_125_2171 vccd1 vssd1 SS_sky130_fd_sc_hd__tapvpwrvgnd_1
XFILLER_80_545 vssd1 vccd1 vccd1 vssd1 SS_sky130_fd_sc_hd__fill_8
XFILLER_33_461 vssd1 vccd1 vssd1 vccd1 SS_sky130_ef_sc_hd__decap_40_12
XFILLER_80_589 vssd1 vccd1 vssd1 vccd1 SS_sky130_ef_sc_hd__decap_40_12
XFILLER_32_29 vssd1 vccd1 vssd1 vccd1 SS_sky130_ef_sc_hd__decap_40_12
XFILLER_20_133 vssd1 vccd1 vccd1 vssd1 SS_sky130_fd_sc_hd__fill_4
XFILLER_21_689 vssd1 vccd1 vssd1 vccd1 SS_sky130_ef_sc_hd__decap_40_12
XFILLER_20_177 vssd1 vccd1 vssd1 vccd1 SS_sky130_ef_sc_hd__decap_40_12
X_0939_ vccd1 vssd1 vccd1 vssd1 _1570_/Q _0754_/X _1602_/Q wire446/X _0939_/X SS_sky130_fd_sc_hd__a22o_2
XTAP_TAPCELL_ROW_54_1111 vccd1 vssd1 SS_sky130_fd_sc_hd__tapvpwrvgnd_1
XFILLER_88_601 vssd1 vccd1 vccd1 vssd1 SS_sky130_fd_sc_hd__fill_4
XFILLER_134_558 vssd1 vccd1 vssd1 vccd1 SS_sky130_ef_sc_hd__decap_40_12
XFILLER_106_249 vssd1 vccd1 vccd1 vssd1 SS_sky130_fd_sc_hd__fill_2
XFILLER_0_505 vssd1 vccd1 vssd1 vccd1 SS_sky130_ef_sc_hd__decap_40_12
XFILLER_87_111 vccd1 vssd1 vccd1 vssd1 SS_sky130_fd_sc_hd__fill_1
XFILLER_115_783 vccd1 vssd1 vccd1 vssd1 SS_sky130_fd_sc_hd__fill_1
XFILLER_0_549 vssd1 vccd1 vccd1 vssd1 SS_sky130_fd_sc_hd__fill_2
XFILLER_57_15 vssd1 vccd1 vssd1 vccd1 SS_sky130_ef_sc_hd__decap_40_12
XFILLER_88_645 vssd1 vccd1 vccd1 vssd1 SS_sky130_fd_sc_hd__fill_4
XFILLER_29_701 vssd1 vccd1 vssd1 vccd1 SS_sky130_ef_sc_hd__decap_40_12
XFILLER_75_317 vssd1 vccd1 vssd1 vccd1 SS_sky130_ef_sc_hd__decap_40_12
XFILLER_102_477 vccd1 vssd1 vccd1 vssd1 SS_sky130_fd_sc_hd__fill_1
XTAP_TAPCELL_ROW_3_343 vccd1 vssd1 SS_sky130_fd_sc_hd__tapvpwrvgnd_1
XFILLER_56_531 vccd1 vssd1 vccd1 vssd1 SS_sky130_fd_sc_hd__fill_1
XFILLER_28_233 vssd1 vccd1 vssd1 vccd1 SS_sky130_ef_sc_hd__decap_40_12
XFILLER_90_309 vssd1 vccd1 vssd1 vccd1 SS_sky130_ef_sc_hd__decap_40_12
XFILLER_113_54 vssd1 vccd1 vccd1 vssd1 SS_sky130_fd_sc_hd__fill_2
XFILLER_16_417 vssd1 vccd1 vccd1 vssd1 SS_sky130_fd_sc_hd__fill_2
XFILLER_28_277 vssd1 vccd1 vssd1 vccd1 SS_sky130_ef_sc_hd__decap_40_12
XFILLER_43_225 vssd1 vccd1 vssd1 vccd1 SS_sky130_ef_sc_hd__decap_40_12
XFILLER_83_361 vssd1 vccd1 vssd1 vccd1 SS_sky130_ef_sc_hd__decap_40_12
XFILLER_73_69 vssd1 vccd1 vssd1 vccd1 SS_sky130_ef_sc_hd__decap_40_12
XFILLER_12_601 vssd1 vccd1 vssd1 vccd1 SS_sky130_ef_sc_hd__decap_40_12
XTAP_TAPCELL_ROW_42_927 vccd1 vssd1 SS_sky130_fd_sc_hd__tapvpwrvgnd_1
XTAP_TAPCELL_ROW_65_1273 vccd1 vssd1 SS_sky130_fd_sc_hd__tapvpwrvgnd_1
XFILLER_11_111 vccd1 vssd1 vccd1 vssd1 SS_sky130_fd_sc_hd__fill_1
XFILLER_12_645 vssd1 vccd1 vssd1 vccd1 SS_sky130_ef_sc_hd__decap_40_12
XFILLER_7_137 vssd1 vccd1 vssd1 vccd1 SS_sky130_ef_sc_hd__decap_40_12
XFILLER_137_330 vccd1 vssd1 vccd1 vssd1 SS_sky130_fd_sc_hd__fill_1
XFILLER_4_811 vccd1 vssd1 vccd1 vssd1 SS_sky130_fd_sc_hd__fill_1
XFILLER_138_51 vssd1 vccd1 vccd1 vssd1 SS_sky130_fd_sc_hd__fill_4
XFILLER_113_709 vssd1 vccd1 vssd1 vccd1 SS_sky130_ef_sc_hd__decap_40_12
XFILLER_98_77 vssd1 vccd1 vccd1 vssd1 SS_sky130_fd_sc_hd__fill_4
XFILLER_78_133 vssd1 vccd1 vccd1 vssd1 SS_sky130_fd_sc_hd__fill_4
XFILLER_105_293 vssd1 vccd1 vssd1 vccd1 SS_sky130_ef_sc_hd__decap_40_12
XFILLER_78_177 vssd1 vccd1 vssd1 vccd1 SS_sky130_ef_sc_hd__decap_40_12
XFILLER_121_797 vssd1 vccd1 vccd1 vssd1 SS_sky130_fd_sc_hd__fill_4
XFILLER_93_125 vssd1 vccd1 vssd1 vccd1 SS_sky130_ef_sc_hd__decap_40_12
XFILLER_47_81 vssd1 vccd1 vssd1 vccd1 SS_sky130_ef_sc_hd__decap_40_12
XFILLER_93_169 vssd1 vccd1 vssd1 vccd1 SS_sky130_ef_sc_hd__decap_40_12
XFILLER_19_277 vssd1 vccd1 vccd1 vssd1 SS_sky130_fd_sc_hd__fill_2
XFILLER_74_361 vssd1 vccd1 vccd1 vssd1 SS_sky130_fd_sc_hd__fill_2
XFILLER_50_707 vccd1 vssd1 vccd1 vssd1 SS_sky130_fd_sc_hd__fill_1
XFILLER_15_461 vssd1 vccd1 vssd1 vccd1 SS_sky130_ef_sc_hd__decap_40_12
XFILLER_62_589 vssd1 vccd1 vccd1 vssd1 SS_sky130_fd_sc_hd__fill_2
X_1842_ vccd1 vssd1 _1842_/X _1842_/A vccd1 vssd1 SS_sky130_fd_sc_hd__buf_2
XFILLER_8_53 vssd1 vccd1 vssd1 vccd1 SS_sky130_ef_sc_hd__decap_40_12
XFILLER_30_475 vccd1 vssd1 vccd1 vssd1 SS_sky130_fd_sc_hd__fill_1
XFILLER_8_97 vssd1 vccd1 vssd1 vccd1 SS_sky130_ef_sc_hd__decap_40_12
XFILLER_128_352 vssd1 vccd1 vssd1 vccd1 SS_sky130_ef_sc_hd__decap_40_12
XTAP_TAPCELL_ROW_96_1745 vccd1 vssd1 SS_sky130_fd_sc_hd__tapvpwrvgnd_1
XTAP_TAPCELL_ROW_96_1734 vccd1 vssd1 SS_sky130_fd_sc_hd__tapvpwrvgnd_1
XFILLER_7_671 vccd1 vssd1 vccd1 vssd1 SS_sky130_fd_sc_hd__fill_1
Xhold616 _1090_/A _1850_/A vccd1 vssd1 vssd1 vccd1 SS_sky130_fd_sc_hd__dlygate4sd3_1
Xhold627 _1362_/A _1887_/A vccd1 vssd1 vssd1 vccd1 SS_sky130_fd_sc_hd__dlygate4sd3_1
Xhold605 _1042_/A _1553_/Q vccd1 vssd1 vssd1 vccd1 SS_sky130_fd_sc_hd__dlygate4sd3_1
Xhold638 _1292_/A _1674_/Q vccd1 vssd1 vssd1 vccd1 SS_sky130_fd_sc_hd__dlygate4sd3_1
Xmax_cap346 vccd1 vssd1 _0865_/B1 wire347/X vccd1 vssd1 SS_sky130_fd_sc_hd__buf_6
Xhold649 _1140_/A _1601_/Q vccd1 vssd1 vssd1 vccd1 SS_sky130_fd_sc_hd__dlygate4sd3_1
XFILLER_116_569 vssd1 vccd1 vssd1 vccd1 SS_sky130_ef_sc_hd__decap_40_12
XFILLER_131_517 vssd1 vccd1 vssd1 vccd1 SS_sky130_ef_sc_hd__decap_40_12
XFILLER_69_111 vccd1 vssd1 vccd1 vssd1 SS_sky130_fd_sc_hd__fill_1
XFILLER_57_317 vssd1 vccd1 vssd1 vccd1 SS_sky130_ef_sc_hd__decap_40_12
XTAP_TAPCELL_ROW_127_2211 vccd1 vssd1 SS_sky130_fd_sc_hd__tapvpwrvgnd_1
XTAP_TAPCELL_ROW_127_2200 vccd1 vssd1 SS_sky130_fd_sc_hd__tapvpwrvgnd_1
XFILLER_97_497 vssd1 vccd1 vccd1 vssd1 SS_sky130_fd_sc_hd__fill_4
XTAP_TAPCELL_ROW_0_302 vccd1 vssd1 SS_sky130_fd_sc_hd__tapvpwrvgnd_1
XFILLER_72_309 vssd1 vccd1 vssd1 vccd1 SS_sky130_ef_sc_hd__decap_40_12
X_1207_ vssd1 vccd1 vccd1 vssd1 _1209_/A2 input43/X _1633_/D _1473_/C1 _1206_/X SS_sky130_fd_sc_hd__o211a_2
XFILLER_25_225 vssd1 vccd1 vssd1 vccd1 SS_sky130_ef_sc_hd__decap_40_12
XFILLER_53_534 vssd1 vccd1 vccd1 vssd1 SS_sky130_fd_sc_hd__fill_8
XFILLER_80_342 vssd1 vccd1 vssd1 vccd1 SS_sky130_ef_sc_hd__decap_40_12
X_1138_ vccd1 vssd1 vccd1 vssd1 _1138_/X _1138_/A _1140_/B SS_sky130_fd_sc_hd__or2_2
XFILLER_41_729 vssd1 vccd1 vssd1 vccd1 SS_sky130_ef_sc_hd__decap_40_12
X_1069_ vssd1 vccd1 vccd1 vssd1 _1077_/A2 input39/X _1566_/D _1465_/C1 _1068_/X SS_sky130_fd_sc_hd__o211a_2
XTAP_TAPCELL_ROW_105_1874 vccd1 vssd1 SS_sky130_fd_sc_hd__tapvpwrvgnd_1
XFILLER_34_792 vccd1 vssd1 vccd1 vssd1 SS_sky130_fd_sc_hd__fill_1
XFILLER_21_497 vssd1 vccd1 vccd1 vssd1 SS_sky130_fd_sc_hd__fill_4
XTAP_TAPCELL_ROW_138_2384 vccd1 vssd1 SS_sky130_fd_sc_hd__tapvpwrvgnd_1
XTAP_TAPCELL_ROW_138_2373 vccd1 vssd1 SS_sky130_fd_sc_hd__tapvpwrvgnd_1
XFILLER_119_385 vccd1 vssd1 vccd1 vssd1 SS_sky130_fd_sc_hd__fill_1
XTAP_TAPCELL_ROW_8_413 vccd1 vssd1 SS_sky130_fd_sc_hd__tapvpwrvgnd_1
XTAP_TAPCELL_ROW_8_424 vccd1 vssd1 SS_sky130_fd_sc_hd__tapvpwrvgnd_1
Xclkbuf_leaf_12_wb_clk_i _1634_/CLK clkbuf_leaf_7_wb_clk_i/A vccd1 vssd1 vssd1 vccd1
+ SS_sky130_fd_sc_hd__clkbuf_8
XFILLER_108_65 vssd1 vccd1 vssd1 vccd1 SS_sky130_ef_sc_hd__decap_40_12
XFILLER_0_335 vccd1 vssd1 vccd1 vssd1 SS_sky130_fd_sc_hd__fill_1
XFILLER_103_753 vssd1 vccd1 vssd1 vccd1 SS_sky130_ef_sc_hd__decap_40_12
XFILLER_88_475 vccd1 vssd1 vccd1 vssd1 SS_sky130_fd_sc_hd__fill_1
XFILLER_75_125 vssd1 vccd1 vssd1 vccd1 SS_sky130_ef_sc_hd__decap_40_12
XFILLER_124_53 vssd1 vccd1 vssd1 vccd1 SS_sky130_ef_sc_hd__decap_40_12
XFILLER_103_797 vssd1 vccd1 vccd1 vssd1 SS_sky130_fd_sc_hd__fill_8
XFILLER_29_553 vssd1 vccd1 vccd1 vssd1 SS_sky130_fd_sc_hd__fill_4
XFILLER_75_169 vssd1 vccd1 vssd1 vccd1 SS_sky130_ef_sc_hd__decap_40_12
XFILLER_124_97 vssd1 vccd1 vssd1 vccd1 SS_sky130_ef_sc_hd__decap_40_12
XTAP_TAPCELL_ROW_27_710 vccd1 vssd1 SS_sky130_fd_sc_hd__tapvpwrvgnd_1
XFILLER_29_597 vssd1 vccd1 vssd1 vccd1 SS_sky130_ef_sc_hd__decap_40_12
XFILLER_44_501 vssd1 vccd1 vccd1 vssd1 SS_sky130_fd_sc_hd__fill_4
XFILLER_44_523 vssd1 vccd1 vccd1 vssd1 SS_sky130_fd_sc_hd__fill_8
XTAP_TAPCELL_ROW_67_1302 vccd1 vssd1 SS_sky130_fd_sc_hd__tapvpwrvgnd_1
XFILLER_84_692 vssd1 vccd1 vccd1 vssd1 SS_sky130_fd_sc_hd__fill_8
XFILLER_91_629 vssd1 vccd1 vssd1 vccd1 SS_sky130_ef_sc_hd__decap_40_12
XFILLER_17_51 vssd1 vccd1 vccd1 vssd1 SS_sky130_fd_sc_hd__fill_4
XFILLER_32_707 vccd1 vssd1 vccd1 vssd1 SS_sky130_fd_sc_hd__fill_1
XFILLER_44_545 vssd1 vccd1 vccd1 vssd1 SS_sky130_fd_sc_hd__fill_4
XFILLER_90_139 vccd1 vssd1 vccd1 vssd1 SS_sky130_fd_sc_hd__fill_1
XFILLER_31_217 vssd1 vccd1 vccd1 vssd1 SS_sky130_fd_sc_hd__fill_4
XFILLER_32_718 vssd1 vccd1 vssd1 vccd1 SS_sky130_ef_sc_hd__decap_40_12
XFILLER_44_589 vssd1 vccd1 vssd1 vccd1 SS_sky130_ef_sc_hd__decap_40_12
XTAP_TAPCELL_ROW_80_1502 vccd1 vssd1 SS_sky130_fd_sc_hd__tapvpwrvgnd_1
XFILLER_25_781 vssd1 vccd1 vccd1 vssd1 SS_sky130_fd_sc_hd__fill_2
XFILLER_8_413 vssd1 vccd1 vccd1 vssd1 SS_sky130_fd_sc_hd__fill_4
XFILLER_129_105 vssd1 vccd1 vccd1 vssd1 SS_sky130_fd_sc_hd__fill_4
XFILLER_12_475 vccd1 vssd1 vccd1 vssd1 SS_sky130_fd_sc_hd__fill_1
XFILLER_129_149 vssd1 vccd1 vssd1 vccd1 SS_sky130_ef_sc_hd__decap_40_12
XFILLER_8_457 vssd1 vccd1 vssd1 vccd1 SS_sky130_ef_sc_hd__decap_40_12
XTAP_TAPCELL_ROW_78_1464 vccd1 vssd1 SS_sky130_fd_sc_hd__tapvpwrvgnd_1
XFILLER_125_311 vssd1 vccd1 vssd1 vccd1 SS_sky130_ef_sc_hd__decap_40_12
XFILLER_4_641 vssd1 vccd1 vccd1 vssd1 SS_sky130_fd_sc_hd__fill_2
XTAP_TAPCELL_ROW_78_1475 vccd1 vssd1 SS_sky130_fd_sc_hd__tapvpwrvgnd_1
XFILLER_125_366 vssd1 vccd1 vssd1 vccd1 SS_sky130_ef_sc_hd__decap_40_12
XFILLER_99_729 vssd1 vccd1 vssd1 vccd1 SS_sky130_ef_sc_hd__decap_40_12
XTAP_TAPCELL_ROW_91_1664 vccd1 vssd1 SS_sky130_fd_sc_hd__tapvpwrvgnd_1
XFILLER_39_317 vssd1 vccd1 vssd1 vccd1 SS_sky130_ef_sc_hd__decap_40_12
XFILLER_67_615 vccd1 vssd1 vccd1 vssd1 SS_sky130_fd_sc_hd__fill_1
XFILLER_121_561 vssd1 vccd1 vccd1 vssd1 SS_sky130_fd_sc_hd__fill_4
XFILLER_94_401 vssd1 vccd1 vssd1 vccd1 SS_sky130_ef_sc_hd__decap_40_12
XFILLER_67_648 vssd1 vccd1 vssd1 vccd1 SS_sky130_ef_sc_hd__decap_40_12
XFILLER_54_309 vssd1 vccd1 vssd1 vccd1 SS_sky130_ef_sc_hd__decap_40_12
XFILLER_35_501 vssd1 vccd1 vccd1 vssd1 SS_sky130_fd_sc_hd__fill_2
XFILLER_47_361 vssd1 vccd1 vccd1 vssd1 SS_sky130_fd_sc_hd__fill_2
XFILLER_94_489 vssd1 vccd1 vssd1 vccd1 SS_sky130_ef_sc_hd__decap_40_12
XTAP_TAPCELL_ROW_122_2130 vccd1 vssd1 SS_sky130_fd_sc_hd__tapvpwrvgnd_1
XFILLER_23_729 vssd1 vccd1 vssd1 vccd1 SS_sky130_ef_sc_hd__decap_40_12
XFILLER_35_589 vssd1 vccd1 vccd1 vssd1 SS_sky130_fd_sc_hd__fill_2
XFILLER_16_781 vssd1 vccd1 vssd1 vccd1 SS_sky130_ef_sc_hd__decap_40_12
XTAP_TAPCELL_ROW_13_492 vccd1 vssd1 SS_sky130_fd_sc_hd__tapvpwrvgnd_1
XTAP_TAPCELL_ROW_100_1793 vccd1 vssd1 SS_sky130_fd_sc_hd__tapvpwrvgnd_1
X_1756_ _1756_/Q _1756_/CLK _1756_/D vccd1 vssd1 vccd1 vssd1 SS_sky130_fd_sc_hd__dfxtp_2
XFILLER_128_193 vssd1 vccd1 vccd1 vssd1 SS_sky130_fd_sc_hd__fill_2
X_1687_ _1687_/Q clkload3/A _1687_/D vccd1 vssd1 vccd1 vssd1 SS_sky130_fd_sc_hd__dfxtp_2
XFILLER_89_217 vssd1 vccd1 vccd1 vssd1 SS_sky130_fd_sc_hd__fill_4
XTAP_TAPCELL_ROW_133_2292 vccd1 vssd1 SS_sky130_fd_sc_hd__tapvpwrvgnd_1
XFILLER_116_377 vssd1 vccd1 vssd1 vccd1 SS_sky130_ef_sc_hd__decap_40_12
XFILLER_100_701 vssd1 vccd1 vssd1 vccd1 SS_sky130_ef_sc_hd__decap_40_12
XFILLER_97_261 vssd1 vccd1 vssd1 vccd1 SS_sky130_ef_sc_hd__decap_40_12
XFILLER_57_125 vssd1 vccd1 vssd1 vccd1 SS_sky130_ef_sc_hd__decap_40_12
XFILLER_85_434 vssd1 vccd1 vssd1 vccd1 SS_sky130_ef_sc_hd__decap_40_12
XFILLER_100_734 vssd1 vccd1 vssd1 vccd1 SS_sky130_ef_sc_hd__decap_40_12
XFILLER_57_169 vssd1 vccd1 vssd1 vccd1 SS_sky130_ef_sc_hd__decap_40_12
XFILLER_26_501 vssd1 vccd1 vssd1 vccd1 SS_sky130_ef_sc_hd__decap_40_12
XFILLER_38_361 vssd1 vccd1 vccd1 vssd1 SS_sky130_fd_sc_hd__fill_2
XFILLER_73_629 vssd1 vccd1 vssd1 vccd1 SS_sky130_ef_sc_hd__decap_40_12
XTAP_TAPCELL_ROW_107_1903 vccd1 vssd1 SS_sky130_fd_sc_hd__tapvpwrvgnd_1
XFILLER_26_545 vssd1 vccd1 vssd1 vccd1 SS_sky130_ef_sc_hd__decap_40_12
XTAP_TAPCELL_ROW_49_1032 vccd1 vssd1 SS_sky130_fd_sc_hd__tapvpwrvgnd_1
XFILLER_54_27 vccd1 vssd1 vccd1 vssd1 SS_sky130_fd_sc_hd__fill_1
XFILLER_72_139 vccd1 vssd1 vccd1 vssd1 SS_sky130_fd_sc_hd__fill_1
XFILLER_81_651 vssd1 vccd1 vssd1 vccd1 SS_sky130_ef_sc_hd__decap_40_12
XFILLER_26_589 vssd1 vccd1 vssd1 vccd1 SS_sky130_ef_sc_hd__decap_40_12
XFILLER_81_673 vssd1 vccd1 vccd1 vssd1 SS_sky130_fd_sc_hd__fill_4
XFILLER_81_684 vssd1 vccd1 vccd1 vssd1 SS_sky130_fd_sc_hd__fill_4
XFILLER_13_217 vssd1 vccd1 vccd1 vssd1 SS_sky130_fd_sc_hd__fill_4
XTAP_TAPCELL_ROW_62_1232 vccd1 vssd1 SS_sky130_fd_sc_hd__tapvpwrvgnd_1
XFILLER_70_15 vssd1 vccd1 vssd1 vccd1 SS_sky130_ef_sc_hd__decap_40_12
XFILLER_110_77 vssd1 vccd1 vccd1 vssd1 SS_sky130_fd_sc_hd__fill_4
XFILLER_21_261 vssd1 vccd1 vssd1 vccd1 SS_sky130_ef_sc_hd__decap_40_12
XFILLER_22_795 vssd1 vccd1 vssd1 vccd1 SS_sky130_ef_sc_hd__decap_40_12
XFILLER_5_405 vssd1 vccd1 vssd1 vccd1 SS_sky130_ef_sc_hd__decap_40_12
XFILLER_5_449 vssd1 vccd1 vssd1 vccd1 SS_sky130_ef_sc_hd__decap_40_12
XFILLER_134_141 vssd1 vccd1 vssd1 vccd1 SS_sky130_ef_sc_hd__decap_40_12
XFILLER_119_193 vssd1 vccd1 vssd1 vccd1 SS_sky130_ef_sc_hd__decap_40_12
XFILLER_107_333 vssd1 vccd1 vccd1 vssd1 SS_sky130_fd_sc_hd__fill_2
XFILLER_79_57 vssd1 vccd1 vssd1 vccd1 SS_sky130_ef_sc_hd__decap_40_12
XFILLER_135_697 vssd1 vccd1 vccd1 vssd1 SS_sky130_fd_sc_hd__fill_8
XFILLER_102_3 vssd1 vccd1 vssd1 vccd1 SS_sky130_ef_sc_hd__decap_40_12
XFILLER_49_615 vccd1 vssd1 vccd1 vssd1 SS_sky130_fd_sc_hd__fill_1
XTAP_TAPCELL_ROW_73_1394 vccd1 vssd1 SS_sky130_fd_sc_hd__tapvpwrvgnd_1
XFILLER_76_401 vssd1 vccd1 vssd1 vccd1 SS_sky130_ef_sc_hd__decap_40_12
XFILLER_103_561 vssd1 vccd1 vccd1 vssd1 SS_sky130_fd_sc_hd__fill_4
XFILLER_49_637 vssd1 vccd1 vssd1 vccd1 SS_sky130_ef_sc_hd__decap_40_12
XFILLER_36_309 vssd1 vccd1 vssd1 vccd1 SS_sky130_ef_sc_hd__decap_40_12
XFILLER_64_618 vssd1 vccd1 vssd1 vccd1 SS_sky130_ef_sc_hd__decap_40_12
XFILLER_76_445 vssd1 vccd1 vssd1 vccd1 SS_sky130_ef_sc_hd__decap_40_12
XFILLER_17_501 vssd1 vccd1 vccd1 vssd1 SS_sky130_fd_sc_hd__fill_2
XFILLER_28_83 vccd1 vssd1 vccd1 vssd1 SS_sky130_fd_sc_hd__fill_1
XFILLER_29_361 vssd1 vccd1 vssd1 vccd1 SS_sky130_ef_sc_hd__decap_40_12
XFILLER_45_821 vssd1 vccd1 vccd1 vssd1 SS_sky130_fd_sc_hd__fill_2
XFILLER_76_489 vssd1 vccd1 vssd1 vccd1 SS_sky130_ef_sc_hd__decap_40_12
XFILLER_60_813 vccd1 vssd1 vccd1 vssd1 SS_sky130_fd_sc_hd__fill_1
XFILLER_60_824 vssd1 vccd1 vccd1 vssd1 SS_sky130_fd_sc_hd__fill_2
XFILLER_72_651 vssd1 vccd1 vssd1 vccd1 SS_sky130_ef_sc_hd__decap_40_12
XFILLER_71_161 vssd1 vccd1 vccd1 vssd1 SS_sky130_fd_sc_hd__fill_4
XFILLER_8_221 vssd1 vccd1 vssd1 vccd1 SS_sky130_ef_sc_hd__decap_40_12
XFILLER_40_581 vssd1 vccd1 vccd1 vssd1 SS_sky130_fd_sc_hd__fill_4
XFILLER_9_777 vssd1 vccd1 vccd1 vssd1 SS_sky130_fd_sc_hd__fill_4
XTAP_TAPCELL_ROW_30_749 vccd1 vssd1 SS_sky130_fd_sc_hd__tapvpwrvgnd_1
XFILLER_8_265 vssd1 vccd1 vssd1 vccd1 SS_sky130_ef_sc_hd__decap_40_12
XTAP_TAPCELL_ROW_10_451 vccd1 vssd1 SS_sky130_fd_sc_hd__tapvpwrvgnd_1
X_1610_ _1870_/A _1610_/CLK _1610_/D vccd1 vssd1 vccd1 vssd1 SS_sky130_fd_sc_hd__dfxtp_2
XFILLER_60_81 vssd1 vccd1 vccd1 vssd1 SS_sky130_fd_sc_hd__fill_2
X_1541_ _1828_/A _1573_/CLK _1541_/D vccd1 vssd1 vccd1 vssd1 SS_sky130_fd_sc_hd__dfxtp_2
XFILLER_126_686 vssd1 vccd1 vssd1 vccd1 SS_sky130_ef_sc_hd__decap_40_12
X_1472_ vccd1 vssd1 vccd1 vssd1 _1472_/X _1472_/A _1472_/B SS_sky130_fd_sc_hd__or2_2
XFILLER_99_559 vccd1 vssd1 vccd1 vssd1 SS_sky130_fd_sc_hd__fill_1
XFILLER_67_401 vssd1 vccd1 vssd1 vccd1 SS_sky130_ef_sc_hd__decap_40_12
XFILLER_86_209 vssd1 vccd1 vssd1 vccd1 SS_sky130_ef_sc_hd__decap_40_12
XFILLER_39_125 vssd1 vccd1 vssd1 vccd1 SS_sky130_ef_sc_hd__decap_40_12
XFILLER_79_261 vssd1 vccd1 vssd1 vccd1 SS_sky130_ef_sc_hd__decap_40_12
XFILLER_95_721 vssd1 vccd1 vccd1 vssd1 SS_sky130_fd_sc_hd__fill_4
XFILLER_67_445 vssd1 vccd1 vccd1 vssd1 SS_sky130_fd_sc_hd__fill_2
XFILLER_95_765 vssd1 vccd1 vccd1 vssd1 SS_sky130_fd_sc_hd__fill_8
XFILLER_94_253 vssd1 vccd1 vssd1 vccd1 SS_sky130_ef_sc_hd__decap_40_12
XFILLER_39_169 vssd1 vccd1 vssd1 vccd1 SS_sky130_ef_sc_hd__decap_40_12
XFILLER_48_681 vssd1 vccd1 vssd1 vccd1 SS_sky130_ef_sc_hd__decap_40_12
XFILLER_55_629 vssd1 vccd1 vccd1 vssd1 SS_sky130_fd_sc_hd__fill_4
XFILLER_54_139 vccd1 vssd1 vccd1 vssd1 SS_sky130_fd_sc_hd__fill_1
XFILLER_63_673 vssd1 vccd1 vssd1 vccd1 SS_sky130_ef_sc_hd__decap_40_12
XTAP_TAPCELL_ROW_18_573 vccd1 vssd1 SS_sky130_fd_sc_hd__tapvpwrvgnd_1
XFILLER_50_301 vssd1 vccd1 vccd1 vssd1 SS_sky130_fd_sc_hd__fill_4
XFILLER_23_559 vccd1 vssd1 vccd1 vssd1 SS_sky130_fd_sc_hd__fill_1
XFILLER_50_345 vssd1 vccd1 vssd1 vccd1 SS_sky130_ef_sc_hd__decap_40_12
XTAP_TAPCELL_ROW_102_1833 vccd1 vssd1 SS_sky130_fd_sc_hd__tapvpwrvgnd_1
XFILLER_10_209 vssd1 vccd1 vssd1 vccd1 SS_sky130_ef_sc_hd__decap_40_12
XFILLER_50_389 vssd1 vccd1 vssd1 vccd1 SS_sky130_ef_sc_hd__decap_40_12
XTAP_TAPCELL_ROW_135_2321 vccd1 vssd1 SS_sky130_fd_sc_hd__tapvpwrvgnd_1
XTAP_TAPCELL_ROW_135_2332 vccd1 vssd1 SS_sky130_fd_sc_hd__tapvpwrvgnd_1
XFILLER_40_29 vssd1 vccd1 vssd1 vccd1 SS_sky130_ef_sc_hd__decap_40_12
XFILLER_136_417 vssd1 vccd1 vccd1 vssd1 SS_sky130_fd_sc_hd__fill_2
XFILLER_136_439 vssd1 vccd1 vssd1 vccd1 SS_sky130_ef_sc_hd__decap_40_12
XFILLER_2_419 vccd1 vssd1 vccd1 vssd1 SS_sky130_fd_sc_hd__fill_1
X_1739_ _1903_/A _1742_/CLK _1739_/D vccd1 vssd1 vccd1 vssd1 SS_sky130_fd_sc_hd__dfxtp_2
XFILLER_132_601 vssd1 vccd1 vssd1 vccd1 SS_sky130_ef_sc_hd__decap_40_12
XFILLER_116_141 vssd1 vccd1 vssd1 vccd1 SS_sky130_ef_sc_hd__decap_40_12
XFILLER_49_27 vssd1 vccd1 vssd1 vccd1 SS_sky130_ef_sc_hd__decap_40_12
XFILLER_131_111 vccd1 vssd1 vccd1 vssd1 SS_sky130_fd_sc_hd__fill_1
XFILLER_132_645 vssd1 vccd1 vssd1 vccd1 SS_sky130_ef_sc_hd__decap_40_12
XTAP_TAPCELL_ROW_113_1995 vccd1 vssd1 SS_sky130_fd_sc_hd__tapvpwrvgnd_1
XFILLER_98_581 vssd1 vccd1 vccd1 vssd1 SS_sky130_fd_sc_hd__fill_4
XFILLER_65_15 vssd1 vccd1 vssd1 vccd1 SS_sky130_ef_sc_hd__decap_40_12
XFILLER_105_55 vccd1 vssd1 vccd1 vssd1 SS_sky130_fd_sc_hd__fill_1
XFILLER_100_553 vssd1 vccd1 vssd1 vccd1 SS_sky130_ef_sc_hd__decap_40_12
XFILLER_100_531 vccd1 vssd1 vccd1 vssd1 SS_sky130_fd_sc_hd__fill_1
XFILLER_18_309 vssd1 vccd1 vssd1 vccd1 SS_sky130_ef_sc_hd__decap_40_12
XFILLER_39_681 vccd1 vssd1 vccd1 vssd1 SS_sky130_fd_sc_hd__fill_1
XTAP_TAPCELL_ROW_37_860 vccd1 vssd1 SS_sky130_fd_sc_hd__tapvpwrvgnd_1
XFILLER_60_109 vssd1 vccd1 vssd1 vccd1 SS_sky130_ef_sc_hd__decap_40_12
XFILLER_53_161 vssd1 vccd1 vccd1 vssd1 SS_sky130_fd_sc_hd__fill_4
XFILLER_54_695 vssd1 vccd1 vccd1 vssd1 SS_sky130_fd_sc_hd__fill_4
XFILLER_121_54 vssd1 vccd1 vccd1 vssd1 SS_sky130_fd_sc_hd__fill_2
XFILLER_81_69 vssd1 vccd1 vssd1 vccd1 SS_sky130_ef_sc_hd__decap_40_12
XFILLER_14_41 vssd1 vccd1 vssd1 vccd1 SS_sky130_ef_sc_hd__decap_40_12
XFILLER_41_389 vssd1 vccd1 vccd1 vssd1 SS_sky130_fd_sc_hd__fill_2
XFILLER_14_85 vssd1 vccd1 vssd1 vccd1 SS_sky130_ef_sc_hd__decap_40_12
XFILLER_22_581 vssd1 vccd1 vccd1 vssd1 SS_sky130_fd_sc_hd__fill_4
XPHY_EDGE_ROW_101_Left_240 vccd1 vssd1 vccd1 vssd1 SS_sky130_fd_sc_hd__decap_3
XFILLER_6_725 vssd1 vccd1 vssd1 vccd1 SS_sky130_ef_sc_hd__decap_40_12
XFILLER_6_769 vssd1 vccd1 vssd1 vccd1 SS_sky130_ef_sc_hd__decap_40_12
XFILLER_108_653 vccd1 vssd1 vccd1 vssd1 SS_sky130_fd_sc_hd__fill_1
XFILLER_5_279 vccd1 vssd1 vccd1 vssd1 SS_sky130_fd_sc_hd__fill_1
XTAP_TAPCELL_ROW_75_1423 vccd1 vssd1 SS_sky130_fd_sc_hd__tapvpwrvgnd_1
XFILLER_123_656 vccd1 vssd1 vccd1 vssd1 SS_sky130_fd_sc_hd__fill_1
XFILLER_123_623 vccd1 vssd1 vccd1 vssd1 SS_sky130_fd_sc_hd__fill_1
XFILLER_108_697 vssd1 vccd1 vccd1 vssd1 SS_sky130_fd_sc_hd__fill_2
XFILLER_1_441 vssd1 vccd1 vccd1 vssd1 SS_sky130_fd_sc_hd__fill_4
XFILLER_68_209 vssd1 vccd1 vssd1 vccd1 SS_sky130_ef_sc_hd__decap_40_12
XFILLER_122_133 vssd1 vccd1 vccd1 vssd1 SS_sky130_fd_sc_hd__fill_4
XFILLER_1_485 vssd1 vccd1 vssd1 vccd1 SS_sky130_ef_sc_hd__decap_40_12
XFILLER_77_721 vssd1 vccd1 vccd1 vssd1 SS_sky130_fd_sc_hd__fill_4
XFILLER_122_177 vssd1 vccd1 vssd1 vccd1 SS_sky130_ef_sc_hd__decap_40_12
XFILLER_39_93 vssd1 vccd1 vssd1 vccd1 SS_sky130_ef_sc_hd__decap_40_12
XFILLER_76_253 vssd1 vccd1 vssd1 vccd1 SS_sky130_ef_sc_hd__decap_40_12
XFILLER_92_735 vccd1 vssd1 vccd1 vssd1 SS_sky130_fd_sc_hd__fill_1
XFILLER_92_713 vssd1 vccd1 vssd1 vccd1 SS_sky130_ef_sc_hd__decap_40_12
XFILLER_36_139 vccd1 vssd1 vccd1 vssd1 SS_sky130_fd_sc_hd__fill_1
XFILLER_91_223 vccd1 vssd1 vccd1 vssd1 SS_sky130_fd_sc_hd__fill_1
XFILLER_92_757 vssd1 vccd1 vssd1 vccd1 SS_sky130_ef_sc_hd__decap_40_12
XTAP_TAPCELL_ROW_35_819 vccd1 vssd1 SS_sky130_fd_sc_hd__tapvpwrvgnd_1
XFILLER_45_673 vssd1 vccd1 vccd1 vssd1 SS_sky130_fd_sc_hd__fill_8
XFILLER_51_109 vssd1 vccd1 vccd1 vssd1 SS_sky130_fd_sc_hd__fill_2
XFILLER_55_81 vssd1 vccd1 vssd1 vccd1 SS_sky130_ef_sc_hd__decap_40_12
XFILLER_32_301 vssd1 vccd1 vccd1 vssd1 SS_sky130_fd_sc_hd__fill_4
XTAP_TAPCELL_ROW_86_1585 vccd1 vssd1 SS_sky130_fd_sc_hd__tapvpwrvgnd_1
XTAP_TAPCELL_ROW_86_1596 vccd1 vssd1 SS_sky130_fd_sc_hd__tapvpwrvgnd_1
XTAP_TAPCELL_ROW_15_521 vccd1 vssd1 SS_sky130_fd_sc_hd__tapvpwrvgnd_1
XTAP_TAPCELL_ROW_15_532 vccd1 vssd1 SS_sky130_fd_sc_hd__tapvpwrvgnd_1
XFILLER_32_345 vssd1 vccd1 vssd1 vccd1 SS_sky130_ef_sc_hd__decap_40_12
XFILLER_60_654 vssd1 vccd1 vssd1 vccd1 SS_sky130_ef_sc_hd__decap_40_12
XFILLER_20_529 vssd1 vccd1 vccd1 vssd1 SS_sky130_fd_sc_hd__fill_2
XFILLER_32_389 vssd1 vccd1 vssd1 vccd1 SS_sky130_ef_sc_hd__decap_40_12
XFILLER_60_698 vssd1 vccd1 vccd1 vssd1 SS_sky130_fd_sc_hd__fill_2
X_0972_ vccd1 vssd1 vccd1 vssd1 _0972_/X _0972_/A _1006_/B SS_sky130_fd_sc_hd__or2_2
XFILLER_9_541 vssd1 vccd1 vssd1 vccd1 SS_sky130_ef_sc_hd__decap_40_12
XFILLER_9_585 vssd1 vccd1 vssd1 vccd1 SS_sky130_ef_sc_hd__decap_40_12
XTAP_TAPCELL_ROW_117_2051 vccd1 vssd1 SS_sky130_fd_sc_hd__tapvpwrvgnd_1
XFILLER_65_3 vssd1 vccd1 vssd1 vccd1 SS_sky130_ef_sc_hd__decap_40_12
XTAP_TAPCELL_ROW_117_2062 vccd1 vssd1 SS_sky130_fd_sc_hd__tapvpwrvgnd_1
X_1524_ _1524_/Q _1748_/CLK _1524_/D vccd1 vssd1 vccd1 vssd1 SS_sky130_fd_sc_hd__dfxtp_2
XTAP_TAPCELL_ROW_130_2251 vccd1 vssd1 SS_sky130_fd_sc_hd__tapvpwrvgnd_1
XFILLER_114_645 vssd1 vccd1 vssd1 vccd1 SS_sky130_ef_sc_hd__decap_40_12
XFILLER_113_111 vccd1 vssd1 vccd1 vssd1 SS_sky130_fd_sc_hd__fill_1
XFILLER_68_721 vssd1 vccd1 vssd1 vccd1 SS_sky130_ef_sc_hd__decap_40_12
X_1455_ vssd1 vccd1 vccd1 vssd1 wire207/X input34/X _1753_/D _1457_/C1 _1454_/X SS_sky130_fd_sc_hd__o211a_2
XFILLER_101_317 vccd1 vssd1 vccd1 vssd1 SS_sky130_fd_sc_hd__fill_1
X_1386_ vccd1 vssd1 vccd1 vssd1 _1386_/X _1386_/A _1404_/B SS_sky130_fd_sc_hd__or2_2
XFILLER_83_713 vssd1 vccd1 vccd1 vssd1 SS_sky130_fd_sc_hd__fill_2
XFILLER_55_437 vssd1 vccd1 vccd1 vssd1 SS_sky130_fd_sc_hd__fill_8
XFILLER_24_813 vccd1 vssd1 vccd1 vssd1 SS_sky130_fd_sc_hd__fill_1
XFILLER_42_109 vssd1 vccd1 vssd1 vccd1 SS_sky130_ef_sc_hd__decap_40_12
XFILLER_82_245 vssd1 vccd1 vccd1 vssd1 SS_sky130_fd_sc_hd__fill_4
XFILLER_35_161 vssd1 vccd1 vccd1 vssd1 SS_sky130_fd_sc_hd__fill_4
XFILLER_82_289 vssd1 vccd1 vssd1 vccd1 SS_sky130_ef_sc_hd__decap_40_12
XFILLER_11_529 vssd1 vccd1 vssd1 vccd1 SS_sky130_ef_sc_hd__decap_40_12
XFILLER_23_389 vssd1 vccd1 vccd1 vssd1 SS_sky130_fd_sc_hd__fill_2
XFILLER_50_153 vssd1 vccd1 vssd1 vccd1 SS_sky130_ef_sc_hd__decap_40_12
XFILLER_50_197 vssd1 vccd1 vssd1 vccd1 SS_sky130_ef_sc_hd__decap_40_12
Xwire409 vccd1 vssd1 vssd1 vccd1 wire409/A analog_ctrl[72] SS_sky130_fd_sc_hd__buf_12
XFILLER_137_737 vssd1 vccd1 vccd1 vssd1 SS_sky130_fd_sc_hd__fill_2
XFILLER_136_247 vssd1 vccd1 vccd1 vssd1 SS_sky130_fd_sc_hd__fill_4
XTAP_TAPCELL_ROW_57_1153 vccd1 vssd1 SS_sky130_fd_sc_hd__tapvpwrvgnd_1
XFILLER_105_623 vccd1 vssd1 vccd1 vssd1 SS_sky130_fd_sc_hd__fill_1
XFILLER_2_249 vssd1 vccd1 vccd1 vssd1 SS_sky130_fd_sc_hd__fill_2
XFILLER_78_507 vccd1 vssd1 vccd1 vssd1 SS_sky130_fd_sc_hd__fill_1
XFILLER_105_656 vssd1 vccd1 vssd1 vccd1 SS_sky130_ef_sc_hd__decap_40_12
XFILLER_104_133 vssd1 vccd1 vccd1 vssd1 SS_sky130_fd_sc_hd__fill_4
XFILLER_116_65 vssd1 vccd1 vssd1 vccd1 SS_sky130_ef_sc_hd__decap_40_12
XFILLER_104_177 vssd1 vccd1 vssd1 vccd1 SS_sky130_ef_sc_hd__decap_40_12
XFILLER_59_765 vssd1 vccd1 vssd1 vccd1 SS_sky130_ef_sc_hd__decap_40_12
XTAP_TAPCELL_ROW_70_1353 vccd1 vssd1 SS_sky130_fd_sc_hd__tapvpwrvgnd_1
XFILLER_19_629 vssd1 vccd1 vssd1 vccd1 SS_sky130_ef_sc_hd__decap_40_12
XFILLER_58_253 vssd1 vccd1 vssd1 vccd1 SS_sky130_ef_sc_hd__decap_40_12
XFILLER_100_361 vssd1 vccd1 vccd1 vssd1 SS_sky130_fd_sc_hd__fill_2
XFILLER_18_139 vccd1 vssd1 vccd1 vssd1 SS_sky130_fd_sc_hd__fill_1
XFILLER_73_223 vccd1 vssd1 vccd1 vssd1 SS_sky130_fd_sc_hd__fill_1
XFILLER_74_735 vssd1 vccd1 vccd1 vssd1 SS_sky130_fd_sc_hd__fill_2
XFILLER_74_757 vssd1 vccd1 vssd1 vccd1 SS_sky130_ef_sc_hd__decap_40_12
XFILLER_132_53 vssd1 vccd1 vssd1 vccd1 SS_sky130_ef_sc_hd__decap_40_12
XFILLER_33_109 vssd1 vccd1 vccd1 vssd1 SS_sky130_fd_sc_hd__fill_2
XFILLER_14_301 vssd1 vccd1 vccd1 vssd1 SS_sky130_fd_sc_hd__fill_4
XFILLER_27_673 vssd1 vccd1 vccd1 vssd1 SS_sky130_fd_sc_hd__fill_8
XFILLER_27_695 vccd1 vssd1 vccd1 vssd1 SS_sky130_fd_sc_hd__fill_1
XFILLER_132_97 vssd1 vccd1 vssd1 vccd1 SS_sky130_ef_sc_hd__decap_40_12
XFILLER_14_345 vssd1 vccd1 vssd1 vccd1 SS_sky130_ef_sc_hd__decap_40_12
XFILLER_25_51 vssd1 vccd1 vccd1 vssd1 SS_sky130_fd_sc_hd__fill_4
XFILLER_14_389 vssd1 vccd1 vssd1 vccd1 SS_sky130_ef_sc_hd__decap_40_12
XFILLER_6_533 vssd1 vccd1 vssd1 vccd1 SS_sky130_ef_sc_hd__decap_40_12
XTAP_TAPCELL_ROW_40_899 vccd1 vssd1 SS_sky130_fd_sc_hd__tapvpwrvgnd_1
XFILLER_127_225 vssd1 vccd1 vssd1 vccd1 SS_sky130_ef_sc_hd__decap_40_12
XFILLER_108_494 vssd1 vccd1 vssd1 vccd1 SS_sky130_ef_sc_hd__decap_40_12
XFILLER_69_529 vssd1 vccd1 vssd1 vccd1 SS_sky130_ef_sc_hd__decap_40_12
XFILLER_96_315 vccd1 vssd1 vccd1 vssd1 SS_sky130_fd_sc_hd__fill_1
XFILLER_1_293 vssd1 vccd1 vssd1 vccd1 SS_sky130_ef_sc_hd__decap_40_12
X_1240_ vccd1 vssd1 vccd1 vssd1 _1240_/X _1240_/A _1272_/B SS_sky130_fd_sc_hd__or2_2
XFILLER_2_77 vssd1 vccd1 vccd1 vssd1 SS_sky130_fd_sc_hd__fill_4
X_1171_ vssd1 vccd1 vccd1 vssd1 wire233/X wire499/X _1615_/D _1425_/C1 _1170_/X SS_sky130_fd_sc_hd__o211a_2
XFILLER_77_573 vssd1 vccd1 vssd1 vccd1 SS_sky130_ef_sc_hd__decap_40_12
XTAP_TAPCELL_ROW_88_1614 vccd1 vssd1 SS_sky130_fd_sc_hd__tapvpwrvgnd_1
XTAP_TAPCELL_ROW_88_1625 vccd1 vssd1 SS_sky130_fd_sc_hd__tapvpwrvgnd_1
XFILLER_64_245 vssd1 vccd1 vccd1 vssd1 SS_sky130_fd_sc_hd__fill_4
XFILLER_17_161 vssd1 vccd1 vccd1 vssd1 SS_sky130_fd_sc_hd__fill_4
XFILLER_24_109 vssd1 vccd1 vssd1 vccd1 SS_sky130_ef_sc_hd__decap_40_12
XFILLER_45_481 vssd1 vccd1 vssd1 vccd1 SS_sky130_ef_sc_hd__decap_40_12
XFILLER_52_429 vssd1 vccd1 vssd1 vccd1 SS_sky130_ef_sc_hd__decap_40_12
XFILLER_64_289 vssd1 vccd1 vssd1 vccd1 SS_sky130_ef_sc_hd__decap_40_12
XFILLER_80_749 vssd1 vccd1 vccd1 vssd1 SS_sky130_fd_sc_hd__fill_4
XFILLER_92_587 vccd1 vssd1 vccd1 vssd1 SS_sky130_fd_sc_hd__fill_1
XFILLER_32_153 vssd1 vccd1 vssd1 vccd1 SS_sky130_ef_sc_hd__decap_40_12
XFILLER_32_197 vssd1 vccd1 vssd1 vccd1 SS_sky130_ef_sc_hd__decap_40_12
XPHY_EDGE_ROW_120_Right_120 vccd1 vssd1 vccd1 vssd1 SS_sky130_fd_sc_hd__decap_3
X_0955_ vssd1 vccd1 vccd1 vssd1 _0989_/A2 input45/X _1510_/D _1149_/C1 _0954_/X SS_sky130_fd_sc_hd__o211a_2
XFILLER_9_393 vssd1 vccd1 vssd1 vccd1 SS_sky130_ef_sc_hd__decap_40_12
X_0886_ vccd1 vssd1 vccd1 vssd1 _1657_/Q _1211_/A _1625_/Q _1145_/A _0886_/X SS_sky130_fd_sc_hd__a22o_2
XTAP_TAPCELL_ROW_99_1787 vccd1 vssd1 SS_sky130_fd_sc_hd__tapvpwrvgnd_1
Xoutput101 vccd1 vssd1 wire343/A _1860_/X vccd1 vssd1 SS_sky130_fd_sc_hd__buf_4
Xoutput112 vccd1 vssd1 wire332/A _1870_/X vccd1 vssd1 SS_sky130_fd_sc_hd__buf_4
Xoutput123 vccd1 vssd1 wire321/A _1880_/X vccd1 vssd1 SS_sky130_fd_sc_hd__buf_4
Xoutput134 vccd1 vssd1 wire416/A _1636_/Q vccd1 vssd1 SS_sky130_fd_sc_hd__buf_4
XFILLER_133_217 vssd1 vccd1 vccd1 vssd1 SS_sky130_fd_sc_hd__fill_4
Xoutput145 vccd1 vssd1 wire406/A _1646_/Q vccd1 vssd1 SS_sky130_fd_sc_hd__buf_4
XFILLER_88_805 vssd1 vccd1 vccd1 vssd1 SS_sky130_fd_sc_hd__fill_4
XFILLER_114_464 vssd1 vccd1 vccd1 vssd1 SS_sky130_fd_sc_hd__fill_2
Xoutput167 vccd1 vssd1 wire309/A _1889_/X vccd1 vssd1 SS_sky130_fd_sc_hd__buf_4
Xoutput156 vccd1 vssd1 wire395/A _1657_/Q vccd1 vssd1 SS_sky130_fd_sc_hd__buf_4
X_1507_ _1835_/A _1573_/CLK _1507_/D vccd1 vssd1 vccd1 vssd1 SS_sky130_fd_sc_hd__dfxtp_2
Xoutput178 vccd1 vssd1 wire377/A _1491_/Q vccd1 vssd1 SS_sky130_fd_sc_hd__buf_4
Xoutput189 vccd1 vssd1 wire366/A _1501_/Q vccd1 vssd1 SS_sky130_fd_sc_hd__buf_4
XFILLER_114_475 vccd1 vssd1 vccd1 vssd1 SS_sky130_fd_sc_hd__fill_1
XFILLER_102_615 vccd1 vssd1 vccd1 vssd1 SS_sky130_fd_sc_hd__fill_1
XFILLER_87_337 vssd1 vccd1 vssd1 vccd1 SS_sky130_ef_sc_hd__decap_40_12
XTAP_TAPCELL_ROW_110_1954 vccd1 vssd1 SS_sky130_fd_sc_hd__tapvpwrvgnd_1
XTAP_TAPCELL_ROW_110_1943 vccd1 vssd1 SS_sky130_fd_sc_hd__tapvpwrvgnd_1
XFILLER_101_125 vssd1 vccd1 vssd1 vccd1 SS_sky130_ef_sc_hd__decap_40_12
X_1438_ vccd1 vssd1 vccd1 vssd1 _1438_/X _1909_/A _1466_/B SS_sky130_fd_sc_hd__or2_2
XTAP_TAPCELL_ROW_52_1083 vccd1 vssd1 SS_sky130_fd_sc_hd__tapvpwrvgnd_1
XFILLER_56_713 vssd1 vccd1 vssd1 vccd1 SS_sky130_ef_sc_hd__decap_40_12
XFILLER_101_169 vssd1 vccd1 vssd1 vccd1 SS_sky130_ef_sc_hd__decap_40_12
XFILLER_55_223 vccd1 vssd1 vccd1 vssd1 SS_sky130_fd_sc_hd__fill_1
XFILLER_56_757 vssd1 vccd1 vssd1 vccd1 SS_sky130_ef_sc_hd__decap_40_12
X_1369_ vssd1 vccd1 vccd1 vssd1 _1369_/A2 wire499/X _1711_/D _1425_/C1 _1368_/X SS_sky130_fd_sc_hd__o211a_2
XFILLER_71_716 vssd1 vccd1 vssd1 vccd1 SS_sky130_ef_sc_hd__decap_40_12
XFILLER_15_109 vssd1 vccd1 vccd1 vssd1 SS_sky130_fd_sc_hd__fill_2
XFILLER_62_27 vccd1 vssd1 vccd1 vssd1 SS_sky130_fd_sc_hd__fill_1
XFILLER_51_473 vssd1 vccd1 vssd1 vccd1 SS_sky130_ef_sc_hd__decap_40_12
XFILLER_8_809 vssd1 vccd1 vccd1 vssd1 SS_sky130_fd_sc_hd__fill_2
XFILLER_11_337 vssd1 vccd1 vssd1 vccd1 SS_sky130_ef_sc_hd__decap_40_12
Xwire239 vccd1 vssd1 wire239/X wire239/A vccd1 vssd1 SS_sky130_fd_sc_hd__buf_4
XFILLER_137_556 vssd1 vccd1 vccd1 vssd1 SS_sky130_fd_sc_hd__fill_4
XFILLER_137_545 vssd1 vccd1 vccd1 vssd1 SS_sky130_fd_sc_hd__fill_2
XFILLER_109_225 vssd1 vccd1 vssd1 vccd1 SS_sky130_ef_sc_hd__decap_40_12
XFILLER_3_503 vccd1 vssd1 vccd1 vssd1 SS_sky130_fd_sc_hd__fill_1
XFILLER_11_42 vssd1 vccd1 vssd1 vccd1 SS_sky130_ef_sc_hd__decap_40_12
XFILLER_125_729 vssd1 vccd1 vccd1 vssd1 SS_sky130_fd_sc_hd__fill_8
XFILLER_118_770 vssd1 vccd1 vssd1 vccd1 SS_sky130_ef_sc_hd__decap_40_12
XFILLER_87_57 vssd1 vccd1 vssd1 vccd1 SS_sky130_ef_sc_hd__decap_40_12
XFILLER_120_401 vssd1 vccd1 vssd1 vccd1 SS_sky130_ef_sc_hd__decap_40_12
XFILLER_105_497 vssd1 vccd1 vccd1 vssd1 SS_sky130_fd_sc_hd__fill_4
XFILLER_78_359 vssd1 vccd1 vccd1 vssd1 SS_sky130_fd_sc_hd__fill_4
Xfanout350 vssd1 vccd1 vccd1 vssd1 _0750_/X _0753_/A SS_sky130_fd_sc_hd__clkdlybuf4s25_1
XTAP_TAPCELL_ROW_6_385 vccd1 vssd1 SS_sky130_fd_sc_hd__tapvpwrvgnd_1
XFILLER_59_551 vssd1 vccd1 vccd1 vssd1 SS_sky130_fd_sc_hd__fill_8
XFILLER_59_573 vssd1 vccd1 vssd1 vccd1 SS_sky130_ef_sc_hd__decap_40_12
XFILLER_120_489 vssd1 vccd1 vssd1 vccd1 SS_sky130_ef_sc_hd__decap_40_12
XFILLER_93_329 vssd1 vccd1 vccd1 vssd1 SS_sky130_fd_sc_hd__fill_4
XTAP_TAPCELL_ROW_6_396 vccd1 vssd1 SS_sky130_fd_sc_hd__tapvpwrvgnd_1
XFILLER_101_681 vssd1 vccd1 vssd1 vccd1 SS_sky130_ef_sc_hd__decap_40_12
XFILLER_46_245 vssd1 vccd1 vccd1 vssd1 SS_sky130_fd_sc_hd__fill_4
XFILLER_74_554 vssd1 vccd1 vssd1 vccd1 SS_sky130_ef_sc_hd__decap_40_12
XFILLER_46_289 vssd1 vccd1 vssd1 vccd1 SS_sky130_ef_sc_hd__decap_40_12
XFILLER_62_749 vssd1 vccd1 vccd1 vssd1 SS_sky130_fd_sc_hd__fill_4
XFILLER_36_83 vccd1 vssd1 vccd1 vssd1 SS_sky130_fd_sc_hd__fill_1
XTAP_TAPCELL_ROW_45_969 vccd1 vssd1 SS_sky130_fd_sc_hd__tapvpwrvgnd_1
XFILLER_61_237 vssd1 vccd1 vssd1 vccd1 SS_sky130_ef_sc_hd__decap_40_12
XTAP_TAPCELL_ROW_83_1544 vccd1 vssd1 SS_sky130_fd_sc_hd__tapvpwrvgnd_1
XFILLER_14_153 vssd1 vccd1 vssd1 vccd1 SS_sky130_ef_sc_hd__decap_40_12
XFILLER_15_665 vssd1 vccd1 vccd1 vssd1 SS_sky130_fd_sc_hd__fill_4
XFILLER_30_613 vssd1 vccd1 vccd1 vssd1 SS_sky130_fd_sc_hd__fill_4
XFILLER_42_473 vssd1 vccd1 vccd1 vssd1 SS_sky130_fd_sc_hd__fill_2
XFILLER_14_197 vssd1 vccd1 vssd1 vccd1 SS_sky130_ef_sc_hd__decap_40_12
XTAP_TAPCELL_ROW_25_671 vccd1 vssd1 SS_sky130_fd_sc_hd__tapvpwrvgnd_1
XTAP_TAPCELL_ROW_25_682 vccd1 vssd1 SS_sky130_fd_sc_hd__tapvpwrvgnd_1
XFILLER_30_657 vssd1 vccd1 vssd1 vccd1 SS_sky130_ef_sc_hd__decap_40_12
XFILLER_128_545 vssd1 vccd1 vssd1 vccd1 SS_sky130_ef_sc_hd__decap_40_12
Xinput14 vssd1 vccd1 vccd1 vssd1 wb_rst_i _0737_/A SS_sky130_fd_sc_hd__clkdlybuf4s25_1
Xinput36 vssd1 vccd1 vccd1 vssd1 input36/A input36/X SS_sky130_fd_sc_hd__clkdlybuf4s25_1
Xinput25 vssd1 vccd1 wire498/A input25/A vccd1 vssd1 SS_sky130_fd_sc_hd__buf_1
X_0740_ vccd1 vssd1 vssd1 vccd1 _0755_/B _0755_/C _0755_/A _0754_/D _0740_/X SS_sky130_fd_sc_hd__and4b_2
Xhold809 hold809/X _1490_/Q vccd1 vssd1 vssd1 vccd1 SS_sky130_fd_sc_hd__dlygate4sd3_1
XFILLER_128_589 vssd1 vccd1 vssd1 vccd1 SS_sky130_ef_sc_hd__decap_40_12
Xinput47 vccd1 vssd1 input47/X input47/A vccd1 vssd1 SS_sky130_fd_sc_hd__buf_2
XTAP_TAPCELL_ROW_114_2010 vccd1 vssd1 SS_sky130_fd_sc_hd__tapvpwrvgnd_1
XFILLER_6_363 vccd1 vssd1 vccd1 vssd1 SS_sky130_fd_sc_hd__fill_1
XFILLER_115_217 vssd1 vccd1 vccd1 vssd1 SS_sky130_fd_sc_hd__fill_4
XFILLER_109_781 vssd1 vccd1 vccd1 vssd1 SS_sky130_fd_sc_hd__fill_2
XFILLER_130_209 vssd1 vccd1 vssd1 vccd1 SS_sky130_ef_sc_hd__decap_40_12
XFILLER_123_261 vssd1 vccd1 vssd1 vccd1 SS_sky130_ef_sc_hd__decap_40_12
XFILLER_111_401 vssd1 vccd1 vssd1 vccd1 SS_sky130_ef_sc_hd__decap_40_12
XFILLER_69_337 vssd1 vccd1 vssd1 vccd1 SS_sky130_ef_sc_hd__decap_40_12
XFILLER_85_808 vssd1 vccd1 vccd1 vssd1 SS_sky130_fd_sc_hd__fill_8
XFILLER_38_713 vccd1 vssd1 vccd1 vssd1 SS_sky130_fd_sc_hd__fill_1
X_1223_ vssd1 vccd1 vccd1 vssd1 _1267_/A2 input47/X _1640_/D _1423_/C1 _1222_/X SS_sky130_fd_sc_hd__o211a_2
XFILLER_84_307 vccd1 vssd1 vccd1 vssd1 SS_sky130_fd_sc_hd__fill_1
XFILLER_37_223 vccd1 vssd1 vccd1 vssd1 SS_sky130_fd_sc_hd__fill_1
XFILLER_38_757 vssd1 vccd1 vssd1 vccd1 SS_sky130_ef_sc_hd__decap_40_12
XFILLER_65_510 vssd1 vccd1 vssd1 vccd1 SS_sky130_ef_sc_hd__decap_40_12
XFILLER_96_189 vssd1 vccd1 vccd1 vssd1 SS_sky130_fd_sc_hd__fill_4
XFILLER_93_841 vccd1 vssd1 vccd1 vssd1 SS_sky130_fd_sc_hd__fill_1
X_1154_ vccd1 vssd1 vccd1 vssd1 _1154_/X _1154_/A _1186_/B SS_sky130_fd_sc_hd__or2_2
XFILLER_25_429 vssd1 vccd1 vssd1 vccd1 SS_sky130_ef_sc_hd__decap_40_12
X_1085_ vssd1 vccd1 vccd1 vssd1 wire239/X input42/X _1573_/D _1149_/C1 _1084_/X SS_sky130_fd_sc_hd__o211a_2
XFILLER_53_727 vccd1 vssd1 vccd1 vssd1 SS_sky130_fd_sc_hd__fill_1
XFILLER_65_598 vssd1 vccd1 vccd1 vssd1 SS_sky130_fd_sc_hd__fill_2
XFILLER_80_513 vssd1 vccd1 vssd1 vccd1 SS_sky130_ef_sc_hd__decap_40_12
XTAP_TAPCELL_ROW_125_2172 vccd1 vssd1 SS_sky130_fd_sc_hd__tapvpwrvgnd_1
XFILLER_21_613 vssd1 vccd1 vccd1 vssd1 SS_sky130_fd_sc_hd__fill_2
XFILLER_33_473 vssd1 vccd1 vssd1 vccd1 SS_sky130_ef_sc_hd__decap_40_12
XFILLER_119_501 vssd1 vccd1 vccd1 vssd1 SS_sky130_fd_sc_hd__fill_2
XFILLER_20_189 vssd1 vccd1 vccd1 vssd1 SS_sky130_fd_sc_hd__fill_4
X_0938_ vccd1 vssd1 vssd1 vccd1 hold788/X _0937_/X _0750_/X _1505_/Q _0938_/X _1473_/C1
+ SS_sky130_fd_sc_hd__o221a_2
XFILLER_107_729 vssd1 vccd1 vccd1 vssd1 SS_sky130_fd_sc_hd__fill_8
X_0869_ vccd1 vssd1 vccd1 vssd1 _1526_/Q _0930_/B1 _1622_/Q _1145_/A _0869_/X SS_sky130_fd_sc_hd__a22o_2
XFILLER_0_517 vssd1 vccd1 vssd1 vccd1 SS_sky130_ef_sc_hd__decap_40_12
XTAP_TAPCELL_ROW_54_1112 vccd1 vssd1 SS_sky130_fd_sc_hd__tapvpwrvgnd_1
XFILLER_102_412 vssd1 vccd1 vccd1 vssd1 SS_sky130_fd_sc_hd__fill_8
XFILLER_76_808 vssd1 vccd1 vccd1 vssd1 SS_sky130_fd_sc_hd__fill_4
XFILLER_29_713 vssd1 vccd1 vssd1 vccd1 SS_sky130_ef_sc_hd__decap_40_12
XFILLER_57_27 vssd1 vccd1 vssd1 vccd1 SS_sky130_ef_sc_hd__decap_40_12
XFILLER_87_167 vccd1 vssd1 vccd1 vssd1 SS_sky130_fd_sc_hd__fill_1
XTAP_TAPCELL_ROW_3_344 vccd1 vssd1 SS_sky130_fd_sc_hd__tapvpwrvgnd_1
XFILLER_68_392 vssd1 vccd1 vssd1 vccd1 SS_sky130_ef_sc_hd__decap_40_12
XFILLER_75_329 vssd1 vccd1 vccd1 vssd1 SS_sky130_fd_sc_hd__fill_4
XFILLER_28_245 vssd1 vccd1 vccd1 vssd1 SS_sky130_fd_sc_hd__fill_4
XFILLER_28_289 vssd1 vccd1 vssd1 vccd1 SS_sky130_ef_sc_hd__decap_40_12
XFILLER_83_373 vssd1 vccd1 vssd1 vccd1 SS_sky130_ef_sc_hd__decap_40_12
XFILLER_43_237 vssd1 vccd1 vssd1 vccd1 SS_sky130_ef_sc_hd__decap_40_12
XFILLER_12_613 vssd1 vccd1 vssd1 vccd1 SS_sky130_ef_sc_hd__decap_40_12
XTAP_TAPCELL_ROW_42_928 vccd1 vssd1 SS_sky130_fd_sc_hd__tapvpwrvgnd_1
XTAP_TAPCELL_ROW_65_1274 vccd1 vssd1 SS_sky130_fd_sc_hd__tapvpwrvgnd_1
XFILLER_24_473 vssd1 vccd1 vccd1 vssd1 SS_sky130_fd_sc_hd__fill_2
XFILLER_51_281 vssd1 vccd1 vssd1 vccd1 SS_sky130_ef_sc_hd__decap_40_12
XFILLER_7_105 vssd1 vccd1 vccd1 vssd1 SS_sky130_fd_sc_hd__fill_4
XFILLER_12_657 vssd1 vccd1 vssd1 vccd1 SS_sky130_ef_sc_hd__decap_40_12
XTAP_TAPCELL_ROW_22_630 vccd1 vssd1 SS_sky130_fd_sc_hd__tapvpwrvgnd_1
XFILLER_132_3 vssd1 vccd1 vssd1 vccd1 SS_sky130_ef_sc_hd__decap_40_12
XFILLER_11_167 vccd1 vssd1 vccd1 vssd1 SS_sky130_fd_sc_hd__fill_1
XFILLER_22_41 vssd1 vccd1 vssd1 vccd1 SS_sky130_ef_sc_hd__decap_40_12
XFILLER_7_149 vssd1 vccd1 vssd1 vccd1 SS_sky130_ef_sc_hd__decap_40_12
XFILLER_22_85 vssd1 vccd1 vssd1 vccd1 SS_sky130_ef_sc_hd__decap_40_12
XFILLER_137_364 vssd1 vccd1 vssd1 vccd1 SS_sky130_ef_sc_hd__decap_40_12
XFILLER_138_85 vssd1 vccd1 vccd1 vssd1 SS_sky130_fd_sc_hd__fill_2
XFILLER_3_333 vssd1 vccd1 vccd1 vssd1 SS_sky130_fd_sc_hd__fill_2
XFILLER_125_559 vccd1 vssd1 vccd1 vssd1 SS_sky130_fd_sc_hd__fill_1
XFILLER_112_209 vssd1 vccd1 vssd1 vccd1 SS_sky130_ef_sc_hd__decap_40_12
XFILLER_105_261 vssd1 vccd1 vssd1 vccd1 SS_sky130_ef_sc_hd__decap_40_12
XFILLER_66_307 vccd1 vssd1 vccd1 vssd1 SS_sky130_fd_sc_hd__fill_1
XFILLER_67_819 vccd1 vssd1 vccd1 vssd1 SS_sky130_fd_sc_hd__fill_1
XFILLER_120_253 vssd1 vccd1 vssd1 vccd1 SS_sky130_ef_sc_hd__decap_40_12
XFILLER_19_223 vccd1 vssd1 vccd1 vssd1 SS_sky130_fd_sc_hd__fill_1
XFILLER_75_841 vccd1 vssd1 vccd1 vssd1 SS_sky130_fd_sc_hd__fill_1
XFILLER_78_189 vssd1 vccd1 vccd1 vssd1 SS_sky130_fd_sc_hd__fill_4
XFILLER_94_638 vssd1 vccd1 vccd1 vssd1 SS_sky130_fd_sc_hd__fill_4
XFILLER_93_137 vssd1 vccd1 vssd1 vccd1 SS_sky130_ef_sc_hd__decap_40_12
XFILLER_47_93 vssd1 vccd1 vssd1 vccd1 SS_sky130_ef_sc_hd__decap_40_12
XFILLER_15_473 vssd1 vccd1 vssd1 vccd1 SS_sky130_ef_sc_hd__decap_40_12
XFILLER_30_421 vssd1 vccd1 vssd1 vccd1 SS_sky130_ef_sc_hd__decap_40_12
XFILLER_63_81 vssd1 vccd1 vssd1 vccd1 SS_sky130_ef_sc_hd__decap_40_12
X_1841_ vccd1 vssd1 _1841_/X _1841_/A vccd1 vssd1 SS_sky130_fd_sc_hd__buf_2
XFILLER_8_65 vssd1 vccd1 vssd1 vccd1 SS_sky130_ef_sc_hd__decap_40_12
XTAP_TAPCELL_ROW_96_1735 vccd1 vssd1 SS_sky130_fd_sc_hd__tapvpwrvgnd_1
Xhold617 _1156_/A _1868_/A vccd1 vssd1 vssd1 vccd1 SS_sky130_fd_sc_hd__dlygate4sd3_1
Xhold606 _1372_/A _1713_/Q vccd1 vssd1 vssd1 vccd1 SS_sky130_fd_sc_hd__dlygate4sd3_1
XFILLER_128_386 vssd1 vccd1 vccd1 vssd1 SS_sky130_fd_sc_hd__fill_2
XTAP_TAPCELL_ROW_96_1746 vccd1 vssd1 SS_sky130_fd_sc_hd__tapvpwrvgnd_1
XFILLER_6_193 vssd1 vccd1 vccd1 vssd1 SS_sky130_fd_sc_hd__fill_2
Xhold639 _1094_/A _1852_/A vccd1 vssd1 vssd1 vccd1 SS_sky130_fd_sc_hd__dlygate4sd3_1
Xhold628 _1034_/A _1549_/Q vccd1 vssd1 vssd1 vccd1 SS_sky130_fd_sc_hd__dlygate4sd3_1
XFILLER_131_529 vssd1 vccd1 vssd1 vccd1 SS_sky130_ef_sc_hd__decap_40_12
XFILLER_124_581 vssd1 vccd1 vccd1 vssd1 SS_sky130_fd_sc_hd__fill_4
XFILLER_58_819 vccd1 vssd1 vccd1 vssd1 SS_sky130_fd_sc_hd__fill_1
XFILLER_69_167 vccd1 vssd1 vccd1 vssd1 SS_sky130_fd_sc_hd__fill_1
XTAP_TAPCELL_ROW_127_2212 vccd1 vssd1 SS_sky130_fd_sc_hd__tapvpwrvgnd_1
XTAP_TAPCELL_ROW_127_2201 vccd1 vssd1 SS_sky130_fd_sc_hd__tapvpwrvgnd_1
XFILLER_38_521 vssd1 vccd1 vccd1 vssd1 SS_sky130_fd_sc_hd__fill_2
XFILLER_57_329 vssd1 vccd1 vccd1 vssd1 SS_sky130_fd_sc_hd__fill_4
XFILLER_84_137 vssd1 vccd1 vccd1 vssd1 SS_sky130_fd_sc_hd__fill_2
XTAP_TAPCELL_ROW_0_303 vccd1 vssd1 SS_sky130_fd_sc_hd__tapvpwrvgnd_1
X_1206_ vccd1 vssd1 vccd1 vssd1 _1206_/X _1206_/A _1208_/B SS_sky130_fd_sc_hd__or2_2
XFILLER_26_738 vssd1 vccd1 vssd1 vccd1 SS_sky130_ef_sc_hd__decap_40_12
X_1137_ vssd1 vccd1 vccd1 vssd1 _1141_/A2 input40/X _1599_/D _1473_/C1 _1136_/X SS_sky130_fd_sc_hd__o211a_2
XFILLER_25_237 vssd1 vccd1 vssd1 vccd1 SS_sky130_ef_sc_hd__decap_40_12
XFILLER_80_321 vssd1 vccd1 vssd1 vccd1 SS_sky130_ef_sc_hd__decap_40_12
XFILLER_43_18 vssd1 vccd1 vssd1 vccd1 SS_sky130_ef_sc_hd__decap_40_12
XFILLER_80_354 vssd1 vccd1 vccd1 vssd1 SS_sky130_fd_sc_hd__fill_8
XFILLER_80_365 vssd1 vccd1 vccd1 vssd1 SS_sky130_fd_sc_hd__fill_2
X_1068_ vccd1 vssd1 vccd1 vssd1 _1068_/X _1068_/A _1076_/B SS_sky130_fd_sc_hd__or2_2
XTAP_TAPCELL_ROW_105_1875 vccd1 vssd1 SS_sky130_fd_sc_hd__tapvpwrvgnd_1
XFILLER_33_281 vssd1 vccd1 vssd1 vccd1 SS_sky130_ef_sc_hd__decap_40_12
XTAP_TAPCELL_ROW_138_2374 vccd1 vssd1 SS_sky130_fd_sc_hd__tapvpwrvgnd_1
XFILLER_138_139 vccd1 vssd1 vccd1 vssd1 SS_sky130_fd_sc_hd__fill_1
XTAP_TAPCELL_ROW_138_2363 vccd1 vssd1 SS_sky130_fd_sc_hd__tapvpwrvgnd_1
XFILLER_5_609 vssd1 vccd1 vccd1 vssd1 SS_sky130_fd_sc_hd__fill_4
XTAP_TAPCELL_ROW_60_1193 vccd1 vssd1 SS_sky130_fd_sc_hd__tapvpwrvgnd_1
XTAP_TAPCELL_ROW_138_2385 vccd1 vssd1 SS_sky130_fd_sc_hd__tapvpwrvgnd_1
XFILLER_134_301 vssd1 vccd1 vccd1 vssd1 SS_sky130_fd_sc_hd__fill_4
XFILLER_135_824 vssd1 vccd1 vccd1 vssd1 SS_sky130_fd_sc_hd__fill_8
XFILLER_107_559 vccd1 vssd1 vccd1 vssd1 SS_sky130_fd_sc_hd__fill_1
XTAP_TAPCELL_ROW_8_414 vccd1 vssd1 SS_sky130_fd_sc_hd__tapvpwrvgnd_1
XTAP_TAPCELL_ROW_8_425 vccd1 vssd1 SS_sky130_fd_sc_hd__tapvpwrvgnd_1
XFILLER_68_26 vssd1 vccd1 vccd1 vssd1 SS_sky130_fd_sc_hd__fill_2
XFILLER_108_77 vssd1 vccd1 vccd1 vssd1 SS_sky130_fd_sc_hd__fill_4
XFILLER_1_837 vssd1 vccd1 vccd1 vssd1 SS_sky130_fd_sc_hd__fill_2
XFILLER_88_421 vssd1 vccd1 vssd1 vccd1 SS_sky130_ef_sc_hd__decap_40_12
XFILLER_115_581 vssd1 vccd1 vccd1 vssd1 SS_sky130_fd_sc_hd__fill_2
XFILLER_48_307 vccd1 vssd1 vccd1 vssd1 SS_sky130_fd_sc_hd__fill_1
XFILLER_103_765 vssd1 vccd1 vssd1 vccd1 SS_sky130_ef_sc_hd__decap_40_12
XFILLER_102_253 vssd1 vccd1 vssd1 vccd1 SS_sky130_ef_sc_hd__decap_40_12
XFILLER_124_65 vssd1 vccd1 vssd1 vccd1 SS_sky130_ef_sc_hd__decap_40_12
XFILLER_57_841 vccd1 vssd1 vccd1 vssd1 SS_sky130_fd_sc_hd__fill_1
XFILLER_75_137 vssd1 vccd1 vssd1 vccd1 SS_sky130_ef_sc_hd__decap_40_12
XFILLER_17_727 vccd1 vssd1 vccd1 vssd1 SS_sky130_fd_sc_hd__fill_1
XTAP_TAPCELL_ROW_27_700 vccd1 vssd1 SS_sky130_fd_sc_hd__tapvpwrvgnd_1
XTAP_TAPCELL_ROW_27_711 vccd1 vssd1 SS_sky130_fd_sc_hd__tapvpwrvgnd_1
XFILLER_56_362 vssd1 vccd1 vccd1 vssd1 SS_sky130_fd_sc_hd__fill_2
XTAP_TAPCELL_ROW_67_1303 vccd1 vssd1 SS_sky130_fd_sc_hd__tapvpwrvgnd_1
XFILLER_44_557 vssd1 vccd1 vssd1 vccd1 SS_sky130_ef_sc_hd__decap_40_12
XFILLER_83_181 vssd1 vccd1 vssd1 vccd1 SS_sky130_ef_sc_hd__decap_40_12
XTAP_TAPCELL_ROW_80_1503 vccd1 vssd1 SS_sky130_fd_sc_hd__tapvpwrvgnd_1
XFILLER_12_421 vssd1 vccd1 vssd1 vccd1 SS_sky130_ef_sc_hd__decap_40_12
XFILLER_40_796 vssd1 vccd1 vssd1 vccd1 SS_sky130_ef_sc_hd__decap_40_12
XFILLER_8_469 vssd1 vccd1 vccd1 vssd1 SS_sky130_fd_sc_hd__fill_4
XFILLER_126_813 vccd1 vssd1 vccd1 vssd1 SS_sky130_fd_sc_hd__fill_1
XFILLER_138_673 vssd1 vccd1 vccd1 vssd1 SS_sky130_fd_sc_hd__fill_2
XFILLER_137_161 vccd1 vssd1 vccd1 vssd1 SS_sky130_fd_sc_hd__fill_1
XFILLER_125_323 vssd1 vccd1 vssd1 vccd1 SS_sky130_ef_sc_hd__decap_40_12
XTAP_TAPCELL_ROW_78_1465 vccd1 vssd1 SS_sky130_fd_sc_hd__tapvpwrvgnd_1
XTAP_TAPCELL_ROW_78_1476 vccd1 vssd1 SS_sky130_fd_sc_hd__tapvpwrvgnd_1
XFILLER_125_378 vssd1 vccd1 vssd1 vccd1 SS_sky130_ef_sc_hd__decap_40_12
XFILLER_4_697 vssd1 vccd1 vccd1 vssd1 SS_sky130_fd_sc_hd__fill_2
XTAP_TAPCELL_ROW_91_1665 vccd1 vssd1 SS_sky130_fd_sc_hd__tapvpwrvgnd_1
XFILLER_39_329 vssd1 vccd1 vccd1 vssd1 SS_sky130_fd_sc_hd__fill_4
XFILLER_58_81 vssd1 vccd1 vccd1 vssd1 SS_sky130_fd_sc_hd__fill_2
XFILLER_94_413 vssd1 vccd1 vccd1 vssd1 SS_sky130_fd_sc_hd__fill_4
XFILLER_66_137 vssd1 vccd1 vccd1 vssd1 SS_sky130_fd_sc_hd__fill_2
XFILLER_75_671 vccd1 vssd1 vccd1 vssd1 SS_sky130_fd_sc_hd__fill_1
XFILLER_90_641 vssd1 vccd1 vccd1 vssd1 SS_sky130_fd_sc_hd__fill_2
XTAP_TAPCELL_ROW_122_2131 vccd1 vssd1 SS_sky130_fd_sc_hd__tapvpwrvgnd_1
XFILLER_62_343 vssd1 vccd1 vssd1 vccd1 SS_sky130_ef_sc_hd__decap_40_12
XFILLER_62_365 vssd1 vccd1 vccd1 vssd1 SS_sky130_fd_sc_hd__fill_4
XFILLER_16_793 vssd1 vccd1 vssd1 vccd1 SS_sky130_ef_sc_hd__decap_40_12
XFILLER_50_549 vccd1 vssd1 vccd1 vssd1 SS_sky130_fd_sc_hd__fill_1
XFILLER_95_3 vssd1 vccd1 vssd1 vccd1 SS_sky130_ef_sc_hd__decap_40_12
XFILLER_15_281 vssd1 vccd1 vssd1 vccd1 SS_sky130_ef_sc_hd__decap_40_12
XFILLER_31_741 vssd1 vccd1 vssd1 vccd1 SS_sky130_ef_sc_hd__decap_40_12
XFILLER_30_251 vccd1 vssd1 vccd1 vssd1 SS_sky130_fd_sc_hd__fill_1
XFILLER_31_785 vssd1 vccd1 vssd1 vccd1 SS_sky130_ef_sc_hd__decap_40_12
XTAP_TAPCELL_ROW_13_493 vccd1 vssd1 SS_sky130_fd_sc_hd__tapvpwrvgnd_1
XFILLER_135_109 vssd1 vccd1 vccd1 vssd1 SS_sky130_fd_sc_hd__fill_2
XTAP_TAPCELL_ROW_100_1794 vccd1 vssd1 SS_sky130_fd_sc_hd__tapvpwrvgnd_1
XFILLER_129_673 vssd1 vccd1 vssd1 vccd1 SS_sky130_ef_sc_hd__decap_40_12
X_1755_ _1755_/Q _1755_/CLK _1755_/D vccd1 vssd1 vccd1 vssd1 SS_sky130_fd_sc_hd__dfxtp_2
XFILLER_116_301 vssd1 vccd1 vccd1 vssd1 SS_sky130_fd_sc_hd__fill_4
XFILLER_132_805 vssd1 vccd1 vccd1 vssd1 SS_sky130_fd_sc_hd__fill_4
XTAP_TAPCELL_ROW_133_2293 vccd1 vssd1 SS_sky130_fd_sc_hd__tapvpwrvgnd_1
XFILLER_116_389 vssd1 vccd1 vssd1 vccd1 SS_sky130_ef_sc_hd__decap_40_12
X_1686_ _1686_/Q _1686_/CLK _1686_/D vccd1 vssd1 vccd1 vssd1 SS_sky130_fd_sc_hd__dfxtp_2
XFILLER_131_337 vssd1 vccd1 vssd1 vccd1 SS_sky130_ef_sc_hd__decap_40_12
XFILLER_38_18 vssd1 vccd1 vccd1 vssd1 SS_sky130_fd_sc_hd__fill_8
XFILLER_38_29 vssd1 vccd1 vssd1 vccd1 SS_sky130_ef_sc_hd__decap_40_12
XFILLER_100_713 vccd1 vssd1 vccd1 vssd1 SS_sky130_fd_sc_hd__fill_1
XFILLER_97_273 vssd1 vccd1 vccd1 vssd1 SS_sky130_fd_sc_hd__fill_4
XFILLER_39_841 vccd1 vssd1 vccd1 vssd1 SS_sky130_fd_sc_hd__fill_1
XFILLER_57_137 vssd1 vccd1 vssd1 vccd1 SS_sky130_ef_sc_hd__decap_40_12
XFILLER_85_446 vssd1 vccd1 vccd1 vssd1 SS_sky130_fd_sc_hd__fill_2
XFILLER_100_746 vssd1 vccd1 vccd1 vssd1 SS_sky130_fd_sc_hd__fill_4
XFILLER_26_513 vssd1 vccd1 vssd1 vccd1 SS_sky130_ef_sc_hd__decap_40_12
XFILLER_54_811 vccd1 vssd1 vccd1 vssd1 SS_sky130_fd_sc_hd__fill_1
XTAP_TAPCELL_ROW_107_1904 vccd1 vssd1 SS_sky130_fd_sc_hd__tapvpwrvgnd_1
XTAP_TAPCELL_ROW_49_1033 vccd1 vssd1 SS_sky130_fd_sc_hd__tapvpwrvgnd_1
XFILLER_65_181 vssd1 vccd1 vssd1 vccd1 SS_sky130_ef_sc_hd__decap_40_12
XFILLER_26_557 vssd1 vccd1 vssd1 vccd1 SS_sky130_ef_sc_hd__decap_40_12
XFILLER_41_516 vssd1 vccd1 vssd1 vccd1 SS_sky130_ef_sc_hd__decap_40_12
XFILLER_81_663 vssd1 vccd1 vccd1 vssd1 SS_sky130_fd_sc_hd__fill_8
XTAP_TAPCELL_ROW_62_1233 vccd1 vssd1 SS_sky130_fd_sc_hd__tapvpwrvgnd_1
XFILLER_80_195 vccd1 vssd1 vccd1 vssd1 SS_sky130_fd_sc_hd__fill_1
XFILLER_21_273 vssd1 vccd1 vccd1 vssd1 SS_sky130_fd_sc_hd__fill_4
XFILLER_70_27 vccd1 vssd1 vccd1 vssd1 SS_sky130_fd_sc_hd__fill_1
XTAP_TAPCELL_ROW_32_780 vccd1 vssd1 SS_sky130_fd_sc_hd__tapvpwrvgnd_1
XFILLER_5_417 vssd1 vccd1 vssd1 vccd1 SS_sky130_ef_sc_hd__decap_40_12
XFILLER_126_109 vssd1 vccd1 vssd1 vccd1 SS_sky130_ef_sc_hd__decap_40_12
XFILLER_119_161 vssd1 vccd1 vccd1 vssd1 SS_sky130_fd_sc_hd__fill_4
XFILLER_108_813 vssd1 vccd1 vssd1 vccd1 SS_sky130_ef_sc_hd__decap_40_12
XFILLER_79_69 vssd1 vccd1 vssd1 vccd1 SS_sky130_ef_sc_hd__decap_40_12
XFILLER_134_153 vssd1 vccd1 vssd1 vccd1 SS_sky130_ef_sc_hd__decap_40_12
XFILLER_107_389 vssd1 vccd1 vccd1 vssd1 SS_sky130_fd_sc_hd__fill_2
XFILLER_0_111 vccd1 vssd1 vccd1 vssd1 SS_sky130_fd_sc_hd__fill_1
XFILLER_89_741 vssd1 vccd1 vssd1 vccd1 SS_sky130_ef_sc_hd__decap_40_12
XFILLER_134_197 vssd1 vccd1 vssd1 vccd1 SS_sky130_ef_sc_hd__decap_40_12
XFILLER_88_251 vccd1 vssd1 vccd1 vssd1 SS_sky130_fd_sc_hd__fill_1
XFILLER_122_359 vssd1 vccd1 vccd1 vssd1 SS_sky130_fd_sc_hd__fill_4
XFILLER_49_649 vssd1 vccd1 vccd1 vssd1 SS_sky130_fd_sc_hd__fill_4
XTAP_TAPCELL_ROW_73_1395 vccd1 vssd1 SS_sky130_fd_sc_hd__tapvpwrvgnd_1
XFILLER_76_413 vssd1 vccd1 vccd1 vssd1 SS_sky130_fd_sc_hd__fill_4
XFILLER_89_785 vssd1 vccd1 vssd1 vccd1 SS_sky130_ef_sc_hd__decap_40_12
XFILLER_130_381 vssd1 vccd1 vccd1 vssd1 SS_sky130_fd_sc_hd__fill_2
XFILLER_95_57 vssd1 vccd1 vssd1 vccd1 SS_sky130_ef_sc_hd__decap_40_12
XFILLER_48_137 vssd1 vccd1 vccd1 vssd1 SS_sky130_fd_sc_hd__fill_2
XFILLER_76_457 vssd1 vccd1 vssd1 vccd1 SS_sky130_ef_sc_hd__decap_40_12
XFILLER_29_373 vssd1 vccd1 vssd1 vccd1 SS_sky130_ef_sc_hd__decap_40_12
XFILLER_57_671 vccd1 vssd1 vccd1 vssd1 SS_sky130_fd_sc_hd__fill_1
XFILLER_91_405 vssd1 vccd1 vssd1 vccd1 SS_sky130_ef_sc_hd__decap_40_12
XFILLER_44_321 vssd1 vccd1 vssd1 vccd1 SS_sky130_ef_sc_hd__decap_40_12
XFILLER_72_630 vssd1 vccd1 vccd1 vssd1 SS_sky130_fd_sc_hd__fill_4
XFILLER_91_449 vssd1 vccd1 vccd1 vssd1 SS_sky130_fd_sc_hd__fill_4
XFILLER_17_557 vssd1 vccd1 vccd1 vssd1 SS_sky130_fd_sc_hd__fill_2
XFILLER_44_365 vssd1 vccd1 vssd1 vccd1 SS_sky130_ef_sc_hd__decap_40_12
XFILLER_72_663 vssd1 vccd1 vccd1 vssd1 SS_sky130_fd_sc_hd__fill_2
XFILLER_13_741 vssd1 vccd1 vssd1 vccd1 SS_sky130_ef_sc_hd__decap_40_12
XFILLER_44_83 vccd1 vssd1 vccd1 vssd1 SS_sky130_fd_sc_hd__fill_1
XFILLER_12_251 vccd1 vssd1 vccd1 vssd1 SS_sky130_fd_sc_hd__fill_1
XFILLER_13_785 vssd1 vccd1 vccd1 vssd1 SS_sky130_fd_sc_hd__fill_4
XFILLER_8_233 vssd1 vccd1 vssd1 vccd1 SS_sky130_ef_sc_hd__decap_40_12
XFILLER_8_277 vssd1 vccd1 vssd1 vccd1 SS_sky130_ef_sc_hd__decap_40_12
XTAP_TAPCELL_ROW_10_452 vccd1 vssd1 SS_sky130_fd_sc_hd__tapvpwrvgnd_1
XFILLER_138_481 vssd1 vccd1 vccd1 vssd1 SS_sky130_fd_sc_hd__fill_2
XFILLER_126_621 vssd1 vccd1 vccd1 vssd1 SS_sky130_fd_sc_hd__fill_2
XFILLER_117_109 vssd1 vccd1 vccd1 vssd1 SS_sky130_fd_sc_hd__fill_2
X_1540_ _1827_/A _1576_/CLK _1540_/D vccd1 vssd1 vccd1 vssd1 SS_sky130_fd_sc_hd__dfxtp_2
XFILLER_126_632 vssd1 vccd1 vssd1 vccd1 SS_sky130_ef_sc_hd__decap_40_12
XFILLER_5_55 vccd1 vssd1 vccd1 vssd1 SS_sky130_fd_sc_hd__fill_1
XFILLER_99_505 vssd1 vccd1 vssd1 vccd1 SS_sky130_ef_sc_hd__decap_40_12
XFILLER_126_698 vssd1 vccd1 vccd1 vssd1 SS_sky130_fd_sc_hd__fill_2
X_1471_ vssd1 vccd1 vccd1 vssd1 wire207/A input43/X _1761_/D _1471_/C1 _1470_/X SS_sky130_fd_sc_hd__o211a_2
XFILLER_67_413 vssd1 vccd1 vssd1 vccd1 SS_sky130_ef_sc_hd__decap_40_12
XFILLER_79_273 vssd1 vccd1 vccd1 vssd1 SS_sky130_fd_sc_hd__fill_4
XFILLER_121_370 vssd1 vccd1 vssd1 vccd1 SS_sky130_ef_sc_hd__decap_40_12
XFILLER_10_3 vssd1 vccd1 vssd1 vccd1 SS_sky130_ef_sc_hd__decap_40_12
XFILLER_39_137 vssd1 vccd1 vssd1 vccd1 SS_sky130_ef_sc_hd__decap_40_12
XFILLER_94_221 vssd1 vccd1 vssd1 vccd1 SS_sky130_ef_sc_hd__decap_40_12
XFILLER_36_811 vccd1 vssd1 vccd1 vssd1 SS_sky130_fd_sc_hd__fill_1
XFILLER_94_265 vssd1 vccd1 vssd1 vccd1 SS_sky130_ef_sc_hd__decap_40_12
XFILLER_47_181 vssd1 vccd1 vssd1 vccd1 SS_sky130_ef_sc_hd__decap_40_12
XFILLER_48_693 vssd1 vccd1 vccd1 vssd1 SS_sky130_fd_sc_hd__fill_4
XFILLER_82_438 vssd1 vccd1 vssd1 vccd1 SS_sky130_ef_sc_hd__decap_40_12
XFILLER_23_505 vssd1 vccd1 vssd1 vccd1 SS_sky130_ef_sc_hd__decap_40_12
XFILLER_63_652 vssd1 vccd1 vssd1 vccd1 SS_sky130_ef_sc_hd__decap_40_12
XTAP_TAPCELL_ROW_18_563 vccd1 vssd1 SS_sky130_fd_sc_hd__tapvpwrvgnd_1
XTAP_TAPCELL_ROW_18_574 vccd1 vssd1 SS_sky130_fd_sc_hd__tapvpwrvgnd_1
XFILLER_63_685 vssd1 vccd1 vssd1 vccd1 SS_sky130_ef_sc_hd__decap_40_12
XTAP_TAPCELL_ROW_102_1823 vccd1 vssd1 SS_sky130_fd_sc_hd__tapvpwrvgnd_1
XFILLER_50_357 vssd1 vccd1 vccd1 vssd1 SS_sky130_fd_sc_hd__fill_4
XFILLER_62_195 vccd1 vssd1 vccd1 vssd1 SS_sky130_fd_sc_hd__fill_1
XTAP_TAPCELL_ROW_102_1834 vccd1 vssd1 SS_sky130_fd_sc_hd__tapvpwrvgnd_1
XTAP_TAPCELL_ROW_135_2322 vccd1 vssd1 SS_sky130_fd_sc_hd__tapvpwrvgnd_1
XFILLER_108_109 vssd1 vccd1 vssd1 vccd1 SS_sky130_ef_sc_hd__decap_40_12
X_1738_ _1902_/A _1738_/CLK _1738_/D vccd1 vssd1 vccd1 vssd1 SS_sky130_fd_sc_hd__dfxtp_2
XFILLER_132_613 vssd1 vccd1 vssd1 vccd1 SS_sky130_ef_sc_hd__decap_40_12
XFILLER_116_153 vssd1 vccd1 vssd1 vccd1 SS_sky130_ef_sc_hd__decap_40_12
X_1669_ _1893_/A _1731_/CLK _1669_/D vccd1 vssd1 vccd1 vssd1 SS_sky130_fd_sc_hd__dfxtp_2
XFILLER_116_197 vssd1 vccd1 vssd1 vccd1 SS_sky130_ef_sc_hd__decap_40_12
XFILLER_49_39 vssd1 vccd1 vssd1 vccd1 SS_sky130_ef_sc_hd__decap_40_12
XFILLER_132_657 vssd1 vccd1 vccd1 vssd1 SS_sky130_fd_sc_hd__fill_2
XFILLER_131_167 vccd1 vssd1 vccd1 vssd1 SS_sky130_fd_sc_hd__fill_1
XTAP_TAPCELL_ROW_113_1996 vccd1 vssd1 SS_sky130_fd_sc_hd__tapvpwrvgnd_1
XFILLER_85_221 vssd1 vccd1 vccd1 vssd1 SS_sky130_fd_sc_hd__fill_2
XFILLER_39_671 vccd1 vssd1 vccd1 vssd1 SS_sky130_fd_sc_hd__fill_1
XFILLER_65_27 vssd1 vccd1 vssd1 vccd1 SS_sky130_ef_sc_hd__decap_40_12
XFILLER_73_405 vssd1 vccd1 vssd1 vccd1 SS_sky130_ef_sc_hd__decap_40_12
XFILLER_100_587 vccd1 vssd1 vccd1 vssd1 SS_sky130_fd_sc_hd__fill_1
XFILLER_100_565 vssd1 vccd1 vssd1 vccd1 SS_sky130_ef_sc_hd__decap_40_12
XFILLER_26_321 vssd1 vccd1 vssd1 vccd1 SS_sky130_ef_sc_hd__decap_40_12
XFILLER_73_449 vssd1 vccd1 vssd1 vccd1 SS_sky130_ef_sc_hd__decap_40_12
XPHY_EDGE_ROW_134_Right_134 vccd1 vssd1 vccd1 vssd1 SS_sky130_fd_sc_hd__decap_3
XFILLER_26_365 vssd1 vccd1 vssd1 vccd1 SS_sky130_ef_sc_hd__decap_40_12
XTAP_TAPCELL_ROW_37_850 vccd1 vssd1 SS_sky130_fd_sc_hd__tapvpwrvgnd_1
XTAP_TAPCELL_ROW_37_861 vccd1 vssd1 SS_sky130_fd_sc_hd__tapvpwrvgnd_1
XFILLER_54_641 vssd1 vccd1 vccd1 vssd1 SS_sky130_fd_sc_hd__fill_2
XFILLER_41_335 vccd1 vssd1 vccd1 vssd1 SS_sky130_fd_sc_hd__fill_1
XFILLER_14_53 vssd1 vccd1 vssd1 vccd1 SS_sky130_ef_sc_hd__decap_40_12
XFILLER_10_755 vccd1 vssd1 vccd1 vssd1 SS_sky130_fd_sc_hd__fill_1
XFILLER_10_777 vccd1 vssd1 vccd1 vssd1 SS_sky130_fd_sc_hd__fill_1
XFILLER_14_97 vssd1 vccd1 vssd1 vccd1 SS_sky130_ef_sc_hd__decap_40_12
XFILLER_5_225 vssd1 vccd1 vssd1 vccd1 SS_sky130_ef_sc_hd__decap_40_12
XFILLER_6_737 vssd1 vccd1 vssd1 vccd1 SS_sky130_ef_sc_hd__decap_40_12
XFILLER_30_41 vssd1 vccd1 vssd1 vccd1 SS_sky130_ef_sc_hd__decap_40_12
XFILLER_108_643 vccd1 vssd1 vccd1 vssd1 SS_sky130_fd_sc_hd__fill_1
XTAP_TAPCELL_ROW_75_1424 vccd1 vssd1 SS_sky130_fd_sc_hd__tapvpwrvgnd_1
XFILLER_135_473 vssd1 vccd1 vccd1 vssd1 SS_sky130_fd_sc_hd__fill_2
XFILLER_123_602 vssd1 vccd1 vssd1 vccd1 SS_sky130_ef_sc_hd__decap_40_12
XFILLER_30_85 vssd1 vccd1 vssd1 vccd1 SS_sky130_ef_sc_hd__decap_40_12
XFILLER_89_571 vccd1 vssd1 vccd1 vssd1 SS_sky130_fd_sc_hd__fill_1
XFILLER_122_189 vssd1 vccd1 vccd1 vssd1 SS_sky130_fd_sc_hd__fill_4
XFILLER_110_307 vccd1 vssd1 vccd1 vssd1 SS_sky130_fd_sc_hd__fill_1
XFILLER_1_497 vssd1 vccd1 vccd1 vssd1 SS_sky130_fd_sc_hd__fill_4
XFILLER_76_221 vssd1 vccd1 vssd1 vccd1 SS_sky130_ef_sc_hd__decap_40_12
XFILLER_76_265 vssd1 vccd1 vssd1 vccd1 SS_sky130_ef_sc_hd__decap_40_12
XFILLER_92_725 vssd1 vccd1 vccd1 vssd1 SS_sky130_fd_sc_hd__fill_8
XFILLER_29_181 vssd1 vccd1 vssd1 vccd1 SS_sky130_ef_sc_hd__decap_40_12
XPHY_EDGE_ROW_101_Right_101 vccd1 vssd1 vccd1 vssd1 SS_sky130_fd_sc_hd__decap_3
XFILLER_92_769 vssd1 vccd1 vssd1 vccd1 SS_sky130_ef_sc_hd__decap_40_12
XFILLER_45_641 vssd1 vccd1 vssd1 vccd1 SS_sky130_ef_sc_hd__decap_40_12
XFILLER_91_279 vccd1 vssd1 vccd1 vssd1 SS_sky130_fd_sc_hd__fill_1
XFILLER_55_93 vssd1 vccd1 vssd1 vccd1 SS_sky130_ef_sc_hd__decap_40_12
XFILLER_60_611 vssd1 vccd1 vssd1 vccd1 SS_sky130_ef_sc_hd__decap_40_12
XTAP_TAPCELL_ROW_86_1586 vccd1 vssd1 SS_sky130_fd_sc_hd__tapvpwrvgnd_1
XTAP_TAPCELL_ROW_86_1597 vccd1 vssd1 SS_sky130_fd_sc_hd__tapvpwrvgnd_1
XTAP_TAPCELL_ROW_15_522 vccd1 vssd1 SS_sky130_fd_sc_hd__tapvpwrvgnd_1
XFILLER_32_357 vssd1 vccd1 vccd1 vssd1 SS_sky130_fd_sc_hd__fill_4
XFILLER_44_195 vccd1 vssd1 vccd1 vssd1 SS_sky130_fd_sc_hd__fill_1
XFILLER_60_666 vssd1 vccd1 vssd1 vccd1 SS_sky130_ef_sc_hd__decap_40_12
X_0971_ vssd1 vccd1 vccd1 vssd1 _0989_/A2 wire500/X _1518_/D wire467/X _0970_/X SS_sky130_fd_sc_hd__o211a_2
XFILLER_9_553 vssd1 vccd1 vccd1 vssd1 SS_sky130_fd_sc_hd__fill_4
XFILLER_71_81 vssd1 vccd1 vssd1 vccd1 SS_sky130_ef_sc_hd__decap_40_12
XFILLER_9_597 vssd1 vccd1 vssd1 vccd1 SS_sky130_ef_sc_hd__decap_40_12
XTAP_TAPCELL_ROW_117_2052 vccd1 vssd1 SS_sky130_fd_sc_hd__tapvpwrvgnd_1
XFILLER_126_462 vssd1 vccd1 vssd1 vccd1 SS_sky130_ef_sc_hd__decap_40_12
XFILLER_5_781 vssd1 vccd1 vccd1 vssd1 SS_sky130_fd_sc_hd__fill_2
XTAP_TAPCELL_ROW_130_2252 vccd1 vssd1 SS_sky130_fd_sc_hd__tapvpwrvgnd_1
XFILLER_99_335 vccd1 vssd1 vccd1 vssd1 SS_sky130_fd_sc_hd__fill_1
X_1523_ _1523_/Q _1747_/CLK _1523_/D vccd1 vssd1 vccd1 vssd1 SS_sky130_fd_sc_hd__dfxtp_2
XFILLER_87_519 vssd1 vccd1 vssd1 vccd1 SS_sky130_ef_sc_hd__decap_40_12
XFILLER_114_657 vssd1 vccd1 vssd1 vccd1 SS_sky130_ef_sc_hd__decap_40_12
X_1454_ vccd1 vssd1 vccd1 vssd1 _1454_/X _1454_/A _1454_/B SS_sky130_fd_sc_hd__or2_2
XFILLER_68_733 vssd1 vccd1 vssd1 vccd1 SS_sky130_ef_sc_hd__decap_40_12
XFILLER_113_167 vccd1 vssd1 vccd1 vssd1 SS_sky130_fd_sc_hd__fill_1
X_1385_ vssd1 vccd1 vccd1 vssd1 _1385_/A2 input32/X _1719_/D _1425_/C1 _1384_/X SS_sky130_fd_sc_hd__o211a_2
XFILLER_67_221 vssd1 vccd1 vccd1 vssd1 SS_sky130_fd_sc_hd__fill_2
XFILLER_68_755 vccd1 vssd1 vccd1 vssd1 SS_sky130_fd_sc_hd__fill_1
XFILLER_55_405 vssd1 vccd1 vccd1 vssd1 SS_sky130_fd_sc_hd__fill_4
XFILLER_83_725 vssd1 vccd1 vccd1 vssd1 SS_sky130_fd_sc_hd__fill_2
XFILLER_55_449 vssd1 vccd1 vssd1 vccd1 SS_sky130_ef_sc_hd__decap_40_12
XFILLER_91_780 vssd1 vccd1 vccd1 vssd1 SS_sky130_fd_sc_hd__fill_4
XFILLER_23_335 vccd1 vssd1 vccd1 vssd1 SS_sky130_fd_sc_hd__fill_1
XFILLER_50_121 vssd1 vccd1 vssd1 vccd1 SS_sky130_ef_sc_hd__decap_40_12
XFILLER_51_633 vssd1 vccd1 vccd1 vssd1 SS_sky130_fd_sc_hd__fill_2
XFILLER_50_165 vssd1 vccd1 vssd1 vccd1 SS_sky130_ef_sc_hd__decap_40_12
XFILLER_51_18 vssd1 vccd1 vssd1 vccd1 SS_sky130_ef_sc_hd__decap_40_12
XFILLER_137_705 vssd1 vccd1 vccd1 vssd1 SS_sky130_fd_sc_hd__fill_4
XFILLER_117_462 vssd1 vccd1 vccd1 vssd1 SS_sky130_fd_sc_hd__fill_2
XFILLER_3_729 vssd1 vccd1 vssd1 vccd1 SS_sky130_ef_sc_hd__decap_40_12
XTAP_TAPCELL_ROW_57_1154 vccd1 vssd1 SS_sky130_fd_sc_hd__tapvpwrvgnd_1
XFILLER_105_668 vssd1 vccd1 vccd1 vssd1 SS_sky130_fd_sc_hd__fill_4
XFILLER_104_189 vssd1 vccd1 vccd1 vssd1 SS_sky130_fd_sc_hd__fill_4
XFILLER_58_221 vssd1 vccd1 vssd1 vccd1 SS_sky130_ef_sc_hd__decap_40_12
XTAP_TAPCELL_ROW_70_1343 vccd1 vssd1 SS_sky130_fd_sc_hd__tapvpwrvgnd_1
XTAP_TAPCELL_ROW_70_1354 vccd1 vssd1 SS_sky130_fd_sc_hd__tapvpwrvgnd_1
XFILLER_76_26 vssd1 vccd1 vccd1 vssd1 SS_sky130_fd_sc_hd__fill_2
XFILLER_120_649 vssd1 vccd1 vccd1 vssd1 SS_sky130_fd_sc_hd__fill_2
XFILLER_116_77 vssd1 vccd1 vccd1 vssd1 SS_sky130_fd_sc_hd__fill_4
XFILLER_101_841 vccd1 vssd1 vccd1 vssd1 SS_sky130_fd_sc_hd__fill_1
XFILLER_58_265 vssd1 vccd1 vssd1 vccd1 SS_sky130_ef_sc_hd__decap_40_12
XFILLER_59_777 vssd1 vccd1 vccd1 vssd1 SS_sky130_fd_sc_hd__fill_4
XFILLER_27_641 vssd1 vccd1 vssd1 vccd1 SS_sky130_ef_sc_hd__decap_40_12
XFILLER_74_769 vssd1 vccd1 vssd1 vccd1 SS_sky130_ef_sc_hd__decap_40_12
XFILLER_132_65 vssd1 vccd1 vssd1 vccd1 SS_sky130_ef_sc_hd__decap_40_12
XFILLER_73_279 vccd1 vssd1 vccd1 vssd1 SS_sky130_fd_sc_hd__fill_1
XFILLER_26_195 vccd1 vssd1 vccd1 vssd1 SS_sky130_fd_sc_hd__fill_1
XFILLER_14_357 vssd1 vccd1 vccd1 vssd1 SS_sky130_fd_sc_hd__fill_4
XFILLER_30_806 vssd1 vccd1 vccd1 vssd1 SS_sky130_fd_sc_hd__fill_4
XFILLER_41_165 vssd1 vccd1 vccd1 vssd1 SS_sky130_fd_sc_hd__fill_2
XFILLER_6_501 vssd1 vccd1 vssd1 vccd1 SS_sky130_ef_sc_hd__decap_40_12
XFILLER_6_545 vssd1 vccd1 vssd1 vccd1 SS_sky130_ef_sc_hd__decap_40_12
XFILLER_10_585 vssd1 vccd1 vccd1 vssd1 SS_sky130_fd_sc_hd__fill_2
XFILLER_127_237 vssd1 vccd1 vssd1 vccd1 SS_sky130_ef_sc_hd__decap_40_12
XFILLER_6_589 vssd1 vccd1 vssd1 vccd1 SS_sky130_ef_sc_hd__decap_40_12
XFILLER_135_281 vssd1 vccd1 vssd1 vccd1 SS_sky130_ef_sc_hd__decap_40_12
XFILLER_123_421 vssd1 vccd1 vccd1 vssd1 SS_sky130_fd_sc_hd__fill_2
Xclkbuf_leaf_7_wb_clk_i _1724_/CLK clkbuf_leaf_7_wb_clk_i/A vccd1 vssd1 vssd1 vccd1
+ SS_sky130_fd_sc_hd__clkbuf_8
XFILLER_1_261 vssd1 vccd1 vssd1 vccd1 SS_sky130_ef_sc_hd__decap_40_12
XFILLER_49_221 vssd1 vccd1 vccd1 vssd1 SS_sky130_fd_sc_hd__fill_2
XFILLER_110_137 vssd1 vccd1 vccd1 vssd1 SS_sky130_fd_sc_hd__fill_2
XFILLER_37_405 vssd1 vccd1 vssd1 vccd1 SS_sky130_ef_sc_hd__decap_40_12
X_1170_ vccd1 vssd1 vccd1 vssd1 _1170_/X _1170_/A _1186_/B SS_sky130_fd_sc_hd__or2_2
XTAP_TAPCELL_ROW_88_1615 vccd1 vssd1 SS_sky130_fd_sc_hd__tapvpwrvgnd_1
XFILLER_37_449 vssd1 vccd1 vssd1 vccd1 SS_sky130_ef_sc_hd__decap_40_12
XFILLER_65_725 vssd1 vccd1 vccd1 vssd1 SS_sky130_fd_sc_hd__fill_2
XFILLER_66_81 vssd1 vccd1 vccd1 vssd1 SS_sky130_fd_sc_hd__fill_2
XFILLER_77_585 vssd1 vccd1 vssd1 vccd1 SS_sky130_ef_sc_hd__decap_40_12
XTAP_TAPCELL_ROW_88_1626 vccd1 vssd1 SS_sky130_fd_sc_hd__tapvpwrvgnd_1
XFILLER_92_533 vssd1 vccd1 vssd1 vccd1 SS_sky130_ef_sc_hd__decap_40_12
XFILLER_18_641 vssd1 vccd1 vccd1 vssd1 SS_sky130_fd_sc_hd__fill_2
XFILLER_52_419 vccd1 vssd1 vccd1 vssd1 SS_sky130_fd_sc_hd__fill_1
XFILLER_32_121 vssd1 vccd1 vssd1 vccd1 SS_sky130_ef_sc_hd__decap_40_12
XFILLER_45_493 vssd1 vccd1 vccd1 vssd1 SS_sky130_fd_sc_hd__fill_4
XFILLER_20_305 vssd1 vccd1 vccd1 vssd1 SS_sky130_fd_sc_hd__fill_2
XFILLER_32_165 vssd1 vccd1 vssd1 vccd1 SS_sky130_ef_sc_hd__decap_40_12
XFILLER_60_463 vssd1 vccd1 vssd1 vccd1 SS_sky130_ef_sc_hd__decap_40_12
XFILLER_33_699 vssd1 vccd1 vssd1 vccd1 SS_sky130_ef_sc_hd__decap_40_12
XFILLER_9_361 vssd1 vccd1 vssd1 vccd1 SS_sky130_ef_sc_hd__decap_40_12
X_0954_ vccd1 vssd1 vccd1 vssd1 _0954_/X _1834_/A _0988_/B SS_sky130_fd_sc_hd__or2_2
XFILLER_119_727 vccd1 vssd1 vccd1 vssd1 SS_sky130_fd_sc_hd__fill_1
X_0885_ vccd1 vssd1 vccd1 vssd1 _1753_/Q _1409_/A _1721_/Q _1343_/A _0889_/B SS_sky130_fd_sc_hd__a22o_2
XTAP_TAPCELL_ROW_99_1788 vccd1 vssd1 SS_sky130_fd_sc_hd__tapvpwrvgnd_1
XFILLER_127_760 vssd1 vccd1 vccd1 vssd1 SS_sky130_fd_sc_hd__fill_4
Xoutput102 vccd1 vssd1 wire342/A _1861_/X vccd1 vssd1 SS_sky130_fd_sc_hd__buf_4
Xoutput113 vccd1 vssd1 wire331/A _1871_/X vccd1 vssd1 SS_sky130_fd_sc_hd__buf_4
Xoutput124 vccd1 vssd1 wire320/A _1881_/X vccd1 vssd1 SS_sky130_fd_sc_hd__buf_4
XFILLER_127_793 vssd1 vccd1 vccd1 vssd1 SS_sky130_fd_sc_hd__fill_2
XFILLER_114_421 vssd1 vccd1 vccd1 vssd1 SS_sky130_fd_sc_hd__fill_4
Xoutput135 vccd1 vssd1 wire415/A _1637_/Q vccd1 vssd1 SS_sky130_fd_sc_hd__buf_4
Xoutput146 vccd1 vssd1 wire405/A _1647_/Q vccd1 vssd1 SS_sky130_fd_sc_hd__buf_4
XFILLER_88_817 vssd1 vccd1 vccd1 vssd1 SS_sky130_fd_sc_hd__fill_2
XPHY_EDGE_ROW_120_Left_259 vccd1 vssd1 vccd1 vssd1 SS_sky130_fd_sc_hd__decap_3
XFILLER_114_432 vssd1 vccd1 vssd1 vccd1 SS_sky130_ef_sc_hd__decap_40_12
Xoutput168 vccd1 vssd1 wire308/A _1890_/X vccd1 vssd1 SS_sky130_fd_sc_hd__buf_4
Xoutput157 vccd1 vssd1 wire394/A _1658_/Q vccd1 vssd1 SS_sky130_fd_sc_hd__buf_4
XFILLER_87_305 vssd1 vccd1 vssd1 vccd1 SS_sky130_ef_sc_hd__decap_40_12
X_1506_ _1506_/Q _1761_/CLK _1506_/D vccd1 vssd1 vccd1 vssd1 SS_sky130_fd_sc_hd__dfxtp_2
Xoutput179 vccd1 vssd1 wire376/A _1492_/Q vccd1 vssd1 SS_sky130_fd_sc_hd__buf_4
XFILLER_99_165 vssd1 vccd1 vccd1 vssd1 SS_sky130_fd_sc_hd__fill_2
X_1437_ vssd1 vccd1 vccd1 vssd1 wire207/X input24/X _1437_/X _1437_/C1 _1436_/X SS_sky130_fd_sc_hd__o211a_2
XFILLER_87_349 vssd1 vccd1 vssd1 vccd1 SS_sky130_ef_sc_hd__decap_40_12
XTAP_TAPCELL_ROW_110_1955 vccd1 vssd1 SS_sky130_fd_sc_hd__tapvpwrvgnd_1
XTAP_TAPCELL_ROW_110_1944 vccd1 vssd1 SS_sky130_fd_sc_hd__tapvpwrvgnd_1
XFILLER_101_137 vssd1 vccd1 vssd1 vccd1 SS_sky130_ef_sc_hd__decap_40_12
XTAP_TAPCELL_ROW_52_1073 vccd1 vssd1 SS_sky130_fd_sc_hd__tapvpwrvgnd_1
XTAP_TAPCELL_ROW_52_1084 vccd1 vssd1 SS_sky130_fd_sc_hd__tapvpwrvgnd_1
X_1368_ vccd1 vssd1 vccd1 vssd1 _1368_/X _1368_/A _1404_/B SS_sky130_fd_sc_hd__or2_2
XFILLER_46_18 vssd1 vccd1 vccd1 vssd1 SS_sky130_fd_sc_hd__fill_8
XFILLER_46_29 vssd1 vccd1 vssd1 vccd1 SS_sky130_ef_sc_hd__decap_40_12
XFILLER_56_725 vssd1 vccd1 vccd1 vssd1 SS_sky130_fd_sc_hd__fill_4
XFILLER_68_585 vssd1 vccd1 vccd1 vssd1 SS_sky130_fd_sc_hd__fill_2
XFILLER_95_393 vssd1 vccd1 vssd1 vccd1 SS_sky130_ef_sc_hd__decap_40_12
XFILLER_56_769 vssd1 vccd1 vssd1 vccd1 SS_sky130_ef_sc_hd__decap_40_12
X_1299_ vssd1 vccd1 vccd1 vssd1 _1337_/A2 wire501/X _1677_/D _1299_/C1 _1298_/X SS_sky130_fd_sc_hd__o211a_2
XFILLER_55_279 vccd1 vssd1 vccd1 vssd1 SS_sky130_fd_sc_hd__fill_1
XFILLER_24_633 vssd1 vccd1 vccd1 vssd1 SS_sky130_fd_sc_hd__fill_2
XFILLER_70_249 vssd1 vccd1 vccd1 vssd1 SS_sky130_fd_sc_hd__fill_2
XFILLER_11_305 vssd1 vccd1 vssd1 vccd1 SS_sky130_ef_sc_hd__decap_40_12
XFILLER_12_817 vssd1 vccd1 vccd1 vssd1 SS_sky130_fd_sc_hd__fill_2
XFILLER_23_165 vssd1 vccd1 vccd1 vssd1 SS_sky130_fd_sc_hd__fill_2
XFILLER_51_485 vssd1 vccd1 vssd1 vccd1 SS_sky130_ef_sc_hd__decap_40_12
XFILLER_11_349 vssd1 vccd1 vssd1 vccd1 SS_sky130_ef_sc_hd__decap_40_12
XFILLER_137_513 vssd1 vccd1 vccd1 vssd1 SS_sky130_fd_sc_hd__fill_8
Xwire207 vccd1 vssd1 wire207/X wire207/A vccd1 vssd1 SS_sky130_fd_sc_hd__buf_4
XFILLER_109_237 vssd1 vccd1 vssd1 vccd1 SS_sky130_ef_sc_hd__decap_40_12
XFILLER_11_54 vssd1 vccd1 vccd1 vssd1 SS_sky130_fd_sc_hd__fill_2
XFILLER_118_782 vssd1 vccd1 vccd1 vssd1 SS_sky130_fd_sc_hd__fill_2
XFILLER_3_559 vccd1 vssd1 vccd1 vssd1 SS_sky130_fd_sc_hd__fill_1
XFILLER_133_741 vssd1 vccd1 vssd1 vccd1 SS_sky130_ef_sc_hd__decap_40_12
XFILLER_117_281 vssd1 vccd1 vssd1 vccd1 SS_sky130_ef_sc_hd__decap_40_12
XFILLER_78_305 vssd1 vccd1 vccd1 vssd1 SS_sky130_fd_sc_hd__fill_2
XFILLER_132_251 vccd1 vssd1 vccd1 vssd1 SS_sky130_fd_sc_hd__fill_1
XFILLER_133_785 vssd1 vccd1 vssd1 vccd1 SS_sky130_ef_sc_hd__decap_40_12
XFILLER_120_413 vssd1 vccd1 vccd1 vssd1 SS_sky130_fd_sc_hd__fill_4
XFILLER_87_69 vssd1 vccd1 vssd1 vccd1 SS_sky130_ef_sc_hd__decap_40_12
XTAP_TAPCELL_ROW_6_386 vccd1 vssd1 SS_sky130_fd_sc_hd__tapvpwrvgnd_1
XFILLER_19_405 vssd1 vccd1 vssd1 vccd1 SS_sky130_ef_sc_hd__decap_40_12
XTAP_TAPCELL_ROW_6_397 vccd1 vssd1 SS_sky130_fd_sc_hd__tapvpwrvgnd_1
XFILLER_47_725 vssd1 vccd1 vccd1 vssd1 SS_sky130_fd_sc_hd__fill_2
XFILLER_59_585 vssd1 vccd1 vccd1 vssd1 SS_sky130_fd_sc_hd__fill_4
XFILLER_74_522 vccd1 vssd1 vccd1 vssd1 SS_sky130_fd_sc_hd__fill_1
XFILLER_74_533 vssd1 vccd1 vssd1 vccd1 SS_sky130_ef_sc_hd__decap_40_12
XFILLER_101_693 vssd1 vccd1 vccd1 vssd1 SS_sky130_fd_sc_hd__fill_8
XFILLER_19_449 vssd1 vccd1 vssd1 vccd1 SS_sky130_ef_sc_hd__decap_40_12
XFILLER_74_566 vssd1 vccd1 vssd1 vccd1 SS_sky130_ef_sc_hd__decap_40_12
XFILLER_34_419 vccd1 vssd1 vccd1 vssd1 SS_sky130_fd_sc_hd__fill_1
XFILLER_61_205 vssd1 vccd1 vssd1 vccd1 SS_sky130_ef_sc_hd__decap_40_12
XFILLER_14_121 vssd1 vccd1 vssd1 vccd1 SS_sky130_ef_sc_hd__decap_40_12
XFILLER_61_249 vssd1 vccd1 vssd1 vccd1 SS_sky130_ef_sc_hd__decap_40_12
XTAP_TAPCELL_ROW_83_1545 vccd1 vssd1 SS_sky130_fd_sc_hd__tapvpwrvgnd_1
XFILLER_42_441 vssd1 vccd1 vccd1 vssd1 SS_sky130_fd_sc_hd__fill_2
XFILLER_14_165 vssd1 vccd1 vssd1 vccd1 SS_sky130_ef_sc_hd__decap_40_12
XTAP_TAPCELL_ROW_25_672 vccd1 vssd1 SS_sky130_fd_sc_hd__tapvpwrvgnd_1
XFILLER_30_636 vssd1 vccd1 vccd1 vssd1 SS_sky130_fd_sc_hd__fill_8
XFILLER_30_669 vssd1 vccd1 vccd1 vssd1 SS_sky130_fd_sc_hd__fill_8
XFILLER_52_83 vccd1 vssd1 vccd1 vssd1 SS_sky130_fd_sc_hd__fill_1
XFILLER_7_821 vssd1 vccd1 vccd1 vssd1 SS_sky130_fd_sc_hd__fill_2
Xinput26 vssd1 vccd1 vccd1 vssd1 input26/A input26/X SS_sky130_fd_sc_hd__clkdlybuf4s25_1
Xinput37 vssd1 vccd1 vccd1 vssd1 input37/A input37/X SS_sky130_fd_sc_hd__clkdlybuf4s25_1
Xinput15 vssd1 vccd1 vccd1 vssd1 input15/A _0754_/D SS_sky130_fd_sc_hd__clkdlybuf4s25_1
XFILLER_128_557 vssd1 vccd1 vssd1 vccd1 SS_sky130_ef_sc_hd__decap_40_12
Xinput48 vssd1 vccd1 wire497/A input48/A vccd1 vssd1 SS_sky130_fd_sc_hd__buf_1
XTAP_TAPCELL_ROW_114_2011 vccd1 vssd1 SS_sky130_fd_sc_hd__tapvpwrvgnd_1
XFILLER_69_305 vssd1 vccd1 vssd1 vccd1 SS_sky130_ef_sc_hd__decap_40_12
XFILLER_111_413 vssd1 vccd1 vccd1 vssd1 SS_sky130_fd_sc_hd__fill_8
XFILLER_2_581 vssd1 vccd1 vccd1 vssd1 SS_sky130_fd_sc_hd__fill_4
XFILLER_69_349 vssd1 vccd1 vssd1 vccd1 SS_sky130_ef_sc_hd__decap_40_12
XFILLER_123_273 vssd1 vccd1 vccd1 vssd1 SS_sky130_fd_sc_hd__fill_4
X_1222_ vccd1 vssd1 vccd1 vssd1 _1222_/X _1640_/Q _1272_/B SS_sky130_fd_sc_hd__or2_2
XFILLER_65_522 vssd1 vccd1 vccd1 vssd1 SS_sky130_fd_sc_hd__fill_4
XFILLER_65_533 vssd1 vccd1 vssd1 vccd1 SS_sky130_ef_sc_hd__decap_40_12
XFILLER_77_393 vssd1 vccd1 vssd1 vccd1 SS_sky130_ef_sc_hd__decap_40_12
XFILLER_93_820 vssd1 vccd1 vccd1 vssd1 SS_sky130_fd_sc_hd__fill_4
X_1153_ vssd1 vccd1 vccd1 vssd1 wire233/X input45/X _1606_/D _1165_/C1 _1152_/X SS_sky130_fd_sc_hd__o211a_2
XFILLER_38_769 vssd1 vccd1 vssd1 vccd1 SS_sky130_ef_sc_hd__decap_40_12
X_1084_ vccd1 vssd1 vccd1 vssd1 _1084_/X _1084_/A _1116_/B SS_sky130_fd_sc_hd__or2_2
XFILLER_37_279 vccd1 vssd1 vccd1 vssd1 SS_sky130_fd_sc_hd__fill_1
XFILLER_80_525 vssd1 vccd1 vccd1 vssd1 SS_sky130_fd_sc_hd__fill_4
XTAP_TAPCELL_ROW_125_2173 vccd1 vssd1 SS_sky130_fd_sc_hd__tapvpwrvgnd_1
XFILLER_92_363 vccd1 vssd1 vccd1 vssd1 SS_sky130_fd_sc_hd__fill_1
XFILLER_52_249 vssd1 vccd1 vccd1 vssd1 SS_sky130_fd_sc_hd__fill_2
XFILLER_33_441 vssd1 vccd1 vccd1 vssd1 SS_sky130_fd_sc_hd__fill_4
XFILLER_33_485 vssd1 vccd1 vssd1 vccd1 SS_sky130_ef_sc_hd__decap_40_12
XFILLER_21_669 vssd1 vccd1 vccd1 vssd1 SS_sky130_fd_sc_hd__fill_2
X_0937_ vssd1 vccd1 vssd1 vccd1 _0744_/X _1633_/Q _0751_/X _0933_/X _0937_/X _0936_/X
+ SS_sky130_fd_sc_hd__a2111o_2
XFILLER_119_557 vssd1 vccd1 vccd1 vssd1 SS_sky130_fd_sc_hd__fill_2
X_0868_ vssd1 vccd1 vssd1 vccd1 _1013_/A _1052_/A _0867_/X _0868_/X SS_sky130_fd_sc_hd__a21o_2
X_0799_ vssd1 vccd1 vssd1 vccd1 wire435/A _1902_/A wire347/X _0797_/X _0799_/X _0798_/X
+ SS_sky130_fd_sc_hd__a2111o_2
XFILLER_115_741 vssd1 vccd1 vssd1 vccd1 SS_sky130_ef_sc_hd__decap_40_12
XFILLER_0_529 vssd1 vccd1 vccd1 vssd1 SS_sky130_fd_sc_hd__fill_2
XTAP_TAPCELL_ROW_54_1113 vccd1 vssd1 SS_sky130_fd_sc_hd__tapvpwrvgnd_1
XFILLER_114_251 vccd1 vssd1 vccd1 vssd1 SS_sky130_fd_sc_hd__fill_1
XFILLER_87_113 vssd1 vccd1 vssd1 vccd1 SS_sky130_ef_sc_hd__decap_40_12
XFILLER_130_755 vccd1 vssd1 vccd1 vssd1 SS_sky130_fd_sc_hd__fill_1
XFILLER_57_39 vssd1 vccd1 vssd1 vccd1 SS_sky130_ef_sc_hd__decap_40_12
XFILLER_102_468 vssd1 vccd1 vccd1 vssd1 SS_sky130_fd_sc_hd__fill_2
XTAP_TAPCELL_ROW_3_345 vccd1 vssd1 SS_sky130_fd_sc_hd__tapvpwrvgnd_1
XFILLER_29_725 vssd1 vccd1 vccd1 vssd1 SS_sky130_fd_sc_hd__fill_2
XFILLER_56_533 vssd1 vccd1 vssd1 vccd1 SS_sky130_ef_sc_hd__decap_40_12
XFILLER_16_419 vccd1 vssd1 vccd1 vssd1 SS_sky130_fd_sc_hd__fill_1
XFILLER_43_205 vssd1 vccd1 vssd1 vccd1 SS_sky130_ef_sc_hd__decap_40_12
XFILLER_56_577 vssd1 vccd1 vccd1 vssd1 SS_sky130_fd_sc_hd__fill_2
XFILLER_71_503 vccd1 vssd1 vccd1 vssd1 SS_sky130_fd_sc_hd__fill_1
XFILLER_83_385 vssd1 vccd1 vccd1 vssd1 SS_sky130_fd_sc_hd__fill_4
XFILLER_43_249 vssd1 vccd1 vssd1 vccd1 SS_sky130_ef_sc_hd__decap_40_12
XTAP_TAPCELL_ROW_42_929 vccd1 vssd1 SS_sky130_fd_sc_hd__tapvpwrvgnd_1
XFILLER_11_113 vssd1 vccd1 vssd1 vccd1 SS_sky130_ef_sc_hd__decap_40_12
XFILLER_12_625 vssd1 vccd1 vssd1 vccd1 SS_sky130_ef_sc_hd__decap_40_12
XTAP_TAPCELL_ROW_65_1275 vccd1 vssd1 SS_sky130_fd_sc_hd__tapvpwrvgnd_1
XFILLER_12_669 vssd1 vccd1 vssd1 vccd1 SS_sky130_ef_sc_hd__decap_40_12
XTAP_TAPCELL_ROW_22_631 vccd1 vssd1 SS_sky130_fd_sc_hd__tapvpwrvgnd_1
XFILLER_51_293 vssd1 vccd1 vssd1 vccd1 SS_sky130_ef_sc_hd__decap_40_12
XFILLER_138_811 vccd1 vssd1 vccd1 vssd1 SS_sky130_fd_sc_hd__fill_1
XFILLER_22_53 vssd1 vccd1 vssd1 vccd1 SS_sky130_ef_sc_hd__decap_40_12
XFILLER_125_505 vssd1 vccd1 vssd1 vccd1 SS_sky130_ef_sc_hd__decap_40_12
XFILLER_125_3 vssd1 vccd1 vssd1 vccd1 SS_sky130_ef_sc_hd__decap_40_12
XFILLER_4_813 vssd1 vccd1 vssd1 vccd1 SS_sky130_ef_sc_hd__decap_40_12
XFILLER_22_97 vssd1 vccd1 vssd1 vccd1 SS_sky130_ef_sc_hd__decap_40_12
XFILLER_79_625 vssd1 vccd1 vssd1 vccd1 SS_sky130_ef_sc_hd__decap_40_12
XFILLER_106_785 vssd1 vccd1 vccd1 vssd1 SS_sky130_fd_sc_hd__fill_2
XFILLER_3_389 vssd1 vccd1 vccd1 vssd1 SS_sky130_fd_sc_hd__fill_2
XFILLER_120_221 vssd1 vccd1 vssd1 vccd1 SS_sky130_ef_sc_hd__decap_40_12
XFILLER_105_273 vssd1 vccd1 vccd1 vssd1 SS_sky130_fd_sc_hd__fill_4
XFILLER_67_809 vssd1 vccd1 vccd1 vssd1 SS_sky130_fd_sc_hd__fill_8
XFILLER_79_669 vssd1 vccd1 vccd1 vssd1 SS_sky130_fd_sc_hd__fill_2
XFILLER_59_382 vssd1 vccd1 vccd1 vssd1 SS_sky130_fd_sc_hd__fill_8
XFILLER_120_265 vssd1 vccd1 vssd1 vccd1 SS_sky130_ef_sc_hd__decap_40_12
XFILLER_93_105 vssd1 vccd1 vccd1 vssd1 SS_sky130_fd_sc_hd__fill_4
XFILLER_59_393 vssd1 vccd1 vssd1 vccd1 SS_sky130_ef_sc_hd__decap_40_12
XFILLER_93_149 vssd1 vccd1 vssd1 vccd1 SS_sky130_ef_sc_hd__decap_40_12
XFILLER_19_279 vccd1 vssd1 vccd1 vssd1 SS_sky130_fd_sc_hd__fill_1
XFILLER_74_363 vccd1 vssd1 vccd1 vssd1 SS_sky130_fd_sc_hd__fill_1
XFILLER_34_249 vssd1 vccd1 vccd1 vssd1 SS_sky130_fd_sc_hd__fill_2
XFILLER_15_441 vssd1 vccd1 vccd1 vssd1 SS_sky130_fd_sc_hd__fill_4
XFILLER_43_761 vccd1 vssd1 vccd1 vssd1 SS_sky130_fd_sc_hd__fill_1
XFILLER_15_485 vssd1 vccd1 vssd1 vccd1 SS_sky130_ef_sc_hd__decap_40_12
XFILLER_43_783 vccd1 vssd1 vccd1 vssd1 SS_sky130_fd_sc_hd__fill_1
XFILLER_63_93 vssd1 vccd1 vssd1 vccd1 SS_sky130_ef_sc_hd__decap_40_12
X_1840_ vccd1 vssd1 _1840_/X _1840_/A vccd1 vssd1 SS_sky130_fd_sc_hd__buf_2
XFILLER_30_433 vssd1 vccd1 vssd1 vccd1 SS_sky130_ef_sc_hd__decap_40_12
XFILLER_30_477 vssd1 vccd1 vssd1 vccd1 SS_sky130_ef_sc_hd__decap_40_12
XFILLER_8_77 vssd1 vccd1 vccd1 vssd1 SS_sky130_fd_sc_hd__fill_4
XTAP_TAPCELL_ROW_96_1736 vccd1 vssd1 SS_sky130_fd_sc_hd__tapvpwrvgnd_1
XFILLER_7_673 vssd1 vccd1 vssd1 vccd1 SS_sky130_ef_sc_hd__decap_40_12
Xhold607 _1306_/A _1681_/Q vccd1 vssd1 vssd1 vccd1 SS_sky130_fd_sc_hd__dlygate4sd3_1
XFILLER_128_365 vssd1 vccd1 vccd1 vssd1 SS_sky130_fd_sc_hd__fill_8
Xhold618 input18/A wbs_adr_i[5] vccd1 vssd1 vssd1 vccd1 SS_sky130_fd_sc_hd__dlygate4sd3_1
XTAP_TAPCELL_ROW_96_1747 vccd1 vssd1 SS_sky130_fd_sc_hd__tapvpwrvgnd_1
Xhold629 _1296_/A _1676_/Q vccd1 vssd1 vssd1 vccd1 SS_sky130_fd_sc_hd__dlygate4sd3_1
XFILLER_40_3 vssd1 vccd1 vssd1 vccd1 SS_sky130_ef_sc_hd__decap_40_12
XFILLER_69_113 vssd1 vccd1 vssd1 vccd1 SS_sky130_ef_sc_hd__decap_40_12
XFILLER_111_221 vssd1 vccd1 vccd1 vssd1 SS_sky130_fd_sc_hd__fill_2
XFILLER_85_617 vssd1 vccd1 vssd1 vccd1 SS_sky130_ef_sc_hd__decap_40_12
XTAP_TAPCELL_ROW_127_2202 vccd1 vssd1 SS_sky130_fd_sc_hd__tapvpwrvgnd_1
XFILLER_112_755 vccd1 vssd1 vccd1 vssd1 SS_sky130_fd_sc_hd__fill_1
XFILLER_38_533 vssd1 vccd1 vssd1 vccd1 SS_sky130_ef_sc_hd__decap_40_12
X_1205_ vssd1 vccd1 vccd1 vssd1 _1209_/A2 input41/X _1632_/D _1431_/C1 _1204_/X SS_sky130_fd_sc_hd__o211a_2
XTAP_TAPCELL_ROW_0_304 vccd1 vssd1 SS_sky130_fd_sc_hd__tapvpwrvgnd_1
XFILLER_25_205 vssd1 vccd1 vssd1 vccd1 SS_sky130_ef_sc_hd__decap_40_12
X_1136_ vccd1 vssd1 vccd1 vssd1 _1136_/X _1136_/A _1140_/B SS_sky130_fd_sc_hd__or2_2
XFILLER_25_249 vssd1 vccd1 vssd1 vccd1 SS_sky130_ef_sc_hd__decap_40_12
XFILLER_80_333 vccd1 vssd1 vccd1 vssd1 SS_sky130_fd_sc_hd__fill_1
XFILLER_92_193 vssd1 vccd1 vccd1 vssd1 SS_sky130_fd_sc_hd__fill_2
XFILLER_41_709 vssd1 vccd1 vssd1 vccd1 SS_sky130_ef_sc_hd__decap_40_12
X_1067_ vssd1 vccd1 vccd1 vssd1 _1077_/A2 input38/X _1565_/D _1133_/C1 _1066_/X SS_sky130_fd_sc_hd__o211a_2
XTAP_TAPCELL_ROW_105_1876 vccd1 vssd1 SS_sky130_fd_sc_hd__tapvpwrvgnd_1
XFILLER_33_293 vssd1 vccd1 vssd1 vccd1 SS_sky130_ef_sc_hd__decap_40_12
XTAP_TAPCELL_ROW_138_2375 vccd1 vssd1 SS_sky130_fd_sc_hd__tapvpwrvgnd_1
XTAP_TAPCELL_ROW_138_2364 vccd1 vssd1 SS_sky130_fd_sc_hd__tapvpwrvgnd_1
XFILLER_119_321 vssd1 vccd1 vssd1 vccd1 SS_sky130_ef_sc_hd__decap_40_12
XTAP_TAPCELL_ROW_60_1194 vccd1 vssd1 SS_sky130_fd_sc_hd__tapvpwrvgnd_1
XTAP_TAPCELL_ROW_138_2386 vccd1 vssd1 SS_sky130_fd_sc_hd__tapvpwrvgnd_1
XFILLER_4_109 vssd1 vccd1 vssd1 vccd1 SS_sky130_ef_sc_hd__decap_40_12
XFILLER_107_505 vssd1 vccd1 vccd1 vssd1 SS_sky130_fd_sc_hd__fill_8
XTAP_TAPCELL_ROW_8_415 vccd1 vssd1 SS_sky130_fd_sc_hd__tapvpwrvgnd_1
XTAP_TAPCELL_ROW_8_426 vccd1 vssd1 SS_sky130_fd_sc_hd__tapvpwrvgnd_1
XFILLER_0_337 vssd1 vccd1 vssd1 vccd1 SS_sky130_ef_sc_hd__decap_40_12
XFILLER_88_433 vssd1 vccd1 vssd1 vccd1 SS_sky130_ef_sc_hd__decap_40_12
XFILLER_130_530 vssd1 vccd1 vccd1 vssd1 SS_sky130_fd_sc_hd__fill_2
XFILLER_102_221 vssd1 vccd1 vssd1 vccd1 SS_sky130_ef_sc_hd__decap_40_12
XFILLER_88_477 vssd1 vccd1 vssd1 vccd1 SS_sky130_ef_sc_hd__decap_40_12
XFILLER_103_777 vssd1 vccd1 vccd1 vssd1 SS_sky130_fd_sc_hd__fill_4
XFILLER_75_105 vssd1 vccd1 vccd1 vssd1 SS_sky130_fd_sc_hd__fill_4
XFILLER_102_265 vssd1 vccd1 vssd1 vccd1 SS_sky130_ef_sc_hd__decap_40_12
XFILLER_75_149 vssd1 vccd1 vssd1 vccd1 SS_sky130_ef_sc_hd__decap_40_12
XFILLER_84_15 vssd1 vccd1 vssd1 vccd1 SS_sky130_ef_sc_hd__decap_40_12
XFILLER_124_77 vssd1 vccd1 vccd1 vssd1 SS_sky130_fd_sc_hd__fill_4
XFILLER_91_609 vssd1 vccd1 vccd1 vssd1 SS_sky130_fd_sc_hd__fill_4
XTAP_TAPCELL_ROW_27_701 vccd1 vssd1 SS_sky130_fd_sc_hd__tapvpwrvgnd_1
XTAP_TAPCELL_ROW_67_1304 vccd1 vssd1 SS_sky130_fd_sc_hd__tapvpwrvgnd_1
XTAP_TAPCELL_ROW_27_712 vccd1 vssd1 SS_sky130_fd_sc_hd__tapvpwrvgnd_1
XFILLER_83_193 vssd1 vccd1 vssd1 vccd1 SS_sky130_ef_sc_hd__decap_40_12
XFILLER_16_249 vssd1 vccd1 vccd1 vssd1 SS_sky130_fd_sc_hd__fill_2
XFILLER_44_569 vssd1 vccd1 vccd1 vssd1 SS_sky130_fd_sc_hd__fill_8
Xclkbuf_leaf_21_wb_clk_i clkload2/A clkload0/A vccd1 vssd1 vssd1 vccd1 SS_sky130_fd_sc_hd__clkbuf_8
XFILLER_25_783 vccd1 vssd1 vccd1 vssd1 SS_sky130_fd_sc_hd__fill_1
XFILLER_52_580 vssd1 vccd1 vccd1 vssd1 SS_sky130_fd_sc_hd__fill_8
XFILLER_71_377 vssd1 vccd1 vccd1 vssd1 SS_sky130_fd_sc_hd__fill_2
XTAP_TAPCELL_ROW_80_1504 vccd1 vssd1 SS_sky130_fd_sc_hd__tapvpwrvgnd_1
XFILLER_12_433 vssd1 vccd1 vssd1 vccd1 SS_sky130_ef_sc_hd__decap_40_12
XFILLER_33_30 vssd1 vccd1 vssd1 vccd1 SS_sky130_ef_sc_hd__decap_40_12
XFILLER_40_753 vssd1 vccd1 vccd1 vssd1 SS_sky130_fd_sc_hd__fill_2
XFILLER_12_477 vssd1 vccd1 vssd1 vccd1 SS_sky130_ef_sc_hd__decap_40_12
XFILLER_4_643 vccd1 vssd1 vccd1 vssd1 SS_sky130_fd_sc_hd__fill_1
XTAP_TAPCELL_ROW_78_1466 vccd1 vssd1 SS_sky130_fd_sc_hd__tapvpwrvgnd_1
XTAP_TAPCELL_ROW_78_1477 vccd1 vssd1 SS_sky130_fd_sc_hd__tapvpwrvgnd_1
XFILLER_125_335 vccd1 vssd1 vccd1 vssd1 SS_sky130_fd_sc_hd__fill_1
XTAP_TAPCELL_ROW_91_1666 vccd1 vssd1 SS_sky130_fd_sc_hd__tapvpwrvgnd_1
XFILLER_67_617 vssd1 vccd1 vssd1 vccd1 SS_sky130_ef_sc_hd__decap_40_12
XFILLER_35_503 vccd1 vssd1 vccd1 vssd1 SS_sky130_fd_sc_hd__fill_1
XFILLER_47_363 vccd1 vssd1 vccd1 vssd1 SS_sky130_fd_sc_hd__fill_1
XFILLER_74_193 vssd1 vccd1 vccd1 vssd1 SS_sky130_fd_sc_hd__fill_2
XTAP_TAPCELL_ROW_122_2132 vccd1 vssd1 SS_sky130_fd_sc_hd__tapvpwrvgnd_1
XFILLER_62_355 vssd1 vccd1 vccd1 vssd1 SS_sky130_fd_sc_hd__fill_8
XFILLER_74_81 vssd1 vccd1 vccd1 vssd1 SS_sky130_fd_sc_hd__fill_2
XFILLER_15_293 vssd1 vccd1 vssd1 vccd1 SS_sky130_ef_sc_hd__decap_40_12
XFILLER_31_753 vssd1 vccd1 vccd1 vssd1 SS_sky130_fd_sc_hd__fill_4
XFILLER_31_797 vssd1 vccd1 vccd1 vssd1 SS_sky130_fd_sc_hd__fill_8
XTAP_TAPCELL_ROW_13_494 vccd1 vssd1 SS_sky130_fd_sc_hd__tapvpwrvgnd_1
XTAP_TAPCELL_ROW_100_1795 vccd1 vssd1 SS_sky130_fd_sc_hd__tapvpwrvgnd_1
X_1754_ _1754_/Q _1754_/CLK _1754_/D vccd1 vssd1 vccd1 vssd1 SS_sky130_fd_sc_hd__dfxtp_2
XFILLER_129_685 vssd1 vccd1 vssd1 vccd1 SS_sky130_ef_sc_hd__decap_40_12
XFILLER_128_195 vccd1 vssd1 vccd1 vssd1 SS_sky130_fd_sc_hd__fill_1
Xwire390 vccd1 vssd1 vssd1 vccd1 wire390/A analog_ctrl[91] SS_sky130_fd_sc_hd__buf_12
X_1685_ _1685_/Q clkload2/A _1685_/D vccd1 vssd1 vccd1 vssd1 SS_sky130_fd_sc_hd__dfxtp_2
XTAP_TAPCELL_ROW_133_2294 vccd1 vssd1 SS_sky130_fd_sc_hd__tapvpwrvgnd_1
XFILLER_132_817 vssd1 vccd1 vccd1 vssd1 SS_sky130_fd_sc_hd__fill_2
XFILLER_131_349 vssd1 vccd1 vssd1 vccd1 SS_sky130_ef_sc_hd__decap_40_12
XPHY_EDGE_ROW_115_Right_115 vccd1 vssd1 vccd1 vssd1 SS_sky130_fd_sc_hd__decap_3
XFILLER_112_552 vssd1 vccd1 vssd1 vccd1 SS_sky130_ef_sc_hd__decap_40_12
XFILLER_112_541 vssd1 vccd1 vccd1 vssd1 SS_sky130_fd_sc_hd__fill_2
XFILLER_112_530 vssd1 vccd1 vccd1 vssd1 SS_sky130_fd_sc_hd__fill_2
XFILLER_57_105 vssd1 vccd1 vccd1 vssd1 SS_sky130_fd_sc_hd__fill_4
XFILLER_85_425 vccd1 vssd1 vccd1 vssd1 SS_sky130_fd_sc_hd__fill_1
Xload_slew351 vccd1 vssd1 _0926_/A2 _0932_/A2 vccd1 vssd1 SS_sky130_fd_sc_hd__buf_4
XFILLER_57_149 vssd1 vccd1 vssd1 vccd1 SS_sky130_ef_sc_hd__decap_40_12
XFILLER_38_363 vccd1 vssd1 vccd1 vssd1 SS_sky130_fd_sc_hd__fill_1
XTAP_TAPCELL_ROW_107_1905 vccd1 vssd1 SS_sky130_fd_sc_hd__tapvpwrvgnd_1
XFILLER_26_525 vssd1 vccd1 vccd1 vssd1 SS_sky130_fd_sc_hd__fill_4
XTAP_TAPCELL_ROW_49_1034 vccd1 vssd1 SS_sky130_fd_sc_hd__tapvpwrvgnd_1
XFILLER_53_333 vssd1 vccd1 vccd1 vssd1 SS_sky130_fd_sc_hd__fill_2
XFILLER_54_29 vssd1 vccd1 vssd1 vccd1 SS_sky130_ef_sc_hd__decap_40_12
XFILLER_26_569 vssd1 vccd1 vssd1 vccd1 SS_sky130_ef_sc_hd__decap_40_12
XFILLER_65_193 vssd1 vccd1 vssd1 vccd1 SS_sky130_ef_sc_hd__decap_40_12
XFILLER_80_141 vssd1 vccd1 vssd1 vccd1 SS_sky130_ef_sc_hd__decap_40_12
X_1119_ vssd1 vccd1 vccd1 vssd1 wire241/X input30/X _1119_/X _1251_/C1 _1118_/X SS_sky130_fd_sc_hd__o211a_2
XFILLER_41_528 vssd1 vccd1 vssd1 vccd1 SS_sky130_ef_sc_hd__decap_40_12
XFILLER_22_753 vssd1 vccd1 vccd1 vssd1 SS_sky130_fd_sc_hd__fill_2
XTAP_TAPCELL_ROW_62_1223 vccd1 vssd1 SS_sky130_fd_sc_hd__tapvpwrvgnd_1
XTAP_TAPCELL_ROW_62_1234 vccd1 vssd1 SS_sky130_fd_sc_hd__tapvpwrvgnd_1
XPHY_EDGE_ROW_17_Right_17 vccd1 vssd1 vccd1 vssd1 SS_sky130_fd_sc_hd__decap_3
XTAP_TAPCELL_ROW_32_781 vccd1 vssd1 SS_sky130_fd_sc_hd__tapvpwrvgnd_1
XFILLER_5_429 vssd1 vccd1 vssd1 vccd1 SS_sky130_ef_sc_hd__decap_40_12
XFILLER_108_825 vccd1 vssd1 vccd1 vssd1 SS_sky130_fd_sc_hd__fill_1
XFILLER_79_15 vssd1 vccd1 vssd1 vccd1 SS_sky130_ef_sc_hd__decap_40_12
XFILLER_134_121 vssd1 vccd1 vssd1 vccd1 SS_sky130_ef_sc_hd__decap_40_12
XFILLER_119_55 vccd1 vssd1 vccd1 vssd1 SS_sky130_fd_sc_hd__fill_1
XFILLER_107_335 vccd1 vssd1 vccd1 vssd1 SS_sky130_fd_sc_hd__fill_1
XFILLER_134_165 vssd1 vccd1 vssd1 vccd1 SS_sky130_ef_sc_hd__decap_40_12
XFILLER_0_101 vssd1 vccd1 vccd1 vssd1 SS_sky130_fd_sc_hd__fill_8
XFILLER_1_613 vssd1 vccd1 vccd1 vssd1 SS_sky130_fd_sc_hd__fill_2
XFILLER_89_753 vssd1 vccd1 vssd1 vccd1 SS_sky130_ef_sc_hd__decap_40_12
XFILLER_115_390 vssd1 vccd1 vccd1 vssd1 SS_sky130_fd_sc_hd__fill_2
XFILLER_103_541 vssd1 vccd1 vssd1 vccd1 SS_sky130_ef_sc_hd__decap_40_12
XFILLER_0_167 vccd1 vssd1 vccd1 vssd1 SS_sky130_fd_sc_hd__fill_1
XPHY_EDGE_ROW_26_Right_26 vccd1 vssd1 vccd1 vssd1 SS_sky130_fd_sc_hd__decap_3
XTAP_TAPCELL_ROW_73_1396 vccd1 vssd1 SS_sky130_fd_sc_hd__tapvpwrvgnd_1
XFILLER_89_797 vssd1 vccd1 vssd1 vccd1 SS_sky130_ef_sc_hd__decap_40_12
XFILLER_130_360 vssd1 vccd1 vccd1 vssd1 SS_sky130_fd_sc_hd__fill_4
XFILLER_28_41 vssd1 vccd1 vssd1 vccd1 SS_sky130_ef_sc_hd__decap_40_12
XFILLER_95_69 vssd1 vccd1 vssd1 vccd1 SS_sky130_ef_sc_hd__decap_40_12
XFILLER_17_503 vccd1 vssd1 vccd1 vssd1 SS_sky130_fd_sc_hd__fill_1
XFILLER_76_469 vssd1 vccd1 vccd1 vssd1 SS_sky130_fd_sc_hd__fill_4
XFILLER_91_417 vssd1 vccd1 vssd1 vccd1 SS_sky130_ef_sc_hd__decap_40_12
XFILLER_28_85 vssd1 vccd1 vssd1 vccd1 SS_sky130_ef_sc_hd__decap_40_12
XFILLER_29_385 vssd1 vccd1 vccd1 vssd1 SS_sky130_fd_sc_hd__fill_4
XFILLER_45_823 vccd1 vssd1 vccd1 vssd1 SS_sky130_fd_sc_hd__fill_1
XFILLER_44_333 vssd1 vccd1 vssd1 vccd1 SS_sky130_ef_sc_hd__decap_40_12
XFILLER_56_193 vssd1 vccd1 vccd1 vssd1 SS_sky130_fd_sc_hd__fill_2
XFILLER_44_377 vssd1 vccd1 vssd1 vccd1 SS_sky130_ef_sc_hd__decap_40_12
XFILLER_13_753 vssd1 vccd1 vssd1 vccd1 SS_sky130_ef_sc_hd__decap_40_12
XPHY_EDGE_ROW_35_Right_35 vccd1 vssd1 vccd1 vssd1 SS_sky130_fd_sc_hd__decap_3
XFILLER_8_245 vssd1 vccd1 vccd1 vssd1 SS_sky130_fd_sc_hd__fill_4
XFILLER_60_83 vccd1 vssd1 vccd1 vssd1 SS_sky130_fd_sc_hd__fill_1
XFILLER_8_289 vssd1 vccd1 vssd1 vccd1 SS_sky130_ef_sc_hd__decap_40_12
XTAP_TAPCELL_ROW_10_453 vccd1 vssd1 SS_sky130_fd_sc_hd__tapvpwrvgnd_1
XFILLER_125_165 vssd1 vccd1 vccd1 vssd1 SS_sky130_fd_sc_hd__fill_2
XFILLER_99_517 vssd1 vccd1 vccd1 vssd1 SS_sky130_fd_sc_hd__fill_2
XFILLER_4_473 vssd1 vccd1 vccd1 vssd1 SS_sky130_fd_sc_hd__fill_2
X_1470_ vccd1 vssd1 vccd1 vssd1 _1470_/X _1470_/A _1472_/B SS_sky130_fd_sc_hd__or2_2
XPHY_EDGE_ROW_44_Right_44 vccd1 vssd1 vccd1 vssd1 SS_sky130_fd_sc_hd__decap_3
XFILLER_69_81 vssd1 vccd1 vssd1 vccd1 SS_sky130_ef_sc_hd__decap_40_12
XFILLER_39_105 vssd1 vccd1 vccd1 vssd1 SS_sky130_fd_sc_hd__fill_4
XFILLER_67_425 vssd1 vccd1 vssd1 vccd1 SS_sky130_ef_sc_hd__decap_40_12
XFILLER_39_149 vssd1 vccd1 vssd1 vccd1 SS_sky130_ef_sc_hd__decap_40_12
XFILLER_67_447 vccd1 vssd1 vccd1 vssd1 SS_sky130_fd_sc_hd__fill_1
XFILLER_121_393 vssd1 vccd1 vssd1 vccd1 SS_sky130_ef_sc_hd__decap_40_12
XFILLER_121_382 vssd1 vccd1 vccd1 vssd1 SS_sky130_fd_sc_hd__fill_8
XFILLER_94_233 vssd1 vccd1 vssd1 vccd1 SS_sky130_ef_sc_hd__decap_40_12
XFILLER_55_609 vssd1 vccd1 vccd1 vssd1 SS_sky130_fd_sc_hd__fill_4
XFILLER_82_417 vssd1 vccd1 vccd1 vssd1 SS_sky130_fd_sc_hd__fill_2
XFILLER_94_277 vssd1 vccd1 vssd1 vccd1 SS_sky130_ef_sc_hd__decap_40_12
XFILLER_35_333 vssd1 vccd1 vccd1 vssd1 SS_sky130_fd_sc_hd__fill_2
XFILLER_47_193 vssd1 vccd1 vssd1 vccd1 SS_sky130_ef_sc_hd__decap_40_12
XFILLER_62_141 vssd1 vccd1 vssd1 vccd1 SS_sky130_ef_sc_hd__decap_40_12
XFILLER_63_642 vssd1 vccd1 vccd1 vssd1 SS_sky130_fd_sc_hd__fill_2
XFILLER_63_664 vssd1 vccd1 vccd1 vssd1 SS_sky130_fd_sc_hd__fill_8
XTAP_TAPCELL_ROW_18_564 vccd1 vssd1 SS_sky130_fd_sc_hd__tapvpwrvgnd_1
XTAP_TAPCELL_ROW_18_575 vccd1 vssd1 SS_sky130_fd_sc_hd__tapvpwrvgnd_1
XFILLER_23_517 vssd1 vccd1 vssd1 vccd1 SS_sky130_ef_sc_hd__decap_40_12
XFILLER_63_697 vssd1 vccd1 vssd1 vccd1 SS_sky130_ef_sc_hd__decap_40_12
XPHY_EDGE_ROW_53_Right_53 vccd1 vssd1 vccd1 vssd1 SS_sky130_fd_sc_hd__decap_3
XTAP_TAPCELL_ROW_102_1835 vccd1 vssd1 SS_sky130_fd_sc_hd__tapvpwrvgnd_1
XTAP_TAPCELL_ROW_102_1824 vccd1 vssd1 SS_sky130_fd_sc_hd__tapvpwrvgnd_1
XFILLER_31_561 vssd1 vccd1 vssd1 vccd1 SS_sky130_ef_sc_hd__decap_40_12
XTAP_TAPCELL_ROW_135_2323 vccd1 vssd1 SS_sky130_fd_sc_hd__tapvpwrvgnd_1
XFILLER_136_408 vssd1 vccd1 vccd1 vssd1 SS_sky130_fd_sc_hd__fill_2
XFILLER_136_419 vccd1 vssd1 vccd1 vssd1 SS_sky130_fd_sc_hd__fill_1
XFILLER_116_121 vssd1 vccd1 vssd1 vccd1 SS_sky130_ef_sc_hd__decap_40_12
X_1737_ _1901_/A clkload7/A _1737_/D vccd1 vssd1 vccd1 vssd1 SS_sky130_fd_sc_hd__dfxtp_2
XFILLER_104_305 vssd1 vccd1 vccd1 vssd1 SS_sky130_fd_sc_hd__fill_2
XPHY_EDGE_ROW_62_Right_62 vccd1 vssd1 vccd1 vssd1 SS_sky130_fd_sc_hd__decap_3
XFILLER_131_113 vssd1 vccd1 vssd1 vccd1 SS_sky130_ef_sc_hd__decap_40_12
XFILLER_132_625 vssd1 vccd1 vssd1 vccd1 SS_sky130_ef_sc_hd__decap_40_12
XFILLER_117_699 vssd1 vccd1 vssd1 vccd1 SS_sky130_ef_sc_hd__decap_40_12
XFILLER_116_165 vssd1 vccd1 vssd1 vccd1 SS_sky130_ef_sc_hd__decap_40_12
X_1668_ _1892_/A _1745_/CLK _1668_/D vccd1 vssd1 vccd1 vssd1 SS_sky130_fd_sc_hd__dfxtp_2
XFILLER_86_701 vssd1 vccd1 vccd1 vssd1 SS_sky130_fd_sc_hd__fill_4
XTAP_TAPCELL_ROW_113_1997 vccd1 vssd1 SS_sky130_fd_sc_hd__tapvpwrvgnd_1
X_1599_ _1599_/Q _1762_/CLK _1599_/D vccd1 vssd1 vccd1 vssd1 SS_sky130_fd_sc_hd__dfxtp_2
XFILLER_100_511 vssd1 vccd1 vccd1 vssd1 SS_sky130_fd_sc_hd__fill_8
XFILLER_58_458 vssd1 vccd1 vssd1 vccd1 SS_sky130_ef_sc_hd__decap_40_12
XFILLER_105_57 vssd1 vccd1 vssd1 vccd1 SS_sky130_ef_sc_hd__decap_40_12
XFILLER_39_661 vssd1 vccd1 vccd1 vssd1 SS_sky130_fd_sc_hd__fill_8
XFILLER_46_609 vccd1 vssd1 vccd1 vssd1 SS_sky130_fd_sc_hd__fill_1
XFILLER_65_39 vssd1 vccd1 vssd1 vccd1 SS_sky130_ef_sc_hd__decap_40_12
XFILLER_73_417 vssd1 vccd1 vssd1 vccd1 SS_sky130_ef_sc_hd__decap_40_12
XFILLER_85_277 vssd1 vccd1 vccd1 vssd1 SS_sky130_fd_sc_hd__fill_2
XFILLER_100_577 vssd1 vccd1 vccd1 vssd1 SS_sky130_fd_sc_hd__fill_8
XFILLER_26_333 vssd1 vccd1 vssd1 vccd1 SS_sky130_ef_sc_hd__decap_40_12
XTAP_TAPCELL_ROW_37_851 vccd1 vssd1 SS_sky130_fd_sc_hd__tapvpwrvgnd_1
XFILLER_38_193 vssd1 vccd1 vccd1 vssd1 SS_sky130_fd_sc_hd__fill_2
XFILLER_26_377 vssd1 vccd1 vssd1 vccd1 SS_sky130_ef_sc_hd__decap_40_12
XTAP_TAPCELL_ROW_37_862 vccd1 vssd1 SS_sky130_fd_sc_hd__tapvpwrvgnd_1
XPHY_EDGE_ROW_71_Right_71 vccd1 vssd1 vccd1 vssd1 SS_sky130_fd_sc_hd__decap_3
XFILLER_81_461 vssd1 vccd1 vssd1 vccd1 SS_sky130_ef_sc_hd__decap_40_12
XFILLER_10_701 vssd1 vccd1 vssd1 vccd1 SS_sky130_ef_sc_hd__decap_40_12
XFILLER_14_65 vssd1 vccd1 vssd1 vccd1 SS_sky130_ef_sc_hd__decap_40_12
XFILLER_5_237 vssd1 vccd1 vssd1 vccd1 SS_sky130_ef_sc_hd__decap_40_12
XFILLER_6_749 vssd1 vccd1 vccd1 vssd1 SS_sky130_fd_sc_hd__fill_4
XPHY_EDGE_ROW_15_Left_154 vccd1 vssd1 vccd1 vssd1 SS_sky130_fd_sc_hd__decap_3
XFILLER_30_53 vssd1 vccd1 vssd1 vccd1 SS_sky130_ef_sc_hd__decap_40_12
XTAP_TAPCELL_ROW_75_1425 vccd1 vssd1 SS_sky130_fd_sc_hd__tapvpwrvgnd_1
XPHY_EDGE_ROW_80_Right_80 vccd1 vssd1 vccd1 vssd1 SS_sky130_fd_sc_hd__decap_3
XFILLER_30_97 vssd1 vccd1 vssd1 vccd1 SS_sky130_ef_sc_hd__decap_40_12
XFILLER_123_614 vssd1 vccd1 vccd1 vssd1 SS_sky130_fd_sc_hd__fill_2
XFILLER_108_699 vccd1 vssd1 vccd1 vssd1 SS_sky130_fd_sc_hd__fill_1
XFILLER_107_165 vssd1 vccd1 vccd1 vssd1 SS_sky130_fd_sc_hd__fill_2
Xhold790 input16/A wbs_adr_i[3] vccd1 vssd1 vssd1 vccd1 SS_sky130_fd_sc_hd__dlygate4sd3_1
XFILLER_111_809 vssd1 vccd1 vssd1 vccd1 SS_sky130_ef_sc_hd__decap_40_12
XFILLER_39_51 vssd1 vccd1 vccd1 vssd1 SS_sky130_fd_sc_hd__fill_4
XFILLER_89_561 vssd1 vccd1 vccd1 vssd1 SS_sky130_fd_sc_hd__fill_8
XFILLER_76_233 vssd1 vccd1 vssd1 vccd1 SS_sky130_ef_sc_hd__decap_40_12
XFILLER_103_393 vssd1 vccd1 vssd1 vccd1 SS_sky130_ef_sc_hd__decap_40_12
XFILLER_64_417 vssd1 vccd1 vccd1 vssd1 SS_sky130_fd_sc_hd__fill_2
XFILLER_76_277 vssd1 vccd1 vssd1 vccd1 SS_sky130_ef_sc_hd__decap_40_12
XPHY_EDGE_ROW_24_Left_163 vccd1 vssd1 vccd1 vssd1 SS_sky130_fd_sc_hd__decap_3
XFILLER_91_225 vssd1 vccd1 vssd1 vccd1 SS_sky130_ef_sc_hd__decap_40_12
XFILLER_17_333 vssd1 vccd1 vccd1 vssd1 SS_sky130_fd_sc_hd__fill_2
XFILLER_29_193 vssd1 vccd1 vssd1 vccd1 SS_sky130_ef_sc_hd__decap_40_12
XFILLER_44_141 vssd1 vccd1 vssd1 vccd1 SS_sky130_ef_sc_hd__decap_40_12
XFILLER_45_653 vssd1 vccd1 vssd1 vccd1 SS_sky130_ef_sc_hd__decap_40_12
XFILLER_60_623 vssd1 vccd1 vssd1 vccd1 SS_sky130_ef_sc_hd__decap_40_12
XTAP_TAPCELL_ROW_86_1587 vccd1 vssd1 SS_sky130_fd_sc_hd__tapvpwrvgnd_1
XTAP_TAPCELL_ROW_15_523 vccd1 vssd1 SS_sky130_fd_sc_hd__tapvpwrvgnd_1
XFILLER_60_645 vccd1 vssd1 vccd1 vssd1 SS_sky130_fd_sc_hd__fill_1
XFILLER_13_561 vssd1 vccd1 vssd1 vccd1 SS_sky130_ef_sc_hd__decap_40_12
X_0970_ vccd1 vssd1 vccd1 vssd1 _0970_/X _0970_/A _0988_/B SS_sky130_fd_sc_hd__or2_2
XFILLER_60_678 vssd1 vccd1 vssd1 vccd1 SS_sky130_ef_sc_hd__decap_40_12
XFILLER_71_93 vssd1 vccd1 vssd1 vccd1 SS_sky130_ef_sc_hd__decap_40_12
XPHY_EDGE_ROW_33_Left_172 vccd1 vssd1 vccd1 vssd1 SS_sky130_fd_sc_hd__decap_3
XTAP_TAPCELL_ROW_117_2053 vccd1 vssd1 SS_sky130_fd_sc_hd__tapvpwrvgnd_1
XFILLER_126_441 vssd1 vccd1 vccd1 vssd1 SS_sky130_fd_sc_hd__fill_4
XTAP_TAPCELL_ROW_130_2253 vccd1 vssd1 SS_sky130_fd_sc_hd__tapvpwrvgnd_1
XFILLER_126_496 vssd1 vccd1 vccd1 vssd1 SS_sky130_fd_sc_hd__fill_4
XFILLER_126_474 vssd1 vccd1 vccd1 vssd1 SS_sky130_fd_sc_hd__fill_2
XFILLER_113_113 vssd1 vccd1 vssd1 vccd1 SS_sky130_ef_sc_hd__decap_40_12
X_1522_ _1522_/Q _1747_/CLK _1522_/D vccd1 vssd1 vccd1 vssd1 SS_sky130_fd_sc_hd__dfxtp_2
XFILLER_87_509 vssd1 vccd1 vccd1 vssd1 SS_sky130_fd_sc_hd__fill_2
XFILLER_114_669 vssd1 vccd1 vssd1 vccd1 SS_sky130_ef_sc_hd__decap_40_12
X_1453_ vssd1 vccd1 vccd1 vssd1 _1463_/A2 input33/X _1453_/X wire493/X _1452_/X SS_sky130_fd_sc_hd__o211a_2
X_1384_ vccd1 vssd1 vccd1 vssd1 _1384_/X _1384_/A _1396_/B SS_sky130_fd_sc_hd__or2_2
XFILLER_68_745 vssd1 vccd1 vccd1 vssd1 SS_sky130_fd_sc_hd__fill_8
XPHY_EDGE_ROW_42_Left_181 vccd1 vssd1 vccd1 vssd1 SS_sky130_fd_sc_hd__decap_3
XFILLER_83_715 vccd1 vssd1 vccd1 vssd1 SS_sky130_fd_sc_hd__fill_1
XFILLER_67_277 vssd1 vccd1 vccd1 vssd1 SS_sky130_fd_sc_hd__fill_2
XTAP_TAPCELL_ROW_34_810 vccd1 vssd1 SS_sky130_fd_sc_hd__tapvpwrvgnd_1
XFILLER_36_697 vssd1 vccd1 vccd1 vssd1 SS_sky130_fd_sc_hd__fill_2
XFILLER_63_461 vssd1 vccd1 vssd1 vccd1 SS_sky130_ef_sc_hd__decap_40_12
XFILLER_50_133 vssd1 vccd1 vccd1 vssd1 SS_sky130_fd_sc_hd__fill_4
XFILLER_50_177 vssd1 vccd1 vssd1 vccd1 SS_sky130_ef_sc_hd__decap_40_12
XFILLER_31_391 vccd1 vssd1 vccd1 vssd1 SS_sky130_fd_sc_hd__fill_1
XPHY_EDGE_ROW_51_Left_190 vccd1 vssd1 vccd1 vssd1 SS_sky130_fd_sc_hd__decap_3
XTAP_TAPCELL_ROW_57_1155 vccd1 vssd1 SS_sky130_fd_sc_hd__tapvpwrvgnd_1
XFILLER_117_474 vssd1 vccd1 vccd1 vssd1 SS_sky130_fd_sc_hd__fill_8
XFILLER_132_477 vssd1 vccd1 vccd1 vssd1 SS_sky130_fd_sc_hd__fill_2
XFILLER_58_233 vssd1 vccd1 vssd1 vccd1 SS_sky130_ef_sc_hd__decap_40_12
XTAP_TAPCELL_ROW_70_1344 vccd1 vssd1 SS_sky130_fd_sc_hd__tapvpwrvgnd_1
XTAP_TAPCELL_ROW_70_1355 vccd1 vssd1 SS_sky130_fd_sc_hd__tapvpwrvgnd_1
XFILLER_86_531 vccd1 vssd1 vccd1 vssd1 SS_sky130_fd_sc_hd__fill_1
XFILLER_19_609 vssd1 vccd1 vccd1 vssd1 SS_sky130_fd_sc_hd__fill_4
XFILLER_74_715 vssd1 vccd1 vssd1 vccd1 SS_sky130_ef_sc_hd__decap_40_12
XFILLER_39_480 vssd1 vccd1 vssd1 vccd1 SS_sky130_ef_sc_hd__decap_40_12
XFILLER_58_277 vssd1 vccd1 vssd1 vccd1 SS_sky130_ef_sc_hd__decap_40_12
XFILLER_73_225 vssd1 vccd1 vssd1 vccd1 SS_sky130_ef_sc_hd__decap_40_12
XFILLER_74_737 vccd1 vssd1 vccd1 vssd1 SS_sky130_fd_sc_hd__fill_1
XFILLER_100_363 vccd1 vssd1 vccd1 vssd1 SS_sky130_fd_sc_hd__fill_1
XFILLER_27_653 vssd1 vccd1 vssd1 vccd1 SS_sky130_ef_sc_hd__decap_40_12
XFILLER_132_77 vssd1 vccd1 vccd1 vssd1 SS_sky130_fd_sc_hd__fill_4
XFILLER_92_15 vssd1 vccd1 vssd1 vccd1 SS_sky130_ef_sc_hd__decap_40_12
XFILLER_26_141 vssd1 vccd1 vssd1 vccd1 SS_sky130_ef_sc_hd__decap_40_12
XFILLER_42_601 vssd1 vccd1 vssd1 vccd1 SS_sky130_ef_sc_hd__decap_40_12
XFILLER_41_111 vccd1 vssd1 vccd1 vssd1 SS_sky130_fd_sc_hd__fill_1
XFILLER_42_645 vssd1 vccd1 vccd1 vssd1 SS_sky130_fd_sc_hd__fill_4
XFILLER_42_656 vssd1 vccd1 vssd1 vccd1 SS_sky130_ef_sc_hd__decap_40_12
XFILLER_10_531 vccd1 vssd1 vccd1 vssd1 SS_sky130_fd_sc_hd__fill_1
XFILLER_41_30 vssd1 vccd1 vssd1 vccd1 SS_sky130_ef_sc_hd__decap_40_12
XFILLER_128_739 vssd1 vccd1 vssd1 vccd1 SS_sky130_ef_sc_hd__decap_40_12
XFILLER_127_205 vssd1 vccd1 vssd1 vccd1 SS_sky130_ef_sc_hd__decap_40_12
XFILLER_6_513 vssd1 vccd1 vssd1 vccd1 SS_sky130_ef_sc_hd__decap_40_12
XFILLER_127_249 vssd1 vccd1 vssd1 vccd1 SS_sky130_ef_sc_hd__decap_40_12
XFILLER_6_557 vssd1 vccd1 vssd1 vccd1 SS_sky130_ef_sc_hd__decap_40_12
XFILLER_136_761 vccd1 vssd1 vccd1 vssd1 SS_sky130_fd_sc_hd__fill_1
XFILLER_135_293 vssd1 vccd1 vssd1 vccd1 SS_sky130_ef_sc_hd__decap_40_12
XFILLER_123_433 vssd1 vccd1 vccd1 vssd1 SS_sky130_fd_sc_hd__fill_8
XFILLER_111_617 vssd1 vccd1 vssd1 vccd1 SS_sky130_ef_sc_hd__decap_40_12
XFILLER_1_273 vssd1 vccd1 vccd1 vssd1 SS_sky130_fd_sc_hd__fill_4
XFILLER_89_391 vccd1 vssd1 vccd1 vssd1 SS_sky130_fd_sc_hd__fill_1
XFILLER_111_639 vssd1 vccd1 vssd1 vccd1 SS_sky130_ef_sc_hd__decap_40_12
XTAP_TAPCELL_ROW_88_1616 vccd1 vssd1 SS_sky130_fd_sc_hd__tapvpwrvgnd_1
XFILLER_92_501 vssd1 vccd1 vssd1 vccd1 SS_sky130_ef_sc_hd__decap_40_12
XFILLER_37_417 vssd1 vccd1 vssd1 vccd1 SS_sky130_ef_sc_hd__decap_40_12
XFILLER_49_277 vssd1 vccd1 vccd1 vssd1 SS_sky130_fd_sc_hd__fill_2
XFILLER_77_597 vssd1 vccd1 vssd1 vccd1 SS_sky130_ef_sc_hd__decap_40_12
XTAP_TAPCELL_ROW_88_1627 vccd1 vssd1 SS_sky130_fd_sc_hd__tapvpwrvgnd_1
XFILLER_92_545 vssd1 vccd1 vssd1 vccd1 SS_sky130_ef_sc_hd__decap_40_12
XFILLER_52_409 vssd1 vccd1 vccd1 vssd1 SS_sky130_fd_sc_hd__fill_2
XFILLER_73_781 vssd1 vccd1 vccd1 vssd1 SS_sky130_fd_sc_hd__fill_2
XFILLER_92_589 vssd1 vccd1 vccd1 vssd1 SS_sky130_fd_sc_hd__fill_8
XFILLER_18_697 vssd1 vccd1 vccd1 vssd1 SS_sky130_fd_sc_hd__fill_2
XFILLER_32_133 vssd1 vccd1 vccd1 vssd1 SS_sky130_fd_sc_hd__fill_4
XFILLER_82_81 vssd1 vccd1 vccd1 vssd1 SS_sky130_fd_sc_hd__fill_2
XFILLER_32_177 vssd1 vccd1 vssd1 vccd1 SS_sky130_ef_sc_hd__decap_40_12
XFILLER_60_475 vccd1 vssd1 vccd1 vssd1 SS_sky130_fd_sc_hd__fill_1
XFILLER_13_391 vccd1 vssd1 vccd1 vssd1 SS_sky130_fd_sc_hd__fill_1
X_0953_ vssd1 vccd1 vccd1 vssd1 _0989_/A2 input42/X _1509_/D _1149_/C1 _0952_/X SS_sky130_fd_sc_hd__o211a_2
XFILLER_9_373 vssd1 vccd1 vssd1 vccd1 SS_sky130_ef_sc_hd__decap_40_12
XFILLER_70_3 vssd1 vccd1 vssd1 vccd1 SS_sky130_ef_sc_hd__decap_40_12
X_0884_ vccd1 vssd1 vssd1 vccd1 _0880_/X _0883_/X _0926_/A2 hold796/X _1496_/D _1451_/C1
+ SS_sky130_fd_sc_hd__o221a_2
XTAP_TAPCELL_ROW_99_1778 vccd1 vssd1 SS_sky130_fd_sc_hd__tapvpwrvgnd_1
XFILLER_118_249 vssd1 vccd1 vccd1 vssd1 SS_sky130_fd_sc_hd__fill_2
XTAP_TAPCELL_ROW_99_1789 vccd1 vssd1 SS_sky130_fd_sc_hd__tapvpwrvgnd_1
Xoutput103 vccd1 vssd1 wire341/A _1862_/X vccd1 vssd1 SS_sky130_fd_sc_hd__buf_4
Xoutput114 vccd1 vssd1 wire330/A _1872_/X vccd1 vssd1 SS_sky130_fd_sc_hd__buf_4
Xoutput125 vccd1 vssd1 wire319/A _1882_/X vccd1 vssd1 SS_sky130_fd_sc_hd__buf_4
XFILLER_127_783 vccd1 vssd1 vccd1 vssd1 SS_sky130_fd_sc_hd__fill_1
XFILLER_99_111 vccd1 vssd1 vccd1 vssd1 SS_sky130_fd_sc_hd__fill_1
Xoutput136 vccd1 vssd1 wire414/A _1638_/Q vccd1 vssd1 SS_sky130_fd_sc_hd__buf_4
Xoutput147 vccd1 vssd1 wire404/A _1648_/Q vccd1 vssd1 SS_sky130_fd_sc_hd__buf_4
X_1505_ _1505_/Q _1761_/CLK _1505_/D vccd1 vssd1 vccd1 vssd1 SS_sky130_fd_sc_hd__dfxtp_2
XFILLER_114_444 vssd1 vccd1 vssd1 vccd1 SS_sky130_ef_sc_hd__decap_40_12
Xoutput158 vccd1 vssd1 wire393/A _1659_/Q vccd1 vssd1 SS_sky130_fd_sc_hd__buf_4
Xoutput169 vccd1 vssd1 wire307/A _1834_/X vccd1 vssd1 SS_sky130_fd_sc_hd__buf_4
XFILLER_87_317 vccd1 vssd1 vccd1 vssd1 SS_sky130_fd_sc_hd__fill_1
XFILLER_114_477 vssd1 vccd1 vssd1 vccd1 SS_sky130_ef_sc_hd__decap_40_12
XFILLER_114_466 vccd1 vssd1 vccd1 vssd1 SS_sky130_fd_sc_hd__fill_1
XFILLER_101_105 vssd1 vccd1 vccd1 vssd1 SS_sky130_fd_sc_hd__fill_4
XFILLER_68_531 vccd1 vssd1 vccd1 vssd1 SS_sky130_fd_sc_hd__fill_1
X_1436_ vccd1 vssd1 vccd1 vssd1 _1436_/X _1908_/A _1454_/B SS_sky130_fd_sc_hd__or2_2
XTAP_TAPCELL_ROW_110_1956 vccd1 vssd1 SS_sky130_fd_sc_hd__tapvpwrvgnd_1
XTAP_TAPCELL_ROW_110_1945 vccd1 vssd1 SS_sky130_fd_sc_hd__tapvpwrvgnd_1
XTAP_TAPCELL_ROW_52_1074 vccd1 vssd1 SS_sky130_fd_sc_hd__tapvpwrvgnd_1
X_1367_ vssd1 vccd1 vccd1 vssd1 _1385_/A2 wire500/X _1710_/D _1445_/C1 _1366_/X SS_sky130_fd_sc_hd__o211a_2
XTAP_TAPCELL_ROW_52_1085 vccd1 vssd1 SS_sky130_fd_sc_hd__tapvpwrvgnd_1
XFILLER_110_661 vssd1 vccd1 vccd1 vssd1 SS_sky130_fd_sc_hd__fill_2
XFILLER_101_149 vssd1 vccd1 vssd1 vccd1 SS_sky130_ef_sc_hd__decap_40_12
XFILLER_28_417 vssd1 vccd1 vccd1 vssd1 SS_sky130_fd_sc_hd__fill_2
XFILLER_55_225 vssd1 vccd1 vssd1 vccd1 SS_sky130_ef_sc_hd__decap_40_12
XFILLER_83_534 vssd1 vccd1 vssd1 vccd1 SS_sky130_ef_sc_hd__decap_40_12
XFILLER_95_361 vssd1 vccd1 vssd1 vccd1 SS_sky130_ef_sc_hd__decap_40_12
X_1298_ vccd1 vssd1 vccd1 vssd1 _1298_/X _1298_/A _1338_/B SS_sky130_fd_sc_hd__or2_2
XFILLER_24_601 vssd1 vccd1 vssd1 vccd1 SS_sky130_ef_sc_hd__decap_40_12
XFILLER_64_781 vssd1 vccd1 vssd1 vccd1 SS_sky130_ef_sc_hd__decap_40_12
XFILLER_71_729 vssd1 vccd1 vccd1 vssd1 SS_sky130_fd_sc_hd__fill_8
XFILLER_23_111 vccd1 vssd1 vccd1 vssd1 SS_sky130_fd_sc_hd__fill_1
XFILLER_24_645 vssd1 vccd1 vccd1 vssd1 SS_sky130_fd_sc_hd__fill_8
XFILLER_62_29 vssd1 vccd1 vssd1 vccd1 SS_sky130_ef_sc_hd__decap_40_12
XFILLER_11_317 vssd1 vccd1 vssd1 vccd1 SS_sky130_ef_sc_hd__decap_40_12
XFILLER_51_497 vssd1 vccd1 vccd1 vssd1 SS_sky130_fd_sc_hd__fill_4
XFILLER_109_205 vssd1 vccd1 vssd1 vccd1 SS_sky130_ef_sc_hd__decap_40_12
XFILLER_137_547 vccd1 vssd1 vccd1 vssd1 SS_sky130_fd_sc_hd__fill_1
XFILLER_137_569 vssd1 vccd1 vccd1 vssd1 SS_sky130_fd_sc_hd__fill_2
XFILLER_109_249 vssd1 vccd1 vssd1 vccd1 SS_sky130_ef_sc_hd__decap_40_12
XFILLER_3_505 vssd1 vccd1 vssd1 vccd1 SS_sky130_ef_sc_hd__decap_40_12
XFILLER_87_15 vssd1 vccd1 vssd1 vccd1 SS_sky130_ef_sc_hd__decap_40_12
XFILLER_133_753 vssd1 vccd1 vccd1 vssd1 SS_sky130_fd_sc_hd__fill_4
XFILLER_127_55 vccd1 vssd1 vccd1 vssd1 SS_sky130_fd_sc_hd__fill_1
XFILLER_117_293 vssd1 vccd1 vssd1 vccd1 SS_sky130_ef_sc_hd__decap_40_12
XFILLER_133_797 vssd1 vccd1 vccd1 vssd1 SS_sky130_fd_sc_hd__fill_4
XTAP_TAPCELL_ROW_6_387 vccd1 vssd1 SS_sky130_fd_sc_hd__tapvpwrvgnd_1
XFILLER_19_417 vssd1 vccd1 vssd1 vccd1 SS_sky130_ef_sc_hd__decap_40_12
XFILLER_86_361 vssd1 vccd1 vccd1 vssd1 SS_sky130_fd_sc_hd__fill_2
XFILLER_74_545 vssd1 vccd1 vccd1 vssd1 SS_sky130_fd_sc_hd__fill_4
XFILLER_100_193 vssd1 vccd1 vccd1 vssd1 SS_sky130_fd_sc_hd__fill_2
XFILLER_27_461 vssd1 vccd1 vssd1 vccd1 SS_sky130_ef_sc_hd__decap_40_12
XFILLER_36_41 vssd1 vccd1 vssd1 vccd1 SS_sky130_ef_sc_hd__decap_40_12
XFILLER_55_781 vssd1 vccd1 vccd1 vssd1 SS_sky130_fd_sc_hd__fill_2
XFILLER_61_217 vssd1 vccd1 vccd1 vssd1 SS_sky130_fd_sc_hd__fill_4
XFILLER_74_578 vssd1 vccd1 vccd1 vssd1 SS_sky130_fd_sc_hd__fill_8
XFILLER_74_589 vccd1 vssd1 vccd1 vssd1 SS_sky130_fd_sc_hd__fill_1
XFILLER_36_85 vssd1 vccd1 vssd1 vccd1 SS_sky130_ef_sc_hd__decap_40_12
XTAP_TAPCELL_ROW_83_1546 vccd1 vssd1 SS_sky130_fd_sc_hd__tapvpwrvgnd_1
XFILLER_14_133 vssd1 vccd1 vccd1 vssd1 SS_sky130_fd_sc_hd__fill_4
XFILLER_14_177 vssd1 vccd1 vssd1 vccd1 SS_sky130_ef_sc_hd__decap_40_12
XTAP_TAPCELL_ROW_25_673 vccd1 vssd1 SS_sky130_fd_sc_hd__tapvpwrvgnd_1
XFILLER_42_475 vccd1 vssd1 vccd1 vssd1 SS_sky130_fd_sc_hd__fill_1
XFILLER_10_361 vssd1 vccd1 vccd1 vssd1 SS_sky130_fd_sc_hd__fill_2
Xinput16 vssd1 vccd1 vccd1 vssd1 input16/A _0755_/A SS_sky130_fd_sc_hd__clkdlybuf4s25_1
Xinput27 vssd1 vccd1 vccd1 vssd1 input27/A input27/X SS_sky130_fd_sc_hd__clkdlybuf4s25_1
XFILLER_6_321 vssd1 vccd1 vssd1 vccd1 SS_sky130_ef_sc_hd__decap_40_12
Xinput38 vssd1 vccd1 vccd1 vssd1 input38/A input38/X SS_sky130_fd_sc_hd__clkdlybuf4s25_1
Xinput49 vssd1 vccd1 wire496/A input49/A vccd1 vssd1 SS_sky130_fd_sc_hd__buf_1
XFILLER_116_709 vssd1 vccd1 vssd1 vccd1 SS_sky130_ef_sc_hd__decap_40_12
XTAP_TAPCELL_ROW_114_2012 vccd1 vssd1 SS_sky130_fd_sc_hd__tapvpwrvgnd_1
XFILLER_6_365 vssd1 vccd1 vssd1 vccd1 SS_sky130_ef_sc_hd__decap_40_12
XFILLER_109_783 vccd1 vssd1 vccd1 vssd1 SS_sky130_fd_sc_hd__fill_1
XFILLER_69_317 vssd1 vccd1 vccd1 vssd1 SS_sky130_fd_sc_hd__fill_4
X_1221_ vssd1 vccd1 vccd1 vssd1 _1273_/A2 input46/X _1639_/D _1417_/C1 _1220_/X SS_sky130_fd_sc_hd__o211a_2
XFILLER_77_81 vssd1 vccd1 vssd1 vccd1 SS_sky130_ef_sc_hd__decap_40_12
XFILLER_84_309 vccd1 vssd1 vccd1 vssd1 SS_sky130_fd_sc_hd__fill_1
X_1152_ vccd1 vssd1 vccd1 vssd1 _1152_/X _1152_/A _1186_/B SS_sky130_fd_sc_hd__or2_2
XFILLER_37_225 vssd1 vccd1 vssd1 vccd1 SS_sky130_ef_sc_hd__decap_40_12
XFILLER_65_545 vssd1 vccd1 vssd1 vccd1 SS_sky130_ef_sc_hd__decap_40_12
X_1083_ vssd1 vccd1 vccd1 vssd1 wire239/X input31/X _1572_/D _1099_/C1 _1082_/X SS_sky130_fd_sc_hd__o211a_2
XFILLER_53_729 vssd1 vccd1 vssd1 vccd1 SS_sky130_ef_sc_hd__decap_40_12
XTAP_TAPCELL_ROW_125_2174 vccd1 vssd1 SS_sky130_fd_sc_hd__tapvpwrvgnd_1
XFILLER_46_781 vssd1 vccd1 vssd1 vccd1 SS_sky130_ef_sc_hd__decap_40_12
XTAP_TAPCELL_ROW_44_960 vccd1 vssd1 SS_sky130_fd_sc_hd__tapvpwrvgnd_1
XFILLER_21_615 vccd1 vssd1 vccd1 vssd1 SS_sky130_fd_sc_hd__fill_1
XFILLER_33_497 vssd1 vccd1 vccd1 vssd1 SS_sky130_fd_sc_hd__fill_4
XFILLER_119_503 vccd1 vssd1 vccd1 vssd1 SS_sky130_fd_sc_hd__fill_1
X_0936_ vccd1 vssd1 vccd1 vssd1 _1537_/Q _0941_/B1 _1569_/Q _1012_/A _0936_/X SS_sky130_fd_sc_hd__a22o_2
XFILLER_9_181 vssd1 vccd1 vssd1 vccd1 SS_sky130_ef_sc_hd__decap_40_12
XFILLER_134_506 vssd1 vccd1 vssd1 vccd1 SS_sky130_ef_sc_hd__decap_40_12
X_0867_ vccd1 vssd1 vccd1 vssd1 _1750_/Q _1409_/A _1718_/Q wire452/X _0867_/X SS_sky130_fd_sc_hd__a22o_2
X_0798_ vccd1 vssd1 vccd1 vssd1 _1674_/Q wire448/X _1885_/A wire454/X _0798_/X SS_sky130_fd_sc_hd__a22o_2
XFILLER_115_753 vssd1 vccd1 vssd1 vccd1 SS_sky130_ef_sc_hd__decap_40_12
XTAP_TAPCELL_ROW_54_1103 vccd1 vssd1 SS_sky130_fd_sc_hd__tapvpwrvgnd_1
XTAP_TAPCELL_ROW_54_1114 vccd1 vssd1 SS_sky130_fd_sc_hd__tapvpwrvgnd_1
XFILLER_130_701 vccd1 vssd1 vccd1 vssd1 SS_sky130_fd_sc_hd__fill_1
XFILLER_87_125 vssd1 vccd1 vssd1 vccd1 SS_sky130_ef_sc_hd__decap_40_12
XFILLER_88_659 vssd1 vccd1 vssd1 vccd1 SS_sky130_ef_sc_hd__decap_40_12
X_1419_ vssd1 vccd1 vccd1 vssd1 _1439_/A2 input46/X _1735_/D _1439_/C1 _1418_/X SS_sky130_fd_sc_hd__o211a_2
XFILLER_87_169 vssd1 vccd1 vssd1 vccd1 SS_sky130_ef_sc_hd__decap_40_12
XFILLER_29_737 vssd1 vccd1 vssd1 vccd1 SS_sky130_ef_sc_hd__decap_40_12
XFILLER_56_501 vssd1 vccd1 vssd1 vccd1 SS_sky130_ef_sc_hd__decap_40_12
XFILLER_68_361 vssd1 vccd1 vccd1 vssd1 SS_sky130_fd_sc_hd__fill_2
XTAP_TAPCELL_ROW_3_346 vccd1 vssd1 SS_sky130_fd_sc_hd__tapvpwrvgnd_1
XFILLER_56_545 vssd1 vccd1 vssd1 vccd1 SS_sky130_ef_sc_hd__decap_40_12
XFILLER_113_57 vssd1 vccd1 vssd1 vccd1 SS_sky130_ef_sc_hd__decap_40_12
XFILLER_37_781 vssd1 vccd1 vccd1 vssd1 SS_sky130_fd_sc_hd__fill_2
XFILLER_43_217 vssd1 vccd1 vccd1 vssd1 SS_sky130_fd_sc_hd__fill_4
XFILLER_12_637 vssd1 vccd1 vccd1 vssd1 SS_sky130_fd_sc_hd__fill_4
XFILLER_24_475 vccd1 vssd1 vccd1 vssd1 SS_sky130_fd_sc_hd__fill_1
XFILLER_51_261 vssd1 vccd1 vssd1 vccd1 SS_sky130_ef_sc_hd__decap_40_12
XFILLER_52_795 vssd1 vccd1 vssd1 vccd1 SS_sky130_ef_sc_hd__decap_40_12
XTAP_TAPCELL_ROW_65_1276 vccd1 vssd1 SS_sky130_fd_sc_hd__tapvpwrvgnd_1
XFILLER_11_125 vssd1 vccd1 vssd1 vccd1 SS_sky130_ef_sc_hd__decap_40_12
XTAP_TAPCELL_ROW_22_632 vccd1 vssd1 SS_sky130_fd_sc_hd__tapvpwrvgnd_1
XFILLER_11_169 vssd1 vccd1 vssd1 vccd1 SS_sky130_ef_sc_hd__decap_40_12
XFILLER_138_10 vccd1 vssd1 vccd1 vssd1 SS_sky130_fd_sc_hd__fill_1
XFILLER_20_681 vssd1 vccd1 vccd1 vssd1 SS_sky130_fd_sc_hd__fill_2
XFILLER_22_65 vssd1 vccd1 vssd1 vccd1 SS_sky130_ef_sc_hd__decap_40_12
XPHY_EDGE_ROW_129_Right_129 vccd1 vssd1 vccd1 vssd1 SS_sky130_fd_sc_hd__decap_3
XFILLER_4_825 vssd1 vccd1 vssd1 vccd1 SS_sky130_ef_sc_hd__decap_40_12
XFILLER_137_399 vssd1 vccd1 vccd1 vssd1 SS_sky130_fd_sc_hd__fill_4
XFILLER_125_517 vssd1 vccd1 vssd1 vccd1 SS_sky130_ef_sc_hd__decap_40_12
XFILLER_3_335 vccd1 vssd1 vccd1 vssd1 SS_sky130_fd_sc_hd__fill_1
XFILLER_138_87 vccd1 vssd1 vccd1 vssd1 SS_sky130_fd_sc_hd__fill_1
XFILLER_0_3 vssd1 vccd1 vssd1 vccd1 SS_sky130_ef_sc_hd__decap_40_12
XFILLER_133_561 vssd1 vccd1 vssd1 vccd1 SS_sky130_ef_sc_hd__decap_40_12
XFILLER_79_637 vssd1 vccd1 vssd1 vccd1 SS_sky130_ef_sc_hd__decap_40_12
XFILLER_121_745 vssd1 vccd1 vccd1 vssd1 SS_sky130_fd_sc_hd__fill_2
XFILLER_66_309 vssd1 vccd1 vssd1 vccd1 SS_sky130_ef_sc_hd__decap_40_12
XFILLER_121_756 vssd1 vccd1 vssd1 vccd1 SS_sky130_ef_sc_hd__decap_40_12
XFILLER_120_233 vssd1 vccd1 vssd1 vccd1 SS_sky130_ef_sc_hd__decap_40_12
XFILLER_59_361 vssd1 vccd1 vssd1 vccd1 SS_sky130_ef_sc_hd__decap_40_12
XFILLER_120_277 vssd1 vccd1 vssd1 vccd1 SS_sky130_ef_sc_hd__decap_40_12
XFILLER_94_629 vccd1 vssd1 vccd1 vssd1 SS_sky130_fd_sc_hd__fill_1
XFILLER_19_225 vssd1 vccd1 vssd1 vccd1 SS_sky130_ef_sc_hd__decap_40_12
XFILLER_47_51 vssd1 vccd1 vccd1 vssd1 SS_sky130_fd_sc_hd__fill_4
XFILLER_35_729 vssd1 vccd1 vssd1 vccd1 SS_sky130_ef_sc_hd__decap_40_12
XFILLER_28_781 vssd1 vccd1 vssd1 vccd1 SS_sky130_ef_sc_hd__decap_40_12
XFILLER_30_401 vssd1 vccd1 vssd1 vccd1 SS_sky130_ef_sc_hd__decap_40_12
XFILLER_70_581 vssd1 vccd1 vccd1 vssd1 SS_sky130_fd_sc_hd__fill_4
XFILLER_15_497 vssd1 vccd1 vccd1 vssd1 SS_sky130_fd_sc_hd__fill_4
XFILLER_30_445 vssd1 vccd1 vssd1 vccd1 SS_sky130_ef_sc_hd__decap_40_12
XTAP_TAPCELL_ROW_120_2093 vccd1 vssd1 SS_sky130_fd_sc_hd__tapvpwrvgnd_1
XPHY_EDGE_ROW_7_Left_146 vccd1 vssd1 vccd1 vssd1 SS_sky130_fd_sc_hd__decap_3
XFILLER_30_489 vssd1 vccd1 vssd1 vccd1 SS_sky130_ef_sc_hd__decap_40_12
XFILLER_128_311 vccd1 vssd1 vccd1 vssd1 SS_sky130_fd_sc_hd__fill_1
XFILLER_7_641 vssd1 vccd1 vssd1 vccd1 SS_sky130_ef_sc_hd__decap_40_12
XFILLER_7_685 vssd1 vccd1 vssd1 vccd1 SS_sky130_ef_sc_hd__decap_40_12
Xhold608 input47/A wbs_dat_i[5] vccd1 vssd1 vssd1 vccd1 SS_sky130_fd_sc_hd__dlygate4sd3_1
XTAP_TAPCELL_ROW_96_1737 vccd1 vssd1 SS_sky130_fd_sc_hd__tapvpwrvgnd_1
XFILLER_6_195 vccd1 vssd1 vccd1 vssd1 SS_sky130_fd_sc_hd__fill_1
Xmax_cap349 vccd1 vssd1 _0860_/A2 _0878_/A2 vccd1 vssd1 SS_sky130_fd_sc_hd__buf_6
Xhold619 _1079_/A _0741_/Y vccd1 vssd1 vssd1 vccd1 SS_sky130_fd_sc_hd__dlygate4sd3_1
XFILLER_112_701 vssd1 vccd1 vssd1 vccd1 SS_sky130_ef_sc_hd__decap_40_12
XFILLER_69_125 vssd1 vccd1 vssd1 vccd1 SS_sky130_ef_sc_hd__decap_40_12
XTAP_TAPCELL_ROW_127_2203 vccd1 vssd1 SS_sky130_fd_sc_hd__tapvpwrvgnd_1
XFILLER_97_445 vssd1 vccd1 vccd1 vssd1 SS_sky130_fd_sc_hd__fill_2
XFILLER_38_501 vssd1 vccd1 vssd1 vccd1 SS_sky130_ef_sc_hd__decap_40_12
XFILLER_66_810 vssd1 vccd1 vccd1 vssd1 SS_sky130_fd_sc_hd__fill_2
XFILLER_69_169 vssd1 vccd1 vssd1 vccd1 SS_sky130_ef_sc_hd__decap_40_12
XFILLER_85_629 vssd1 vccd1 vssd1 vccd1 SS_sky130_ef_sc_hd__decap_40_12
XFILLER_111_277 vssd1 vccd1 vccd1 vssd1 SS_sky130_fd_sc_hd__fill_2
XFILLER_38_523 vccd1 vssd1 vccd1 vssd1 SS_sky130_fd_sc_hd__fill_1
XFILLER_38_545 vssd1 vccd1 vssd1 vccd1 SS_sky130_ef_sc_hd__decap_40_12
XFILLER_84_139 vccd1 vssd1 vccd1 vssd1 SS_sky130_fd_sc_hd__fill_1
X_1204_ vccd1 vssd1 vccd1 vssd1 _1204_/X _1204_/A _1208_/B SS_sky130_fd_sc_hd__or2_2
XTAP_TAPCELL_ROW_0_305 vccd1 vssd1 SS_sky130_fd_sc_hd__tapvpwrvgnd_1
XFILLER_26_718 vssd1 vccd1 vccd1 vssd1 SS_sky130_fd_sc_hd__fill_2
XFILLER_38_589 vssd1 vccd1 vssd1 vccd1 SS_sky130_ef_sc_hd__decap_40_12
XFILLER_65_353 vssd1 vccd1 vccd1 vssd1 SS_sky130_fd_sc_hd__fill_2
Xclkbuf_0_wb_clk_i vssd1 vccd1 vssd1 vccd1 wb_clk_i clkbuf_0_wb_clk_i/X SS_sky130_fd_sc_hd__clkbuf_16
XFILLER_80_301 vssd1 vccd1 vccd1 vssd1 SS_sky130_fd_sc_hd__fill_4
XFILLER_81_813 vccd1 vssd1 vccd1 vssd1 SS_sky130_fd_sc_hd__fill_1
X_1135_ vssd1 vccd1 vccd1 vssd1 _1141_/A2 input39/X _1598_/D _1465_/C1 _1134_/X SS_sky130_fd_sc_hd__o211a_2
XFILLER_93_673 vssd1 vccd1 vssd1 vccd1 SS_sky130_ef_sc_hd__decap_40_12
XFILLER_25_217 vssd1 vccd1 vccd1 vssd1 SS_sky130_fd_sc_hd__fill_4
XFILLER_65_386 vccd1 vssd1 vccd1 vssd1 SS_sky130_fd_sc_hd__fill_1
XFILLER_34_762 vssd1 vccd1 vssd1 vccd1 SS_sky130_ef_sc_hd__decap_40_12
XFILLER_53_559 vccd1 vssd1 vccd1 vssd1 SS_sky130_fd_sc_hd__fill_1
X_1066_ vccd1 vssd1 vccd1 vssd1 _1066_/X _1066_/A _1076_/B SS_sky130_fd_sc_hd__or2_2
XFILLER_33_261 vssd1 vccd1 vssd1 vccd1 SS_sky130_ef_sc_hd__decap_40_12
XFILLER_40_209 vssd1 vccd1 vssd1 vccd1 SS_sky130_ef_sc_hd__decap_40_12
XTAP_TAPCELL_ROW_105_1877 vccd1 vssd1 SS_sky130_fd_sc_hd__tapvpwrvgnd_1
XFILLER_21_445 vssd1 vccd1 vccd1 vssd1 SS_sky130_fd_sc_hd__fill_2
XTAP_TAPCELL_ROW_138_2365 vccd1 vssd1 SS_sky130_fd_sc_hd__tapvpwrvgnd_1
XTAP_TAPCELL_ROW_60_1195 vccd1 vssd1 SS_sky130_fd_sc_hd__tapvpwrvgnd_1
XTAP_TAPCELL_ROW_138_2376 vccd1 vssd1 SS_sky130_fd_sc_hd__tapvpwrvgnd_1
XTAP_TAPCELL_ROW_138_2387 vccd1 vssd1 SS_sky130_fd_sc_hd__tapvpwrvgnd_1
XFILLER_119_333 vssd1 vccd1 vccd1 vssd1 SS_sky130_fd_sc_hd__fill_2
X_1899_ vccd1 vssd1 _1899_/X _1899_/A vccd1 vssd1 SS_sky130_fd_sc_hd__buf_2
X_0919_ vssd1 vccd1 vccd1 vssd1 _0919_/B _0919_/C _0943_/A _0919_/X SS_sky130_fd_sc_hd__or3_2
XTAP_TAPCELL_ROW_8_416 vccd1 vssd1 SS_sky130_fd_sc_hd__tapvpwrvgnd_1
XTAP_TAPCELL_ROW_8_427 vccd1 vssd1 SS_sky130_fd_sc_hd__tapvpwrvgnd_1
XFILLER_88_401 vssd1 vccd1 vccd1 vssd1 SS_sky130_fd_sc_hd__fill_8
XFILLER_115_561 vssd1 vccd1 vssd1 vccd1 SS_sky130_ef_sc_hd__decap_40_12
XFILLER_1_839 vccd1 vssd1 vccd1 vssd1 SS_sky130_fd_sc_hd__fill_1
XFILLER_115_583 vccd1 vssd1 vccd1 vssd1 SS_sky130_fd_sc_hd__fill_1
XFILLER_0_349 vssd1 vccd1 vccd1 vssd1 SS_sky130_fd_sc_hd__fill_4
XFILLER_88_445 vssd1 vccd1 vssd1 vccd1 SS_sky130_ef_sc_hd__decap_40_12
XFILLER_130_553 vccd1 vssd1 vccd1 vssd1 SS_sky130_fd_sc_hd__fill_1
XFILLER_102_233 vssd1 vccd1 vssd1 vccd1 SS_sky130_ef_sc_hd__decap_40_12
XFILLER_29_501 vssd1 vccd1 vccd1 vssd1 SS_sky130_fd_sc_hd__fill_2
XFILLER_48_309 vssd1 vccd1 vssd1 vccd1 SS_sky130_ef_sc_hd__decap_40_12
XFILLER_88_489 vssd1 vccd1 vccd1 vssd1 SS_sky130_fd_sc_hd__fill_2
XFILLER_102_277 vssd1 vccd1 vssd1 vccd1 SS_sky130_ef_sc_hd__decap_40_12
XFILLER_56_331 vccd1 vssd1 vccd1 vssd1 SS_sky130_fd_sc_hd__fill_1
XFILLER_84_27 vccd1 vssd1 vccd1 vssd1 SS_sky130_fd_sc_hd__fill_1
XFILLER_17_729 vssd1 vccd1 vssd1 vccd1 SS_sky130_ef_sc_hd__decap_40_12
XTAP_TAPCELL_ROW_27_702 vccd1 vssd1 SS_sky130_fd_sc_hd__tapvpwrvgnd_1
XFILLER_56_353 vccd1 vssd1 vccd1 vssd1 SS_sky130_fd_sc_hd__fill_1
XTAP_TAPCELL_ROW_67_1305 vccd1 vssd1 SS_sky130_fd_sc_hd__tapvpwrvgnd_1
XFILLER_72_802 vssd1 vccd1 vccd1 vssd1 SS_sky130_fd_sc_hd__fill_2
XFILLER_90_109 vssd1 vccd1 vssd1 vccd1 SS_sky130_ef_sc_hd__decap_40_12
XFILLER_83_161 vssd1 vccd1 vccd1 vssd1 SS_sky130_fd_sc_hd__fill_4
XFILLER_71_345 vssd1 vccd1 vssd1 vccd1 SS_sky130_ef_sc_hd__decap_40_12
XFILLER_12_401 vssd1 vccd1 vssd1 vccd1 SS_sky130_ef_sc_hd__decap_40_12
XFILLER_40_721 vssd1 vccd1 vssd1 vccd1 SS_sky130_ef_sc_hd__decap_40_12
XFILLER_71_389 vssd1 vccd1 vccd1 vssd1 SS_sky130_fd_sc_hd__fill_2
XTAP_TAPCELL_ROW_80_1505 vccd1 vssd1 SS_sky130_fd_sc_hd__tapvpwrvgnd_1
XFILLER_12_445 vssd1 vccd1 vssd1 vccd1 SS_sky130_ef_sc_hd__decap_40_12
XFILLER_33_42 vssd1 vccd1 vssd1 vccd1 SS_sky130_ef_sc_hd__decap_40_12
XFILLER_12_489 vssd1 vccd1 vssd1 vccd1 SS_sky130_ef_sc_hd__decap_40_12
XTAP_TAPCELL_ROW_78_1467 vccd1 vssd1 SS_sky130_fd_sc_hd__tapvpwrvgnd_1
XFILLER_137_196 vssd1 vccd1 vccd1 vssd1 SS_sky130_fd_sc_hd__fill_4
XFILLER_98_209 vssd1 vccd1 vssd1 vccd1 SS_sky130_ef_sc_hd__decap_40_12
XFILLER_3_165 vssd1 vccd1 vccd1 vssd1 SS_sky130_fd_sc_hd__fill_2
XFILLER_4_699 vccd1 vssd1 vccd1 vssd1 SS_sky130_fd_sc_hd__fill_1
XFILLER_79_445 vssd1 vccd1 vccd1 vssd1 SS_sky130_fd_sc_hd__fill_2
XTAP_TAPCELL_ROW_91_1667 vccd1 vssd1 SS_sky130_fd_sc_hd__tapvpwrvgnd_1
XFILLER_58_83 vccd1 vssd1 vccd1 vssd1 SS_sky130_fd_sc_hd__fill_1
XFILLER_67_629 vssd1 vccd1 vccd1 vssd1 SS_sky130_fd_sc_hd__fill_2
XFILLER_66_139 vccd1 vssd1 vccd1 vssd1 SS_sky130_fd_sc_hd__fill_1
XFILLER_63_813 vccd1 vssd1 vccd1 vssd1 SS_sky130_fd_sc_hd__fill_1
XFILLER_75_673 vccd1 vssd1 vccd1 vssd1 SS_sky130_fd_sc_hd__fill_1
XFILLER_81_109 vssd1 vccd1 vccd1 vssd1 SS_sky130_fd_sc_hd__fill_2
XFILLER_47_386 vccd1 vssd1 vccd1 vssd1 SS_sky130_fd_sc_hd__fill_1
XFILLER_47_397 vssd1 vccd1 vccd1 vssd1 SS_sky130_fd_sc_hd__fill_2
XFILLER_62_301 vssd1 vccd1 vccd1 vssd1 SS_sky130_fd_sc_hd__fill_4
XTAP_TAPCELL_ROW_122_2133 vccd1 vssd1 SS_sky130_fd_sc_hd__tapvpwrvgnd_1
XFILLER_50_507 vssd1 vccd1 vssd1 vccd1 SS_sky130_ef_sc_hd__decap_40_12
XFILLER_90_643 vccd1 vssd1 vccd1 vssd1 SS_sky130_fd_sc_hd__fill_1
XFILLER_15_261 vssd1 vccd1 vssd1 vccd1 SS_sky130_ef_sc_hd__decap_40_12
XFILLER_22_209 vssd1 vccd1 vssd1 vccd1 SS_sky130_ef_sc_hd__decap_40_12
XFILLER_43_581 vssd1 vccd1 vssd1 vccd1 SS_sky130_ef_sc_hd__decap_40_12
XFILLER_30_253 vssd1 vccd1 vssd1 vccd1 SS_sky130_ef_sc_hd__decap_40_12
XFILLER_90_81 vssd1 vccd1 vccd1 vssd1 SS_sky130_fd_sc_hd__fill_2
XFILLER_129_631 vccd1 vssd1 vccd1 vssd1 SS_sky130_fd_sc_hd__fill_1
XTAP_TAPCELL_ROW_100_1796 vccd1 vssd1 SS_sky130_fd_sc_hd__tapvpwrvgnd_1
XTAP_TAPCELL_ROW_13_495 vccd1 vssd1 SS_sky130_fd_sc_hd__tapvpwrvgnd_1
XFILLER_128_141 vssd1 vccd1 vssd1 vccd1 SS_sky130_ef_sc_hd__decap_40_12
X_1753_ _1753_/Q _1753_/CLK _1753_/D vccd1 vssd1 vccd1 vssd1 SS_sky130_fd_sc_hd__dfxtp_2
X_1684_ _1684_/Q _1748_/CLK _1684_/D vccd1 vssd1 vccd1 vssd1 SS_sky130_fd_sc_hd__dfxtp_2
XFILLER_129_697 vssd1 vccd1 vccd1 vssd1 SS_sky130_fd_sc_hd__fill_4
Xwire380 vccd1 vssd1 vssd1 vccd1 wire380/A wbs_dat_o[13] SS_sky130_fd_sc_hd__buf_12
Xwire391 vccd1 vssd1 vssd1 vccd1 wire391/A analog_ctrl[90] SS_sky130_fd_sc_hd__buf_12
XTAP_TAPCELL_ROW_133_2295 vccd1 vssd1 SS_sky130_fd_sc_hd__tapvpwrvgnd_1
Xload_slew352 vccd1 vssd1 _0932_/A2 _0753_/A vccd1 vssd1 SS_sky130_fd_sc_hd__buf_4
XFILLER_112_564 vssd1 vccd1 vssd1 vccd1 SS_sky130_ef_sc_hd__decap_40_12
XFILLER_112_597 vssd1 vccd1 vssd1 vccd1 SS_sky130_ef_sc_hd__decap_40_12
XFILLER_97_297 vssd1 vccd1 vccd1 vssd1 SS_sky130_fd_sc_hd__fill_2
XFILLER_54_813 vccd1 vssd1 vccd1 vssd1 SS_sky130_fd_sc_hd__fill_1
XFILLER_72_109 vssd1 vccd1 vssd1 vccd1 SS_sky130_ef_sc_hd__decap_40_12
XTAP_TAPCELL_ROW_107_1906 vccd1 vssd1 SS_sky130_fd_sc_hd__tapvpwrvgnd_1
XTAP_TAPCELL_ROW_49_1035 vccd1 vssd1 SS_sky130_fd_sc_hd__tapvpwrvgnd_1
XFILLER_65_161 vssd1 vccd1 vccd1 vssd1 SS_sky130_fd_sc_hd__fill_4
X_1118_ vccd1 vssd1 vccd1 vssd1 _1118_/X _1864_/A _1126_/B SS_sky130_fd_sc_hd__or2_2
XFILLER_53_389 vssd1 vccd1 vccd1 vssd1 SS_sky130_fd_sc_hd__fill_2
X_1049_ vssd1 vccd1 vccd1 vssd1 _1051_/A2 input28/X _1556_/D _1295_/C1 _1048_/X SS_sky130_fd_sc_hd__o211a_2
XFILLER_80_153 vssd1 vccd1 vssd1 vccd1 SS_sky130_ef_sc_hd__decap_40_12
XTAP_TAPCELL_ROW_62_1224 vccd1 vssd1 SS_sky130_fd_sc_hd__tapvpwrvgnd_1
XTAP_TAPCELL_ROW_62_1235 vccd1 vssd1 SS_sky130_fd_sc_hd__tapvpwrvgnd_1
XFILLER_80_197 vssd1 vccd1 vssd1 vccd1 SS_sky130_ef_sc_hd__decap_40_12
XFILLER_70_29 vssd1 vccd1 vssd1 vccd1 SS_sky130_ef_sc_hd__decap_40_12
XTAP_TAPCELL_ROW_32_782 vccd1 vssd1 SS_sky130_fd_sc_hd__tapvpwrvgnd_1
XFILLER_79_27 vssd1 vccd1 vssd1 vccd1 SS_sky130_ef_sc_hd__decap_40_12
XFILLER_134_133 vssd1 vccd1 vccd1 vssd1 SS_sky130_fd_sc_hd__fill_4
XPHY_EDGE_ROW_79_Left_218 vccd1 vssd1 vccd1 vssd1 SS_sky130_fd_sc_hd__decap_3
XFILLER_89_721 vssd1 vccd1 vccd1 vssd1 SS_sky130_fd_sc_hd__fill_4
XFILLER_134_177 vssd1 vccd1 vssd1 vccd1 SS_sky130_ef_sc_hd__decap_40_12
XFILLER_0_113 vssd1 vccd1 vssd1 vccd1 SS_sky130_ef_sc_hd__decap_40_12
XFILLER_1_669 vssd1 vccd1 vccd1 vssd1 SS_sky130_fd_sc_hd__fill_2
XFILLER_89_765 vssd1 vccd1 vssd1 vccd1 SS_sky130_ef_sc_hd__decap_40_12
XFILLER_135_55 vccd1 vssd1 vccd1 vssd1 SS_sky130_fd_sc_hd__fill_1
XFILLER_103_553 vssd1 vccd1 vccd1 vssd1 SS_sky130_fd_sc_hd__fill_4
XFILLER_0_157 vssd1 vccd1 vccd1 vssd1 SS_sky130_fd_sc_hd__fill_2
XTAP_TAPCELL_ROW_73_1397 vccd1 vssd1 SS_sky130_fd_sc_hd__tapvpwrvgnd_1
XFILLER_88_253 vssd1 vccd1 vssd1 vccd1 SS_sky130_ef_sc_hd__decap_40_12
XFILLER_95_15 vssd1 vccd1 vssd1 vccd1 SS_sky130_ef_sc_hd__decap_40_12
XFILLER_48_139 vccd1 vssd1 vccd1 vssd1 SS_sky130_fd_sc_hd__fill_1
XFILLER_28_53 vssd1 vccd1 vssd1 vccd1 SS_sky130_ef_sc_hd__decap_40_12
XFILLER_57_673 vssd1 vccd1 vssd1 vccd1 SS_sky130_ef_sc_hd__decap_40_12
XFILLER_63_109 vssd1 vccd1 vccd1 vssd1 SS_sky130_fd_sc_hd__fill_2
XFILLER_28_97 vssd1 vccd1 vssd1 vccd1 SS_sky130_ef_sc_hd__decap_40_12
XFILLER_44_301 vssd1 vccd1 vccd1 vssd1 SS_sky130_fd_sc_hd__fill_4
XFILLER_91_429 vssd1 vccd1 vssd1 vccd1 SS_sky130_ef_sc_hd__decap_40_12
XFILLER_17_559 vccd1 vssd1 vccd1 vssd1 SS_sky130_fd_sc_hd__fill_1
XFILLER_44_345 vssd1 vccd1 vssd1 vccd1 SS_sky130_ef_sc_hd__decap_40_12
XFILLER_32_529 vssd1 vccd1 vccd1 vssd1 SS_sky130_fd_sc_hd__fill_2
XFILLER_44_41 vssd1 vccd1 vssd1 vccd1 SS_sky130_ef_sc_hd__decap_40_12
XFILLER_44_389 vssd1 vccd1 vssd1 vccd1 SS_sky130_ef_sc_hd__decap_40_12
XFILLER_72_698 vssd1 vccd1 vccd1 vssd1 SS_sky130_fd_sc_hd__fill_2
XPHY_EDGE_ROW_88_Left_227 vccd1 vssd1 vccd1 vssd1 SS_sky130_fd_sc_hd__decap_3
XFILLER_13_721 vssd1 vccd1 vccd1 vssd1 SS_sky130_fd_sc_hd__fill_4
XFILLER_44_85 vssd1 vccd1 vssd1 vccd1 SS_sky130_ef_sc_hd__decap_40_12
XFILLER_9_725 vssd1 vccd1 vccd1 vssd1 SS_sky130_fd_sc_hd__fill_2
XFILLER_12_253 vssd1 vccd1 vssd1 vccd1 SS_sky130_ef_sc_hd__decap_40_12
XFILLER_13_765 vccd1 vssd1 vccd1 vssd1 SS_sky130_fd_sc_hd__fill_1
XTAP_TAPCELL_ROW_10_443 vccd1 vssd1 SS_sky130_fd_sc_hd__tapvpwrvgnd_1
XFILLER_126_601 vssd1 vccd1 vssd1 vccd1 SS_sky130_ef_sc_hd__decap_40_12
XTAP_TAPCELL_ROW_10_454 vccd1 vssd1 SS_sky130_fd_sc_hd__tapvpwrvgnd_1
XFILLER_126_645 vssd1 vccd1 vccd1 vssd1 SS_sky130_fd_sc_hd__fill_4
XFILLER_126_623 vccd1 vssd1 vccd1 vssd1 SS_sky130_fd_sc_hd__fill_1
XFILLER_125_111 vccd1 vssd1 vccd1 vssd1 SS_sky130_fd_sc_hd__fill_1
XPHY_EDGE_ROW_97_Left_236 vccd1 vssd1 vccd1 vssd1 SS_sky130_fd_sc_hd__decap_3
XFILLER_5_57 vssd1 vccd1 vssd1 vccd1 SS_sky130_ef_sc_hd__decap_40_12
XFILLER_69_93 vssd1 vccd1 vssd1 vccd1 SS_sky130_ef_sc_hd__decap_40_12
XFILLER_67_437 vssd1 vccd1 vccd1 vssd1 SS_sky130_fd_sc_hd__fill_8
XFILLER_36_813 vssd1 vccd1 vccd1 vssd1 SS_sky130_fd_sc_hd__fill_4
XFILLER_54_109 vssd1 vccd1 vssd1 vccd1 SS_sky130_ef_sc_hd__decap_40_12
XFILLER_94_245 vssd1 vccd1 vccd1 vssd1 SS_sky130_fd_sc_hd__fill_4
XFILLER_47_161 vssd1 vccd1 vccd1 vssd1 SS_sky130_fd_sc_hd__fill_4
XFILLER_82_429 vssd1 vccd1 vccd1 vssd1 SS_sky130_fd_sc_hd__fill_2
XFILLER_85_81 vssd1 vccd1 vssd1 vccd1 SS_sky130_ef_sc_hd__decap_40_12
XFILLER_94_289 vssd1 vccd1 vssd1 vccd1 SS_sky130_ef_sc_hd__decap_40_12
XFILLER_51_805 vssd1 vccd1 vccd1 vssd1 SS_sky130_fd_sc_hd__fill_2
XTAP_TAPCELL_ROW_18_565 vccd1 vssd1 SS_sky130_fd_sc_hd__tapvpwrvgnd_1
XTAP_TAPCELL_ROW_18_576 vccd1 vssd1 SS_sky130_fd_sc_hd__tapvpwrvgnd_1
XFILLER_23_529 vssd1 vccd1 vssd1 vccd1 SS_sky130_ef_sc_hd__decap_40_12
XFILLER_35_389 vssd1 vccd1 vccd1 vssd1 SS_sky130_fd_sc_hd__fill_2
XFILLER_62_153 vssd1 vccd1 vssd1 vccd1 SS_sky130_ef_sc_hd__decap_40_12
XFILLER_90_473 vssd1 vccd1 vccd1 vssd1 SS_sky130_fd_sc_hd__fill_2
XFILLER_16_581 vssd1 vccd1 vccd1 vssd1 SS_sky130_fd_sc_hd__fill_4
XFILLER_62_197 vssd1 vccd1 vssd1 vccd1 SS_sky130_ef_sc_hd__decap_40_12
XTAP_TAPCELL_ROW_102_1836 vccd1 vssd1 SS_sky130_fd_sc_hd__tapvpwrvgnd_1
XTAP_TAPCELL_ROW_102_1825 vccd1 vssd1 SS_sky130_fd_sc_hd__tapvpwrvgnd_1
XFILLER_31_573 vssd1 vccd1 vssd1 vccd1 SS_sky130_ef_sc_hd__decap_40_12
XFILLER_129_461 vssd1 vccd1 vssd1 vccd1 SS_sky130_ef_sc_hd__decap_40_12
XTAP_TAPCELL_ROW_135_2324 vccd1 vssd1 SS_sky130_fd_sc_hd__tapvpwrvgnd_1
XFILLER_117_634 vssd1 vccd1 vssd1 vccd1 SS_sky130_ef_sc_hd__decap_40_12
X_1736_ _1900_/A _1745_/CLK _1736_/D vccd1 vssd1 vccd1 vssd1 SS_sky130_fd_sc_hd__dfxtp_2
XFILLER_116_133 vssd1 vccd1 vccd1 vssd1 SS_sky130_fd_sc_hd__fill_4
X_1667_ _1891_/A _1731_/CLK _1667_/D vccd1 vssd1 vccd1 vssd1 SS_sky130_fd_sc_hd__dfxtp_2
XFILLER_132_637 vssd1 vccd1 vccd1 vssd1 SS_sky130_fd_sc_hd__fill_4
XFILLER_116_177 vssd1 vccd1 vssd1 vccd1 SS_sky130_ef_sc_hd__decap_40_12
XFILLER_131_125 vssd1 vccd1 vssd1 vccd1 SS_sky130_ef_sc_hd__decap_40_12
XFILLER_132_659 vccd1 vssd1 vccd1 vssd1 SS_sky130_fd_sc_hd__fill_1
X_1598_ _1598_/Q _1758_/CLK _1598_/D vccd1 vssd1 vccd1 vssd1 SS_sky130_fd_sc_hd__dfxtp_2
XFILLER_131_169 vssd1 vccd1 vssd1 vccd1 SS_sky130_ef_sc_hd__decap_40_12
XTAP_TAPCELL_ROW_113_1998 vccd1 vssd1 SS_sky130_fd_sc_hd__tapvpwrvgnd_1
XFILLER_85_223 vccd1 vssd1 vccd1 vssd1 SS_sky130_fd_sc_hd__fill_1
XFILLER_105_69 vssd1 vccd1 vssd1 vccd1 SS_sky130_ef_sc_hd__decap_40_12
XFILLER_26_301 vssd1 vccd1 vccd1 vssd1 SS_sky130_fd_sc_hd__fill_4
XFILLER_27_813 vccd1 vssd1 vccd1 vssd1 SS_sky130_fd_sc_hd__fill_1
XFILLER_39_673 vssd1 vccd1 vccd1 vssd1 SS_sky130_fd_sc_hd__fill_8
XFILLER_45_109 vssd1 vccd1 vccd1 vssd1 SS_sky130_fd_sc_hd__fill_2
XFILLER_66_470 vssd1 vccd1 vccd1 vssd1 SS_sky130_fd_sc_hd__fill_4
XFILLER_73_429 vssd1 vccd1 vccd1 vssd1 SS_sky130_fd_sc_hd__fill_4
XFILLER_100_589 vssd1 vccd1 vssd1 vccd1 SS_sky130_ef_sc_hd__decap_40_12
XFILLER_26_345 vssd1 vccd1 vssd1 vccd1 SS_sky130_ef_sc_hd__decap_40_12
XTAP_TAPCELL_ROW_37_852 vccd1 vssd1 SS_sky130_fd_sc_hd__tapvpwrvgnd_1
XFILLER_54_643 vccd1 vssd1 vccd1 vssd1 SS_sky130_fd_sc_hd__fill_1
XFILLER_14_529 vssd1 vccd1 vccd1 vssd1 SS_sky130_fd_sc_hd__fill_2
XFILLER_26_389 vssd1 vccd1 vssd1 vccd1 SS_sky130_ef_sc_hd__decap_40_12
XFILLER_81_473 vssd1 vccd1 vssd1 vccd1 SS_sky130_ef_sc_hd__decap_40_12
XFILLER_121_57 vssd1 vccd1 vssd1 vccd1 SS_sky130_ef_sc_hd__decap_40_12
XFILLER_41_337 vssd1 vccd1 vssd1 vccd1 SS_sky130_ef_sc_hd__decap_40_12
XFILLER_10_713 vssd1 vccd1 vssd1 vccd1 SS_sky130_ef_sc_hd__decap_40_12
XFILLER_14_77 vssd1 vccd1 vccd1 vssd1 SS_sky130_fd_sc_hd__fill_4
XFILLER_10_757 vssd1 vccd1 vssd1 vccd1 SS_sky130_ef_sc_hd__decap_40_12
XFILLER_108_601 vssd1 vccd1 vssd1 vccd1 SS_sky130_ef_sc_hd__decap_40_12
XFILLER_5_205 vssd1 vccd1 vssd1 vccd1 SS_sky130_ef_sc_hd__decap_40_12
XFILLER_108_645 vssd1 vccd1 vccd1 vssd1 SS_sky130_fd_sc_hd__fill_8
XFILLER_107_111 vccd1 vssd1 vccd1 vssd1 SS_sky130_fd_sc_hd__fill_1
XFILLER_5_249 vssd1 vccd1 vssd1 vccd1 SS_sky130_ef_sc_hd__decap_40_12
XFILLER_30_65 vssd1 vccd1 vssd1 vccd1 SS_sky130_ef_sc_hd__decap_40_12
XTAP_TAPCELL_ROW_75_1426 vccd1 vssd1 SS_sky130_fd_sc_hd__tapvpwrvgnd_1
XFILLER_100_3 vssd1 vccd1 vssd1 vccd1 SS_sky130_ef_sc_hd__decap_40_12
Xhold780 _1114_/A _1862_/A vccd1 vssd1 vssd1 vccd1 SS_sky130_fd_sc_hd__dlygate4sd3_1
Xhold791 hold791/X _0744_/X vccd1 vssd1 vssd1 vccd1 SS_sky130_fd_sc_hd__dlygate4sd3_1
XFILLER_131_670 vssd1 vccd1 vccd1 vssd1 SS_sky130_fd_sc_hd__fill_2
XFILLER_110_309 vssd1 vccd1 vssd1 vccd1 SS_sky130_ef_sc_hd__decap_40_12
XFILLER_103_383 vccd1 vssd1 vccd1 vssd1 SS_sky130_fd_sc_hd__fill_1
XFILLER_76_245 vssd1 vccd1 vccd1 vssd1 SS_sky130_fd_sc_hd__fill_4
XFILLER_18_813 vccd1 vssd1 vccd1 vssd1 SS_sky130_fd_sc_hd__fill_1
XFILLER_29_161 vssd1 vccd1 vccd1 vssd1 SS_sky130_fd_sc_hd__fill_4
XFILLER_36_109 vssd1 vccd1 vssd1 vccd1 SS_sky130_ef_sc_hd__decap_40_12
XFILLER_57_470 vssd1 vccd1 vssd1 vccd1 SS_sky130_ef_sc_hd__decap_40_12
XFILLER_76_289 vssd1 vccd1 vssd1 vccd1 SS_sky130_ef_sc_hd__decap_40_12
XFILLER_55_51 vssd1 vccd1 vccd1 vssd1 SS_sky130_fd_sc_hd__fill_4
XFILLER_91_237 vssd1 vccd1 vssd1 vccd1 SS_sky130_ef_sc_hd__decap_40_12
XFILLER_17_389 vssd1 vccd1 vccd1 vssd1 SS_sky130_fd_sc_hd__fill_2
XFILLER_44_153 vssd1 vccd1 vssd1 vccd1 SS_sky130_ef_sc_hd__decap_40_12
XFILLER_45_665 vssd1 vccd1 vccd1 vssd1 SS_sky130_fd_sc_hd__fill_4
XTAP_TAPCELL_ROW_86_1588 vccd1 vssd1 SS_sky130_fd_sc_hd__tapvpwrvgnd_1
XTAP_TAPCELL_ROW_15_524 vccd1 vssd1 SS_sky130_fd_sc_hd__tapvpwrvgnd_1
XFILLER_44_197 vssd1 vccd1 vssd1 vccd1 SS_sky130_ef_sc_hd__decap_40_12
XFILLER_60_635 vssd1 vccd1 vccd1 vssd1 SS_sky130_fd_sc_hd__fill_4
XFILLER_13_573 vssd1 vccd1 vssd1 vccd1 SS_sky130_ef_sc_hd__decap_40_12
XFILLER_118_409 vssd1 vccd1 vccd1 vssd1 SS_sky130_fd_sc_hd__fill_2
XTAP_TAPCELL_ROW_117_2054 vccd1 vssd1 SS_sky130_fd_sc_hd__tapvpwrvgnd_1
XFILLER_5_783 vccd1 vssd1 vccd1 vssd1 SS_sky130_fd_sc_hd__fill_1
XTAP_TAPCELL_ROW_130_2243 vccd1 vssd1 SS_sky130_fd_sc_hd__tapvpwrvgnd_1
X_1521_ _1521_/Q _1727_/CLK _1521_/D vccd1 vssd1 vccd1 vssd1 SS_sky130_fd_sc_hd__dfxtp_2
XTAP_TAPCELL_ROW_130_2254 vccd1 vssd1 SS_sky130_fd_sc_hd__tapvpwrvgnd_1
XFILLER_113_125 vssd1 vccd1 vssd1 vccd1 SS_sky130_ef_sc_hd__decap_40_12
XFILLER_99_337 vssd1 vccd1 vssd1 vccd1 SS_sky130_ef_sc_hd__decap_40_12
X_1452_ vccd1 vssd1 vccd1 vssd1 _1452_/X _1752_/Q _1466_/B SS_sky130_fd_sc_hd__or2_2
XFILLER_113_169 vssd1 vccd1 vssd1 vccd1 SS_sky130_ef_sc_hd__decap_40_12
XFILLER_67_223 vccd1 vssd1 vccd1 vssd1 SS_sky130_fd_sc_hd__fill_1
XFILLER_68_757 vssd1 vccd1 vssd1 vccd1 SS_sky130_ef_sc_hd__decap_40_12
XFILLER_122_681 vssd1 vccd1 vssd1 vccd1 SS_sky130_ef_sc_hd__decap_40_12
X_1383_ vssd1 vccd1 vccd1 vssd1 _1397_/A2 input30/X _1718_/D _1461_/C1 _1382_/X SS_sky130_fd_sc_hd__o211a_2
XFILLER_27_109 vssd1 vccd1 vccd1 vssd1 SS_sky130_fd_sc_hd__fill_2
XFILLER_36_621 vssd1 vccd1 vssd1 vccd1 SS_sky130_ef_sc_hd__decap_40_12
XFILLER_76_790 vssd1 vccd1 vccd1 vssd1 SS_sky130_fd_sc_hd__fill_8
XFILLER_83_727 vccd1 vssd1 vccd1 vssd1 SS_sky130_fd_sc_hd__fill_1
XFILLER_51_613 vssd1 vccd1 vccd1 vssd1 SS_sky130_fd_sc_hd__fill_2
XFILLER_63_473 vssd1 vccd1 vssd1 vccd1 SS_sky130_ef_sc_hd__decap_40_12
XFILLER_23_337 vssd1 vccd1 vssd1 vccd1 SS_sky130_ef_sc_hd__decap_40_12
XTAP_TAPCELL_ROW_34_811 vccd1 vssd1 SS_sky130_fd_sc_hd__tapvpwrvgnd_1
XFILLER_51_635 vccd1 vssd1 vccd1 vssd1 SS_sky130_fd_sc_hd__fill_1
XFILLER_51_657 vssd1 vccd1 vccd1 vssd1 SS_sky130_fd_sc_hd__fill_2
XFILLER_50_189 vssd1 vccd1 vccd1 vssd1 SS_sky130_fd_sc_hd__fill_4
XFILLER_137_729 vssd1 vccd1 vccd1 vssd1 SS_sky130_fd_sc_hd__fill_8
XFILLER_3_709 vssd1 vccd1 vssd1 vccd1 SS_sky130_ef_sc_hd__decap_40_12
XFILLER_117_453 vccd1 vssd1 vccd1 vssd1 SS_sky130_fd_sc_hd__fill_1
X_1719_ _1719_/Q clkload4/A _1719_/D vccd1 vssd1 vccd1 vssd1 SS_sky130_fd_sc_hd__dfxtp_2
XFILLER_117_464 vccd1 vssd1 vccd1 vssd1 SS_sky130_fd_sc_hd__fill_1
XTAP_TAPCELL_ROW_57_1156 vccd1 vssd1 SS_sky130_fd_sc_hd__tapvpwrvgnd_1
XFILLER_132_434 vssd1 vccd1 vssd1 vccd1 SS_sky130_ef_sc_hd__decap_40_12
XTAP_TAPCELL_ROW_70_1345 vccd1 vssd1 SS_sky130_fd_sc_hd__tapvpwrvgnd_1
XTAP_TAPCELL_ROW_70_1356 vccd1 vssd1 SS_sky130_fd_sc_hd__tapvpwrvgnd_1
XFILLER_58_245 vssd1 vccd1 vccd1 vssd1 SS_sky130_fd_sc_hd__fill_4
XFILLER_74_705 vssd1 vccd1 vccd1 vssd1 SS_sky130_fd_sc_hd__fill_2
XFILLER_86_576 vssd1 vccd1 vssd1 vccd1 SS_sky130_ef_sc_hd__decap_40_12
XFILLER_18_109 vssd1 vccd1 vssd1 vccd1 SS_sky130_ef_sc_hd__decap_40_12
XFILLER_46_418 vssd1 vccd1 vccd1 vssd1 SS_sky130_fd_sc_hd__fill_2
XFILLER_58_289 vssd1 vccd1 vssd1 vccd1 SS_sky130_ef_sc_hd__decap_40_12
XFILLER_74_727 vssd1 vccd1 vccd1 vssd1 SS_sky130_fd_sc_hd__fill_8
XFILLER_39_492 vssd1 vccd1 vssd1 vccd1 SS_sky130_ef_sc_hd__decap_40_12
XFILLER_73_237 vssd1 vccd1 vssd1 vccd1 SS_sky130_ef_sc_hd__decap_40_12
XFILLER_92_27 vccd1 vssd1 vccd1 vssd1 SS_sky130_fd_sc_hd__fill_1
XFILLER_26_153 vssd1 vccd1 vssd1 vccd1 SS_sky130_ef_sc_hd__decap_40_12
XFILLER_27_665 vssd1 vccd1 vccd1 vssd1 SS_sky130_fd_sc_hd__fill_4
XFILLER_42_613 vssd1 vccd1 vssd1 vccd1 SS_sky130_ef_sc_hd__decap_40_12
XFILLER_54_473 vssd1 vccd1 vccd1 vssd1 SS_sky130_fd_sc_hd__fill_2
XFILLER_26_197 vssd1 vccd1 vssd1 vccd1 SS_sky130_ef_sc_hd__decap_40_12
XFILLER_81_281 vssd1 vccd1 vssd1 vccd1 SS_sky130_ef_sc_hd__decap_40_12
XFILLER_42_668 vssd1 vccd1 vssd1 vccd1 SS_sky130_ef_sc_hd__decap_40_12
XFILLER_41_167 vccd1 vssd1 vccd1 vssd1 SS_sky130_fd_sc_hd__fill_1
XFILLER_6_525 vssd1 vccd1 vccd1 vssd1 SS_sky130_fd_sc_hd__fill_4
XFILLER_10_587 vccd1 vssd1 vccd1 vssd1 SS_sky130_fd_sc_hd__fill_1
XFILLER_41_42 vssd1 vccd1 vssd1 vccd1 SS_sky130_ef_sc_hd__decap_40_12
XFILLER_127_217 vssd1 vccd1 vccd1 vssd1 SS_sky130_fd_sc_hd__fill_4
XFILLER_6_569 vssd1 vccd1 vssd1 vccd1 SS_sky130_ef_sc_hd__decap_40_12
XTAP_TAPCELL_ROW_20_593 vccd1 vssd1 SS_sky130_fd_sc_hd__tapvpwrvgnd_1
XFILLER_136_740 vssd1 vccd1 vccd1 vssd1 SS_sky130_fd_sc_hd__fill_2
XFILLER_108_431 vssd1 vccd1 vccd1 vssd1 SS_sky130_fd_sc_hd__fill_8
XFILLER_135_261 vssd1 vccd1 vssd1 vccd1 SS_sky130_ef_sc_hd__decap_40_12
XFILLER_123_423 vccd1 vssd1 vccd1 vssd1 SS_sky130_fd_sc_hd__fill_1
XFILLER_2_753 vssd1 vccd1 vccd1 vssd1 SS_sky130_fd_sc_hd__fill_2
XFILLER_111_629 vssd1 vccd1 vccd1 vssd1 SS_sky130_fd_sc_hd__fill_2
XFILLER_49_223 vccd1 vssd1 vccd1 vssd1 SS_sky130_fd_sc_hd__fill_1
XFILLER_110_139 vccd1 vssd1 vccd1 vssd1 SS_sky130_fd_sc_hd__fill_1
XFILLER_104_681 vssd1 vccd1 vssd1 vccd1 SS_sky130_ef_sc_hd__decap_40_12
XFILLER_37_429 vssd1 vccd1 vssd1 vccd1 SS_sky130_ef_sc_hd__decap_40_12
XFILLER_65_727 vccd1 vssd1 vccd1 vssd1 SS_sky130_fd_sc_hd__fill_1
XTAP_TAPCELL_ROW_88_1617 vccd1 vssd1 SS_sky130_fd_sc_hd__tapvpwrvgnd_1
XFILLER_92_513 vssd1 vccd1 vssd1 vccd1 SS_sky130_ef_sc_hd__decap_40_12
XFILLER_18_643 vccd1 vssd1 vccd1 vssd1 SS_sky130_fd_sc_hd__fill_1
XFILLER_66_83 vccd1 vssd1 vccd1 vssd1 SS_sky130_fd_sc_hd__fill_1
XFILLER_92_557 vssd1 vccd1 vssd1 vccd1 SS_sky130_ef_sc_hd__decap_40_12
XFILLER_33_613 vssd1 vccd1 vccd1 vssd1 SS_sky130_fd_sc_hd__fill_2
XFILLER_60_421 vssd1 vccd1 vssd1 vccd1 SS_sky130_ef_sc_hd__decap_40_12
XFILLER_20_307 vccd1 vssd1 vccd1 vssd1 SS_sky130_fd_sc_hd__fill_1
X_0952_ vccd1 vssd1 vccd1 vssd1 _0952_/X _1833_/A _0988_/B SS_sky130_fd_sc_hd__or2_2
XFILLER_32_189 vssd1 vccd1 vccd1 vssd1 SS_sky130_fd_sc_hd__fill_4
XFILLER_119_729 vssd1 vccd1 vssd1 vccd1 SS_sky130_ef_sc_hd__decap_40_12
XFILLER_9_385 vssd1 vccd1 vccd1 vssd1 SS_sky130_fd_sc_hd__fill_4
X_0883_ vssd1 vccd1 vccd1 vssd1 _0883_/B _0883_/C _0943_/A _0883_/X SS_sky130_fd_sc_hd__or3_2
XTAP_TAPCELL_ROW_99_1779 vccd1 vssd1 SS_sky130_fd_sc_hd__tapvpwrvgnd_1
Xoutput104 vccd1 vssd1 wire340/A _1863_/X vccd1 vssd1 SS_sky130_fd_sc_hd__buf_4
Xoutput115 vccd1 vssd1 wire329/A _1873_/X vccd1 vssd1 SS_sky130_fd_sc_hd__buf_4
XFILLER_114_401 vssd1 vccd1 vssd1 vccd1 SS_sky130_ef_sc_hd__decap_40_12
Xoutput126 vccd1 vssd1 wire318/A _1883_/X vccd1 vssd1 SS_sky130_fd_sc_hd__buf_4
Xoutput137 vccd1 vssd1 wire413/A _1639_/Q vccd1 vssd1 SS_sky130_fd_sc_hd__buf_4
Xoutput148 vccd1 vssd1 wire403/A _1649_/Q vccd1 vssd1 SS_sky130_fd_sc_hd__buf_4
X_1504_ _1504_/Q _1634_/CLK _1504_/D vccd1 vssd1 vccd1 vssd1 SS_sky130_fd_sc_hd__dfxtp_2
Xoutput159 vccd1 vssd1 wire392/A _1660_/Q vccd1 vssd1 SS_sky130_fd_sc_hd__buf_4
XFILLER_88_819 vccd1 vssd1 vccd1 vssd1 SS_sky130_fd_sc_hd__fill_1
XFILLER_114_456 vssd1 vccd1 vccd1 vssd1 SS_sky130_fd_sc_hd__fill_8
XFILLER_99_167 vccd1 vssd1 vccd1 vssd1 SS_sky130_fd_sc_hd__fill_1
X_1435_ vssd1 vccd1 vccd1 vssd1 _1463_/A2 wire499/X _1743_/D _1451_/C1 _1434_/X SS_sky130_fd_sc_hd__o211a_2
XFILLER_114_489 vssd1 vccd1 vssd1 vccd1 SS_sky130_ef_sc_hd__decap_40_12
XTAP_TAPCELL_ROW_110_1957 vccd1 vssd1 SS_sky130_fd_sc_hd__tapvpwrvgnd_1
XTAP_TAPCELL_ROW_110_1946 vccd1 vssd1 SS_sky130_fd_sc_hd__tapvpwrvgnd_1
XTAP_TAPCELL_ROW_52_1075 vccd1 vssd1 SS_sky130_fd_sc_hd__tapvpwrvgnd_1
X_1366_ vccd1 vssd1 vccd1 vssd1 _1366_/X _1366_/A _1396_/B SS_sky130_fd_sc_hd__or2_2
XTAP_TAPCELL_ROW_52_1086 vccd1 vssd1 SS_sky130_fd_sc_hd__tapvpwrvgnd_1
XFILLER_68_587 vccd1 vssd1 vccd1 vssd1 SS_sky130_fd_sc_hd__fill_1
XFILLER_83_513 vccd1 vssd1 vccd1 vssd1 SS_sky130_fd_sc_hd__fill_1
XFILLER_55_237 vssd1 vccd1 vssd1 vccd1 SS_sky130_ef_sc_hd__decap_40_12
X_1297_ vssd1 vccd1 vccd1 vssd1 _1337_/A2 wire494/X _1676_/D _1387_/C1 _1296_/X SS_sky130_fd_sc_hd__o211a_2
XFILLER_83_546 vssd1 vccd1 vssd1 vccd1 SS_sky130_ef_sc_hd__decap_40_12
XFILLER_102_15 vssd1 vccd1 vssd1 vccd1 SS_sky130_ef_sc_hd__decap_40_12
XFILLER_24_613 vssd1 vccd1 vssd1 vccd1 SS_sky130_ef_sc_hd__decap_40_12
XFILLER_24_635 vccd1 vssd1 vccd1 vssd1 SS_sky130_fd_sc_hd__fill_1
XFILLER_36_473 vssd1 vccd1 vccd1 vssd1 SS_sky130_fd_sc_hd__fill_2
XFILLER_63_281 vssd1 vccd1 vssd1 vccd1 SS_sky130_ef_sc_hd__decap_40_12
XFILLER_64_793 vssd1 vccd1 vssd1 vccd1 SS_sky130_ef_sc_hd__decap_40_12
XFILLER_12_819 vccd1 vssd1 vccd1 vssd1 SS_sky130_fd_sc_hd__fill_1
XFILLER_11_329 vssd1 vccd1 vccd1 vssd1 SS_sky130_fd_sc_hd__fill_4
XFILLER_23_167 vccd1 vssd1 vccd1 vssd1 SS_sky130_fd_sc_hd__fill_1
XFILLER_137_537 vssd1 vccd1 vccd1 vssd1 SS_sky130_fd_sc_hd__fill_8
XFILLER_109_217 vssd1 vccd1 vccd1 vssd1 SS_sky130_fd_sc_hd__fill_4
XFILLER_3_517 vssd1 vccd1 vssd1 vccd1 SS_sky130_ef_sc_hd__decap_40_12
XFILLER_124_209 vssd1 vccd1 vssd1 vccd1 SS_sky130_ef_sc_hd__decap_40_12
XFILLER_117_261 vssd1 vccd1 vssd1 vccd1 SS_sky130_ef_sc_hd__decap_40_12
XFILLER_133_721 vssd1 vccd1 vccd1 vssd1 SS_sky130_fd_sc_hd__fill_4
XFILLER_78_307 vccd1 vssd1 vccd1 vssd1 SS_sky130_fd_sc_hd__fill_1
XFILLER_79_819 vccd1 vssd1 vccd1 vssd1 SS_sky130_fd_sc_hd__fill_1
XFILLER_87_27 vssd1 vccd1 vssd1 vccd1 SS_sky130_ef_sc_hd__decap_40_12
XFILLER_132_253 vssd1 vccd1 vssd1 vccd1 SS_sky130_ef_sc_hd__decap_40_12
Xclkbuf_leaf_15_wb_clk_i _1727_/CLK clkbuf_leaf_7_wb_clk_i/A vccd1 vssd1 vssd1 vccd1
+ SS_sky130_fd_sc_hd__clkbuf_8
XFILLER_99_690 vssd1 vccd1 vssd1 vccd1 SS_sky130_ef_sc_hd__decap_40_12
XFILLER_87_841 vccd1 vssd1 vccd1 vssd1 SS_sky130_fd_sc_hd__fill_1
XTAP_TAPCELL_ROW_6_388 vccd1 vssd1 SS_sky130_fd_sc_hd__tapvpwrvgnd_1
XFILLER_19_429 vssd1 vccd1 vssd1 vccd1 SS_sky130_ef_sc_hd__decap_40_12
XFILLER_47_727 vccd1 vssd1 vccd1 vssd1 SS_sky130_fd_sc_hd__fill_1
XFILLER_36_53 vssd1 vccd1 vssd1 vccd1 SS_sky130_ef_sc_hd__decap_40_12
XFILLER_15_613 vssd1 vccd1 vccd1 vssd1 SS_sky130_fd_sc_hd__fill_2
XFILLER_27_473 vssd1 vccd1 vssd1 vccd1 SS_sky130_ef_sc_hd__decap_40_12
XFILLER_36_97 vssd1 vccd1 vssd1 vccd1 SS_sky130_ef_sc_hd__decap_40_12
XFILLER_42_421 vssd1 vccd1 vssd1 vccd1 SS_sky130_ef_sc_hd__decap_40_12
XTAP_TAPCELL_ROW_83_1547 vccd1 vssd1 SS_sky130_fd_sc_hd__tapvpwrvgnd_1
XFILLER_14_189 vssd1 vccd1 vccd1 vssd1 SS_sky130_fd_sc_hd__fill_4
XTAP_TAPCELL_ROW_25_674 vccd1 vssd1 SS_sky130_fd_sc_hd__tapvpwrvgnd_1
XFILLER_52_41 vssd1 vccd1 vssd1 vccd1 SS_sky130_ef_sc_hd__decap_40_12
XFILLER_11_841 vccd1 vssd1 vccd1 vssd1 SS_sky130_fd_sc_hd__fill_1
XFILLER_52_85 vssd1 vccd1 vssd1 vccd1 SS_sky130_ef_sc_hd__decap_40_12
XFILLER_7_823 vccd1 vssd1 vccd1 vssd1 SS_sky130_fd_sc_hd__fill_1
Xinput28 vssd1 vccd1 vccd1 vssd1 input28/A input28/X SS_sky130_fd_sc_hd__clkdlybuf4s25_1
Xinput17 vssd1 vccd1 vccd1 vssd1 input17/A _0755_/C SS_sky130_fd_sc_hd__clkdlybuf4s25_1
XFILLER_6_333 vssd1 vccd1 vssd1 vccd1 SS_sky130_ef_sc_hd__decap_40_12
Xinput39 vssd1 vccd1 vccd1 vssd1 input39/A input39/X SS_sky130_fd_sc_hd__clkdlybuf4s25_1
XTAP_TAPCELL_ROW_114_2013 vccd1 vssd1 SS_sky130_fd_sc_hd__tapvpwrvgnd_1
XFILLER_6_377 vssd1 vccd1 vssd1 vccd1 SS_sky130_ef_sc_hd__decap_40_12
XFILLER_124_754 vssd1 vccd1 vccd1 vssd1 SS_sky130_fd_sc_hd__fill_2
XFILLER_28_6 vssd1 vccd1 vssd1 vccd1 SS_sky130_ef_sc_hd__decap_40_12
X_1220_ vccd1 vssd1 vccd1 vssd1 _1220_/X _1220_/A _1272_/B SS_sky130_fd_sc_hd__or2_2
XFILLER_96_137 vssd1 vccd1 vccd1 vssd1 SS_sky130_fd_sc_hd__fill_2
X_1151_ vssd1 vccd1 vccd1 vssd1 wire233/X input42/X _1605_/D _1151_/C1 _1150_/X SS_sky130_fd_sc_hd__o211a_2
XFILLER_65_502 vssd1 vccd1 vccd1 vssd1 SS_sky130_fd_sc_hd__fill_2
XFILLER_77_93 vssd1 vccd1 vssd1 vccd1 SS_sky130_ef_sc_hd__decap_40_12
XFILLER_37_237 vssd1 vccd1 vssd1 vccd1 SS_sky130_ef_sc_hd__decap_40_12
XFILLER_65_557 vssd1 vccd1 vccd1 vssd1 SS_sky130_fd_sc_hd__fill_2
XFILLER_92_321 vssd1 vccd1 vssd1 vccd1 SS_sky130_ef_sc_hd__decap_40_12
X_1082_ vccd1 vssd1 vccd1 vssd1 _1082_/X _1082_/A _1116_/B SS_sky130_fd_sc_hd__or2_2
XTAP_TAPCELL_ROW_125_2175 vccd1 vssd1 SS_sky130_fd_sc_hd__tapvpwrvgnd_1
XFILLER_92_365 vssd1 vccd1 vssd1 vccd1 SS_sky130_ef_sc_hd__decap_40_12
XFILLER_18_473 vssd1 vccd1 vccd1 vssd1 SS_sky130_fd_sc_hd__fill_2
XFILLER_45_281 vssd1 vccd1 vssd1 vccd1 SS_sky130_ef_sc_hd__decap_40_12
XFILLER_46_793 vssd1 vccd1 vccd1 vssd1 SS_sky130_fd_sc_hd__fill_4
XFILLER_93_81 vssd1 vccd1 vssd1 vccd1 SS_sky130_ef_sc_hd__decap_40_12
XFILLER_61_741 vssd1 vccd1 vccd1 vssd1 SS_sky130_fd_sc_hd__fill_8
XTAP_TAPCELL_ROW_44_961 vccd1 vssd1 SS_sky130_fd_sc_hd__tapvpwrvgnd_1
XFILLER_60_251 vccd1 vssd1 vccd1 vssd1 SS_sky130_fd_sc_hd__fill_1
XFILLER_61_785 vssd1 vccd1 vssd1 vccd1 SS_sky130_ef_sc_hd__decap_40_12
XFILLER_20_137 vssd1 vccd1 vccd1 vssd1 SS_sky130_fd_sc_hd__fill_2
X_0935_ vssd1 vccd1 vssd1 vccd1 hold787/X _1338_/A _0934_/X _0935_/X SS_sky130_fd_sc_hd__a21o_2
XFILLER_9_193 vssd1 vccd1 vssd1 vccd1 SS_sky130_ef_sc_hd__decap_40_12
X_0866_ vccd1 vssd1 vssd1 vccd1 _0862_/X _0865_/X _0878_/A2 hold801/X _1493_/D _1381_/C1
+ SS_sky130_fd_sc_hd__o221a_2
XFILLER_119_559 vccd1 vssd1 vccd1 vssd1 SS_sky130_fd_sc_hd__fill_1
XFILLER_134_518 vssd1 vccd1 vccd1 vssd1 SS_sky130_fd_sc_hd__fill_4
XFILLER_106_209 vssd1 vccd1 vssd1 vccd1 SS_sky130_ef_sc_hd__decap_40_12
X_0797_ vccd1 vssd1 vccd1 vssd1 _1837_/A wire421/X _1870_/A _0876_/B1 _0797_/X SS_sky130_fd_sc_hd__a22o_2
XTAP_TAPCELL_ROW_54_1104 vccd1 vssd1 SS_sky130_fd_sc_hd__tapvpwrvgnd_1
XTAP_TAPCELL_ROW_54_1115 vccd1 vssd1 SS_sky130_fd_sc_hd__tapvpwrvgnd_1
XFILLER_88_605 vssd1 vccd1 vccd1 vssd1 SS_sky130_fd_sc_hd__fill_2
XFILLER_115_765 vssd1 vccd1 vssd1 vccd1 SS_sky130_ef_sc_hd__decap_40_12
XFILLER_114_253 vssd1 vccd1 vssd1 vccd1 SS_sky130_ef_sc_hd__decap_40_12
XFILLER_88_649 vccd1 vssd1 vccd1 vssd1 SS_sky130_fd_sc_hd__fill_1
XFILLER_69_841 vccd1 vssd1 vccd1 vssd1 SS_sky130_fd_sc_hd__fill_1
X_1418_ vccd1 vssd1 vccd1 vssd1 _1418_/X _1899_/A _1466_/B SS_sky130_fd_sc_hd__or2_2
XFILLER_87_137 vssd1 vccd1 vssd1 vccd1 SS_sky130_ef_sc_hd__decap_40_12
XFILLER_130_757 vssd1 vccd1 vssd1 vccd1 SS_sky130_ef_sc_hd__decap_40_12
XFILLER_114_297 vssd1 vccd1 vccd1 vssd1 SS_sky130_fd_sc_hd__fill_2
XFILLER_29_727 vccd1 vssd1 vccd1 vssd1 SS_sky130_fd_sc_hd__fill_1
XFILLER_56_513 vssd1 vccd1 vssd1 vccd1 SS_sky130_ef_sc_hd__decap_40_12
XTAP_TAPCELL_ROW_3_347 vccd1 vssd1 SS_sky130_fd_sc_hd__tapvpwrvgnd_1
XFILLER_29_749 vssd1 vccd1 vssd1 vccd1 SS_sky130_ef_sc_hd__decap_40_12
XFILLER_56_557 vssd1 vccd1 vssd1 vccd1 SS_sky130_ef_sc_hd__decap_40_12
X_1349_ vssd1 vccd1 vccd1 vssd1 _1369_/A2 input42/X _1701_/D _1417_/C1 _1348_/X SS_sky130_fd_sc_hd__o211a_2
XFILLER_95_181 vssd1 vccd1 vssd1 vccd1 SS_sky130_ef_sc_hd__decap_40_12
XFILLER_56_579 vccd1 vssd1 vccd1 vssd1 SS_sky130_fd_sc_hd__fill_1
XFILLER_71_505 vssd1 vccd1 vssd1 vccd1 SS_sky130_ef_sc_hd__decap_40_12
XFILLER_73_18 vssd1 vccd1 vssd1 vccd1 SS_sky130_ef_sc_hd__decap_40_12
XFILLER_113_69 vssd1 vccd1 vssd1 vccd1 SS_sky130_ef_sc_hd__decap_40_12
XFILLER_24_421 vssd1 vccd1 vssd1 vccd1 SS_sky130_ef_sc_hd__decap_40_12
XFILLER_51_273 vssd1 vccd1 vccd1 vssd1 SS_sky130_fd_sc_hd__fill_4
XTAP_TAPCELL_ROW_65_1277 vccd1 vssd1 SS_sky130_fd_sc_hd__tapvpwrvgnd_1
XFILLER_11_137 vssd1 vccd1 vssd1 vccd1 SS_sky130_ef_sc_hd__decap_40_12
XTAP_TAPCELL_ROW_22_633 vccd1 vssd1 SS_sky130_fd_sc_hd__tapvpwrvgnd_1
XFILLER_138_835 vssd1 vccd1 vccd1 vssd1 SS_sky130_fd_sc_hd__fill_4
XFILLER_22_77 vssd1 vccd1 vccd1 vssd1 SS_sky130_fd_sc_hd__fill_4
XFILLER_138_55 vccd1 vssd1 vccd1 vssd1 SS_sky130_fd_sc_hd__fill_1
XFILLER_125_529 vssd1 vccd1 vssd1 vccd1 SS_sky130_ef_sc_hd__decap_40_12
XFILLER_98_26 vssd1 vccd1 vccd1 vssd1 SS_sky130_fd_sc_hd__fill_2
XFILLER_4_837 vssd1 vccd1 vccd1 vssd1 SS_sky130_fd_sc_hd__fill_4
XFILLER_118_581 vssd1 vccd1 vccd1 vssd1 SS_sky130_fd_sc_hd__fill_4
XFILLER_106_754 vssd1 vccd1 vccd1 vssd1 SS_sky130_fd_sc_hd__fill_2
XFILLER_79_649 vssd1 vccd1 vssd1 vccd1 SS_sky130_ef_sc_hd__decap_40_12
XFILLER_133_573 vssd1 vccd1 vssd1 vccd1 SS_sky130_ef_sc_hd__decap_40_12
XFILLER_78_137 vssd1 vccd1 vccd1 vssd1 SS_sky130_fd_sc_hd__fill_2
XFILLER_121_768 vssd1 vccd1 vssd1 vccd1 SS_sky130_ef_sc_hd__decap_40_12
XFILLER_120_245 vssd1 vccd1 vccd1 vssd1 SS_sky130_fd_sc_hd__fill_4
XFILLER_47_502 vssd1 vccd1 vccd1 vssd1 SS_sky130_fd_sc_hd__fill_2
XFILLER_59_373 vccd1 vssd1 vccd1 vssd1 SS_sky130_fd_sc_hd__fill_1
XFILLER_120_289 vssd1 vccd1 vccd1 vssd1 SS_sky130_fd_sc_hd__fill_4
XFILLER_19_237 vssd1 vccd1 vssd1 vccd1 SS_sky130_ef_sc_hd__decap_40_12
XFILLER_74_321 vssd1 vccd1 vssd1 vccd1 SS_sky130_ef_sc_hd__decap_40_12
XFILLER_35_708 vssd1 vccd1 vssd1 vccd1 SS_sky130_ef_sc_hd__decap_40_12
XFILLER_62_505 vssd1 vccd1 vssd1 vccd1 SS_sky130_ef_sc_hd__decap_40_12
XFILLER_74_365 vssd1 vccd1 vssd1 vccd1 SS_sky130_ef_sc_hd__decap_40_12
XFILLER_28_793 vssd1 vccd1 vssd1 vccd1 SS_sky130_ef_sc_hd__decap_40_12
XFILLER_27_281 vssd1 vccd1 vssd1 vccd1 SS_sky130_ef_sc_hd__decap_40_12
XFILLER_30_413 vssd1 vccd1 vccd1 vssd1 SS_sky130_fd_sc_hd__fill_4
XFILLER_42_251 vccd1 vssd1 vccd1 vssd1 SS_sky130_fd_sc_hd__fill_1
XFILLER_43_785 vssd1 vccd1 vssd1 vccd1 SS_sky130_ef_sc_hd__decap_40_12
XTAP_TAPCELL_ROW_41_920 vccd1 vssd1 SS_sky130_fd_sc_hd__tapvpwrvgnd_1
XTAP_TAPCELL_ROW_120_2094 vccd1 vssd1 SS_sky130_fd_sc_hd__tapvpwrvgnd_1
XFILLER_30_457 vssd1 vccd1 vssd1 vccd1 SS_sky130_ef_sc_hd__decap_40_12
XFILLER_11_671 vccd1 vssd1 vccd1 vssd1 SS_sky130_fd_sc_hd__fill_1
XFILLER_6_141 vssd1 vccd1 vssd1 vccd1 SS_sky130_ef_sc_hd__decap_40_12
XFILLER_7_653 vssd1 vccd1 vssd1 vccd1 SS_sky130_ef_sc_hd__decap_40_12
XFILLER_128_378 vssd1 vccd1 vccd1 vssd1 SS_sky130_fd_sc_hd__fill_8
Xhold609 _1672_/D _1289_/X vccd1 vssd1 vssd1 vccd1 SS_sky130_fd_sc_hd__dlygate4sd3_1
XTAP_TAPCELL_ROW_96_1738 vccd1 vssd1 SS_sky130_fd_sc_hd__tapvpwrvgnd_1
XFILLER_7_697 vssd1 vccd1 vssd1 vccd1 SS_sky130_ef_sc_hd__decap_40_12
XFILLER_88_81 vssd1 vccd1 vccd1 vssd1 SS_sky130_fd_sc_hd__fill_2
XFILLER_112_713 vssd1 vccd1 vccd1 vssd1 SS_sky130_fd_sc_hd__fill_4
XFILLER_69_137 vssd1 vccd1 vssd1 vccd1 SS_sky130_ef_sc_hd__decap_40_12
XTAP_TAPCELL_ROW_127_2204 vccd1 vssd1 SS_sky130_fd_sc_hd__tapvpwrvgnd_1
XFILLER_112_757 vssd1 vccd1 vssd1 vccd1 SS_sky130_ef_sc_hd__decap_40_12
XFILLER_111_223 vccd1 vssd1 vccd1 vssd1 SS_sky130_fd_sc_hd__fill_1
XFILLER_38_513 vssd1 vccd1 vccd1 vssd1 SS_sky130_fd_sc_hd__fill_2
XFILLER_78_671 vssd1 vccd1 vssd1 vccd1 SS_sky130_ef_sc_hd__decap_40_12
X_1203_ vssd1 vccd1 vccd1 vssd1 _1209_/A2 input40/X _1631_/D _1401_/C1 _1202_/X SS_sky130_fd_sc_hd__o211a_2
XFILLER_77_181 vssd1 vccd1 vssd1 vccd1 SS_sky130_ef_sc_hd__decap_40_12
XPHY_EDGE_ROW_108_Left_247 vccd1 vssd1 vccd1 vssd1 SS_sky130_fd_sc_hd__decap_3
XTAP_TAPCELL_ROW_0_306 vccd1 vssd1 SS_sky130_fd_sc_hd__tapvpwrvgnd_1
XFILLER_38_557 vssd1 vccd1 vssd1 vccd1 SS_sky130_ef_sc_hd__decap_40_12
X_1134_ vccd1 vssd1 vccd1 vssd1 _1134_/X _1134_/A _1140_/B SS_sky130_fd_sc_hd__or2_2
XFILLER_19_793 vccd1 vssd1 vccd1 vssd1 SS_sky130_fd_sc_hd__fill_1
X_1065_ vssd1 vccd1 vccd1 vssd1 _1065_/A2 input37/X _1564_/D _1329_/C1 _1064_/X SS_sky130_fd_sc_hd__o211a_2
XFILLER_93_685 vssd1 vccd1 vssd1 vccd1 SS_sky130_ef_sc_hd__decap_40_12
XFILLER_92_195 vccd1 vssd1 vccd1 vssd1 SS_sky130_fd_sc_hd__fill_1
XFILLER_34_774 vssd1 vccd1 vssd1 vccd1 SS_sky130_ef_sc_hd__decap_40_12
XTAP_TAPCELL_ROW_105_1878 vccd1 vssd1 SS_sky130_fd_sc_hd__tapvpwrvgnd_1
XFILLER_33_273 vssd1 vccd1 vccd1 vssd1 SS_sky130_fd_sc_hd__fill_4
XTAP_TAPCELL_ROW_138_2366 vccd1 vssd1 SS_sky130_fd_sc_hd__tapvpwrvgnd_1
XPHY_EDGE_ROW_117_Left_256 vccd1 vssd1 vccd1 vssd1 SS_sky130_fd_sc_hd__decap_3
XTAP_TAPCELL_ROW_138_2377 vccd1 vssd1 SS_sky130_fd_sc_hd__tapvpwrvgnd_1
XTAP_TAPCELL_ROW_138_2388 vccd1 vssd1 SS_sky130_fd_sc_hd__tapvpwrvgnd_1
XTAP_TAPCELL_ROW_60_1196 vccd1 vssd1 SS_sky130_fd_sc_hd__tapvpwrvgnd_1
X_1898_ vccd1 vssd1 _1898_/X _1898_/A vccd1 vssd1 SS_sky130_fd_sc_hd__buf_2
XFILLER_135_805 vssd1 vccd1 vccd1 vssd1 SS_sky130_fd_sc_hd__fill_2
X_0918_ vccd1 vssd1 vccd1 vssd1 _1662_/Q _0748_/X _1630_/Q _0927_/A2 _0919_/C SS_sky130_fd_sc_hd__a22o_2
X_0849_ vccd1 vssd1 vccd1 vssd1 _1747_/Q _0874_/A2 _1619_/Q _1145_/A _0849_/X SS_sky130_fd_sc_hd__a22o_2
XTAP_TAPCELL_ROW_8_417 vccd1 vssd1 SS_sky130_fd_sc_hd__tapvpwrvgnd_1
XFILLER_68_18 vssd1 vccd1 vccd1 vssd1 SS_sky130_fd_sc_hd__fill_8
XFILLER_68_29 vssd1 vccd1 vssd1 vccd1 SS_sky130_ef_sc_hd__decap_40_12
XFILLER_115_573 vssd1 vccd1 vccd1 vssd1 SS_sky130_fd_sc_hd__fill_8
XFILLER_88_457 vssd1 vccd1 vssd1 vccd1 SS_sky130_ef_sc_hd__decap_40_12
XFILLER_102_245 vssd1 vccd1 vccd1 vssd1 SS_sky130_fd_sc_hd__fill_4
XFILLER_69_671 vccd1 vssd1 vccd1 vssd1 SS_sky130_fd_sc_hd__fill_1
XPHY_EDGE_ROW_126_Left_265 vccd1 vssd1 vccd1 vssd1 SS_sky130_fd_sc_hd__decap_3
XFILLER_56_321 vssd1 vccd1 vccd1 vssd1 SS_sky130_fd_sc_hd__fill_8
XFILLER_102_289 vssd1 vccd1 vssd1 vccd1 SS_sky130_ef_sc_hd__decap_40_12
XFILLER_29_557 vssd1 vccd1 vccd1 vssd1 SS_sky130_fd_sc_hd__fill_2
XFILLER_56_365 vssd1 vccd1 vssd1 vccd1 SS_sky130_ef_sc_hd__decap_40_12
XTAP_TAPCELL_ROW_67_1306 vccd1 vssd1 SS_sky130_fd_sc_hd__tapvpwrvgnd_1
XFILLER_17_55 vccd1 vssd1 vccd1 vssd1 SS_sky130_fd_sc_hd__fill_1
XTAP_TAPCELL_ROW_27_703 vccd1 vssd1 SS_sky130_fd_sc_hd__tapvpwrvgnd_1
XFILLER_71_357 vssd1 vccd1 vssd1 vccd1 SS_sky130_ef_sc_hd__decap_40_12
XFILLER_24_251 vccd1 vssd1 vccd1 vssd1 SS_sky130_fd_sc_hd__fill_1
XFILLER_25_785 vssd1 vccd1 vssd1 vccd1 SS_sky130_ef_sc_hd__decap_40_12
XFILLER_71_379 vccd1 vssd1 vccd1 vssd1 SS_sky130_fd_sc_hd__fill_1
XTAP_TAPCELL_ROW_80_1506 vccd1 vssd1 SS_sky130_fd_sc_hd__tapvpwrvgnd_1
XFILLER_12_413 vssd1 vccd1 vccd1 vssd1 SS_sky130_fd_sc_hd__fill_4
XFILLER_40_733 vssd1 vccd1 vssd1 vccd1 SS_sky130_ef_sc_hd__decap_40_12
XFILLER_40_755 vccd1 vssd1 vccd1 vssd1 SS_sky130_fd_sc_hd__fill_1
XPHY_EDGE_ROW_135_Left_274 vccd1 vssd1 vccd1 vssd1 SS_sky130_fd_sc_hd__decap_3
XFILLER_8_417 vssd1 vccd1 vccd1 vssd1 SS_sky130_fd_sc_hd__fill_2
XFILLER_12_457 vssd1 vccd1 vssd1 vccd1 SS_sky130_ef_sc_hd__decap_40_12
XFILLER_33_54 vssd1 vccd1 vccd1 vssd1 SS_sky130_fd_sc_hd__fill_2
XFILLER_129_109 vssd1 vccd1 vccd1 vssd1 SS_sky130_fd_sc_hd__fill_2
XFILLER_130_3 vssd1 vccd1 vssd1 vccd1 SS_sky130_ef_sc_hd__decap_40_12
XFILLER_138_643 vccd1 vssd1 vccd1 vssd1 SS_sky130_fd_sc_hd__fill_1
XFILLER_4_601 vssd1 vccd1 vssd1 vccd1 SS_sky130_ef_sc_hd__decap_40_12
XFILLER_3_111 vccd1 vssd1 vccd1 vssd1 SS_sky130_fd_sc_hd__fill_1
Xclkbuf_leaf_30_wb_clk_i _1610_/CLK clkload1/A vccd1 vssd1 vssd1 vccd1 SS_sky130_fd_sc_hd__clkbuf_8
XTAP_TAPCELL_ROW_78_1468 vccd1 vssd1 SS_sky130_fd_sc_hd__tapvpwrvgnd_1
XFILLER_125_337 vssd1 vccd1 vccd1 vssd1 SS_sky130_fd_sc_hd__fill_4
XFILLER_4_645 vssd1 vccd1 vssd1 vccd1 SS_sky130_ef_sc_hd__decap_40_12
XFILLER_79_413 vssd1 vccd1 vssd1 vccd1 SS_sky130_ef_sc_hd__decap_40_12
XTAP_TAPCELL_ROW_91_1668 vccd1 vssd1 SS_sky130_fd_sc_hd__tapvpwrvgnd_1
XFILLER_48_811 vccd1 vssd1 vccd1 vssd1 SS_sky130_fd_sc_hd__fill_1
XFILLER_121_565 vssd1 vccd1 vccd1 vssd1 SS_sky130_fd_sc_hd__fill_2
XFILLER_59_181 vssd1 vccd1 vssd1 vccd1 SS_sky130_ef_sc_hd__decap_40_12
XFILLER_35_505 vssd1 vccd1 vssd1 vccd1 SS_sky130_ef_sc_hd__decap_40_12
XFILLER_75_641 vssd1 vccd1 vssd1 vccd1 SS_sky130_ef_sc_hd__decap_40_12
XTAP_TAPCELL_ROW_122_2134 vccd1 vssd1 SS_sky130_fd_sc_hd__tapvpwrvgnd_1
XTAP_TAPCELL_ROW_122_2123 vccd1 vssd1 SS_sky130_fd_sc_hd__tapvpwrvgnd_1
XFILLER_74_83 vccd1 vssd1 vccd1 vssd1 SS_sky130_fd_sc_hd__fill_1
XFILLER_74_195 vccd1 vssd1 vccd1 vssd1 SS_sky130_fd_sc_hd__fill_1
XFILLER_31_700 vssd1 vccd1 vssd1 vccd1 SS_sky130_ef_sc_hd__decap_40_12
XFILLER_50_519 vssd1 vccd1 vssd1 vccd1 SS_sky130_ef_sc_hd__decap_40_12
XFILLER_15_273 vssd1 vccd1 vccd1 vssd1 SS_sky130_fd_sc_hd__fill_4
XFILLER_30_221 vssd1 vccd1 vssd1 vccd1 SS_sky130_ef_sc_hd__decap_40_12
XFILLER_43_593 vssd1 vccd1 vssd1 vccd1 SS_sky130_ef_sc_hd__decap_40_12
XFILLER_31_766 vssd1 vccd1 vssd1 vccd1 SS_sky130_ef_sc_hd__decap_40_12
XFILLER_129_610 vssd1 vccd1 vccd1 vssd1 SS_sky130_fd_sc_hd__fill_4
XFILLER_30_265 vssd1 vccd1 vssd1 vccd1 SS_sky130_ef_sc_hd__decap_40_12
XTAP_TAPCELL_ROW_13_496 vccd1 vssd1 SS_sky130_fd_sc_hd__tapvpwrvgnd_1
XFILLER_128_153 vssd1 vccd1 vssd1 vccd1 SS_sky130_ef_sc_hd__decap_40_12
XTAP_TAPCELL_ROW_100_1797 vccd1 vssd1 SS_sky130_fd_sc_hd__tapvpwrvgnd_1
X_1752_ _1752_/Q _1752_/CLK _1752_/D vccd1 vssd1 vccd1 vssd1 SS_sky130_fd_sc_hd__dfxtp_2
XFILLER_7_461 vssd1 vccd1 vssd1 vccd1 SS_sky130_ef_sc_hd__decap_40_12
XFILLER_128_197 vssd1 vccd1 vssd1 vccd1 SS_sky130_ef_sc_hd__decap_40_12
Xwire381 vccd1 vssd1 vssd1 vccd1 wire381/A wbs_dat_o[12] SS_sky130_fd_sc_hd__buf_12
Xwire370 vccd1 vssd1 vssd1 vccd1 wire370/A wbs_dat_o[22] SS_sky130_fd_sc_hd__buf_12
Xwire392 vccd1 vssd1 vssd1 vccd1 wire392/A analog_ctrl[89] SS_sky130_fd_sc_hd__buf_12
X_1683_ _1683_/Q _1747_/CLK _1683_/D vccd1 vssd1 vccd1 vssd1 SS_sky130_fd_sc_hd__dfxtp_2
XTAP_TAPCELL_ROW_133_2296 vccd1 vssd1 SS_sky130_fd_sc_hd__tapvpwrvgnd_1
XFILLER_132_819 vccd1 vssd1 vccd1 vssd1 SS_sky130_fd_sc_hd__fill_1
XFILLER_112_543 vccd1 vssd1 vccd1 vssd1 SS_sky130_fd_sc_hd__fill_1
XFILLER_112_521 vccd1 vssd1 vccd1 vssd1 SS_sky130_fd_sc_hd__fill_1
XFILLER_97_221 vssd1 vccd1 vccd1 vssd1 SS_sky130_fd_sc_hd__fill_2
XFILLER_85_405 vssd1 vccd1 vssd1 vccd1 SS_sky130_ef_sc_hd__decap_40_12
XFILLER_112_576 vssd1 vccd1 vccd1 vssd1 SS_sky130_fd_sc_hd__fill_4
XFILLER_38_321 vssd1 vccd1 vssd1 vccd1 SS_sky130_ef_sc_hd__decap_40_12
XFILLER_85_449 vssd1 vccd1 vssd1 vccd1 SS_sky130_ef_sc_hd__decap_40_12
XTAP_TAPCELL_ROW_107_1907 vccd1 vssd1 SS_sky130_fd_sc_hd__tapvpwrvgnd_1
XFILLER_38_365 vssd1 vccd1 vssd1 vccd1 SS_sky130_ef_sc_hd__decap_40_12
X_1117_ vssd1 vccd1 vccd1 vssd1 wire239/A input29/X _1589_/D _1425_/C1 _1116_/X SS_sky130_fd_sc_hd__o211a_2
XTAP_TAPCELL_ROW_49_1036 vccd1 vssd1 SS_sky130_fd_sc_hd__tapvpwrvgnd_1
XFILLER_53_335 vccd1 vssd1 vccd1 vssd1 SS_sky130_fd_sc_hd__fill_1
XFILLER_80_121 vssd1 vccd1 vssd1 vccd1 SS_sky130_ef_sc_hd__decap_40_12
X_1048_ vccd1 vssd1 vccd1 vssd1 _1048_/X _1048_/A _1050_/B SS_sky130_fd_sc_hd__or2_2
XFILLER_80_165 vssd1 vccd1 vssd1 vccd1 SS_sky130_ef_sc_hd__decap_40_12
XFILLER_81_677 vssd1 vccd1 vccd1 vssd1 SS_sky130_fd_sc_hd__fill_2
XFILLER_81_688 vssd1 vccd1 vccd1 vssd1 SS_sky130_fd_sc_hd__fill_2
XFILLER_110_15 vssd1 vccd1 vssd1 vccd1 SS_sky130_ef_sc_hd__decap_40_12
XFILLER_21_221 vssd1 vccd1 vccd1 vssd1 SS_sky130_fd_sc_hd__fill_2
XFILLER_61_390 vssd1 vccd1 vccd1 vssd1 SS_sky130_fd_sc_hd__fill_2
XTAP_TAPCELL_ROW_62_1225 vccd1 vssd1 SS_sky130_fd_sc_hd__tapvpwrvgnd_1
XTAP_TAPCELL_ROW_62_1236 vccd1 vssd1 SS_sky130_fd_sc_hd__tapvpwrvgnd_1
XPHY_EDGE_ROW_3_Right_3 vccd1 vssd1 vccd1 vssd1 SS_sky130_fd_sc_hd__decap_3
XFILLER_22_755 vccd1 vssd1 vccd1 vssd1 SS_sky130_fd_sc_hd__fill_1
XFILLER_22_777 vccd1 vssd1 vccd1 vssd1 SS_sky130_fd_sc_hd__fill_1
XTAP_TAPCELL_ROW_32_783 vccd1 vssd1 SS_sky130_fd_sc_hd__tapvpwrvgnd_1
XFILLER_119_57 vssd1 vccd1 vssd1 vccd1 SS_sky130_ef_sc_hd__decap_40_12
XFILLER_107_337 vssd1 vccd1 vssd1 vccd1 SS_sky130_ef_sc_hd__decap_40_12
XFILLER_79_39 vssd1 vccd1 vssd1 vccd1 SS_sky130_ef_sc_hd__decap_40_12
XFILLER_1_615 vccd1 vssd1 vccd1 vssd1 SS_sky130_fd_sc_hd__fill_1
XFILLER_134_189 vssd1 vccd1 vccd1 vssd1 SS_sky130_fd_sc_hd__fill_4
XFILLER_135_23 vccd1 vssd1 vccd1 vssd1 SS_sky130_fd_sc_hd__fill_1
XFILLER_0_125 vssd1 vccd1 vssd1 vccd1 SS_sky130_ef_sc_hd__decap_40_12
XFILLER_88_221 vssd1 vccd1 vssd1 vccd1 SS_sky130_ef_sc_hd__decap_40_12
XFILLER_131_841 vccd1 vssd1 vccd1 vssd1 SS_sky130_fd_sc_hd__fill_1
XFILLER_0_169 vssd1 vccd1 vssd1 vccd1 SS_sky130_ef_sc_hd__decap_40_12
XTAP_TAPCELL_ROW_73_1398 vccd1 vssd1 SS_sky130_fd_sc_hd__tapvpwrvgnd_1
XFILLER_88_265 vssd1 vccd1 vssd1 vccd1 SS_sky130_ef_sc_hd__decap_40_12
XFILLER_89_777 vssd1 vccd1 vccd1 vssd1 SS_sky130_fd_sc_hd__fill_4
XFILLER_103_565 vssd1 vccd1 vccd1 vssd1 SS_sky130_fd_sc_hd__fill_2
XFILLER_95_27 vssd1 vccd1 vssd1 vccd1 SS_sky130_ef_sc_hd__decap_40_12
XFILLER_28_65 vssd1 vccd1 vssd1 vccd1 SS_sky130_ef_sc_hd__decap_40_12
XFILLER_45_803 vccd1 vssd1 vccd1 vssd1 SS_sky130_fd_sc_hd__fill_1
XFILLER_57_641 vssd1 vccd1 vssd1 vccd1 SS_sky130_ef_sc_hd__decap_40_12
XFILLER_17_505 vssd1 vccd1 vssd1 vccd1 SS_sky130_ef_sc_hd__decap_40_12
XFILLER_57_685 vssd1 vccd1 vssd1 vccd1 SS_sky130_ef_sc_hd__decap_40_12
XFILLER_44_357 vssd1 vccd1 vccd1 vssd1 SS_sky130_fd_sc_hd__fill_4
XFILLER_56_195 vccd1 vssd1 vccd1 vssd1 SS_sky130_fd_sc_hd__fill_1
XFILLER_44_53 vssd1 vccd1 vssd1 vccd1 SS_sky130_ef_sc_hd__decap_40_12
XFILLER_71_165 vssd1 vccd1 vccd1 vssd1 SS_sky130_fd_sc_hd__fill_2
XFILLER_12_221 vssd1 vccd1 vssd1 vccd1 SS_sky130_ef_sc_hd__decap_40_12
XFILLER_44_97 vssd1 vccd1 vssd1 vccd1 SS_sky130_ef_sc_hd__decap_40_12
XFILLER_12_265 vssd1 vccd1 vssd1 vccd1 SS_sky130_ef_sc_hd__decap_40_12
XFILLER_40_585 vssd1 vccd1 vccd1 vssd1 SS_sky130_fd_sc_hd__fill_2
XFILLER_100_81 vssd1 vccd1 vccd1 vssd1 SS_sky130_fd_sc_hd__fill_2
XFILLER_60_41 vssd1 vccd1 vssd1 vccd1 SS_sky130_ef_sc_hd__decap_40_12
XTAP_TAPCELL_ROW_10_444 vccd1 vssd1 SS_sky130_fd_sc_hd__tapvpwrvgnd_1
XTAP_TAPCELL_ROW_10_455 vccd1 vssd1 SS_sky130_fd_sc_hd__tapvpwrvgnd_1
XFILLER_60_85 vssd1 vccd1 vssd1 vccd1 SS_sky130_ef_sc_hd__decap_40_12
XFILLER_126_613 vssd1 vccd1 vccd1 vssd1 SS_sky130_fd_sc_hd__fill_8
XFILLER_99_519 vccd1 vssd1 vccd1 vssd1 SS_sky130_fd_sc_hd__fill_1
XFILLER_4_475 vccd1 vssd1 vccd1 vssd1 SS_sky130_fd_sc_hd__fill_1
XFILLER_5_69 vssd1 vccd1 vssd1 vccd1 SS_sky130_ef_sc_hd__decap_40_12
XFILLER_125_167 vccd1 vssd1 vccd1 vssd1 SS_sky130_fd_sc_hd__fill_1
XFILLER_79_221 vssd1 vccd1 vccd1 vssd1 SS_sky130_fd_sc_hd__fill_2
XFILLER_134_690 vssd1 vccd1 vccd1 vssd1 SS_sky130_fd_sc_hd__fill_8
XFILLER_95_725 vssd1 vccd1 vccd1 vssd1 SS_sky130_fd_sc_hd__fill_2
XFILLER_67_449 vssd1 vccd1 vssd1 vccd1 SS_sky130_ef_sc_hd__decap_40_12
XFILLER_82_419 vccd1 vssd1 vccd1 vssd1 SS_sky130_fd_sc_hd__fill_1
XFILLER_85_93 vssd1 vccd1 vssd1 vccd1 SS_sky130_ef_sc_hd__decap_40_12
XFILLER_35_335 vccd1 vssd1 vccd1 vssd1 SS_sky130_fd_sc_hd__fill_1
XFILLER_62_121 vssd1 vccd1 vssd1 vccd1 SS_sky130_ef_sc_hd__decap_40_12
XTAP_TAPCELL_ROW_18_566 vccd1 vssd1 SS_sky130_fd_sc_hd__tapvpwrvgnd_1
XTAP_TAPCELL_ROW_18_577 vccd1 vssd1 SS_sky130_fd_sc_hd__tapvpwrvgnd_1
XFILLER_50_305 vssd1 vccd1 vccd1 vssd1 SS_sky130_fd_sc_hd__fill_2
XFILLER_62_165 vssd1 vccd1 vssd1 vccd1 SS_sky130_ef_sc_hd__decap_40_12
XFILLER_90_485 vssd1 vccd1 vssd1 vccd1 SS_sky130_ef_sc_hd__decap_40_12
XTAP_TAPCELL_ROW_102_1837 vccd1 vssd1 SS_sky130_fd_sc_hd__tapvpwrvgnd_1
XTAP_TAPCELL_ROW_102_1826 vccd1 vssd1 SS_sky130_fd_sc_hd__tapvpwrvgnd_1
XFILLER_31_541 vssd1 vccd1 vssd1 vccd1 SS_sky130_ef_sc_hd__decap_40_12
XFILLER_31_585 vccd1 vssd1 vccd1 vssd1 SS_sky130_fd_sc_hd__fill_1
XTAP_TAPCELL_ROW_135_2325 vccd1 vssd1 SS_sky130_fd_sc_hd__tapvpwrvgnd_1
XFILLER_8_781 vssd1 vccd1 vssd1 vccd1 SS_sky130_ef_sc_hd__decap_40_12
X_1735_ _1899_/A clkload6/A _1735_/D vccd1 vssd1 vccd1 vssd1 SS_sky130_fd_sc_hd__dfxtp_2
XFILLER_129_473 vssd1 vccd1 vssd1 vccd1 SS_sky130_ef_sc_hd__decap_40_12
XFILLER_117_613 vssd1 vccd1 vccd1 vssd1 SS_sky130_fd_sc_hd__fill_2
XFILLER_117_646 vssd1 vccd1 vssd1 vccd1 SS_sky130_ef_sc_hd__decap_40_12
XFILLER_116_189 vssd1 vccd1 vccd1 vssd1 SS_sky130_fd_sc_hd__fill_4
X_1666_ _1666_/Q _1762_/CLK _1666_/D vccd1 vssd1 vccd1 vssd1 SS_sky130_fd_sc_hd__dfxtp_2
XFILLER_104_307 vccd1 vssd1 vccd1 vssd1 SS_sky130_fd_sc_hd__fill_1
XFILLER_131_137 vssd1 vccd1 vssd1 vccd1 SS_sky130_ef_sc_hd__decap_40_12
X_1597_ _1597_/Q _1692_/CLK _1597_/D vccd1 vssd1 vccd1 vssd1 SS_sky130_fd_sc_hd__dfxtp_2
XFILLER_113_841 vccd1 vssd1 vccd1 vssd1 SS_sky130_fd_sc_hd__fill_1
XTAP_TAPCELL_ROW_113_1999 vccd1 vssd1 SS_sky130_fd_sc_hd__tapvpwrvgnd_1
XTAP_TAPCELL_ROW_113_1988 vccd1 vssd1 SS_sky130_fd_sc_hd__tapvpwrvgnd_1
XFILLER_105_15 vssd1 vccd1 vssd1 vccd1 SS_sky130_ef_sc_hd__decap_40_12
XFILLER_98_585 vssd1 vccd1 vccd1 vssd1 SS_sky130_fd_sc_hd__fill_2
XFILLER_85_279 vccd1 vssd1 vccd1 vssd1 SS_sky130_fd_sc_hd__fill_1
XFILLER_38_195 vccd1 vssd1 vccd1 vssd1 SS_sky130_fd_sc_hd__fill_1
XFILLER_81_441 vssd1 vccd1 vccd1 vssd1 SS_sky130_fd_sc_hd__fill_4
XFILLER_26_357 vssd1 vccd1 vccd1 vssd1 SS_sky130_fd_sc_hd__fill_4
XTAP_TAPCELL_ROW_37_853 vccd1 vssd1 SS_sky130_fd_sc_hd__tapvpwrvgnd_1
XFILLER_41_305 vssd1 vccd1 vssd1 vccd1 SS_sky130_ef_sc_hd__decap_40_12
XFILLER_53_165 vssd1 vccd1 vccd1 vssd1 SS_sky130_fd_sc_hd__fill_2
XFILLER_54_677 vccd1 vssd1 vccd1 vssd1 SS_sky130_fd_sc_hd__fill_1
XFILLER_81_18 vssd1 vccd1 vssd1 vccd1 SS_sky130_ef_sc_hd__decap_40_12
XFILLER_121_69 vssd1 vccd1 vssd1 vccd1 SS_sky130_ef_sc_hd__decap_40_12
XFILLER_41_349 vssd1 vccd1 vssd1 vccd1 SS_sky130_ef_sc_hd__decap_40_12
XFILLER_54_699 vccd1 vssd1 vccd1 vssd1 SS_sky130_fd_sc_hd__fill_1
XFILLER_81_485 vssd1 vccd1 vssd1 vccd1 SS_sky130_ef_sc_hd__decap_40_12
XFILLER_10_725 vssd1 vccd1 vssd1 vccd1 SS_sky130_ef_sc_hd__decap_40_12
XFILLER_22_585 vssd1 vccd1 vccd1 vssd1 SS_sky130_fd_sc_hd__fill_2
XFILLER_10_769 vssd1 vccd1 vccd1 vssd1 SS_sky130_fd_sc_hd__fill_8
XFILLER_5_217 vssd1 vccd1 vccd1 vssd1 SS_sky130_fd_sc_hd__fill_4
XFILLER_108_613 vssd1 vccd1 vssd1 vccd1 SS_sky130_ef_sc_hd__decap_40_12
XTAP_TAPCELL_ROW_75_1427 vccd1 vssd1 SS_sky130_fd_sc_hd__tapvpwrvgnd_1
XFILLER_30_77 vssd1 vccd1 vccd1 vssd1 SS_sky130_fd_sc_hd__fill_4
XFILLER_135_465 vssd1 vccd1 vccd1 vssd1 SS_sky130_fd_sc_hd__fill_8
XFILLER_107_167 vccd1 vssd1 vccd1 vssd1 SS_sky130_fd_sc_hd__fill_1
Xhold781 _1048_/A _1556_/Q vccd1 vssd1 vssd1 vccd1 SS_sky130_fd_sc_hd__dlygate4sd3_1
Xhold770 _0994_/A _1530_/Q vccd1 vssd1 vssd1 vccd1 SS_sky130_fd_sc_hd__dlygate4sd3_1
XFILLER_122_137 vssd1 vccd1 vccd1 vssd1 SS_sky130_fd_sc_hd__fill_2
XFILLER_1_445 vssd1 vccd1 vccd1 vssd1 SS_sky130_fd_sc_hd__fill_2
XFILLER_49_405 vssd1 vccd1 vssd1 vccd1 SS_sky130_ef_sc_hd__decap_40_12
Xhold792 hold792/X _0940_/X vccd1 vssd1 vssd1 vccd1 SS_sky130_fd_sc_hd__dlygate4sd3_1
XFILLER_49_449 vssd1 vccd1 vssd1 vccd1 SS_sky130_ef_sc_hd__decap_40_12
XFILLER_77_725 vssd1 vccd1 vccd1 vssd1 SS_sky130_fd_sc_hd__fill_2
XFILLER_77_769 vssd1 vccd1 vssd1 vccd1 SS_sky130_ef_sc_hd__decap_40_12
XFILLER_64_419 vccd1 vssd1 vccd1 vssd1 SS_sky130_fd_sc_hd__fill_1
XFILLER_85_780 vssd1 vccd1 vccd1 vssd1 SS_sky130_fd_sc_hd__fill_4
XFILLER_91_205 vssd1 vccd1 vssd1 vccd1 SS_sky130_ef_sc_hd__decap_40_12
XFILLER_17_335 vccd1 vssd1 vccd1 vssd1 SS_sky130_fd_sc_hd__fill_1
XFILLER_44_121 vssd1 vccd1 vssd1 vccd1 SS_sky130_ef_sc_hd__decap_40_12
XFILLER_57_482 vssd1 vccd1 vssd1 vccd1 SS_sky130_ef_sc_hd__decap_40_12
XFILLER_91_249 vssd1 vccd1 vssd1 vccd1 SS_sky130_ef_sc_hd__decap_40_12
XFILLER_32_305 vssd1 vccd1 vccd1 vssd1 SS_sky130_fd_sc_hd__fill_2
XFILLER_44_165 vssd1 vccd1 vssd1 vccd1 SS_sky130_ef_sc_hd__decap_40_12
XTAP_TAPCELL_ROW_86_1589 vccd1 vssd1 SS_sky130_fd_sc_hd__tapvpwrvgnd_1
XTAP_TAPCELL_ROW_15_525 vccd1 vssd1 SS_sky130_fd_sc_hd__tapvpwrvgnd_1
XFILLER_9_501 vssd1 vccd1 vccd1 vssd1 SS_sky130_fd_sc_hd__fill_2
XFILLER_13_541 vssd1 vccd1 vssd1 vccd1 SS_sky130_ef_sc_hd__decap_40_12
XFILLER_13_585 vssd1 vccd1 vssd1 vccd1 SS_sky130_ef_sc_hd__decap_40_12
XTAP_TAPCELL_ROW_117_2055 vccd1 vssd1 SS_sky130_fd_sc_hd__tapvpwrvgnd_1
XFILLER_138_281 vssd1 vccd1 vccd1 vssd1 SS_sky130_fd_sc_hd__fill_2
XFILLER_58_6 vssd1 vccd1 vssd1 vccd1 SS_sky130_ef_sc_hd__decap_40_12
X_1520_ _1520_/Q clkload5/A _1520_/D vccd1 vssd1 vccd1 vssd1 SS_sky130_fd_sc_hd__dfxtp_2
XTAP_TAPCELL_ROW_130_2244 vccd1 vssd1 SS_sky130_fd_sc_hd__tapvpwrvgnd_1
XFILLER_114_605 vssd1 vccd1 vssd1 vccd1 SS_sky130_ef_sc_hd__decap_40_12
XFILLER_99_305 vssd1 vccd1 vssd1 vccd1 SS_sky130_ef_sc_hd__decap_40_12
X_1451_ vssd1 vccd1 vccd1 vssd1 wire207/X input32/X _1751_/D _1451_/C1 _1450_/X SS_sky130_fd_sc_hd__o211a_2
XTAP_TAPCELL_ROW_130_2255 vccd1 vssd1 SS_sky130_fd_sc_hd__tapvpwrvgnd_1
XFILLER_113_137 vssd1 vccd1 vssd1 vccd1 SS_sky130_ef_sc_hd__decap_40_12
XFILLER_99_349 vssd1 vccd1 vssd1 vccd1 SS_sky130_ef_sc_hd__decap_40_12
X_1382_ vccd1 vssd1 vccd1 vssd1 _1382_/X _1382_/A _1396_/B SS_sky130_fd_sc_hd__or2_2
XFILLER_122_693 vssd1 vccd1 vccd1 vssd1 SS_sky130_fd_sc_hd__fill_4
XFILLER_110_811 vccd1 vssd1 vccd1 vssd1 SS_sky130_fd_sc_hd__fill_1
XFILLER_68_769 vssd1 vccd1 vssd1 vccd1 SS_sky130_ef_sc_hd__decap_40_12
XFILLER_121_181 vssd1 vccd1 vssd1 vccd1 SS_sky130_ef_sc_hd__decap_40_12
XFILLER_96_81 vssd1 vccd1 vccd1 vssd1 SS_sky130_fd_sc_hd__fill_2
XFILLER_67_279 vccd1 vssd1 vccd1 vssd1 SS_sky130_fd_sc_hd__fill_1
XFILLER_36_633 vssd1 vccd1 vccd1 vssd1 SS_sky130_fd_sc_hd__fill_2
XFILLER_82_249 vssd1 vccd1 vccd1 vssd1 SS_sky130_fd_sc_hd__fill_2
XFILLER_23_305 vssd1 vccd1 vssd1 vccd1 SS_sky130_ef_sc_hd__decap_40_12
XFILLER_35_165 vssd1 vccd1 vccd1 vssd1 SS_sky130_fd_sc_hd__fill_2
XTAP_TAPCELL_ROW_34_812 vccd1 vssd1 SS_sky130_fd_sc_hd__tapvpwrvgnd_1
XFILLER_36_699 vccd1 vssd1 vccd1 vssd1 SS_sky130_fd_sc_hd__fill_1
XFILLER_63_485 vssd1 vccd1 vssd1 vccd1 SS_sky130_ef_sc_hd__decap_40_12
XFILLER_23_349 vssd1 vccd1 vssd1 vccd1 SS_sky130_ef_sc_hd__decap_40_12
XFILLER_31_393 vssd1 vccd1 vssd1 vccd1 SS_sky130_ef_sc_hd__decap_40_12
XFILLER_129_281 vssd1 vccd1 vssd1 vccd1 SS_sky130_ef_sc_hd__decap_40_12
XFILLER_2_209 vssd1 vccd1 vssd1 vccd1 SS_sky130_ef_sc_hd__decap_40_12
X_1718_ _1718_/Q _1756_/CLK _1718_/D vccd1 vssd1 vccd1 vssd1 SS_sky130_fd_sc_hd__dfxtp_2
XTAP_TAPCELL_ROW_57_1157 vccd1 vssd1 SS_sky130_fd_sc_hd__tapvpwrvgnd_1
X_1649_ _1649_/Q clkload6/A _1649_/D vccd1 vssd1 vccd1 vssd1 SS_sky130_fd_sc_hd__dfxtp_2
XFILLER_132_446 vssd1 vccd1 vssd1 vccd1 SS_sky130_ef_sc_hd__decap_40_12
XFILLER_104_137 vssd1 vccd1 vccd1 vssd1 SS_sky130_fd_sc_hd__fill_2
XTAP_TAPCELL_ROW_70_1346 vccd1 vssd1 SS_sky130_fd_sc_hd__tapvpwrvgnd_1
XTAP_TAPCELL_ROW_70_1357 vccd1 vssd1 SS_sky130_fd_sc_hd__tapvpwrvgnd_1
XFILLER_76_18 vssd1 vccd1 vccd1 vssd1 SS_sky130_fd_sc_hd__fill_8
XFILLER_76_29 vssd1 vccd1 vssd1 vccd1 SS_sky130_ef_sc_hd__decap_40_12
XFILLER_86_533 vssd1 vccd1 vssd1 vccd1 SS_sky130_ef_sc_hd__decap_40_12
XFILLER_113_671 vccd1 vssd1 vccd1 vssd1 SS_sky130_fd_sc_hd__fill_1
XFILLER_101_822 vssd1 vccd1 vccd1 vssd1 SS_sky130_fd_sc_hd__fill_2
XFILLER_100_321 vssd1 vccd1 vssd1 vccd1 SS_sky130_ef_sc_hd__decap_40_12
XFILLER_73_205 vssd1 vccd1 vssd1 vccd1 SS_sky130_ef_sc_hd__decap_40_12
XFILLER_100_365 vssd1 vccd1 vssd1 vccd1 SS_sky130_ef_sc_hd__decap_40_12
XFILLER_26_121 vssd1 vccd1 vssd1 vccd1 SS_sky130_ef_sc_hd__decap_40_12
XFILLER_73_249 vssd1 vccd1 vssd1 vccd1 SS_sky130_ef_sc_hd__decap_40_12
XFILLER_14_305 vssd1 vccd1 vccd1 vssd1 SS_sky130_fd_sc_hd__fill_2
XFILLER_26_165 vssd1 vccd1 vssd1 vccd1 SS_sky130_ef_sc_hd__decap_40_12
XFILLER_41_113 vssd1 vccd1 vssd1 vccd1 SS_sky130_ef_sc_hd__decap_40_12
XFILLER_42_625 vssd1 vccd1 vccd1 vssd1 SS_sky130_fd_sc_hd__fill_4
XFILLER_25_55 vccd1 vssd1 vccd1 vssd1 SS_sky130_fd_sc_hd__fill_1
XFILLER_81_293 vssd1 vccd1 vccd1 vssd1 SS_sky130_fd_sc_hd__fill_8
XFILLER_10_533 vssd1 vccd1 vssd1 vccd1 SS_sky130_ef_sc_hd__decap_40_12
XFILLER_41_54 vssd1 vccd1 vccd1 vssd1 SS_sky130_fd_sc_hd__fill_2
XFILLER_108_421 vssd1 vccd1 vccd1 vssd1 SS_sky130_fd_sc_hd__fill_2
XTAP_TAPCELL_ROW_20_594 vccd1 vssd1 SS_sky130_fd_sc_hd__tapvpwrvgnd_1
XFILLER_135_273 vssd1 vccd1 vccd1 vssd1 SS_sky130_fd_sc_hd__fill_4
XFILLER_123_457 vssd1 vccd1 vssd1 vccd1 SS_sky130_ef_sc_hd__decap_40_12
XFILLER_111_608 vssd1 vccd1 vccd1 vssd1 SS_sky130_fd_sc_hd__fill_8
XFILLER_2_15 vssd1 vccd1 vssd1 vccd1 SS_sky130_ef_sc_hd__decap_40_12
XFILLER_77_533 vssd1 vccd1 vccd1 vssd1 SS_sky130_fd_sc_hd__fill_2
XFILLER_104_693 vssd1 vccd1 vccd1 vssd1 SS_sky130_fd_sc_hd__fill_4
XFILLER_89_393 vssd1 vccd1 vssd1 vccd1 SS_sky130_ef_sc_hd__decap_40_12
XFILLER_103_181 vssd1 vccd1 vssd1 vccd1 SS_sky130_ef_sc_hd__decap_40_12
XFILLER_49_279 vccd1 vssd1 vccd1 vssd1 SS_sky130_fd_sc_hd__fill_1
XTAP_TAPCELL_ROW_88_1618 vccd1 vssd1 SS_sky130_fd_sc_hd__tapvpwrvgnd_1
XFILLER_92_525 vssd1 vccd1 vccd1 vssd1 SS_sky130_fd_sc_hd__fill_4
XFILLER_64_249 vssd1 vccd1 vccd1 vssd1 SS_sky130_fd_sc_hd__fill_2
XFILLER_92_569 vssd1 vccd1 vssd1 vccd1 SS_sky130_ef_sc_hd__decap_40_12
XFILLER_17_165 vssd1 vccd1 vccd1 vssd1 SS_sky130_fd_sc_hd__fill_2
XFILLER_18_699 vccd1 vssd1 vccd1 vssd1 SS_sky130_fd_sc_hd__fill_1
XFILLER_73_783 vccd1 vssd1 vccd1 vssd1 SS_sky130_fd_sc_hd__fill_1
XFILLER_21_809 vssd1 vccd1 vccd1 vssd1 SS_sky130_fd_sc_hd__fill_4
XFILLER_60_433 vssd1 vccd1 vssd1 vccd1 SS_sky130_ef_sc_hd__decap_40_12
XFILLER_82_83 vccd1 vssd1 vccd1 vssd1 SS_sky130_fd_sc_hd__fill_1
X_0951_ vssd1 vccd1 vccd1 vssd1 _0989_/A2 input31/X _1508_/D _1099_/C1 _0950_/X SS_sky130_fd_sc_hd__o211a_2
XFILLER_60_477 vssd1 vccd1 vssd1 vccd1 SS_sky130_ef_sc_hd__decap_40_12
XFILLER_13_393 vssd1 vccd1 vssd1 vccd1 SS_sky130_ef_sc_hd__decap_40_12
X_0882_ vccd1 vssd1 vccd1 vssd1 _1624_/Q _0927_/A2 _1688_/Q wire448/A _0883_/C SS_sky130_fd_sc_hd__a22o_2
Xoutput105 vccd1 vssd1 wire339/A _1864_/X vccd1 vssd1 SS_sky130_fd_sc_hd__buf_4
Xoutput116 vccd1 vssd1 wire328/A _1874_/X vccd1 vssd1 SS_sky130_fd_sc_hd__buf_4
XFILLER_127_785 vssd1 vccd1 vccd1 vssd1 SS_sky130_fd_sc_hd__fill_8
XFILLER_126_251 vccd1 vssd1 vccd1 vssd1 SS_sky130_fd_sc_hd__fill_1
Xoutput127 vccd1 vssd1 wire317/A _1884_/X vccd1 vssd1 SS_sky130_fd_sc_hd__buf_4
Xoutput138 vccd1 vssd1 wire412/A _1640_/Q vccd1 vssd1 SS_sky130_fd_sc_hd__buf_4
Xoutput149 vccd1 vssd1 wire402/A _1650_/Q vccd1 vssd1 SS_sky130_fd_sc_hd__buf_4
XFILLER_114_413 vssd1 vccd1 vccd1 vssd1 SS_sky130_fd_sc_hd__fill_4
X_1503_ _1503_/Q _1762_/CLK _1503_/D vccd1 vssd1 vccd1 vssd1 SS_sky130_fd_sc_hd__dfxtp_2
XFILLER_99_113 vssd1 vccd1 vssd1 vccd1 SS_sky130_ef_sc_hd__decap_40_12
XFILLER_88_809 vssd1 vccd1 vccd1 vssd1 SS_sky130_fd_sc_hd__fill_2
X_1434_ vccd1 vssd1 vccd1 vssd1 _1434_/X _1907_/A _1466_/B SS_sky130_fd_sc_hd__or2_2
XTAP_TAPCELL_ROW_110_1947 vccd1 vssd1 SS_sky130_fd_sc_hd__tapvpwrvgnd_1
XTAP_TAPCELL_ROW_52_1076 vccd1 vssd1 SS_sky130_fd_sc_hd__tapvpwrvgnd_1
XFILLER_68_533 vssd1 vccd1 vssd1 vccd1 SS_sky130_ef_sc_hd__decap_40_12
X_1365_ vssd1 vccd1 vccd1 vssd1 _1369_/A2 wire501/X _1709_/D _1423_/C1 _1364_/X SS_sky130_fd_sc_hd__o211a_2
XFILLER_110_641 vssd1 vccd1 vccd1 vssd1 SS_sky130_fd_sc_hd__fill_2
XFILLER_28_419 vccd1 vssd1 vccd1 vssd1 SS_sky130_fd_sc_hd__fill_1
XTAP_TAPCELL_ROW_52_1087 vccd1 vssd1 SS_sky130_fd_sc_hd__tapvpwrvgnd_1
XFILLER_55_205 vssd1 vccd1 vssd1 vccd1 SS_sky130_ef_sc_hd__decap_40_12
XFILLER_55_249 vssd1 vccd1 vssd1 vccd1 SS_sky130_ef_sc_hd__decap_40_12
X_1296_ vccd1 vssd1 vccd1 vssd1 _1296_/X _1296_/A _1338_/B SS_sky130_fd_sc_hd__or2_2
XFILLER_83_558 vssd1 vccd1 vccd1 vssd1 SS_sky130_fd_sc_hd__fill_2
XFILLER_102_27 vccd1 vssd1 vccd1 vssd1 SS_sky130_fd_sc_hd__fill_1
XFILLER_23_113 vssd1 vccd1 vssd1 vccd1 SS_sky130_ef_sc_hd__decap_40_12
XFILLER_24_625 vssd1 vccd1 vccd1 vssd1 SS_sky130_fd_sc_hd__fill_8
XFILLER_63_293 vssd1 vccd1 vssd1 vccd1 SS_sky130_ef_sc_hd__decap_40_12
XFILLER_11_57 vssd1 vccd1 vssd1 vccd1 SS_sky130_ef_sc_hd__decap_40_12
XFILLER_3_529 vssd1 vccd1 vssd1 vccd1 SS_sky130_ef_sc_hd__decap_40_12
XFILLER_132_221 vssd1 vccd1 vssd1 vccd1 SS_sky130_ef_sc_hd__decap_40_12
XFILLER_127_57 vssd1 vccd1 vssd1 vccd1 SS_sky130_ef_sc_hd__decap_40_12
XFILLER_117_273 vssd1 vccd1 vccd1 vssd1 SS_sky130_fd_sc_hd__fill_4
XFILLER_87_39 vssd1 vccd1 vssd1 vccd1 SS_sky130_ef_sc_hd__decap_40_12
XFILLER_105_446 vssd1 vccd1 vccd1 vssd1 SS_sky130_fd_sc_hd__fill_2
XFILLER_132_265 vssd1 vccd1 vssd1 vccd1 SS_sky130_ef_sc_hd__decap_40_12
XFILLER_59_533 vccd1 vssd1 vccd1 vssd1 SS_sky130_fd_sc_hd__fill_1
XFILLER_86_341 vssd1 vccd1 vssd1 vccd1 SS_sky130_ef_sc_hd__decap_40_12
XFILLER_101_641 vssd1 vccd1 vssd1 vccd1 SS_sky130_ef_sc_hd__decap_40_12
XTAP_TAPCELL_ROW_6_389 vccd1 vssd1 SS_sky130_fd_sc_hd__tapvpwrvgnd_1
XFILLER_86_363 vccd1 vssd1 vccd1 vssd1 SS_sky130_fd_sc_hd__fill_1
XFILLER_46_249 vssd1 vccd1 vccd1 vssd1 SS_sky130_fd_sc_hd__fill_2
XFILLER_100_195 vccd1 vssd1 vccd1 vssd1 SS_sky130_fd_sc_hd__fill_1
XFILLER_27_441 vssd1 vccd1 vccd1 vssd1 SS_sky130_fd_sc_hd__fill_4
XFILLER_27_485 vssd1 vccd1 vssd1 vccd1 SS_sky130_ef_sc_hd__decap_40_12
XFILLER_36_65 vssd1 vccd1 vssd1 vccd1 SS_sky130_ef_sc_hd__decap_40_12
XFILLER_55_783 vccd1 vssd1 vccd1 vssd1 SS_sky130_fd_sc_hd__fill_1
XFILLER_15_669 vssd1 vccd1 vccd1 vssd1 SS_sky130_fd_sc_hd__fill_2
XFILLER_42_433 vssd1 vccd1 vccd1 vssd1 SS_sky130_fd_sc_hd__fill_8
XTAP_TAPCELL_ROW_83_1548 vccd1 vssd1 SS_sky130_fd_sc_hd__tapvpwrvgnd_1
XTAP_TAPCELL_ROW_25_675 vccd1 vssd1 SS_sky130_fd_sc_hd__tapvpwrvgnd_1
XFILLER_30_617 vssd1 vccd1 vccd1 vssd1 SS_sky130_fd_sc_hd__fill_2
XFILLER_42_477 vssd1 vccd1 vssd1 vccd1 SS_sky130_ef_sc_hd__decap_40_12
XFILLER_23_691 vssd1 vccd1 vssd1 vccd1 SS_sky130_ef_sc_hd__decap_40_12
XFILLER_52_53 vssd1 vccd1 vssd1 vccd1 SS_sky130_ef_sc_hd__decap_40_12
XFILLER_6_301 vssd1 vccd1 vccd1 vssd1 SS_sky130_fd_sc_hd__fill_4
XFILLER_52_97 vssd1 vccd1 vssd1 vccd1 SS_sky130_ef_sc_hd__decap_40_12
Xinput18 vssd1 vccd1 vccd1 vssd1 input18/A _0755_/B SS_sky130_fd_sc_hd__clkdlybuf4s25_1
XFILLER_10_363 vccd1 vssd1 vccd1 vssd1 SS_sky130_fd_sc_hd__fill_1
Xinput29 vssd1 vccd1 vccd1 vssd1 input29/A input29/X SS_sky130_fd_sc_hd__clkdlybuf4s25_1
XTAP_TAPCELL_ROW_114_2014 vccd1 vssd1 SS_sky130_fd_sc_hd__tapvpwrvgnd_1
XTAP_TAPCELL_ROW_114_2003 vccd1 vssd1 SS_sky130_fd_sc_hd__tapvpwrvgnd_1
XFILLER_109_741 vssd1 vccd1 vssd1 vccd1 SS_sky130_ef_sc_hd__decap_40_12
XFILLER_6_345 vssd1 vccd1 vssd1 vccd1 SS_sky130_ef_sc_hd__decap_40_12
XFILLER_136_560 vssd1 vccd1 vssd1 vccd1 SS_sky130_ef_sc_hd__decap_40_12
XFILLER_109_785 vssd1 vccd1 vccd1 vssd1 SS_sky130_fd_sc_hd__fill_4
XFILLER_108_251 vccd1 vssd1 vccd1 vssd1 SS_sky130_fd_sc_hd__fill_1
XFILLER_6_389 vssd1 vccd1 vssd1 vccd1 SS_sky130_ef_sc_hd__decap_40_12
XFILLER_124_722 vssd1 vccd1 vssd1 vccd1 SS_sky130_ef_sc_hd__decap_40_12
XFILLER_123_221 vssd1 vccd1 vccd1 vssd1 SS_sky130_fd_sc_hd__fill_2
XFILLER_97_617 vssd1 vccd1 vssd1 vccd1 SS_sky130_ef_sc_hd__decap_40_12
XFILLER_111_449 vssd1 vccd1 vssd1 vccd1 SS_sky130_ef_sc_hd__decap_40_12
XFILLER_37_205 vssd1 vccd1 vssd1 vccd1 SS_sky130_ef_sc_hd__decap_40_12
X_1150_ vccd1 vssd1 vccd1 vssd1 _1150_/X _1848_/A _1186_/B SS_sky130_fd_sc_hd__or2_2
XFILLER_92_333 vssd1 vccd1 vssd1 vccd1 SS_sky130_ef_sc_hd__decap_40_12
X_1081_ vssd1 vccd1 vccd1 vssd1 wire239/X input20/X _1571_/D _1149_/C1 _1080_/X SS_sky130_fd_sc_hd__o211a_2
XFILLER_37_249 vssd1 vccd1 vssd1 vccd1 SS_sky130_ef_sc_hd__decap_40_12
XTAP_TAPCELL_ROW_125_2176 vccd1 vssd1 SS_sky130_fd_sc_hd__tapvpwrvgnd_1
XFILLER_92_377 vssd1 vccd1 vssd1 vccd1 SS_sky130_ef_sc_hd__decap_40_12
XFILLER_93_93 vssd1 vccd1 vssd1 vccd1 SS_sky130_ef_sc_hd__decap_40_12
XFILLER_45_293 vssd1 vccd1 vssd1 vccd1 SS_sky130_ef_sc_hd__decap_40_12
XFILLER_21_617 vssd1 vccd1 vssd1 vccd1 SS_sky130_ef_sc_hd__decap_40_12
XTAP_TAPCELL_ROW_44_962 vccd1 vssd1 SS_sky130_fd_sc_hd__tapvpwrvgnd_1
XFILLER_61_797 vssd1 vccd1 vssd1 vccd1 SS_sky130_ef_sc_hd__decap_40_12
XFILLER_9_161 vssd1 vccd1 vccd1 vssd1 SS_sky130_fd_sc_hd__fill_4
X_0934_ vccd1 vssd1 vccd1 vssd1 _1665_/Q wire431/X _1761_/Q _0745_/X _0934_/X SS_sky130_fd_sc_hd__a22o_2
XFILLER_119_505 vssd1 vccd1 vssd1 vccd1 SS_sky130_ef_sc_hd__decap_40_12
X_0865_ vssd1 vccd1 vssd1 vccd1 _1277_/A _1314_/A _0865_/B1 _0863_/X _0865_/X _0864_/X
+ SS_sky130_fd_sc_hd__a2111o_2
X_0796_ vccd1 vssd1 vccd1 vssd1 _0795_/X _1028_/A wire424/X _1642_/Q wire430/X _0796_/X
+ SS_sky130_fd_sc_hd__a221o_2
XTAP_TAPCELL_ROW_54_1105 vccd1 vssd1 SS_sky130_fd_sc_hd__tapvpwrvgnd_1
XTAP_TAPCELL_ROW_54_1116 vccd1 vssd1 SS_sky130_fd_sc_hd__tapvpwrvgnd_1
XFILLER_115_777 vssd1 vccd1 vccd1 vssd1 SS_sky130_fd_sc_hd__fill_4
XFILLER_114_221 vssd1 vccd1 vssd1 vccd1 SS_sky130_ef_sc_hd__decap_40_12
XFILLER_87_105 vssd1 vccd1 vccd1 vssd1 SS_sky130_fd_sc_hd__fill_4
XFILLER_114_265 vssd1 vccd1 vssd1 vccd1 SS_sky130_ef_sc_hd__decap_40_12
X_1417_ vssd1 vccd1 vccd1 vssd1 _1439_/A2 input45/X _1734_/D _1417_/C1 _1416_/X SS_sky130_fd_sc_hd__o211a_2
XFILLER_87_149 vssd1 vccd1 vssd1 vccd1 SS_sky130_ef_sc_hd__decap_40_12
XFILLER_130_769 vssd1 vccd1 vssd1 vccd1 SS_sky130_ef_sc_hd__decap_40_12
XFILLER_68_363 vccd1 vssd1 vccd1 vssd1 SS_sky130_fd_sc_hd__fill_1
XTAP_TAPCELL_ROW_3_348 vccd1 vssd1 SS_sky130_fd_sc_hd__tapvpwrvgnd_1
XFILLER_56_525 vssd1 vccd1 vccd1 vssd1 SS_sky130_fd_sc_hd__fill_4
X_1348_ vccd1 vssd1 vccd1 vssd1 _1348_/X _1880_/A _1404_/B SS_sky130_fd_sc_hd__or2_2
XFILLER_95_193 vssd1 vccd1 vssd1 vccd1 SS_sky130_ef_sc_hd__decap_40_12
XFILLER_28_249 vssd1 vccd1 vccd1 vssd1 SS_sky130_fd_sc_hd__fill_2
XFILLER_44_709 vssd1 vccd1 vccd1 vssd1 SS_sky130_fd_sc_hd__fill_2
XFILLER_56_569 vssd1 vccd1 vccd1 vssd1 SS_sky130_fd_sc_hd__fill_8
X_1279_ vssd1 vccd1 vccd1 vssd1 _1339_/A2 input20/X _1279_/X _1417_/C1 _1278_/X SS_sky130_fd_sc_hd__o211a_2
XFILLER_37_783 vccd1 vssd1 vccd1 vssd1 SS_sky130_fd_sc_hd__fill_1
XFILLER_71_517 vssd1 vccd1 vccd1 vssd1 SS_sky130_fd_sc_hd__fill_4
XFILLER_24_433 vssd1 vccd1 vssd1 vccd1 SS_sky130_ef_sc_hd__decap_40_12
XFILLER_52_753 vssd1 vccd1 vccd1 vssd1 SS_sky130_fd_sc_hd__fill_2
XFILLER_11_105 vssd1 vccd1 vccd1 vssd1 SS_sky130_fd_sc_hd__fill_4
XFILLER_24_477 vssd1 vccd1 vssd1 vccd1 SS_sky130_ef_sc_hd__decap_40_12
XTAP_TAPCELL_ROW_65_1278 vccd1 vssd1 SS_sky130_fd_sc_hd__tapvpwrvgnd_1
XTAP_TAPCELL_ROW_22_623 vccd1 vssd1 SS_sky130_fd_sc_hd__tapvpwrvgnd_1
XTAP_TAPCELL_ROW_22_634 vccd1 vssd1 SS_sky130_fd_sc_hd__tapvpwrvgnd_1
XFILLER_7_109 vssd1 vccd1 vccd1 vssd1 SS_sky130_fd_sc_hd__fill_2
XFILLER_11_149 vssd1 vccd1 vssd1 vccd1 SS_sky130_ef_sc_hd__decap_40_12
XFILLER_4_805 vssd1 vccd1 vccd1 vssd1 SS_sky130_fd_sc_hd__fill_4
XFILLER_3_337 vssd1 vccd1 vssd1 vccd1 SS_sky130_ef_sc_hd__decap_40_12
XFILLER_79_606 vssd1 vccd1 vccd1 vssd1 SS_sky130_fd_sc_hd__fill_2
XFILLER_133_552 vssd1 vccd1 vccd1 vssd1 SS_sky130_fd_sc_hd__fill_8
XFILLER_105_221 vssd1 vccd1 vccd1 vssd1 SS_sky130_fd_sc_hd__fill_2
XFILLER_133_585 vssd1 vccd1 vssd1 vccd1 SS_sky130_ef_sc_hd__decap_40_12
XFILLER_121_747 vccd1 vssd1 vccd1 vssd1 SS_sky130_fd_sc_hd__fill_1
XPHY_EDGE_ROW_110_Right_110 vccd1 vssd1 vccd1 vssd1 SS_sky130_fd_sc_hd__decap_3
XFILLER_19_205 vssd1 vccd1 vssd1 vccd1 SS_sky130_ef_sc_hd__decap_40_12
XFILLER_74_333 vssd1 vccd1 vssd1 vccd1 SS_sky130_ef_sc_hd__decap_40_12
XFILLER_19_249 vssd1 vccd1 vssd1 vccd1 SS_sky130_ef_sc_hd__decap_40_12
XFILLER_47_558 vssd1 vccd1 vccd1 vssd1 SS_sky130_fd_sc_hd__fill_2
XFILLER_47_569 vssd1 vccd1 vssd1 vccd1 SS_sky130_ef_sc_hd__decap_40_12
XFILLER_86_193 vssd1 vccd1 vccd1 vssd1 SS_sky130_fd_sc_hd__fill_2
XFILLER_90_804 vssd1 vccd1 vccd1 vssd1 SS_sky130_fd_sc_hd__fill_8
XFILLER_62_517 vssd1 vccd1 vssd1 vccd1 SS_sky130_ef_sc_hd__decap_40_12
XFILLER_74_377 vssd1 vccd1 vssd1 vccd1 SS_sky130_ef_sc_hd__decap_40_12
XFILLER_27_293 vssd1 vccd1 vssd1 vccd1 SS_sky130_ef_sc_hd__decap_40_12
XFILLER_63_30 vssd1 vccd1 vssd1 vccd1 SS_sky130_ef_sc_hd__decap_40_12
XFILLER_103_81 vssd1 vccd1 vssd1 vccd1 SS_sky130_ef_sc_hd__decap_40_12
XTAP_TAPCELL_ROW_41_910 vccd1 vssd1 SS_sky130_fd_sc_hd__tapvpwrvgnd_1
XTAP_TAPCELL_ROW_41_921 vccd1 vssd1 SS_sky130_fd_sc_hd__tapvpwrvgnd_1
XFILLER_43_797 vssd1 vccd1 vccd1 vssd1 SS_sky130_fd_sc_hd__fill_4
XTAP_TAPCELL_ROW_120_2095 vccd1 vssd1 SS_sky130_fd_sc_hd__tapvpwrvgnd_1
XFILLER_30_469 vssd1 vccd1 vccd1 vssd1 SS_sky130_fd_sc_hd__fill_4
XFILLER_6_153 vssd1 vccd1 vssd1 vccd1 SS_sky130_ef_sc_hd__decap_40_12
XFILLER_7_665 vssd1 vccd1 vccd1 vssd1 SS_sky130_fd_sc_hd__fill_4
XFILLER_10_193 vssd1 vccd1 vccd1 vssd1 SS_sky130_fd_sc_hd__fill_2
XFILLER_116_508 vssd1 vccd1 vccd1 vssd1 SS_sky130_fd_sc_hd__fill_8
XTAP_TAPCELL_ROW_96_1739 vccd1 vssd1 SS_sky130_fd_sc_hd__tapvpwrvgnd_1
XFILLER_6_197 vssd1 vccd1 vssd1 vccd1 SS_sky130_ef_sc_hd__decap_40_12
XFILLER_69_105 vssd1 vccd1 vccd1 vssd1 SS_sky130_fd_sc_hd__fill_4
XFILLER_124_585 vssd1 vccd1 vccd1 vssd1 SS_sky130_fd_sc_hd__fill_2
XFILLER_69_149 vssd1 vccd1 vssd1 vccd1 SS_sky130_ef_sc_hd__decap_40_12
XFILLER_112_769 vssd1 vccd1 vssd1 vccd1 SS_sky130_ef_sc_hd__decap_40_12
XFILLER_97_447 vccd1 vssd1 vccd1 vssd1 SS_sky130_fd_sc_hd__fill_1
XTAP_TAPCELL_ROW_127_2205 vccd1 vssd1 SS_sky130_fd_sc_hd__tapvpwrvgnd_1
X_1202_ vccd1 vssd1 vccd1 vssd1 _1202_/X _1202_/A _1208_/B SS_sky130_fd_sc_hd__or2_2
XFILLER_111_279 vccd1 vssd1 vccd1 vssd1 SS_sky130_fd_sc_hd__fill_1
XFILLER_19_3 vssd1 vccd1 vssd1 vccd1 SS_sky130_ef_sc_hd__decap_40_12
XFILLER_78_683 vssd1 vccd1 vssd1 vccd1 SS_sky130_ef_sc_hd__decap_40_12
XTAP_TAPCELL_ROW_0_307 vccd1 vssd1 SS_sky130_fd_sc_hd__tapvpwrvgnd_1
XFILLER_26_709 vccd1 vssd1 vccd1 vssd1 SS_sky130_fd_sc_hd__fill_1
XFILLER_38_569 vssd1 vccd1 vssd1 vccd1 SS_sky130_ef_sc_hd__decap_40_12
XFILLER_65_366 vssd1 vccd1 vssd1 vccd1 SS_sky130_ef_sc_hd__decap_40_12
XFILLER_77_193 vssd1 vccd1 vssd1 vccd1 SS_sky130_ef_sc_hd__decap_40_12
X_1133_ vssd1 vccd1 vccd1 vssd1 _1141_/A2 input38/X _1597_/D _1133_/C1 _1132_/X SS_sky130_fd_sc_hd__o211a_2
XFILLER_93_653 vssd1 vccd1 vccd1 vssd1 SS_sky130_fd_sc_hd__fill_8
XFILLER_92_141 vssd1 vccd1 vssd1 vccd1 SS_sky130_ef_sc_hd__decap_40_12
XFILLER_19_783 vccd1 vssd1 vccd1 vssd1 SS_sky130_fd_sc_hd__fill_1
X_1064_ vccd1 vssd1 vccd1 vssd1 _1064_/X _1064_/A _1076_/B SS_sky130_fd_sc_hd__or2_2
XFILLER_93_697 vssd1 vccd1 vccd1 vssd1 SS_sky130_fd_sc_hd__fill_2
XFILLER_34_786 vssd1 vccd1 vccd1 vssd1 SS_sky130_fd_sc_hd__fill_4
XFILLER_61_561 vssd1 vccd1 vssd1 vccd1 SS_sky130_ef_sc_hd__decap_40_12
Xclkbuf_leaf_0_wb_clk_i _1746_/CLK clkbuf_leaf_9_wb_clk_i/A vccd1 vssd1 vssd1 vccd1
+ SS_sky130_fd_sc_hd__clkbuf_8
XTAP_TAPCELL_ROW_105_1879 vccd1 vssd1 SS_sky130_fd_sc_hd__tapvpwrvgnd_1
XTAP_TAPCELL_ROW_105_1868 vccd1 vssd1 SS_sky130_fd_sc_hd__tapvpwrvgnd_1
XFILLER_21_447 vccd1 vssd1 vccd1 vssd1 SS_sky130_fd_sc_hd__fill_1
XTAP_TAPCELL_ROW_138_2378 vccd1 vssd1 SS_sky130_fd_sc_hd__tapvpwrvgnd_1
XTAP_TAPCELL_ROW_138_2389 vccd1 vssd1 SS_sky130_fd_sc_hd__tapvpwrvgnd_1
XTAP_TAPCELL_ROW_138_2367 vccd1 vssd1 SS_sky130_fd_sc_hd__tapvpwrvgnd_1
X_0917_ vccd1 vssd1 vccd1 vssd1 _0915_/X _1464_/A wire435/A _1398_/A wire452/X _0917_/X
+ SS_sky130_fd_sc_hd__a221o_2
XFILLER_119_335 vccd1 vssd1 vccd1 vssd1 SS_sky130_fd_sc_hd__fill_1
XTAP_TAPCELL_ROW_60_1197 vccd1 vssd1 SS_sky130_fd_sc_hd__tapvpwrvgnd_1
XFILLER_134_305 vssd1 vccd1 vccd1 vssd1 SS_sky130_fd_sc_hd__fill_2
X_1897_ vccd1 vssd1 _1897_/X _1897_/A vccd1 vssd1 SS_sky130_fd_sc_hd__buf_2
X_0848_ vccd1 vssd1 vssd1 vccd1 _0845_/X _0847_/X _0878_/A2 hold809/X _0848_/X _1309_/C1
+ SS_sky130_fd_sc_hd__o221a_2
XFILLER_108_26 vssd1 vccd1 vccd1 vssd1 SS_sky130_fd_sc_hd__fill_2
XTAP_TAPCELL_ROW_8_418 vccd1 vssd1 SS_sky130_fd_sc_hd__tapvpwrvgnd_1
X_0779_ vccd1 vssd1 vccd1 vssd1 _1845_/A wire443/A _1889_/A wire448/X _0779_/X SS_sky130_fd_sc_hd__a22o_2
XFILLER_0_307 vccd1 vssd1 vccd1 vssd1 SS_sky130_fd_sc_hd__fill_1
XFILLER_130_533 vssd1 vccd1 vssd1 vccd1 SS_sky130_ef_sc_hd__decap_40_12
XFILLER_29_503 vccd1 vssd1 vccd1 vssd1 SS_sky130_fd_sc_hd__fill_1
XFILLER_57_801 vccd1 vssd1 vccd1 vssd1 SS_sky130_fd_sc_hd__fill_1
XFILLER_76_609 vssd1 vccd1 vccd1 vssd1 SS_sky130_fd_sc_hd__fill_2
XFILLER_88_469 vssd1 vccd1 vccd1 vssd1 SS_sky130_fd_sc_hd__fill_4
XFILLER_84_29 vssd1 vccd1 vssd1 vccd1 SS_sky130_ef_sc_hd__decap_40_12
XFILLER_84_631 vssd1 vccd1 vssd1 vccd1 SS_sky130_ef_sc_hd__decap_40_12
XFILLER_17_709 vssd1 vccd1 vssd1 vccd1 SS_sky130_ef_sc_hd__decap_40_12
XTAP_TAPCELL_ROW_67_1307 vccd1 vssd1 SS_sky130_fd_sc_hd__tapvpwrvgnd_1
XFILLER_68_193 vssd1 vccd1 vccd1 vssd1 SS_sky130_fd_sc_hd__fill_2
XTAP_TAPCELL_ROW_27_704 vccd1 vssd1 SS_sky130_fd_sc_hd__tapvpwrvgnd_1
XFILLER_56_388 vssd1 vccd1 vssd1 vccd1 SS_sky130_ef_sc_hd__decap_40_12
XFILLER_71_325 vccd1 vssd1 vccd1 vssd1 SS_sky130_fd_sc_hd__fill_1
XFILLER_25_731 vccd1 vssd1 vccd1 vssd1 SS_sky130_fd_sc_hd__fill_1
XFILLER_71_369 vssd1 vccd1 vccd1 vssd1 SS_sky130_fd_sc_hd__fill_8
XTAP_TAPCELL_ROW_80_1507 vccd1 vssd1 SS_sky130_fd_sc_hd__tapvpwrvgnd_1
XFILLER_25_797 vssd1 vccd1 vccd1 vssd1 SS_sky130_fd_sc_hd__fill_8
XFILLER_40_745 vssd1 vccd1 vccd1 vssd1 SS_sky130_fd_sc_hd__fill_8
XFILLER_12_469 vssd1 vccd1 vccd1 vssd1 SS_sky130_fd_sc_hd__fill_4
XFILLER_40_789 vccd1 vssd1 vccd1 vssd1 SS_sky130_fd_sc_hd__fill_1
XFILLER_4_613 vssd1 vccd1 vssd1 vccd1 SS_sky130_ef_sc_hd__decap_40_12
XTAP_TAPCELL_ROW_78_1469 vccd1 vssd1 SS_sky130_fd_sc_hd__tapvpwrvgnd_1
XFILLER_138_699 vccd1 vssd1 vccd1 vssd1 SS_sky130_fd_sc_hd__fill_1
XFILLER_137_187 vssd1 vccd1 vccd1 vssd1 SS_sky130_fd_sc_hd__fill_2
XFILLER_4_657 vssd1 vccd1 vssd1 vccd1 SS_sky130_ef_sc_hd__decap_40_12
XFILLER_106_541 vssd1 vccd1 vssd1 vccd1 SS_sky130_ef_sc_hd__decap_40_12
XFILLER_3_167 vccd1 vssd1 vccd1 vssd1 SS_sky130_fd_sc_hd__fill_1
XFILLER_79_425 vssd1 vccd1 vccd1 vssd1 SS_sky130_fd_sc_hd__fill_4
XFILLER_106_585 vssd1 vccd1 vccd1 vssd1 SS_sky130_fd_sc_hd__fill_2
XFILLER_0_841 vccd1 vssd1 vccd1 vssd1 SS_sky130_fd_sc_hd__fill_1
XFILLER_79_447 vccd1 vssd1 vccd1 vssd1 SS_sky130_fd_sc_hd__fill_1
XTAP_TAPCELL_ROW_91_1658 vccd1 vssd1 SS_sky130_fd_sc_hd__tapvpwrvgnd_1
XFILLER_121_533 vssd1 vccd1 vccd1 vssd1 SS_sky130_fd_sc_hd__fill_2
XTAP_TAPCELL_ROW_91_1669 vccd1 vssd1 SS_sky130_fd_sc_hd__tapvpwrvgnd_1
XFILLER_58_41 vssd1 vccd1 vssd1 vccd1 SS_sky130_ef_sc_hd__decap_40_12
XFILLER_67_609 vssd1 vccd1 vccd1 vssd1 SS_sky130_fd_sc_hd__fill_4
XFILLER_79_469 vssd1 vccd1 vssd1 vccd1 SS_sky130_ef_sc_hd__decap_40_12
XFILLER_94_417 vssd1 vccd1 vccd1 vssd1 SS_sky130_fd_sc_hd__fill_2
XFILLER_58_85 vssd1 vccd1 vssd1 vccd1 SS_sky130_ef_sc_hd__decap_40_12
XFILLER_47_333 vssd1 vccd1 vccd1 vssd1 SS_sky130_fd_sc_hd__fill_2
XFILLER_59_193 vssd1 vccd1 vssd1 vccd1 SS_sky130_ef_sc_hd__decap_40_12
XFILLER_74_141 vssd1 vccd1 vssd1 vccd1 SS_sky130_ef_sc_hd__decap_40_12
XFILLER_75_653 vssd1 vccd1 vssd1 vccd1 SS_sky130_ef_sc_hd__decap_40_12
XFILLER_35_517 vssd1 vccd1 vssd1 vccd1 SS_sky130_ef_sc_hd__decap_40_12
XFILLER_47_377 vccd1 vssd1 vccd1 vssd1 SS_sky130_fd_sc_hd__fill_1
XFILLER_90_601 vssd1 vccd1 vssd1 vccd1 SS_sky130_ef_sc_hd__decap_40_12
XTAP_TAPCELL_ROW_122_2124 vccd1 vssd1 SS_sky130_fd_sc_hd__tapvpwrvgnd_1
XFILLER_90_645 vssd1 vccd1 vssd1 vccd1 SS_sky130_ef_sc_hd__decap_40_12
XTAP_TAPCELL_ROW_122_2135 vccd1 vssd1 SS_sky130_fd_sc_hd__tapvpwrvgnd_1
XFILLER_16_753 vssd1 vccd1 vccd1 vssd1 SS_sky130_fd_sc_hd__fill_2
XFILLER_31_712 vssd1 vccd1 vssd1 vccd1 SS_sky130_ef_sc_hd__decap_40_12
XFILLER_43_550 vccd1 vssd1 vccd1 vssd1 SS_sky130_fd_sc_hd__fill_1
XFILLER_62_369 vccd1 vssd1 vccd1 vssd1 SS_sky130_fd_sc_hd__fill_1
XFILLER_30_233 vssd1 vccd1 vssd1 vccd1 SS_sky130_ef_sc_hd__decap_40_12
XFILLER_31_778 vssd1 vccd1 vccd1 vssd1 SS_sky130_fd_sc_hd__fill_4
XFILLER_88_6 vssd1 vccd1 vssd1 vccd1 SS_sky130_ef_sc_hd__decap_40_12
XFILLER_30_277 vssd1 vccd1 vssd1 vccd1 SS_sky130_ef_sc_hd__decap_40_12
XFILLER_90_83 vccd1 vssd1 vccd1 vssd1 SS_sky130_fd_sc_hd__fill_1
XFILLER_128_121 vssd1 vccd1 vssd1 vccd1 SS_sky130_ef_sc_hd__decap_40_12
XTAP_TAPCELL_ROW_13_497 vccd1 vssd1 SS_sky130_fd_sc_hd__tapvpwrvgnd_1
X_1751_ _1751_/Q _1751_/CLK _1751_/D vccd1 vssd1 vccd1 vssd1 SS_sky130_fd_sc_hd__dfxtp_2
Xwire360 vccd1 vssd1 vssd1 vccd1 wire360/A wbs_dat_o[31] SS_sky130_fd_sc_hd__buf_12
XFILLER_117_817 vssd1 vccd1 vccd1 vssd1 SS_sky130_fd_sc_hd__fill_2
XTAP_TAPCELL_ROW_100_1798 vccd1 vssd1 SS_sky130_fd_sc_hd__tapvpwrvgnd_1
XFILLER_7_473 vssd1 vccd1 vssd1 vccd1 SS_sky130_ef_sc_hd__decap_40_12
X_1682_ _1682_/Q _1746_/CLK _1682_/D vccd1 vssd1 vccd1 vssd1 SS_sky130_fd_sc_hd__dfxtp_2
XFILLER_128_165 vssd1 vccd1 vssd1 vccd1 SS_sky130_ef_sc_hd__decap_40_12
Xwire382 vccd1 vssd1 vssd1 vccd1 wire382/A wbs_dat_o[11] SS_sky130_fd_sc_hd__buf_12
Xwire371 vccd1 vssd1 vssd1 vccd1 wire371/A wbs_dat_o[21] SS_sky130_fd_sc_hd__buf_12
XFILLER_116_305 vssd1 vccd1 vccd1 vssd1 SS_sky130_fd_sc_hd__fill_2
Xwire393 vccd1 vssd1 vssd1 vccd1 wire393/A analog_ctrl[88] SS_sky130_fd_sc_hd__buf_12
XFILLER_132_809 vssd1 vccd1 vccd1 vssd1 SS_sky130_fd_sc_hd__fill_2
XFILLER_99_81 vssd1 vccd1 vssd1 vccd1 SS_sky130_ef_sc_hd__decap_40_12
XTAP_TAPCELL_ROW_133_2297 vccd1 vssd1 SS_sky130_fd_sc_hd__tapvpwrvgnd_1
XFILLER_98_701 vssd1 vccd1 vccd1 vssd1 SS_sky130_fd_sc_hd__fill_4
XFILLER_112_533 vssd1 vccd1 vccd1 vssd1 SS_sky130_fd_sc_hd__fill_8
XFILLER_39_801 vssd1 vccd1 vssd1 vccd1 SS_sky130_ef_sc_hd__decap_40_12
XFILLER_85_417 vssd1 vccd1 vccd1 vssd1 SS_sky130_fd_sc_hd__fill_8
XFILLER_97_277 vssd1 vccd1 vccd1 vssd1 SS_sky130_fd_sc_hd__fill_2
XFILLER_66_631 vssd1 vccd1 vccd1 vssd1 SS_sky130_fd_sc_hd__fill_4
XFILLER_97_299 vccd1 vssd1 vccd1 vssd1 SS_sky130_fd_sc_hd__fill_1
XFILLER_38_333 vssd1 vccd1 vssd1 vccd1 SS_sky130_ef_sc_hd__decap_40_12
XTAP_TAPCELL_ROW_107_1908 vccd1 vssd1 SS_sky130_fd_sc_hd__tapvpwrvgnd_1
XFILLER_38_377 vssd1 vccd1 vssd1 vccd1 SS_sky130_ef_sc_hd__decap_40_12
X_1116_ vccd1 vssd1 vccd1 vssd1 _1116_/X _1116_/A _1116_/B SS_sky130_fd_sc_hd__or2_2
XFILLER_93_472 vssd1 vccd1 vssd1 vccd1 SS_sky130_ef_sc_hd__decap_40_12
XTAP_TAPCELL_ROW_49_1037 vccd1 vssd1 SS_sky130_fd_sc_hd__tapvpwrvgnd_1
XFILLER_80_133 vssd1 vccd1 vccd1 vssd1 SS_sky130_fd_sc_hd__fill_4
XFILLER_0_81 vssd1 vccd1 vccd1 vssd1 SS_sky130_fd_sc_hd__fill_2
XFILLER_22_701 vssd1 vccd1 vssd1 vccd1 SS_sky130_ef_sc_hd__decap_40_12
X_1047_ vssd1 vccd1 vccd1 vssd1 _1065_/A2 input27/X _1047_/X _1309_/C1 _1046_/X SS_sky130_fd_sc_hd__o211a_2
XFILLER_34_572 vssd1 vccd1 vssd1 vccd1 SS_sky130_ef_sc_hd__decap_40_12
XTAP_TAPCELL_ROW_62_1226 vccd1 vssd1 SS_sky130_fd_sc_hd__tapvpwrvgnd_1
XTAP_TAPCELL_ROW_62_1237 vccd1 vssd1 SS_sky130_fd_sc_hd__tapvpwrvgnd_1
XFILLER_80_177 vssd1 vccd1 vssd1 vccd1 SS_sky130_ef_sc_hd__decap_40_12
XFILLER_110_27 vccd1 vssd1 vccd1 vssd1 SS_sky130_fd_sc_hd__fill_1
XFILLER_21_277 vssd1 vccd1 vccd1 vssd1 SS_sky130_fd_sc_hd__fill_2
XTAP_TAPCELL_ROW_32_773 vccd1 vssd1 SS_sky130_fd_sc_hd__tapvpwrvgnd_1
XTAP_TAPCELL_ROW_32_784 vccd1 vssd1 SS_sky130_fd_sc_hd__tapvpwrvgnd_1
XFILLER_135_625 vssd1 vccd1 vssd1 vccd1 SS_sky130_ef_sc_hd__decap_40_12
XFILLER_119_165 vssd1 vccd1 vccd1 vssd1 SS_sky130_fd_sc_hd__fill_2
XFILLER_119_69 vssd1 vccd1 vssd1 vccd1 SS_sky130_ef_sc_hd__decap_40_12
XFILLER_107_305 vssd1 vccd1 vssd1 vccd1 SS_sky130_ef_sc_hd__decap_40_12
XFILLER_135_669 vssd1 vccd1 vccd1 vssd1 SS_sky130_fd_sc_hd__fill_2
XFILLER_107_349 vssd1 vccd1 vssd1 vccd1 SS_sky130_ef_sc_hd__decap_40_12
XFILLER_88_233 vssd1 vccd1 vssd1 vccd1 SS_sky130_ef_sc_hd__decap_40_12
XFILLER_131_820 vssd1 vccd1 vccd1 vssd1 SS_sky130_fd_sc_hd__fill_4
XFILLER_115_393 vssd1 vccd1 vssd1 vccd1 SS_sky130_ef_sc_hd__decap_40_12
XFILLER_0_137 vssd1 vccd1 vccd1 vssd1 SS_sky130_fd_sc_hd__fill_2
XFILLER_49_609 vccd1 vssd1 vccd1 vssd1 SS_sky130_fd_sc_hd__fill_1
XTAP_TAPCELL_ROW_73_1388 vccd1 vssd1 SS_sky130_fd_sc_hd__tapvpwrvgnd_1
XTAP_TAPCELL_ROW_73_1399 vccd1 vssd1 SS_sky130_fd_sc_hd__tapvpwrvgnd_1
XFILLER_76_417 vssd1 vccd1 vccd1 vssd1 SS_sky130_fd_sc_hd__fill_2
XFILLER_135_57 vssd1 vccd1 vssd1 vccd1 SS_sky130_ef_sc_hd__decap_40_12
XFILLER_95_39 vssd1 vccd1 vssd1 vccd1 SS_sky130_ef_sc_hd__decap_40_12
XFILLER_88_277 vssd1 vccd1 vssd1 vccd1 SS_sky130_ef_sc_hd__decap_40_12
XFILLER_29_333 vssd1 vccd1 vccd1 vssd1 SS_sky130_fd_sc_hd__fill_2
XFILLER_57_653 vssd1 vccd1 vssd1 vccd1 SS_sky130_ef_sc_hd__decap_40_12
XFILLER_17_517 vssd1 vccd1 vssd1 vccd1 SS_sky130_ef_sc_hd__decap_40_12
XFILLER_28_77 vssd1 vccd1 vccd1 vssd1 SS_sky130_fd_sc_hd__fill_4
XFILLER_56_141 vssd1 vccd1 vssd1 vccd1 SS_sky130_ef_sc_hd__decap_40_12
XFILLER_57_697 vssd1 vccd1 vssd1 vccd1 SS_sky130_ef_sc_hd__decap_40_12
XFILLER_84_450 vssd1 vccd1 vccd1 vssd1 SS_sky130_fd_sc_hd__fill_4
XFILLER_71_111 vccd1 vssd1 vccd1 vssd1 SS_sky130_fd_sc_hd__fill_1
XFILLER_72_634 vssd1 vccd1 vccd1 vssd1 SS_sky130_fd_sc_hd__fill_2
XFILLER_25_561 vssd1 vccd1 vssd1 vccd1 SS_sky130_ef_sc_hd__decap_40_12
XFILLER_44_65 vssd1 vccd1 vssd1 vccd1 SS_sky130_ef_sc_hd__decap_40_12
XFILLER_9_727 vccd1 vssd1 vccd1 vssd1 SS_sky130_fd_sc_hd__fill_1
XFILLER_12_233 vssd1 vccd1 vssd1 vccd1 SS_sky130_ef_sc_hd__decap_40_12
XFILLER_40_531 vccd1 vssd1 vccd1 vssd1 SS_sky130_fd_sc_hd__fill_1
XFILLER_12_277 vssd1 vccd1 vssd1 vccd1 SS_sky130_ef_sc_hd__decap_40_12
XFILLER_60_53 vssd1 vccd1 vssd1 vccd1 SS_sky130_ef_sc_hd__decap_40_12
XTAP_TAPCELL_ROW_10_445 vccd1 vssd1 SS_sky130_fd_sc_hd__tapvpwrvgnd_1
XTAP_TAPCELL_ROW_10_456 vccd1 vssd1 SS_sky130_fd_sc_hd__tapvpwrvgnd_1
XFILLER_60_97 vssd1 vccd1 vssd1 vccd1 SS_sky130_ef_sc_hd__decap_40_12
XFILLER_125_113 vssd1 vccd1 vssd1 vccd1 SS_sky130_ef_sc_hd__decap_40_12
XFILLER_4_421 vssd1 vccd1 vssd1 vccd1 SS_sky130_ef_sc_hd__decap_40_12
XFILLER_5_15 vssd1 vccd1 vssd1 vccd1 SS_sky130_ef_sc_hd__decap_40_12
XFILLER_69_51 vssd1 vccd1 vccd1 vssd1 SS_sky130_fd_sc_hd__fill_4
XFILLER_121_330 vccd1 vssd1 vccd1 vssd1 SS_sky130_fd_sc_hd__fill_1
XFILLER_0_671 vccd1 vssd1 vccd1 vssd1 SS_sky130_fd_sc_hd__fill_1
XFILLER_79_277 vssd1 vccd1 vccd1 vssd1 SS_sky130_fd_sc_hd__fill_2
XPHY_EDGE_ROW_13_Right_13 vccd1 vssd1 vccd1 vssd1 SS_sky130_fd_sc_hd__decap_3
XFILLER_48_642 vssd1 vccd1 vccd1 vssd1 SS_sky130_fd_sc_hd__fill_2
XFILLER_48_697 vssd1 vccd1 vccd1 vssd1 SS_sky130_fd_sc_hd__fill_2
XFILLER_75_461 vssd1 vccd1 vssd1 vccd1 SS_sky130_ef_sc_hd__decap_40_12
XFILLER_62_133 vssd1 vccd1 vccd1 vssd1 SS_sky130_fd_sc_hd__fill_4
XTAP_TAPCELL_ROW_18_567 vccd1 vssd1 SS_sky130_fd_sc_hd__tapvpwrvgnd_1
XFILLER_51_807 vccd1 vssd1 vccd1 vssd1 SS_sky130_fd_sc_hd__fill_1
XFILLER_90_475 vccd1 vssd1 vccd1 vssd1 SS_sky130_fd_sc_hd__fill_1
XFILLER_62_177 vssd1 vccd1 vssd1 vccd1 SS_sky130_ef_sc_hd__decap_40_12
XFILLER_90_497 vssd1 vccd1 vssd1 vccd1 SS_sky130_ef_sc_hd__decap_40_12
XTAP_TAPCELL_ROW_102_1827 vccd1 vssd1 SS_sky130_fd_sc_hd__tapvpwrvgnd_1
XFILLER_31_553 vssd1 vccd1 vccd1 vssd1 SS_sky130_fd_sc_hd__fill_4
XFILLER_43_391 vccd1 vssd1 vccd1 vssd1 SS_sky130_fd_sc_hd__fill_1
XPHY_EDGE_ROW_22_Right_22 vccd1 vssd1 vccd1 vssd1 SS_sky130_fd_sc_hd__decap_3
XFILLER_129_430 vssd1 vccd1 vssd1 vccd1 SS_sky130_ef_sc_hd__decap_40_12
XTAP_TAPCELL_ROW_135_2326 vccd1 vssd1 SS_sky130_fd_sc_hd__tapvpwrvgnd_1
X_1734_ _1898_/A clkload8/A _1734_/D vccd1 vssd1 vccd1 vssd1 SS_sky130_fd_sc_hd__dfxtp_2
XFILLER_129_485 vssd1 vccd1 vssd1 vccd1 SS_sky130_ef_sc_hd__decap_40_12
XFILLER_117_625 vssd1 vccd1 vccd1 vssd1 SS_sky130_fd_sc_hd__fill_2
XFILLER_7_281 vssd1 vccd1 vssd1 vccd1 SS_sky130_ef_sc_hd__decap_40_12
XFILLER_8_793 vssd1 vccd1 vssd1 vccd1 SS_sky130_ef_sc_hd__decap_40_12
XFILLER_117_658 vssd1 vccd1 vssd1 vccd1 SS_sky130_ef_sc_hd__decap_40_12
XFILLER_105_809 vssd1 vccd1 vccd1 vssd1 SS_sky130_fd_sc_hd__fill_4
XFILLER_131_105 vssd1 vccd1 vccd1 vssd1 SS_sky130_fd_sc_hd__fill_4
X_1665_ _1665_/Q _1761_/CLK _1665_/D vccd1 vssd1 vccd1 vssd1 SS_sky130_fd_sc_hd__dfxtp_2
X_1596_ _1596_/Q _1692_/CLK _1596_/D vccd1 vssd1 vccd1 vssd1 SS_sky130_fd_sc_hd__dfxtp_2
XFILLER_113_820 vssd1 vccd1 vccd1 vssd1 SS_sky130_fd_sc_hd__fill_4
XFILLER_131_149 vssd1 vccd1 vssd1 vccd1 SS_sky130_ef_sc_hd__decap_40_12
XTAP_TAPCELL_ROW_113_1989 vccd1 vssd1 SS_sky130_fd_sc_hd__tapvpwrvgnd_1
XPHY_EDGE_ROW_31_Right_31 vccd1 vssd1 vccd1 vssd1 SS_sky130_fd_sc_hd__decap_3
XFILLER_85_225 vssd1 vccd1 vssd1 vccd1 SS_sky130_ef_sc_hd__decap_40_12
XFILLER_112_363 vccd1 vssd1 vccd1 vssd1 SS_sky130_fd_sc_hd__fill_1
XFILLER_105_27 vssd1 vccd1 vssd1 vccd1 SS_sky130_ef_sc_hd__decap_40_12
XFILLER_39_631 vssd1 vccd1 vccd1 vssd1 SS_sky130_fd_sc_hd__fill_2
XFILLER_38_141 vssd1 vccd1 vssd1 vccd1 SS_sky130_ef_sc_hd__decap_40_12
XFILLER_54_601 vssd1 vccd1 vssd1 vccd1 SS_sky130_ef_sc_hd__decap_40_12
XFILLER_53_111 vccd1 vssd1 vccd1 vssd1 SS_sky130_fd_sc_hd__fill_1
XFILLER_54_645 vssd1 vccd1 vssd1 vccd1 SS_sky130_ef_sc_hd__decap_40_12
XFILLER_94_792 vssd1 vccd1 vccd1 vssd1 SS_sky130_fd_sc_hd__fill_2
XTAP_TAPCELL_ROW_37_854 vccd1 vssd1 SS_sky130_fd_sc_hd__tapvpwrvgnd_1
XFILLER_41_317 vssd1 vccd1 vssd1 vccd1 SS_sky130_ef_sc_hd__decap_40_12
XFILLER_81_497 vssd1 vccd1 vccd1 vssd1 SS_sky130_fd_sc_hd__fill_4
XFILLER_22_531 vccd1 vssd1 vccd1 vssd1 SS_sky130_fd_sc_hd__fill_1
XPHY_EDGE_ROW_40_Right_40 vccd1 vssd1 vccd1 vssd1 SS_sky130_fd_sc_hd__decap_3
XFILLER_10_737 vssd1 vccd1 vssd1 vccd1 SS_sky130_ef_sc_hd__decap_40_12
XFILLER_135_411 vccd1 vssd1 vccd1 vssd1 SS_sky130_fd_sc_hd__fill_1
XFILLER_108_625 vssd1 vccd1 vssd1 vccd1 SS_sky130_ef_sc_hd__decap_40_12
XFILLER_107_113 vssd1 vccd1 vssd1 vccd1 SS_sky130_ef_sc_hd__decap_40_12
XTAP_TAPCELL_ROW_75_1428 vccd1 vssd1 SS_sky130_fd_sc_hd__tapvpwrvgnd_1
XFILLER_123_617 vssd1 vccd1 vccd1 vssd1 SS_sky130_fd_sc_hd__fill_4
Xhold771 _1120_/A _1865_/A vccd1 vssd1 vssd1 vccd1 SS_sky130_fd_sc_hd__dlygate4sd3_1
Xhold782 _1378_/A _1716_/Q vccd1 vssd1 vssd1 vccd1 SS_sky130_fd_sc_hd__dlygate4sd3_1
Xhold760 _1304_/A _1680_/Q vccd1 vssd1 vssd1 vccd1 SS_sky130_fd_sc_hd__dlygate4sd3_1
Xhold793 _1506_/D _0944_/X vccd1 vssd1 vssd1 vccd1 SS_sky130_fd_sc_hd__dlygate4sd3_1
XFILLER_49_417 vssd1 vccd1 vssd1 vccd1 SS_sky130_ef_sc_hd__decap_40_12
XFILLER_130_193 vssd1 vccd1 vccd1 vssd1 SS_sky130_fd_sc_hd__fill_2
XFILLER_91_217 vssd1 vccd1 vccd1 vssd1 SS_sky130_fd_sc_hd__fill_4
XFILLER_57_494 vssd1 vccd1 vccd1 vssd1 SS_sky130_fd_sc_hd__fill_8
XFILLER_44_133 vssd1 vccd1 vccd1 vssd1 SS_sky130_fd_sc_hd__fill_4
XTAP_TAPCELL_ROW_15_526 vccd1 vssd1 SS_sky130_fd_sc_hd__tapvpwrvgnd_1
XFILLER_44_177 vssd1 vccd1 vssd1 vccd1 SS_sky130_ef_sc_hd__decap_40_12
XFILLER_72_475 vccd1 vssd1 vccd1 vssd1 SS_sky130_fd_sc_hd__fill_1
XFILLER_13_553 vssd1 vccd1 vccd1 vssd1 SS_sky130_fd_sc_hd__fill_4
XFILLER_25_391 vccd1 vssd1 vccd1 vssd1 SS_sky130_fd_sc_hd__fill_1
XFILLER_71_30 vssd1 vccd1 vssd1 vccd1 SS_sky130_ef_sc_hd__decap_40_12
XFILLER_111_81 vssd1 vccd1 vssd1 vccd1 SS_sky130_ef_sc_hd__decap_40_12
XFILLER_40_361 vssd1 vccd1 vccd1 vssd1 SS_sky130_fd_sc_hd__fill_2
XFILLER_9_557 vssd1 vccd1 vccd1 vssd1 SS_sky130_fd_sc_hd__fill_2
XFILLER_13_597 vssd1 vccd1 vssd1 vccd1 SS_sky130_ef_sc_hd__decap_40_12
XTAP_TAPCELL_ROW_117_2056 vccd1 vssd1 SS_sky130_fd_sc_hd__tapvpwrvgnd_1
XFILLER_5_741 vssd1 vccd1 vssd1 vccd1 SS_sky130_ef_sc_hd__decap_40_12
XFILLER_4_251 vccd1 vssd1 vccd1 vssd1 SS_sky130_fd_sc_hd__fill_1
XFILLER_126_477 vssd1 vccd1 vccd1 vssd1 SS_sky130_fd_sc_hd__fill_2
XFILLER_114_617 vssd1 vccd1 vccd1 vssd1 SS_sky130_fd_sc_hd__fill_2
XFILLER_99_317 vssd1 vccd1 vssd1 vccd1 SS_sky130_ef_sc_hd__decap_40_12
XFILLER_5_785 vssd1 vccd1 vssd1 vccd1 SS_sky130_ef_sc_hd__decap_40_12
X_1450_ vccd1 vssd1 vccd1 vssd1 _1450_/X _1450_/A _1454_/B SS_sky130_fd_sc_hd__or2_2
XTAP_TAPCELL_ROW_130_2245 vccd1 vssd1 SS_sky130_fd_sc_hd__tapvpwrvgnd_1
XTAP_TAPCELL_ROW_130_2256 vccd1 vssd1 SS_sky130_fd_sc_hd__tapvpwrvgnd_1
XFILLER_113_105 vssd1 vccd1 vccd1 vssd1 SS_sky130_fd_sc_hd__fill_4
X_1381_ vssd1 vccd1 vccd1 vssd1 _1391_/A2 input29/X _1717_/D _1381_/C1 _1380_/X SS_sky130_fd_sc_hd__o211a_2
XFILLER_113_149 vssd1 vccd1 vssd1 vccd1 SS_sky130_ef_sc_hd__decap_40_12
XFILLER_67_225 vssd1 vccd1 vssd1 vccd1 SS_sky130_ef_sc_hd__decap_40_12
XFILLER_95_534 vssd1 vccd1 vssd1 vccd1 SS_sky130_ef_sc_hd__decap_40_12
XFILLER_95_501 vssd1 vccd1 vccd1 vssd1 SS_sky130_fd_sc_hd__fill_2
XFILLER_121_193 vssd1 vccd1 vssd1 vccd1 SS_sky130_ef_sc_hd__decap_40_12
XFILLER_55_409 vssd1 vccd1 vccd1 vssd1 SS_sky130_fd_sc_hd__fill_2
XFILLER_83_729 vssd1 vccd1 vssd1 vccd1 SS_sky130_ef_sc_hd__decap_40_12
XFILLER_35_111 vccd1 vssd1 vccd1 vssd1 SS_sky130_fd_sc_hd__fill_1
XFILLER_36_645 vssd1 vccd1 vssd1 vccd1 SS_sky130_ef_sc_hd__decap_40_12
XPHY_EDGE_ROW_11_Left_150 vccd1 vssd1 vccd1 vssd1 SS_sky130_fd_sc_hd__decap_3
XFILLER_24_807 vssd1 vccd1 vccd1 vssd1 SS_sky130_fd_sc_hd__fill_4
XFILLER_23_317 vssd1 vccd1 vssd1 vccd1 SS_sky130_ef_sc_hd__decap_40_12
XTAP_TAPCELL_ROW_34_813 vccd1 vssd1 SS_sky130_fd_sc_hd__tapvpwrvgnd_1
XFILLER_51_615 vccd1 vssd1 vccd1 vssd1 SS_sky130_fd_sc_hd__fill_1
XFILLER_63_497 vssd1 vccd1 vccd1 vssd1 SS_sky130_fd_sc_hd__fill_4
XFILLER_31_361 vssd1 vccd1 vssd1 vccd1 SS_sky130_ef_sc_hd__decap_40_12
XFILLER_137_709 vssd1 vccd1 vccd1 vssd1 SS_sky130_fd_sc_hd__fill_2
XFILLER_129_293 vssd1 vccd1 vccd1 vssd1 SS_sky130_fd_sc_hd__fill_8
X_1717_ _1717_/Q _1717_/CLK _1717_/D vccd1 vssd1 vccd1 vssd1 SS_sky130_fd_sc_hd__dfxtp_2
XFILLER_105_617 vssd1 vccd1 vccd1 vssd1 SS_sky130_fd_sc_hd__fill_4
XTAP_TAPCELL_ROW_57_1158 vccd1 vssd1 SS_sky130_fd_sc_hd__tapvpwrvgnd_1
X_1648_ _1648_/Q clkload5/A _1648_/D vccd1 vssd1 vccd1 vssd1 SS_sky130_fd_sc_hd__dfxtp_2
XFILLER_132_458 vssd1 vccd1 vssd1 vccd1 SS_sky130_ef_sc_hd__decap_40_12
XFILLER_116_26 vssd1 vccd1 vccd1 vssd1 SS_sky130_fd_sc_hd__fill_2
X_1579_ _1853_/A clkload3/A _1579_/D vccd1 vssd1 vccd1 vssd1 SS_sky130_fd_sc_hd__dfxtp_2
XTAP_TAPCELL_ROW_70_1347 vccd1 vssd1 SS_sky130_fd_sc_hd__tapvpwrvgnd_1
XFILLER_86_501 vssd1 vccd1 vssd1 vccd1 SS_sky130_ef_sc_hd__decap_40_12
XFILLER_86_545 vssd1 vccd1 vssd1 vccd1 SS_sky130_ef_sc_hd__decap_40_12
XFILLER_112_193 vssd1 vccd1 vccd1 vssd1 SS_sky130_fd_sc_hd__fill_2
XFILLER_100_333 vssd1 vccd1 vssd1 vccd1 SS_sky130_ef_sc_hd__decap_40_12
XFILLER_73_217 vssd1 vccd1 vccd1 vssd1 SS_sky130_fd_sc_hd__fill_4
XFILLER_86_589 vssd1 vccd1 vssd1 vccd1 SS_sky130_ef_sc_hd__decap_40_12
XFILLER_100_377 vssd1 vccd1 vssd1 vccd1 SS_sky130_ef_sc_hd__decap_40_12
XFILLER_67_781 vssd1 vccd1 vccd1 vssd1 SS_sky130_fd_sc_hd__fill_2
XFILLER_26_133 vssd1 vccd1 vccd1 vssd1 SS_sky130_fd_sc_hd__fill_4
XFILLER_54_453 vccd1 vssd1 vccd1 vssd1 SS_sky130_fd_sc_hd__fill_1
XFILLER_92_29 vssd1 vccd1 vssd1 vccd1 SS_sky130_ef_sc_hd__decap_40_12
XFILLER_26_177 vssd1 vccd1 vssd1 vccd1 SS_sky130_ef_sc_hd__decap_40_12
XFILLER_54_475 vccd1 vssd1 vccd1 vssd1 SS_sky130_fd_sc_hd__fill_1
XFILLER_81_261 vssd1 vccd1 vssd1 vccd1 SS_sky130_ef_sc_hd__decap_40_12
XFILLER_41_125 vssd1 vccd1 vssd1 vccd1 SS_sky130_ef_sc_hd__decap_40_12
XFILLER_10_501 vssd1 vccd1 vssd1 vccd1 SS_sky130_ef_sc_hd__decap_40_12
XFILLER_22_361 vssd1 vccd1 vccd1 vssd1 SS_sky130_fd_sc_hd__fill_2
XFILLER_41_169 vssd1 vccd1 vssd1 vccd1 SS_sky130_ef_sc_hd__decap_40_12
XFILLER_10_545 vssd1 vccd1 vssd1 vccd1 SS_sky130_ef_sc_hd__decap_40_12
XFILLER_10_589 vssd1 vccd1 vssd1 vccd1 SS_sky130_ef_sc_hd__decap_40_12
XTAP_TAPCELL_ROW_20_595 vccd1 vssd1 SS_sky130_fd_sc_hd__tapvpwrvgnd_1
XFILLER_1_221 vssd1 vccd1 vccd1 vssd1 SS_sky130_fd_sc_hd__fill_2
XFILLER_2_755 vccd1 vssd1 vccd1 vssd1 SS_sky130_fd_sc_hd__fill_1
Xhold590 input20/A wbs_dat_i[0] vccd1 vssd1 vssd1 vccd1 SS_sky130_fd_sc_hd__dlygate4sd3_1
XFILLER_123_469 vssd1 vccd1 vssd1 vccd1 SS_sky130_ef_sc_hd__decap_40_12
XFILLER_96_309 vccd1 vssd1 vccd1 vssd1 SS_sky130_fd_sc_hd__fill_1
XFILLER_77_501 vssd1 vccd1 vccd1 vssd1 SS_sky130_fd_sc_hd__fill_2
XFILLER_89_383 vssd1 vccd1 vccd1 vssd1 SS_sky130_fd_sc_hd__fill_8
XFILLER_2_27 vccd1 vssd1 vccd1 vssd1 SS_sky130_fd_sc_hd__fill_1
XFILLER_49_225 vssd1 vccd1 vssd1 vccd1 SS_sky130_ef_sc_hd__decap_40_12
XFILLER_77_556 vssd1 vccd1 vccd1 vssd1 SS_sky130_fd_sc_hd__fill_4
XFILLER_106_81 vssd1 vccd1 vccd1 vssd1 SS_sky130_fd_sc_hd__fill_2
XFILLER_103_193 vssd1 vccd1 vssd1 vccd1 SS_sky130_ef_sc_hd__decap_40_12
XFILLER_18_601 vssd1 vccd1 vssd1 vccd1 SS_sky130_ef_sc_hd__decap_40_12
XFILLER_65_729 vssd1 vccd1 vccd1 vssd1 SS_sky130_fd_sc_hd__fill_4
XFILLER_66_41 vssd1 vccd1 vssd1 vccd1 SS_sky130_ef_sc_hd__decap_40_12
XTAP_TAPCELL_ROW_88_1619 vccd1 vssd1 SS_sky130_fd_sc_hd__tapvpwrvgnd_1
XFILLER_17_111 vccd1 vssd1 vccd1 vssd1 SS_sky130_fd_sc_hd__fill_1
XFILLER_18_645 vssd1 vccd1 vssd1 vccd1 SS_sky130_ef_sc_hd__decap_40_12
XFILLER_66_85 vssd1 vccd1 vssd1 vccd1 SS_sky130_ef_sc_hd__decap_40_12
XFILLER_33_615 vccd1 vssd1 vccd1 vssd1 SS_sky130_fd_sc_hd__fill_1
XFILLER_45_497 vssd1 vccd1 vccd1 vssd1 SS_sky130_fd_sc_hd__fill_2
XFILLER_60_401 vssd1 vccd1 vccd1 vssd1 SS_sky130_fd_sc_hd__fill_2
XFILLER_60_445 vssd1 vccd1 vccd1 vssd1 SS_sky130_fd_sc_hd__fill_8
XFILLER_13_361 vssd1 vccd1 vssd1 vccd1 SS_sky130_ef_sc_hd__decap_40_12
XFILLER_20_309 vssd1 vccd1 vssd1 vccd1 SS_sky130_ef_sc_hd__decap_40_12
X_0950_ vccd1 vssd1 vccd1 vssd1 _0950_/X _1836_/A _0988_/B SS_sky130_fd_sc_hd__or2_2
XFILLER_60_489 vssd1 vccd1 vccd1 vssd1 SS_sky130_fd_sc_hd__fill_4
XFILLER_119_709 vssd1 vccd1 vssd1 vccd1 SS_sky130_ef_sc_hd__decap_40_12
X_0881_ vccd1 vssd1 vccd1 vssd1 _1656_/Q _0748_/X _1720_/Q wire452/X _0883_/B SS_sky130_fd_sc_hd__a22o_2
XPHY_EDGE_ROW_124_Right_124 vccd1 vssd1 vccd1 vssd1 SS_sky130_fd_sc_hd__decap_3
Xoutput106 vccd1 vssd1 wire338/A _1829_/X vccd1 vssd1 SS_sky130_fd_sc_hd__buf_4
XFILLER_127_764 vssd1 vccd1 vccd1 vssd1 SS_sky130_fd_sc_hd__fill_2
Xoutput117 vccd1 vssd1 wire327/A _1830_/X vccd1 vssd1 SS_sky130_fd_sc_hd__buf_4
Xoutput128 vccd1 vssd1 wire316/A _1831_/X vccd1 vssd1 SS_sky130_fd_sc_hd__buf_4
Xoutput139 vccd1 vssd1 wire311/A _1832_/X vccd1 vssd1 SS_sky130_fd_sc_hd__buf_4
X_1502_ _1502_/Q _1634_/CLK _1502_/D vccd1 vssd1 vccd1 vssd1 SS_sky130_fd_sc_hd__dfxtp_2
XFILLER_114_425 vccd1 vssd1 vccd1 vssd1 SS_sky130_fd_sc_hd__fill_1
XFILLER_99_125 vssd1 vccd1 vssd1 vccd1 SS_sky130_ef_sc_hd__decap_40_12
XFILLER_49_3 vssd1 vccd1 vssd1 vccd1 SS_sky130_ef_sc_hd__decap_40_12
X_1433_ vssd1 vccd1 vccd1 vssd1 wire207/X wire500/X _1742_/D _1447_/C1 _1432_/X SS_sky130_fd_sc_hd__o211a_2
XFILLER_99_169 vssd1 vccd1 vssd1 vccd1 SS_sky130_ef_sc_hd__decap_40_12
XFILLER_68_501 vssd1 vccd1 vssd1 vccd1 SS_sky130_ef_sc_hd__decap_40_12
XTAP_TAPCELL_ROW_110_1948 vccd1 vssd1 SS_sky130_fd_sc_hd__tapvpwrvgnd_1
XFILLER_68_545 vssd1 vccd1 vssd1 vccd1 SS_sky130_ef_sc_hd__decap_40_12
X_1364_ vccd1 vssd1 vccd1 vssd1 _1364_/X _1364_/A _1404_/B SS_sky130_fd_sc_hd__or2_2
XFILLER_95_320 vssd1 vccd1 vssd1 vccd1 SS_sky130_ef_sc_hd__decap_40_12
XTAP_TAPCELL_ROW_52_1077 vccd1 vssd1 SS_sky130_fd_sc_hd__tapvpwrvgnd_1
X_1295_ vssd1 vccd1 vccd1 vssd1 _1319_/A2 wire495/X _1675_/D _1295_/C1 _1294_/X SS_sky130_fd_sc_hd__o211a_2
XFILLER_68_589 vssd1 vccd1 vssd1 vccd1 SS_sky130_ef_sc_hd__decap_40_12
XFILLER_49_781 vssd1 vccd1 vccd1 vssd1 SS_sky130_fd_sc_hd__fill_2
XFILLER_55_217 vssd1 vccd1 vccd1 vssd1 SS_sky130_fd_sc_hd__fill_4
XFILLER_95_386 vssd1 vccd1 vccd1 vssd1 SS_sky130_fd_sc_hd__fill_4
XFILLER_70_209 vssd1 vccd1 vssd1 vccd1 SS_sky130_ef_sc_hd__decap_40_12
XFILLER_36_475 vccd1 vssd1 vccd1 vssd1 SS_sky130_fd_sc_hd__fill_1
XFILLER_63_261 vssd1 vccd1 vssd1 vccd1 SS_sky130_ef_sc_hd__decap_40_12
XFILLER_23_125 vssd1 vccd1 vssd1 vccd1 SS_sky130_ef_sc_hd__decap_40_12
XFILLER_51_445 vssd1 vccd1 vccd1 vssd1 SS_sky130_fd_sc_hd__fill_2
XFILLER_20_810 vssd1 vccd1 vccd1 vssd1 SS_sky130_fd_sc_hd__fill_2
XFILLER_23_169 vssd1 vccd1 vssd1 vccd1 SS_sky130_ef_sc_hd__decap_40_12
XFILLER_11_69 vssd1 vccd1 vssd1 vccd1 SS_sky130_ef_sc_hd__decap_40_12
XFILLER_78_309 vssd1 vccd1 vccd1 vssd1 SS_sky130_fd_sc_hd__fill_4
XFILLER_132_233 vssd1 vccd1 vssd1 vccd1 SS_sky130_ef_sc_hd__decap_40_12
XFILLER_127_69 vssd1 vccd1 vssd1 vccd1 SS_sky130_ef_sc_hd__decap_40_12
XFILLER_132_277 vssd1 vccd1 vssd1 vccd1 SS_sky130_ef_sc_hd__decap_40_12
XFILLER_120_417 vssd1 vccd1 vccd1 vssd1 SS_sky130_fd_sc_hd__fill_2
XFILLER_120_439 vssd1 vccd1 vssd1 vccd1 SS_sky130_ef_sc_hd__decap_40_12
XFILLER_47_729 vssd1 vccd1 vssd1 vccd1 SS_sky130_ef_sc_hd__decap_40_12
XFILLER_59_589 vssd1 vccd1 vccd1 vssd1 SS_sky130_fd_sc_hd__fill_2
XFILLER_86_353 vssd1 vccd1 vccd1 vssd1 SS_sky130_fd_sc_hd__fill_8
XFILLER_101_653 vssd1 vccd1 vssd1 vccd1 SS_sky130_ef_sc_hd__decap_40_12
XFILLER_100_141 vssd1 vccd1 vssd1 vccd1 SS_sky130_ef_sc_hd__decap_40_12
XFILLER_86_386 vssd1 vccd1 vssd1 vccd1 SS_sky130_ef_sc_hd__decap_40_12
XFILLER_15_615 vccd1 vssd1 vccd1 vssd1 SS_sky130_fd_sc_hd__fill_1
XFILLER_36_77 vssd1 vccd1 vccd1 vssd1 SS_sky130_fd_sc_hd__fill_4
XFILLER_42_401 vssd1 vccd1 vssd1 vccd1 SS_sky130_ef_sc_hd__decap_40_12
XFILLER_27_497 vssd1 vccd1 vccd1 vssd1 SS_sky130_fd_sc_hd__fill_4
XTAP_TAPCELL_ROW_83_1538 vccd1 vssd1 SS_sky130_fd_sc_hd__tapvpwrvgnd_1
XTAP_TAPCELL_ROW_83_1549 vccd1 vssd1 SS_sky130_fd_sc_hd__tapvpwrvgnd_1
XTAP_TAPCELL_ROW_25_676 vccd1 vssd1 SS_sky130_fd_sc_hd__tapvpwrvgnd_1
XFILLER_42_489 vssd1 vccd1 vccd1 vssd1 SS_sky130_fd_sc_hd__fill_4
Xclkbuf_leaf_24_wb_clk_i clkload8/A clkload1/A vccd1 vssd1 vssd1 vccd1 SS_sky130_fd_sc_hd__clkbuf_8
XFILLER_52_65 vssd1 vccd1 vssd1 vccd1 SS_sky130_ef_sc_hd__decap_40_12
Xinput19 vssd1 vccd1 vccd1 vssd1 wbs_cyc_i _0945_/C SS_sky130_fd_sc_hd__clkdlybuf4s25_1
XTAP_TAPCELL_ROW_114_2004 vccd1 vssd1 SS_sky130_fd_sc_hd__tapvpwrvgnd_1
XFILLER_6_357 vssd1 vccd1 vccd1 vssd1 SS_sky130_fd_sc_hd__fill_4
XTAP_TAPCELL_ROW_114_2015 vccd1 vssd1 SS_sky130_fd_sc_hd__tapvpwrvgnd_1
XFILLER_109_753 vssd1 vccd1 vssd1 vccd1 SS_sky130_ef_sc_hd__decap_40_12
XTAP_TAPCELL_ROW_98_1770 vccd1 vssd1 SS_sky130_fd_sc_hd__tapvpwrvgnd_1
XFILLER_136_572 vssd1 vccd1 vccd1 vssd1 SS_sky130_fd_sc_hd__fill_4
XFILLER_124_734 vssd1 vccd1 vssd1 vccd1 SS_sky130_ef_sc_hd__decap_40_12
XFILLER_123_277 vssd1 vccd1 vccd1 vssd1 SS_sky130_fd_sc_hd__fill_2
XFILLER_111_428 vssd1 vccd1 vssd1 vccd1 SS_sky130_ef_sc_hd__decap_40_12
XFILLER_2_585 vssd1 vccd1 vccd1 vssd1 SS_sky130_fd_sc_hd__fill_2
XFILLER_77_51 vssd1 vccd1 vccd1 vssd1 SS_sky130_fd_sc_hd__fill_4
XFILLER_96_139 vccd1 vssd1 vccd1 vssd1 SS_sky130_fd_sc_hd__fill_1
XFILLER_38_718 vssd1 vccd1 vssd1 vccd1 SS_sky130_ef_sc_hd__decap_40_12
XFILLER_37_217 vssd1 vccd1 vccd1 vssd1 SS_sky130_fd_sc_hd__fill_4
XFILLER_65_526 vccd1 vssd1 vccd1 vssd1 SS_sky130_fd_sc_hd__fill_1
XFILLER_92_301 vssd1 vccd1 vccd1 vssd1 SS_sky130_fd_sc_hd__fill_4
X_1080_ vccd1 vssd1 vccd1 vssd1 _1080_/X _1841_/A _1116_/B SS_sky130_fd_sc_hd__or2_2
XFILLER_65_559 vccd1 vssd1 vccd1 vssd1 SS_sky130_fd_sc_hd__fill_1
XTAP_TAPCELL_ROW_125_2177 vccd1 vssd1 SS_sky130_fd_sc_hd__tapvpwrvgnd_1
XFILLER_92_345 vssd1 vccd1 vssd1 vccd1 SS_sky130_ef_sc_hd__decap_40_12
XFILLER_18_475 vccd1 vssd1 vccd1 vssd1 SS_sky130_fd_sc_hd__fill_1
XFILLER_45_261 vssd1 vccd1 vssd1 vccd1 SS_sky130_ef_sc_hd__decap_40_12
XFILLER_52_209 vssd1 vccd1 vssd1 vccd1 SS_sky130_ef_sc_hd__decap_40_12
XFILLER_61_721 vssd1 vccd1 vccd1 vssd1 SS_sky130_fd_sc_hd__fill_4
XFILLER_80_529 vssd1 vccd1 vccd1 vssd1 SS_sky130_fd_sc_hd__fill_2
XFILLER_92_389 vssd1 vccd1 vssd1 vccd1 SS_sky130_ef_sc_hd__decap_40_12
XFILLER_33_445 vssd1 vccd1 vccd1 vssd1 SS_sky130_fd_sc_hd__fill_2
XFILLER_21_629 vssd1 vccd1 vssd1 vccd1 SS_sky130_ef_sc_hd__decap_40_12
XTAP_TAPCELL_ROW_44_963 vccd1 vssd1 SS_sky130_fd_sc_hd__tapvpwrvgnd_1
XFILLER_60_253 vssd1 vccd1 vssd1 vccd1 SS_sky130_ef_sc_hd__decap_40_12
XFILLER_61_776 vssd1 vccd1 vccd1 vssd1 SS_sky130_fd_sc_hd__fill_8
XFILLER_14_681 vssd1 vccd1 vssd1 vccd1 SS_sky130_ef_sc_hd__decap_40_12
XFILLER_20_139 vccd1 vssd1 vccd1 vssd1 SS_sky130_fd_sc_hd__fill_1
X_0933_ vccd1 vssd1 vccd1 vssd1 _1601_/Q wire445/A _1729_/Q wire455/X _0933_/X SS_sky130_fd_sc_hd__a22o_2
XFILLER_119_517 vssd1 vccd1 vssd1 vccd1 SS_sky130_ef_sc_hd__decap_40_12
X_0864_ vccd1 vssd1 vccd1 vssd1 _1557_/Q wire424/A _1749_/Q _0874_/A2 _0864_/X SS_sky130_fd_sc_hd__a22o_2
XFILLER_127_561 vssd1 vccd1 vssd1 vccd1 SS_sky130_ef_sc_hd__decap_40_12
X_0795_ vccd1 vssd1 vccd1 vssd1 input10/X wire433/X _1852_/A wire443/X _0795_/X SS_sky130_fd_sc_hd__a22o_2
XTAP_TAPCELL_ROW_54_1106 vccd1 vssd1 SS_sky130_fd_sc_hd__tapvpwrvgnd_1
XTAP_TAPCELL_ROW_54_1117 vccd1 vssd1 SS_sky130_fd_sc_hd__tapvpwrvgnd_1
XFILLER_114_233 vssd1 vccd1 vssd1 vccd1 SS_sky130_ef_sc_hd__decap_40_12
XFILLER_114_277 vssd1 vccd1 vssd1 vccd1 SS_sky130_ef_sc_hd__decap_40_12
XFILLER_102_428 vssd1 vccd1 vssd1 vccd1 SS_sky130_ef_sc_hd__decap_40_12
X_1416_ vccd1 vssd1 vccd1 vssd1 _1416_/X _1416_/A _1466_/B SS_sky130_fd_sc_hd__or2_2
XFILLER_3_81 vssd1 vccd1 vssd1 vccd1 SS_sky130_ef_sc_hd__decap_40_12
X_1347_ vssd1 vccd1 vccd1 vssd1 _1405_/A2 input31/X _1700_/D _1439_/C1 _1346_/X SS_sky130_fd_sc_hd__o211a_2
XFILLER_84_813 vssd1 vccd1 vccd1 vssd1 SS_sky130_fd_sc_hd__fill_4
XFILLER_96_673 vssd1 vccd1 vssd1 vccd1 SS_sky130_ef_sc_hd__decap_40_12
XTAP_TAPCELL_ROW_3_338 vccd1 vssd1 SS_sky130_fd_sc_hd__tapvpwrvgnd_1
XTAP_TAPCELL_ROW_3_349 vccd1 vssd1 SS_sky130_fd_sc_hd__tapvpwrvgnd_1
XFILLER_84_835 vccd1 vssd1 vccd1 vssd1 SS_sky130_fd_sc_hd__fill_1
XFILLER_110_494 vssd1 vccd1 vssd1 vccd1 SS_sky130_ef_sc_hd__decap_40_12
XFILLER_95_161 vssd1 vccd1 vccd1 vssd1 SS_sky130_fd_sc_hd__fill_4
X_1278_ vccd1 vssd1 vccd1 vssd1 _1278_/X _1891_/A _1338_/B SS_sky130_fd_sc_hd__or2_2
XFILLER_24_401 vssd1 vccd1 vssd1 vccd1 SS_sky130_ef_sc_hd__decap_40_12
XFILLER_83_389 vssd1 vccd1 vccd1 vssd1 SS_sky130_fd_sc_hd__fill_2
XFILLER_24_445 vssd1 vccd1 vssd1 vccd1 SS_sky130_ef_sc_hd__decap_40_12
XTAP_TAPCELL_ROW_65_1268 vccd1 vssd1 SS_sky130_fd_sc_hd__tapvpwrvgnd_1
XTAP_TAPCELL_ROW_65_1279 vccd1 vssd1 SS_sky130_fd_sc_hd__tapvpwrvgnd_1
XTAP_TAPCELL_ROW_22_624 vccd1 vssd1 SS_sky130_fd_sc_hd__tapvpwrvgnd_1
XTAP_TAPCELL_ROW_22_635 vccd1 vssd1 SS_sky130_fd_sc_hd__tapvpwrvgnd_1
XFILLER_24_489 vssd1 vccd1 vssd1 vccd1 SS_sky130_ef_sc_hd__decap_40_12
XFILLER_138_57 vssd1 vccd1 vccd1 vssd1 SS_sky130_fd_sc_hd__fill_2
XFILLER_118_6 vssd1 vccd1 vssd1 vccd1 SS_sky130_ef_sc_hd__decap_40_12
XFILLER_106_701 vssd1 vccd1 vssd1 vccd1 SS_sky130_ef_sc_hd__decap_40_12
XFILLER_3_305 vssd1 vccd1 vssd1 vccd1 SS_sky130_ef_sc_hd__decap_40_12
XFILLER_3_349 vssd1 vccd1 vssd1 vccd1 SS_sky130_ef_sc_hd__decap_40_12
XFILLER_105_277 vssd1 vccd1 vccd1 vssd1 SS_sky130_fd_sc_hd__fill_2
XFILLER_78_139 vccd1 vssd1 vccd1 vssd1 SS_sky130_fd_sc_hd__fill_1
XFILLER_133_597 vssd1 vccd1 vssd1 vccd1 SS_sky130_ef_sc_hd__decap_40_12
XFILLER_87_673 vssd1 vccd1 vssd1 vccd1 SS_sky130_ef_sc_hd__decap_40_12
XFILLER_93_109 vssd1 vccd1 vccd1 vssd1 SS_sky130_fd_sc_hd__fill_2
XFILLER_19_217 vssd1 vccd1 vccd1 vssd1 SS_sky130_fd_sc_hd__fill_4
XFILLER_47_515 vssd1 vccd1 vssd1 vccd1 SS_sky130_ef_sc_hd__decap_40_12
XFILLER_74_301 vssd1 vccd1 vccd1 vssd1 SS_sky130_fd_sc_hd__fill_4
XFILLER_101_483 vssd1 vccd1 vssd1 vccd1 SS_sky130_ef_sc_hd__decap_40_12
XFILLER_101_461 vssd1 vccd1 vccd1 vssd1 SS_sky130_fd_sc_hd__fill_4
XFILLER_28_740 vssd1 vccd1 vssd1 vccd1 SS_sky130_ef_sc_hd__decap_40_12
XFILLER_74_345 vssd1 vccd1 vssd1 vccd1 SS_sky130_ef_sc_hd__decap_40_12
XFILLER_27_261 vssd1 vccd1 vssd1 vccd1 SS_sky130_ef_sc_hd__decap_40_12
XFILLER_34_209 vssd1 vccd1 vssd1 vccd1 SS_sky130_ef_sc_hd__decap_40_12
XFILLER_62_529 vssd1 vccd1 vccd1 vssd1 SS_sky130_fd_sc_hd__fill_2
XFILLER_74_389 vssd1 vccd1 vccd1 vssd1 SS_sky130_fd_sc_hd__fill_4
XFILLER_15_445 vssd1 vccd1 vccd1 vssd1 SS_sky130_fd_sc_hd__fill_2
XFILLER_63_42 vssd1 vccd1 vssd1 vccd1 SS_sky130_ef_sc_hd__decap_40_12
XFILLER_103_93 vssd1 vccd1 vssd1 vccd1 SS_sky130_ef_sc_hd__decap_40_12
XFILLER_42_253 vssd1 vccd1 vssd1 vccd1 SS_sky130_ef_sc_hd__decap_40_12
XPHY_EDGE_ROW_69_Right_69 vccd1 vssd1 vccd1 vssd1 SS_sky130_fd_sc_hd__decap_3
XTAP_TAPCELL_ROW_41_911 vccd1 vssd1 SS_sky130_fd_sc_hd__tapvpwrvgnd_1
XTAP_TAPCELL_ROW_41_922 vccd1 vssd1 SS_sky130_fd_sc_hd__tapvpwrvgnd_1
XTAP_TAPCELL_ROW_120_2096 vccd1 vssd1 SS_sky130_fd_sc_hd__tapvpwrvgnd_1
XFILLER_8_26 vssd1 vccd1 vccd1 vssd1 SS_sky130_fd_sc_hd__fill_2
XFILLER_11_673 vssd1 vccd1 vssd1 vccd1 SS_sky130_ef_sc_hd__decap_40_12
XFILLER_6_121 vssd1 vccd1 vssd1 vccd1 SS_sky130_ef_sc_hd__decap_40_12
XFILLER_6_165 vssd1 vccd1 vssd1 vccd1 SS_sky130_ef_sc_hd__decap_40_12
XFILLER_109_561 vssd1 vccd1 vccd1 vssd1 SS_sky130_fd_sc_hd__fill_2
XPHY_EDGE_ROW_78_Right_78 vccd1 vssd1 vccd1 vssd1 SS_sky130_fd_sc_hd__decap_3
XFILLER_124_531 vccd1 vssd1 vccd1 vssd1 SS_sky130_fd_sc_hd__fill_1
XFILLER_33_6 vssd1 vccd1 vssd1 vccd1 SS_sky130_ef_sc_hd__decap_40_12
XFILLER_88_83 vccd1 vssd1 vccd1 vssd1 SS_sky130_fd_sc_hd__fill_1
XFILLER_111_225 vssd1 vccd1 vssd1 vccd1 SS_sky130_ef_sc_hd__decap_40_12
XFILLER_66_813 vssd1 vccd1 vccd1 vssd1 SS_sky130_fd_sc_hd__fill_4
XFILLER_84_109 vssd1 vccd1 vssd1 vccd1 SS_sky130_ef_sc_hd__decap_40_12
XTAP_TAPCELL_ROW_127_2206 vccd1 vssd1 SS_sky130_fd_sc_hd__tapvpwrvgnd_1
X_1201_ vssd1 vccd1 vccd1 vssd1 _1209_/A2 input39/X _1630_/D _1403_/C1 _1200_/X SS_sky130_fd_sc_hd__o211a_2
XFILLER_38_515 vccd1 vssd1 vccd1 vssd1 SS_sky130_fd_sc_hd__fill_1
XFILLER_77_161 vssd1 vccd1 vccd1 vssd1 SS_sky130_fd_sc_hd__fill_4
XFILLER_78_695 vssd1 vccd1 vccd1 vssd1 SS_sky130_fd_sc_hd__fill_4
XFILLER_120_781 vssd1 vccd1 vssd1 vccd1 SS_sky130_ef_sc_hd__decap_40_12
XFILLER_65_334 vssd1 vccd1 vccd1 vssd1 SS_sky130_fd_sc_hd__fill_2
X_1132_ vccd1 vssd1 vccd1 vssd1 _1132_/X _1132_/A _1140_/B SS_sky130_fd_sc_hd__or2_2
XFILLER_65_378 vssd1 vccd1 vccd1 vssd1 SS_sky130_fd_sc_hd__fill_8
X_1063_ vssd1 vccd1 vccd1 vssd1 _1065_/A2 input36/X _1063_/X _1327_/C1 _1062_/X SS_sky130_fd_sc_hd__o211a_2
XFILLER_92_153 vssd1 vccd1 vssd1 vccd1 SS_sky130_ef_sc_hd__decap_40_12
XFILLER_34_743 vssd1 vccd1 vssd1 vccd1 SS_sky130_ef_sc_hd__decap_40_12
XPHY_EDGE_ROW_87_Right_87 vccd1 vssd1 vccd1 vssd1 SS_sky130_fd_sc_hd__decap_3
XFILLER_92_197 vssd1 vccd1 vssd1 vccd1 SS_sky130_ef_sc_hd__decap_40_12
XTAP_TAPCELL_ROW_105_1869 vccd1 vssd1 SS_sky130_fd_sc_hd__tapvpwrvgnd_1
XFILLER_61_573 vssd1 vccd1 vssd1 vccd1 SS_sky130_ef_sc_hd__decap_40_12
XTAP_TAPCELL_ROW_138_2379 vccd1 vssd1 SS_sky130_fd_sc_hd__tapvpwrvgnd_1
XTAP_TAPCELL_ROW_138_2368 vccd1 vssd1 SS_sky130_fd_sc_hd__tapvpwrvgnd_1
X_0916_ vccd1 vssd1 vccd1 vssd1 _1534_/Q _0930_/B1 _1694_/Q wire448/A _0919_/B SS_sky130_fd_sc_hd__a22o_2
XTAP_TAPCELL_ROW_60_1198 vccd1 vssd1 SS_sky130_fd_sc_hd__tapvpwrvgnd_1
X_1896_ vccd1 vssd1 _1896_/X _1896_/A vccd1 vssd1 SS_sky130_fd_sc_hd__buf_2
X_0847_ vssd1 vccd1 vssd1 vccd1 _1145_/A _1618_/Q _0751_/X _0843_/X _0847_/X _0846_/X
+ SS_sky130_fd_sc_hd__a2111o_2
XPHY_EDGE_ROW_96_Right_96 vccd1 vssd1 vccd1 vssd1 SS_sky130_fd_sc_hd__decap_3
XFILLER_1_809 vssd1 vccd1 vssd1 vccd1 SS_sky130_ef_sc_hd__decap_40_12
XTAP_TAPCELL_ROW_8_419 vccd1 vssd1 SS_sky130_fd_sc_hd__tapvpwrvgnd_1
X_0778_ vccd1 vssd1 vccd1 vssd1 _0777_/X _1840_/A wire421/X input7/X _0815_/B1 _0778_/X
+ SS_sky130_fd_sc_hd__a221o_2
XFILLER_127_391 vccd1 vssd1 vccd1 vssd1 SS_sky130_fd_sc_hd__fill_1
XFILLER_103_726 vssd1 vccd1 vccd1 vssd1 SS_sky130_fd_sc_hd__fill_2
XFILLER_130_545 vssd1 vccd1 vccd1 vssd1 SS_sky130_fd_sc_hd__fill_8
XFILLER_75_109 vssd1 vccd1 vccd1 vssd1 SS_sky130_fd_sc_hd__fill_2
XFILLER_124_15 vssd1 vccd1 vssd1 vccd1 SS_sky130_ef_sc_hd__decap_40_12
XFILLER_56_301 vssd1 vccd1 vccd1 vssd1 SS_sky130_fd_sc_hd__fill_4
XFILLER_69_673 vssd1 vccd1 vssd1 vccd1 SS_sky130_ef_sc_hd__decap_40_12
XFILLER_130_589 vssd1 vccd1 vssd1 vccd1 SS_sky130_ef_sc_hd__decap_40_12
XPHY_EDGE_ROW_3_Left_142 vccd1 vssd1 vccd1 vssd1 SS_sky130_fd_sc_hd__decap_3
XFILLER_29_559 vccd1 vssd1 vccd1 vssd1 SS_sky130_fd_sc_hd__fill_1
XFILLER_84_643 vccd1 vssd1 vccd1 vssd1 SS_sky130_fd_sc_hd__fill_1
XFILLER_16_209 vssd1 vccd1 vssd1 vccd1 SS_sky130_ef_sc_hd__decap_40_12
XTAP_TAPCELL_ROW_27_705 vccd1 vssd1 SS_sky130_fd_sc_hd__tapvpwrvgnd_1
XTAP_TAPCELL_ROW_67_1308 vccd1 vssd1 SS_sky130_fd_sc_hd__tapvpwrvgnd_1
XFILLER_17_57 vssd1 vccd1 vssd1 vccd1 SS_sky130_ef_sc_hd__decap_40_12
XFILLER_25_721 vssd1 vccd1 vccd1 vssd1 SS_sky130_fd_sc_hd__fill_4
XFILLER_37_581 vccd1 vssd1 vccd1 vssd1 SS_sky130_fd_sc_hd__fill_1
XFILLER_24_253 vssd1 vccd1 vssd1 vccd1 SS_sky130_ef_sc_hd__decap_40_12
XFILLER_8_419 vccd1 vssd1 vccd1 vssd1 SS_sky130_fd_sc_hd__fill_1
XFILLER_40_757 vssd1 vccd1 vssd1 vccd1 SS_sky130_ef_sc_hd__decap_40_12
XFILLER_138_645 vssd1 vccd1 vccd1 vssd1 SS_sky130_fd_sc_hd__fill_4
XFILLER_137_111 vccd1 vssd1 vccd1 vssd1 SS_sky130_fd_sc_hd__fill_1
XPHY_EDGE_ROW_49_Left_188 vccd1 vssd1 vccd1 vssd1 SS_sky130_fd_sc_hd__decap_3
XFILLER_138_667 vssd1 vccd1 vccd1 vssd1 SS_sky130_fd_sc_hd__fill_4
XFILLER_4_625 vssd1 vccd1 vssd1 vccd1 SS_sky130_ef_sc_hd__decap_40_12
XFILLER_137_177 vssd1 vccd1 vccd1 vssd1 SS_sky130_fd_sc_hd__fill_2
XFILLER_3_113 vssd1 vccd1 vssd1 vccd1 SS_sky130_ef_sc_hd__decap_40_12
XFILLER_134_840 vssd1 vccd1 vccd1 vssd1 SS_sky130_fd_sc_hd__fill_2
XFILLER_4_669 vssd1 vccd1 vssd1 vccd1 SS_sky130_ef_sc_hd__decap_40_12
XFILLER_121_501 vssd1 vccd1 vccd1 vssd1 SS_sky130_fd_sc_hd__fill_2
XFILLER_106_553 vssd1 vccd1 vssd1 vccd1 SS_sky130_ef_sc_hd__decap_40_12
XTAP_TAPCELL_ROW_91_1659 vccd1 vssd1 SS_sky130_fd_sc_hd__tapvpwrvgnd_1
XFILLER_58_53 vssd1 vccd1 vssd1 vccd1 SS_sky130_ef_sc_hd__decap_40_12
XFILLER_66_109 vssd1 vccd1 vssd1 vccd1 SS_sky130_ef_sc_hd__decap_40_12
XFILLER_48_813 vccd1 vssd1 vccd1 vssd1 SS_sky130_fd_sc_hd__fill_1
XPHY_EDGE_ROW_58_Left_197 vccd1 vssd1 vccd1 vssd1 SS_sky130_fd_sc_hd__decap_3
XFILLER_58_97 vssd1 vccd1 vssd1 vccd1 SS_sky130_ef_sc_hd__decap_40_12
XFILLER_59_161 vssd1 vccd1 vccd1 vssd1 SS_sky130_fd_sc_hd__fill_4
XFILLER_121_589 vssd1 vccd1 vssd1 vccd1 SS_sky130_ef_sc_hd__decap_40_12
XFILLER_102_781 vssd1 vccd1 vssd1 vccd1 SS_sky130_ef_sc_hd__decap_40_12
XFILLER_75_665 vssd1 vccd1 vccd1 vssd1 SS_sky130_fd_sc_hd__fill_4
XFILLER_35_529 vssd1 vccd1 vssd1 vccd1 SS_sky130_ef_sc_hd__decap_40_12
XFILLER_74_41 vssd1 vccd1 vssd1 vccd1 SS_sky130_ef_sc_hd__decap_40_12
XFILLER_74_153 vssd1 vccd1 vssd1 vccd1 SS_sky130_ef_sc_hd__decap_40_12
XFILLER_90_613 vssd1 vccd1 vssd1 vccd1 SS_sky130_ef_sc_hd__decap_40_12
XTAP_TAPCELL_ROW_122_2125 vccd1 vssd1 SS_sky130_fd_sc_hd__tapvpwrvgnd_1
XFILLER_114_81 vssd1 vccd1 vccd1 vssd1 SS_sky130_fd_sc_hd__fill_2
XFILLER_28_581 vssd1 vccd1 vccd1 vssd1 SS_sky130_fd_sc_hd__fill_4
XFILLER_74_85 vssd1 vccd1 vssd1 vccd1 SS_sky130_ef_sc_hd__decap_40_12
XFILLER_74_197 vssd1 vccd1 vssd1 vccd1 SS_sky130_ef_sc_hd__decap_40_12
XFILLER_90_657 vssd1 vccd1 vssd1 vccd1 SS_sky130_ef_sc_hd__decap_40_12
XTAP_TAPCELL_ROW_122_2136 vccd1 vssd1 SS_sky130_fd_sc_hd__tapvpwrvgnd_1
XFILLER_31_724 vssd1 vccd1 vccd1 vssd1 SS_sky130_fd_sc_hd__fill_4
XFILLER_30_245 vssd1 vccd1 vccd1 vssd1 SS_sky130_fd_sc_hd__fill_4
XFILLER_31_757 vccd1 vssd1 vccd1 vssd1 SS_sky130_fd_sc_hd__fill_1
XFILLER_30_289 vssd1 vccd1 vssd1 vccd1 SS_sky130_ef_sc_hd__decap_40_12
X_1750_ _1750_/Q _1756_/CLK _1750_/D vccd1 vssd1 vccd1 vssd1 SS_sky130_fd_sc_hd__dfxtp_2
XFILLER_7_441 vssd1 vccd1 vccd1 vssd1 SS_sky130_fd_sc_hd__fill_4
XTAP_TAPCELL_ROW_13_498 vccd1 vssd1 SS_sky130_fd_sc_hd__tapvpwrvgnd_1
XFILLER_128_133 vssd1 vccd1 vccd1 vssd1 SS_sky130_fd_sc_hd__fill_4
XTAP_TAPCELL_ROW_100_1799 vccd1 vssd1 SS_sky130_fd_sc_hd__tapvpwrvgnd_1
XFILLER_7_485 vssd1 vccd1 vssd1 vccd1 SS_sky130_ef_sc_hd__decap_40_12
X_1681_ _1681_/Q _1746_/CLK _1681_/D vccd1 vssd1 vccd1 vssd1 SS_sky130_fd_sc_hd__dfxtp_2
XFILLER_128_177 vssd1 vccd1 vssd1 vccd1 SS_sky130_ef_sc_hd__decap_40_12
Xwire383 vccd1 vssd1 vssd1 vccd1 wire383/A wbs_dat_o[10] SS_sky130_fd_sc_hd__buf_12
Xwire361 vccd1 vssd1 vssd1 vccd1 wire361/A wbs_dat_o[30] SS_sky130_fd_sc_hd__buf_12
Xwire372 vccd1 vssd1 vssd1 vccd1 wire372/A wbs_dat_o[20] SS_sky130_fd_sc_hd__buf_12
Xafe_wb analog_ctrl[7] afe_wb/HI vccd1 vssd1 vssd1 vccd1 SS_sky130_fd_sc_hd__conb_1
XFILLER_109_391 vccd1 vssd1 vccd1 vssd1 SS_sky130_fd_sc_hd__fill_1
Xwire394 vccd1 vssd1 vssd1 vccd1 wire394/A analog_ctrl[87] SS_sky130_fd_sc_hd__buf_12
XTAP_TAPCELL_ROW_133_2298 vccd1 vssd1 SS_sky130_fd_sc_hd__tapvpwrvgnd_1
XFILLER_112_501 vssd1 vccd1 vssd1 vccd1 SS_sky130_ef_sc_hd__decap_40_12
XFILLER_99_93 vssd1 vccd1 vssd1 vccd1 SS_sky130_ef_sc_hd__decap_40_12
XFILLER_98_724 vssd1 vccd1 vssd1 vccd1 SS_sky130_ef_sc_hd__decap_40_12
XFILLER_98_757 vssd1 vccd1 vssd1 vccd1 SS_sky130_ef_sc_hd__decap_40_12
XFILLER_97_223 vccd1 vssd1 vccd1 vssd1 SS_sky130_fd_sc_hd__fill_1
XFILLER_38_301 vssd1 vccd1 vccd1 vssd1 SS_sky130_fd_sc_hd__fill_4
XFILLER_39_813 vssd1 vccd1 vccd1 vssd1 SS_sky130_fd_sc_hd__fill_2
XFILLER_57_109 vssd1 vccd1 vccd1 vssd1 SS_sky130_fd_sc_hd__fill_2
XFILLER_38_345 vssd1 vccd1 vssd1 vccd1 SS_sky130_ef_sc_hd__decap_40_12
XFILLER_54_805 vssd1 vccd1 vccd1 vssd1 SS_sky130_fd_sc_hd__fill_4
XFILLER_26_529 vssd1 vccd1 vccd1 vssd1 SS_sky130_fd_sc_hd__fill_2
XFILLER_38_389 vssd1 vccd1 vssd1 vccd1 SS_sky130_ef_sc_hd__decap_40_12
X_1115_ vssd1 vccd1 vccd1 vssd1 wire239/A input28/X _1588_/D _1445_/C1 _1114_/X SS_sky130_fd_sc_hd__o211a_2
XTAP_TAPCELL_ROW_107_1909 vccd1 vssd1 SS_sky130_fd_sc_hd__tapvpwrvgnd_1
XTAP_TAPCELL_ROW_49_1038 vccd1 vssd1 SS_sky130_fd_sc_hd__tapvpwrvgnd_1
XFILLER_53_337 vssd1 vccd1 vssd1 vccd1 SS_sky130_ef_sc_hd__decap_40_12
XFILLER_93_484 vssd1 vccd1 vssd1 vccd1 SS_sky130_ef_sc_hd__decap_40_12
X_1046_ vccd1 vssd1 vccd1 vssd1 _1046_/X _1555_/Q _1076_/B SS_sky130_fd_sc_hd__or2_2
XFILLER_22_713 vssd1 vccd1 vssd1 vccd1 SS_sky130_ef_sc_hd__decap_40_12
XFILLER_34_584 vssd1 vccd1 vccd1 vssd1 SS_sky130_fd_sc_hd__fill_4
XFILLER_61_381 vccd1 vssd1 vccd1 vssd1 SS_sky130_fd_sc_hd__fill_1
XTAP_TAPCELL_ROW_62_1227 vccd1 vssd1 SS_sky130_fd_sc_hd__tapvpwrvgnd_1
XFILLER_80_189 vssd1 vccd1 vccd1 vssd1 SS_sky130_fd_sc_hd__fill_4
XFILLER_21_223 vccd1 vssd1 vccd1 vssd1 SS_sky130_fd_sc_hd__fill_1
XFILLER_22_757 vssd1 vccd1 vssd1 vccd1 SS_sky130_ef_sc_hd__decap_40_12
XTAP_TAPCELL_ROW_32_774 vccd1 vssd1 SS_sky130_fd_sc_hd__tapvpwrvgnd_1
XTAP_TAPCELL_ROW_32_785 vccd1 vssd1 SS_sky130_fd_sc_hd__tapvpwrvgnd_1
XFILLER_119_111 vccd1 vssd1 vccd1 vssd1 SS_sky130_fd_sc_hd__fill_1
XFILLER_119_15 vssd1 vccd1 vssd1 vccd1 SS_sky130_ef_sc_hd__decap_40_12
X_1879_ vccd1 vssd1 _1879_/X _1879_/A vccd1 vssd1 SS_sky130_fd_sc_hd__buf_2
XFILLER_135_637 vssd1 vccd1 vssd1 vccd1 SS_sky130_ef_sc_hd__decap_40_12
XFILLER_107_317 vssd1 vccd1 vssd1 vccd1 SS_sky130_ef_sc_hd__decap_40_12
XFILLER_1_617 vssd1 vccd1 vssd1 vccd1 SS_sky130_ef_sc_hd__decap_40_12
XFILLER_122_309 vssd1 vccd1 vccd1 vssd1 SS_sky130_fd_sc_hd__fill_2
XFILLER_103_501 vssd1 vccd1 vccd1 vssd1 SS_sky130_fd_sc_hd__fill_2
XTAP_TAPCELL_ROW_73_1389 vccd1 vssd1 SS_sky130_fd_sc_hd__tapvpwrvgnd_1
XFILLER_88_245 vssd1 vccd1 vccd1 vssd1 SS_sky130_fd_sc_hd__fill_4
XFILLER_135_69 vssd1 vccd1 vssd1 vccd1 SS_sky130_ef_sc_hd__decap_40_12
XFILLER_103_567 vccd1 vssd1 vccd1 vssd1 SS_sky130_fd_sc_hd__fill_1
XFILLER_48_109 vssd1 vccd1 vssd1 vccd1 SS_sky130_ef_sc_hd__decap_40_12
XFILLER_88_289 vssd1 vccd1 vssd1 vccd1 SS_sky130_ef_sc_hd__decap_40_12
XFILLER_103_589 vssd1 vccd1 vssd1 vccd1 SS_sky130_ef_sc_hd__decap_40_12
XFILLER_17_529 vssd1 vccd1 vssd1 vccd1 SS_sky130_ef_sc_hd__decap_40_12
XFILLER_56_153 vssd1 vccd1 vssd1 vccd1 SS_sky130_ef_sc_hd__decap_40_12
XFILLER_57_665 vssd1 vccd1 vccd1 vssd1 SS_sky130_fd_sc_hd__fill_4
XFILLER_29_389 vssd1 vccd1 vccd1 vssd1 SS_sky130_fd_sc_hd__fill_2
XFILLER_56_197 vssd1 vccd1 vssd1 vccd1 SS_sky130_ef_sc_hd__decap_40_12
XFILLER_71_167 vccd1 vssd1 vccd1 vssd1 SS_sky130_fd_sc_hd__fill_1
XFILLER_25_573 vssd1 vccd1 vssd1 vccd1 SS_sky130_ef_sc_hd__decap_40_12
XFILLER_44_77 vssd1 vccd1 vccd1 vssd1 SS_sky130_fd_sc_hd__fill_4
XFILLER_12_245 vssd1 vccd1 vccd1 vssd1 SS_sky130_fd_sc_hd__fill_4
XFILLER_40_587 vccd1 vssd1 vccd1 vssd1 SS_sky130_fd_sc_hd__fill_1
XFILLER_8_249 vssd1 vccd1 vccd1 vssd1 SS_sky130_fd_sc_hd__fill_2
XFILLER_12_289 vssd1 vccd1 vssd1 vccd1 SS_sky130_ef_sc_hd__decap_40_12
XFILLER_60_65 vssd1 vccd1 vssd1 vccd1 SS_sky130_ef_sc_hd__decap_40_12
XFILLER_100_83 vccd1 vssd1 vccd1 vssd1 SS_sky130_fd_sc_hd__fill_1
XTAP_TAPCELL_ROW_10_446 vccd1 vssd1 SS_sky130_fd_sc_hd__tapvpwrvgnd_1
XTAP_TAPCELL_ROW_10_457 vccd1 vssd1 SS_sky130_fd_sc_hd__tapvpwrvgnd_1
XFILLER_138_475 vccd1 vssd1 vccd1 vssd1 SS_sky130_fd_sc_hd__fill_1
XFILLER_4_433 vssd1 vccd1 vssd1 vccd1 SS_sky130_ef_sc_hd__decap_40_12
XFILLER_5_27 vssd1 vccd1 vssd1 vccd1 SS_sky130_ef_sc_hd__decap_40_12
XFILLER_125_125 vssd1 vccd1 vssd1 vccd1 SS_sky130_ef_sc_hd__decap_40_12
XFILLER_4_477 vssd1 vccd1 vssd1 vccd1 SS_sky130_ef_sc_hd__decap_40_12
XFILLER_125_169 vssd1 vccd1 vssd1 vccd1 SS_sky130_ef_sc_hd__decap_40_12
XFILLER_113_309 vssd1 vccd1 vssd1 vccd1 SS_sky130_ef_sc_hd__decap_40_12
XFILLER_109_81 vssd1 vccd1 vssd1 vccd1 SS_sky130_ef_sc_hd__decap_40_12
XFILLER_79_223 vccd1 vssd1 vccd1 vssd1 SS_sky130_fd_sc_hd__fill_1
XFILLER_122_821 vssd1 vccd1 vccd1 vssd1 SS_sky130_fd_sc_hd__fill_4
XPHY_EDGE_ROW_66_Left_205 vccd1 vssd1 vccd1 vssd1 SS_sky130_fd_sc_hd__decap_3
XFILLER_39_109 vssd1 vccd1 vccd1 vssd1 SS_sky130_fd_sc_hd__fill_2
XFILLER_95_727 vccd1 vssd1 vccd1 vssd1 SS_sky130_fd_sc_hd__fill_1
XFILLER_85_51 vssd1 vccd1 vccd1 vssd1 SS_sky130_fd_sc_hd__fill_4
XFILLER_36_805 vssd1 vccd1 vccd1 vssd1 SS_sky130_fd_sc_hd__fill_4
XFILLER_75_473 vssd1 vccd1 vssd1 vccd1 SS_sky130_ef_sc_hd__decap_40_12
XFILLER_35_337 vssd1 vccd1 vssd1 vccd1 SS_sky130_ef_sc_hd__decap_40_12
XFILLER_90_421 vssd1 vccd1 vssd1 vccd1 SS_sky130_ef_sc_hd__decap_40_12
XTAP_TAPCELL_ROW_18_568 vccd1 vssd1 SS_sky130_fd_sc_hd__tapvpwrvgnd_1
XFILLER_50_307 vccd1 vssd1 vccd1 vssd1 SS_sky130_fd_sc_hd__fill_1
XFILLER_62_189 vssd1 vccd1 vccd1 vssd1 SS_sky130_fd_sc_hd__fill_4
XTAP_TAPCELL_ROW_102_1828 vccd1 vssd1 SS_sky130_fd_sc_hd__tapvpwrvgnd_1
XPHY_EDGE_ROW_75_Left_214 vccd1 vssd1 vccd1 vssd1 SS_sky130_fd_sc_hd__decap_3
XFILLER_12_790 vssd1 vccd1 vssd1 vccd1 SS_sky130_ef_sc_hd__decap_40_12
XFILLER_79_3 vssd1 vccd1 vssd1 vccd1 SS_sky130_ef_sc_hd__decap_40_12
XFILLER_129_442 vssd1 vccd1 vccd1 vssd1 SS_sky130_fd_sc_hd__fill_4
XTAP_TAPCELL_ROW_135_2327 vccd1 vssd1 SS_sky130_fd_sc_hd__tapvpwrvgnd_1
XFILLER_117_615 vccd1 vssd1 vccd1 vssd1 SS_sky130_fd_sc_hd__fill_1
X_1733_ _1897_/A _1762_/CLK _1733_/D vccd1 vssd1 vccd1 vssd1 SS_sky130_fd_sc_hd__dfxtp_2
XFILLER_7_293 vssd1 vccd1 vssd1 vccd1 SS_sky130_ef_sc_hd__decap_40_12
XFILLER_129_497 vssd1 vccd1 vccd1 vssd1 SS_sky130_fd_sc_hd__fill_4
XFILLER_104_309 vccd1 vssd1 vccd1 vssd1 SS_sky130_fd_sc_hd__fill_1
X_1664_ _1664_/Q _1727_/CLK _1664_/D vccd1 vssd1 vccd1 vssd1 SS_sky130_fd_sc_hd__dfxtp_2
XPHY_EDGE_ROW_84_Left_223 vccd1 vssd1 vccd1 vssd1 SS_sky130_fd_sc_hd__decap_3
X_1595_ _1595_/Q _1755_/CLK _1595_/D vccd1 vssd1 vccd1 vssd1 SS_sky130_fd_sc_hd__dfxtp_2
XFILLER_58_407 vssd1 vccd1 vssd1 vccd1 SS_sky130_ef_sc_hd__decap_40_12
XFILLER_86_705 vssd1 vccd1 vccd1 vssd1 SS_sky130_fd_sc_hd__fill_2
XFILLER_86_716 vssd1 vccd1 vssd1 vccd1 SS_sky130_ef_sc_hd__decap_40_12
XFILLER_105_39 vssd1 vccd1 vssd1 vccd1 SS_sky130_ef_sc_hd__decap_40_12
XFILLER_98_587 vccd1 vssd1 vccd1 vssd1 SS_sky130_fd_sc_hd__fill_1
XFILLER_85_237 vssd1 vccd1 vssd1 vccd1 SS_sky130_ef_sc_hd__decap_40_12
XFILLER_38_153 vssd1 vccd1 vssd1 vccd1 SS_sky130_ef_sc_hd__decap_40_12
XFILLER_54_613 vssd1 vccd1 vssd1 vccd1 SS_sky130_ef_sc_hd__decap_40_12
XFILLER_38_197 vssd1 vccd1 vssd1 vccd1 SS_sky130_ef_sc_hd__decap_40_12
XFILLER_93_281 vssd1 vccd1 vssd1 vccd1 SS_sky130_ef_sc_hd__decap_40_12
XTAP_TAPCELL_ROW_37_855 vccd1 vssd1 SS_sky130_fd_sc_hd__tapvpwrvgnd_1
XFILLER_54_657 vssd1 vccd1 vssd1 vccd1 SS_sky130_ef_sc_hd__decap_40_12
XFILLER_41_329 vssd1 vccd1 vccd1 vssd1 SS_sky130_fd_sc_hd__fill_4
XFILLER_53_167 vccd1 vssd1 vccd1 vssd1 SS_sky130_fd_sc_hd__fill_1
X_1029_ vssd1 vccd1 vccd1 vssd1 _1033_/A2 wire496/X _1546_/D _1447_/C1 _1028_/X SS_sky130_fd_sc_hd__o211a_2
XPHY_EDGE_ROW_138_Right_138 vccd1 vssd1 vccd1 vssd1 SS_sky130_fd_sc_hd__decap_3
XPHY_EDGE_ROW_93_Left_232 vccd1 vssd1 vccd1 vssd1 SS_sky130_fd_sc_hd__decap_3
XFILLER_22_587 vccd1 vssd1 vccd1 vssd1 SS_sky130_fd_sc_hd__fill_1
XFILLER_10_749 vssd1 vccd1 vccd1 vssd1 SS_sky130_fd_sc_hd__fill_4
XTAP_TAPCELL_ROW_75_1418 vccd1 vssd1 SS_sky130_fd_sc_hd__tapvpwrvgnd_1
XFILLER_108_637 vssd1 vccd1 vccd1 vssd1 SS_sky130_fd_sc_hd__fill_4
XFILLER_107_125 vssd1 vccd1 vssd1 vccd1 SS_sky130_ef_sc_hd__decap_40_12
XTAP_TAPCELL_ROW_75_1429 vccd1 vssd1 SS_sky130_fd_sc_hd__tapvpwrvgnd_1
XFILLER_107_169 vssd1 vccd1 vssd1 vccd1 SS_sky130_ef_sc_hd__decap_40_12
Xhold772 _1186_/A _1623_/Q vccd1 vssd1 vssd1 vccd1 SS_sky130_fd_sc_hd__dlygate4sd3_1
Xhold761 _1040_/A _1552_/Q vccd1 vssd1 vssd1 vccd1 SS_sky130_fd_sc_hd__dlygate4sd3_1
XFILLER_122_139 vccd1 vssd1 vccd1 vssd1 SS_sky130_fd_sc_hd__fill_1
Xhold750 _0992_/A _1529_/Q vccd1 vssd1 vssd1 vccd1 SS_sky130_fd_sc_hd__dlygate4sd3_1
XFILLER_104_810 vssd1 vccd1 vccd1 vssd1 SS_sky130_fd_sc_hd__fill_2
XFILLER_1_447 vccd1 vssd1 vccd1 vssd1 SS_sky130_fd_sc_hd__fill_1
Xhold783 _1312_/A _1684_/Q vccd1 vssd1 vssd1 vccd1 SS_sky130_fd_sc_hd__dlygate4sd3_1
Xhold794 input17/A wbs_adr_i[4] vccd1 vssd1 vssd1 vccd1 SS_sky130_fd_sc_hd__dlygate4sd3_1
XFILLER_39_55 vccd1 vssd1 vccd1 vssd1 SS_sky130_fd_sc_hd__fill_1
XFILLER_49_429 vssd1 vccd1 vccd1 vssd1 SS_sky130_fd_sc_hd__fill_4
XFILLER_77_727 vccd1 vssd1 vccd1 vssd1 SS_sky130_fd_sc_hd__fill_1
XFILLER_77_749 vssd1 vccd1 vccd1 vssd1 SS_sky130_fd_sc_hd__fill_2
XFILLER_131_673 vssd1 vccd1 vssd1 vccd1 SS_sky130_ef_sc_hd__decap_40_12
XFILLER_103_375 vssd1 vccd1 vccd1 vssd1 SS_sky130_fd_sc_hd__fill_8
XFILLER_17_337 vssd1 vccd1 vssd1 vccd1 SS_sky130_ef_sc_hd__decap_40_12
XFILLER_72_421 vssd1 vccd1 vccd1 vssd1 SS_sky130_fd_sc_hd__fill_8
XFILLER_33_819 vccd1 vssd1 vccd1 vssd1 SS_sky130_fd_sc_hd__fill_1
XFILLER_32_307 vccd1 vssd1 vccd1 vssd1 SS_sky130_fd_sc_hd__fill_1
XFILLER_44_189 vssd1 vccd1 vccd1 vssd1 SS_sky130_fd_sc_hd__fill_4
XPHY_EDGE_ROW_105_Right_105 vccd1 vssd1 vccd1 vssd1 SS_sky130_fd_sc_hd__decap_3
XTAP_TAPCELL_ROW_15_527 vccd1 vssd1 SS_sky130_fd_sc_hd__tapvpwrvgnd_1
XFILLER_41_841 vccd1 vssd1 vccd1 vssd1 SS_sky130_fd_sc_hd__fill_1
XFILLER_9_503 vccd1 vssd1 vccd1 vssd1 SS_sky130_fd_sc_hd__fill_1
XFILLER_71_42 vssd1 vccd1 vssd1 vccd1 SS_sky130_ef_sc_hd__decap_40_12
XFILLER_111_93 vssd1 vccd1 vssd1 vccd1 SS_sky130_ef_sc_hd__decap_40_12
XTAP_TAPCELL_ROW_117_2057 vccd1 vssd1 SS_sky130_fd_sc_hd__tapvpwrvgnd_1
XFILLER_5_753 vssd1 vccd1 vssd1 vccd1 SS_sky130_ef_sc_hd__decap_40_12
XFILLER_5_797 vssd1 vccd1 vssd1 vccd1 SS_sky130_ef_sc_hd__decap_40_12
XTAP_TAPCELL_ROW_130_2246 vccd1 vssd1 SS_sky130_fd_sc_hd__tapvpwrvgnd_1
XTAP_TAPCELL_ROW_130_2257 vccd1 vssd1 SS_sky130_fd_sc_hd__tapvpwrvgnd_1
XFILLER_99_329 vssd1 vccd1 vccd1 vssd1 SS_sky130_fd_sc_hd__fill_4
X_1380_ vccd1 vssd1 vccd1 vssd1 _1380_/X _1380_/A _1396_/B SS_sky130_fd_sc_hd__or2_2
XFILLER_122_651 vccd1 vssd1 vccd1 vssd1 SS_sky130_fd_sc_hd__fill_1
XFILLER_121_161 vssd1 vccd1 vccd1 vssd1 SS_sky130_fd_sc_hd__fill_4
XFILLER_110_813 vssd1 vccd1 vssd1 vccd1 SS_sky130_ef_sc_hd__decap_40_12
XFILLER_95_513 vssd1 vccd1 vccd1 vssd1 SS_sky130_fd_sc_hd__fill_4
XFILLER_67_237 vssd1 vccd1 vssd1 vccd1 SS_sky130_ef_sc_hd__decap_40_12
XFILLER_96_83 vccd1 vssd1 vccd1 vssd1 SS_sky130_fd_sc_hd__fill_1
XFILLER_95_546 vssd1 vccd1 vssd1 vccd1 SS_sky130_ef_sc_hd__decap_40_12
XFILLER_36_635 vccd1 vssd1 vccd1 vssd1 SS_sky130_fd_sc_hd__fill_1
XFILLER_75_281 vssd1 vccd1 vssd1 vccd1 SS_sky130_ef_sc_hd__decap_40_12
XFILLER_36_657 vssd1 vccd1 vssd1 vccd1 SS_sky130_ef_sc_hd__decap_40_12
XFILLER_51_605 vssd1 vccd1 vccd1 vssd1 SS_sky130_fd_sc_hd__fill_8
XFILLER_23_329 vssd1 vccd1 vccd1 vssd1 SS_sky130_fd_sc_hd__fill_4
XTAP_TAPCELL_ROW_34_803 vccd1 vssd1 SS_sky130_fd_sc_hd__tapvpwrvgnd_1
XTAP_TAPCELL_ROW_34_814 vccd1 vssd1 SS_sky130_fd_sc_hd__tapvpwrvgnd_1
XFILLER_35_167 vccd1 vssd1 vccd1 vssd1 SS_sky130_fd_sc_hd__fill_1
XFILLER_90_251 vccd1 vssd1 vccd1 vssd1 SS_sky130_fd_sc_hd__fill_1
XFILLER_91_785 vssd1 vccd1 vccd1 vssd1 SS_sky130_fd_sc_hd__fill_8
XFILLER_50_137 vssd1 vccd1 vccd1 vssd1 SS_sky130_fd_sc_hd__fill_2
XFILLER_31_373 vssd1 vccd1 vssd1 vccd1 SS_sky130_ef_sc_hd__decap_40_12
XFILLER_129_261 vssd1 vccd1 vssd1 vccd1 SS_sky130_ef_sc_hd__decap_40_12
XFILLER_117_401 vssd1 vccd1 vssd1 vccd1 SS_sky130_ef_sc_hd__decap_40_12
X_1716_ _1716_/Q _1748_/CLK _1716_/D vccd1 vssd1 vccd1 vssd1 SS_sky130_fd_sc_hd__dfxtp_2
XFILLER_132_404 vssd1 vccd1 vssd1 vccd1 SS_sky130_ef_sc_hd__decap_40_12
XFILLER_6_81 vssd1 vccd1 vccd1 vssd1 SS_sky130_fd_sc_hd__fill_2
XTAP_TAPCELL_ROW_57_1148 vccd1 vssd1 SS_sky130_fd_sc_hd__tapvpwrvgnd_1
XTAP_TAPCELL_ROW_57_1159 vccd1 vssd1 SS_sky130_fd_sc_hd__tapvpwrvgnd_1
X_1647_ _1647_/Q _1752_/CLK _1647_/D vccd1 vssd1 vccd1 vssd1 SS_sky130_fd_sc_hd__dfxtp_2
XFILLER_104_139 vccd1 vssd1 vccd1 vssd1 SS_sky130_fd_sc_hd__fill_1
XFILLER_99_841 vccd1 vssd1 vccd1 vssd1 SS_sky130_fd_sc_hd__fill_1
X_1578_ _1852_/A clkload3/A _1578_/D vccd1 vssd1 vccd1 vssd1 SS_sky130_fd_sc_hd__dfxtp_2
XTAP_TAPCELL_ROW_70_1348 vccd1 vssd1 SS_sky130_fd_sc_hd__tapvpwrvgnd_1
XFILLER_86_513 vssd1 vccd1 vssd1 vccd1 SS_sky130_ef_sc_hd__decap_40_12
XFILLER_113_673 vssd1 vccd1 vssd1 vccd1 SS_sky130_ef_sc_hd__decap_40_12
XFILLER_100_301 vssd1 vccd1 vccd1 vssd1 SS_sky130_fd_sc_hd__fill_4
XFILLER_86_557 vssd1 vccd1 vccd1 vssd1 SS_sky130_fd_sc_hd__fill_2
XFILLER_132_15 vssd1 vccd1 vssd1 vccd1 SS_sky130_ef_sc_hd__decap_40_12
XFILLER_100_345 vssd1 vccd1 vssd1 vccd1 SS_sky130_ef_sc_hd__decap_40_12
XFILLER_27_613 vssd1 vccd1 vccd1 vssd1 SS_sky130_fd_sc_hd__fill_2
XFILLER_54_421 vssd1 vccd1 vssd1 vccd1 SS_sky130_ef_sc_hd__decap_40_12
XFILLER_100_389 vssd1 vccd1 vccd1 vssd1 SS_sky130_fd_sc_hd__fill_8
XFILLER_14_307 vccd1 vssd1 vccd1 vssd1 SS_sky130_fd_sc_hd__fill_1
XFILLER_26_189 vssd1 vccd1 vccd1 vssd1 SS_sky130_fd_sc_hd__fill_4
XFILLER_81_273 vssd1 vccd1 vccd1 vssd1 SS_sky130_fd_sc_hd__fill_4
XFILLER_82_774 vssd1 vccd1 vssd1 vccd1 SS_sky130_ef_sc_hd__decap_40_12
XFILLER_23_841 vccd1 vssd1 vccd1 vssd1 SS_sky130_fd_sc_hd__fill_1
XFILLER_25_57 vssd1 vccd1 vssd1 vccd1 SS_sky130_ef_sc_hd__decap_40_12
XFILLER_41_137 vssd1 vccd1 vssd1 vccd1 SS_sky130_ef_sc_hd__decap_40_12
XFILLER_42_649 vccd1 vssd1 vccd1 vssd1 SS_sky130_fd_sc_hd__fill_1
XTAP_TAPCELL_ROW_85_1580 vccd1 vssd1 SS_sky130_fd_sc_hd__tapvpwrvgnd_1
XFILLER_10_513 vssd1 vccd1 vssd1 vccd1 SS_sky130_ef_sc_hd__decap_40_12
XFILLER_50_693 vssd1 vccd1 vccd1 vssd1 SS_sky130_fd_sc_hd__fill_4
XFILLER_10_557 vssd1 vccd1 vssd1 vccd1 SS_sky130_ef_sc_hd__decap_40_12
XFILLER_108_401 vssd1 vccd1 vssd1 vccd1 SS_sky130_ef_sc_hd__decap_40_12
XTAP_TAPCELL_ROW_20_596 vccd1 vssd1 SS_sky130_fd_sc_hd__tapvpwrvgnd_1
XFILLER_136_776 vssd1 vccd1 vssd1 vccd1 SS_sky130_ef_sc_hd__decap_40_12
XFILLER_108_456 vssd1 vccd1 vssd1 vccd1 SS_sky130_ef_sc_hd__decap_40_12
XFILLER_2_701 vssd1 vccd1 vssd1 vccd1 SS_sky130_ef_sc_hd__decap_40_12
XFILLER_9_3 vssd1 vccd1 vssd1 vccd1 SS_sky130_ef_sc_hd__decap_40_12
Xhold580 _1162_/A _1871_/A vccd1 vssd1 vssd1 vccd1 SS_sky130_fd_sc_hd__dlygate4sd3_1
XFILLER_1_277 vssd1 vccd1 vccd1 vssd1 SS_sky130_fd_sc_hd__fill_2
Xhold591 _1667_/D _1279_/X vccd1 vssd1 vssd1 vccd1 SS_sky130_fd_sc_hd__dlygate4sd3_1
XFILLER_89_373 vssd1 vccd1 vccd1 vssd1 SS_sky130_fd_sc_hd__fill_2
XFILLER_110_109 vssd1 vccd1 vssd1 vccd1 SS_sky130_ef_sc_hd__decap_40_12
XFILLER_49_237 vssd1 vccd1 vssd1 vccd1 SS_sky130_ef_sc_hd__decap_40_12
XFILLER_77_535 vccd1 vssd1 vccd1 vssd1 SS_sky130_fd_sc_hd__fill_1
XFILLER_103_161 vssd1 vccd1 vccd1 vssd1 SS_sky130_fd_sc_hd__fill_4
XFILLER_66_53 vssd1 vccd1 vssd1 vccd1 SS_sky130_ef_sc_hd__decap_40_12
XFILLER_18_613 vssd1 vccd1 vssd1 vccd1 SS_sky130_ef_sc_hd__decap_40_12
XFILLER_57_281 vssd1 vccd1 vssd1 vccd1 SS_sky130_ef_sc_hd__decap_40_12
XFILLER_66_97 vssd1 vccd1 vssd1 vccd1 SS_sky130_ef_sc_hd__decap_40_12
XFILLER_85_590 vssd1 vccd1 vssd1 vccd1 SS_sky130_ef_sc_hd__decap_40_12
XFILLER_18_657 vssd1 vccd1 vssd1 vccd1 SS_sky130_ef_sc_hd__decap_40_12
XFILLER_73_741 vssd1 vccd1 vssd1 vccd1 SS_sky130_ef_sc_hd__decap_40_12
XFILLER_17_167 vccd1 vssd1 vccd1 vssd1 SS_sky130_fd_sc_hd__fill_1
XFILLER_72_251 vccd1 vssd1 vccd1 vssd1 SS_sky130_fd_sc_hd__fill_1
XFILLER_73_785 vssd1 vccd1 vssd1 vccd1 SS_sky130_ef_sc_hd__decap_40_12
XFILLER_82_41 vssd1 vccd1 vssd1 vccd1 SS_sky130_ef_sc_hd__decap_40_12
XFILLER_122_81 vssd1 vccd1 vccd1 vssd1 SS_sky130_fd_sc_hd__fill_2
XFILLER_32_137 vssd1 vccd1 vccd1 vssd1 SS_sky130_fd_sc_hd__fill_2
XFILLER_82_85 vssd1 vccd1 vssd1 vccd1 SS_sky130_ef_sc_hd__decap_40_12
XFILLER_9_333 vssd1 vccd1 vccd1 vssd1 SS_sky130_fd_sc_hd__fill_2
XFILLER_13_373 vssd1 vccd1 vssd1 vccd1 SS_sky130_ef_sc_hd__decap_40_12
XFILLER_41_671 vccd1 vssd1 vccd1 vssd1 SS_sky130_fd_sc_hd__fill_1
XFILLER_118_209 vssd1 vccd1 vssd1 vccd1 SS_sky130_ef_sc_hd__decap_40_12
X_0880_ vccd1 vssd1 vccd1 vssd1 _0879_/X _1560_/Q _1013_/A _1866_/A wire445/X _0880_/X
+ SS_sky130_fd_sc_hd__a221o_2
XFILLER_63_6 vssd1 vccd1 vssd1 vccd1 SS_sky130_ef_sc_hd__decap_40_12
XFILLER_127_721 vssd1 vccd1 vccd1 vssd1 SS_sky130_fd_sc_hd__fill_4
Xoutput107 vccd1 vssd1 wire337/A _1865_/X vccd1 vssd1 SS_sky130_fd_sc_hd__buf_4
XFILLER_126_253 vssd1 vccd1 vssd1 vccd1 SS_sky130_ef_sc_hd__decap_40_12
XFILLER_5_561 vssd1 vccd1 vssd1 vccd1 SS_sky130_ef_sc_hd__decap_40_12
Xoutput118 vccd1 vssd1 wire326/A _1875_/X vccd1 vssd1 SS_sky130_fd_sc_hd__buf_4
Xoutput129 vccd1 vssd1 wire315/A _1885_/X vccd1 vssd1 SS_sky130_fd_sc_hd__buf_4
X_1501_ _1501_/Q _1758_/CLK _1501_/D vccd1 vssd1 vccd1 vssd1 SS_sky130_fd_sc_hd__dfxtp_2
X_1432_ vccd1 vssd1 vccd1 vssd1 _1432_/X _1432_/A _1454_/B SS_sky130_fd_sc_hd__or2_2
XFILLER_99_137 vssd1 vccd1 vssd1 vccd1 SS_sky130_ef_sc_hd__decap_40_12
XFILLER_68_513 vssd1 vccd1 vssd1 vccd1 SS_sky130_ef_sc_hd__decap_40_12
XTAP_TAPCELL_ROW_110_1949 vccd1 vssd1 SS_sky130_fd_sc_hd__tapvpwrvgnd_1
XFILLER_101_109 vssd1 vccd1 vccd1 vssd1 SS_sky130_fd_sc_hd__fill_2
XFILLER_68_557 vssd1 vccd1 vssd1 vccd1 SS_sky130_ef_sc_hd__decap_40_12
X_1363_ vssd1 vccd1 vccd1 vssd1 _1369_/A2 wire494/X _1708_/D _1423_/C1 _1362_/X SS_sky130_fd_sc_hd__o211a_2
XFILLER_110_643 vccd1 vssd1 vccd1 vssd1 SS_sky130_fd_sc_hd__fill_1
XFILLER_95_332 vssd1 vccd1 vccd1 vssd1 SS_sky130_fd_sc_hd__fill_4
XTAP_TAPCELL_ROW_52_1078 vccd1 vssd1 SS_sky130_fd_sc_hd__tapvpwrvgnd_1
X_1294_ vccd1 vssd1 vccd1 vssd1 _1294_/X _1294_/A _1318_/B SS_sky130_fd_sc_hd__or2_2
XFILLER_83_505 vssd1 vccd1 vccd1 vssd1 SS_sky130_fd_sc_hd__fill_8
XFILLER_110_676 vssd1 vccd1 vssd1 vccd1 SS_sky130_ef_sc_hd__decap_40_12
XFILLER_36_421 vssd1 vccd1 vssd1 vccd1 SS_sky130_ef_sc_hd__decap_40_12
XFILLER_63_273 vssd1 vccd1 vccd1 vssd1 SS_sky130_fd_sc_hd__fill_4
XFILLER_102_29 vssd1 vccd1 vssd1 vccd1 SS_sky130_ef_sc_hd__decap_40_12
XFILLER_23_137 vssd1 vccd1 vssd1 vccd1 SS_sky130_ef_sc_hd__decap_40_12
XFILLER_20_800 vccd1 vssd1 vccd1 vssd1 SS_sky130_fd_sc_hd__fill_1
XFILLER_31_181 vssd1 vccd1 vssd1 vccd1 SS_sky130_ef_sc_hd__decap_40_12
XFILLER_127_15 vssd1 vccd1 vssd1 vccd1 SS_sky130_ef_sc_hd__decap_40_12
XFILLER_132_245 vssd1 vccd1 vccd1 vssd1 SS_sky130_fd_sc_hd__fill_4
XFILLER_133_757 vccd1 vssd1 vccd1 vssd1 SS_sky130_fd_sc_hd__fill_1
XFILLER_105_437 vssd1 vccd1 vccd1 vssd1 SS_sky130_fd_sc_hd__fill_2
XFILLER_120_429 vssd1 vccd1 vccd1 vssd1 SS_sky130_fd_sc_hd__fill_2
XFILLER_99_671 vccd1 vssd1 vccd1 vssd1 SS_sky130_fd_sc_hd__fill_1
Xfanout345 vssd1 vccd1 vccd1 vssd1 _0751_/X wire347/A SS_sky130_fd_sc_hd__clkdlybuf4s25_1
XFILLER_132_289 vssd1 vccd1 vssd1 vccd1 SS_sky130_ef_sc_hd__decap_40_12
XFILLER_101_621 vssd1 vccd1 vccd1 vssd1 SS_sky130_fd_sc_hd__fill_2
XFILLER_86_365 vssd1 vccd1 vccd1 vssd1 SS_sky130_fd_sc_hd__fill_4
XFILLER_101_665 vssd1 vccd1 vccd1 vssd1 SS_sky130_fd_sc_hd__fill_2
XFILLER_86_398 vssd1 vccd1 vccd1 vssd1 SS_sky130_fd_sc_hd__fill_8
XFILLER_100_153 vssd1 vccd1 vssd1 vccd1 SS_sky130_ef_sc_hd__decap_40_12
XFILLER_39_281 vssd1 vccd1 vssd1 vccd1 SS_sky130_ef_sc_hd__decap_40_12
XFILLER_55_741 vssd1 vccd1 vssd1 vccd1 SS_sky130_ef_sc_hd__decap_40_12
XFILLER_100_197 vssd1 vccd1 vssd1 vccd1 SS_sky130_ef_sc_hd__decap_40_12
XFILLER_42_413 vssd1 vccd1 vccd1 vssd1 SS_sky130_fd_sc_hd__fill_4
XFILLER_54_251 vccd1 vssd1 vccd1 vssd1 SS_sky130_fd_sc_hd__fill_1
XFILLER_55_785 vssd1 vccd1 vssd1 vccd1 SS_sky130_ef_sc_hd__decap_40_12
XFILLER_14_137 vssd1 vccd1 vccd1 vssd1 SS_sky130_fd_sc_hd__fill_2
XTAP_TAPCELL_ROW_83_1539 vccd1 vssd1 SS_sky130_fd_sc_hd__tapvpwrvgnd_1
XFILLER_70_777 vssd1 vccd1 vccd1 vssd1 SS_sky130_fd_sc_hd__fill_2
XFILLER_23_671 vccd1 vssd1 vccd1 vssd1 SS_sky130_fd_sc_hd__fill_1
XTAP_TAPCELL_ROW_25_677 vccd1 vssd1 SS_sky130_fd_sc_hd__tapvpwrvgnd_1
XFILLER_10_321 vssd1 vccd1 vssd1 vccd1 SS_sky130_ef_sc_hd__decap_40_12
XPHY_EDGE_ROW_30_Left_169 vccd1 vssd1 vccd1 vssd1 SS_sky130_fd_sc_hd__decap_3
XFILLER_52_77 vssd1 vccd1 vccd1 vssd1 SS_sky130_fd_sc_hd__fill_4
XFILLER_128_507 vssd1 vccd1 vccd1 vssd1 SS_sky130_fd_sc_hd__fill_8
XFILLER_10_365 vssd1 vccd1 vssd1 vccd1 SS_sky130_ef_sc_hd__decap_40_12
XTAP_TAPCELL_ROW_114_2005 vccd1 vssd1 SS_sky130_fd_sc_hd__tapvpwrvgnd_1
XTAP_TAPCELL_ROW_114_2016 vccd1 vssd1 SS_sky130_fd_sc_hd__tapvpwrvgnd_1
XFILLER_109_765 vssd1 vccd1 vssd1 vccd1 SS_sky130_ef_sc_hd__decap_40_12
XFILLER_108_253 vssd1 vccd1 vssd1 vccd1 SS_sky130_ef_sc_hd__decap_40_12
XTAP_TAPCELL_ROW_98_1771 vccd1 vssd1 SS_sky130_fd_sc_hd__tapvpwrvgnd_1
XFILLER_124_713 vccd1 vssd1 vccd1 vssd1 SS_sky130_fd_sc_hd__fill_1
XFILLER_2_531 vccd1 vssd1 vccd1 vssd1 SS_sky130_fd_sc_hd__fill_1
XFILLER_124_757 vssd1 vccd1 vssd1 vccd1 SS_sky130_ef_sc_hd__decap_40_12
XFILLER_124_746 vssd1 vccd1 vccd1 vssd1 SS_sky130_fd_sc_hd__fill_8
XFILLER_123_223 vccd1 vssd1 vccd1 vssd1 SS_sky130_fd_sc_hd__fill_1
XFILLER_97_608 vssd1 vccd1 vccd1 vssd1 SS_sky130_fd_sc_hd__fill_8
XFILLER_117_81 vssd1 vccd1 vssd1 vccd1 SS_sky130_ef_sc_hd__decap_40_12
XFILLER_89_181 vssd1 vccd1 vssd1 vccd1 SS_sky130_ef_sc_hd__decap_40_12
XTAP_TAPCELL_ROW_5_380 vccd1 vssd1 SS_sky130_fd_sc_hd__tapvpwrvgnd_1
XFILLER_18_421 vssd1 vccd1 vssd1 vccd1 SS_sky130_ef_sc_hd__decap_40_12
XFILLER_92_357 vssd1 vccd1 vccd1 vssd1 SS_sky130_fd_sc_hd__fill_4
XTAP_TAPCELL_ROW_125_2178 vccd1 vssd1 SS_sky130_fd_sc_hd__tapvpwrvgnd_1
XFILLER_45_273 vssd1 vccd1 vccd1 vssd1 SS_sky130_fd_sc_hd__fill_4
XFILLER_60_221 vssd1 vccd1 vssd1 vccd1 SS_sky130_ef_sc_hd__decap_40_12
XFILLER_73_593 vssd1 vccd1 vccd1 vssd1 SS_sky130_fd_sc_hd__fill_2
XTAP_TAPCELL_ROW_44_953 vccd1 vssd1 SS_sky130_fd_sc_hd__tapvpwrvgnd_1
XTAP_TAPCELL_ROW_44_964 vccd1 vssd1 SS_sky130_fd_sc_hd__tapvpwrvgnd_1
XFILLER_60_265 vssd1 vccd1 vssd1 vccd1 SS_sky130_ef_sc_hd__decap_40_12
XFILLER_14_693 vssd1 vccd1 vccd1 vssd1 SS_sky130_fd_sc_hd__fill_4
XFILLER_13_181 vssd1 vccd1 vssd1 vccd1 SS_sky130_ef_sc_hd__decap_40_12
X_0932_ vccd1 vssd1 vssd1 vccd1 _0929_/X _0931_/X _0932_/A2 hold798/X _1504_/D _1401_/C1
+ SS_sky130_fd_sc_hd__o221a_2
X_0863_ vccd1 vssd1 vccd1 vssd1 _1525_/Q wire421/A _1863_/A wire443/A _0863_/X SS_sky130_fd_sc_hd__a22o_2
XFILLER_119_529 vssd1 vccd1 vssd1 vccd1 SS_sky130_ef_sc_hd__decap_40_12
X_0794_ vccd1 vssd1 vssd1 vccd1 _0790_/X _0793_/X _0860_/A2 _1481_/Q _1481_/D _1299_/C1
+ SS_sky130_fd_sc_hd__o221a_2
XFILLER_127_573 vssd1 vccd1 vccd1 vssd1 SS_sky130_fd_sc_hd__fill_8
XFILLER_5_391 vccd1 vssd1 vccd1 vssd1 SS_sky130_fd_sc_hd__fill_1
XTAP_TAPCELL_ROW_54_1107 vccd1 vssd1 SS_sky130_fd_sc_hd__tapvpwrvgnd_1
XFILLER_114_245 vssd1 vccd1 vccd1 vssd1 SS_sky130_fd_sc_hd__fill_4
XFILLER_130_727 vssd1 vccd1 vssd1 vccd1 SS_sky130_ef_sc_hd__decap_40_12
XFILLER_68_321 vssd1 vccd1 vssd1 vccd1 SS_sky130_ef_sc_hd__decap_40_12
XFILLER_114_289 vssd1 vccd1 vccd1 vssd1 SS_sky130_fd_sc_hd__fill_8
X_1415_ vssd1 vccd1 vccd1 vssd1 _1467_/A2 input42/X _1733_/D _1473_/C1 _1414_/X SS_sky130_fd_sc_hd__o211a_2
XFILLER_96_630 vssd1 vccd1 vccd1 vssd1 SS_sky130_fd_sc_hd__fill_2
XFILLER_68_365 vssd1 vccd1 vssd1 vccd1 SS_sky130_ef_sc_hd__decap_40_12
X_1346_ vccd1 vssd1 vccd1 vssd1 _1346_/X _1879_/A _1404_/B SS_sky130_fd_sc_hd__or2_2
XFILLER_96_641 vssd1 vccd1 vccd1 vssd1 SS_sky130_fd_sc_hd__fill_2
XFILLER_3_93 vssd1 vccd1 vssd1 vccd1 SS_sky130_ef_sc_hd__decap_40_12
XTAP_TAPCELL_ROW_3_339 vccd1 vssd1 SS_sky130_fd_sc_hd__tapvpwrvgnd_1
XFILLER_110_473 vssd1 vccd1 vccd1 vssd1 SS_sky130_fd_sc_hd__fill_2
XFILLER_96_685 vssd1 vccd1 vssd1 vccd1 SS_sky130_ef_sc_hd__decap_40_12
XFILLER_37_741 vssd1 vccd1 vssd1 vccd1 SS_sky130_ef_sc_hd__decap_40_12
X_1277_ vccd1 vssd1 vssd1 vccd1 _1277_/Y _1277_/A _1409_/B SS_sky130_fd_sc_hd__nand2_2
XFILLER_36_251 vccd1 vssd1 vccd1 vssd1 SS_sky130_fd_sc_hd__fill_1
XFILLER_37_785 vssd1 vccd1 vssd1 vccd1 SS_sky130_ef_sc_hd__decap_40_12
XFILLER_64_560 vssd1 vccd1 vssd1 vccd1 SS_sky130_ef_sc_hd__decap_40_12
XFILLER_24_413 vssd1 vccd1 vccd1 vssd1 SS_sky130_fd_sc_hd__fill_4
XFILLER_51_221 vssd1 vccd1 vccd1 vssd1 SS_sky130_fd_sc_hd__fill_2
XFILLER_24_457 vssd1 vccd1 vssd1 vccd1 SS_sky130_ef_sc_hd__decap_40_12
XFILLER_52_755 vccd1 vssd1 vccd1 vssd1 SS_sky130_fd_sc_hd__fill_1
XFILLER_52_766 vssd1 vccd1 vssd1 vccd1 SS_sky130_ef_sc_hd__decap_40_12
XTAP_TAPCELL_ROW_65_1269 vccd1 vssd1 SS_sky130_fd_sc_hd__tapvpwrvgnd_1
XTAP_TAPCELL_ROW_22_625 vccd1 vssd1 SS_sky130_fd_sc_hd__tapvpwrvgnd_1
XFILLER_20_641 vssd1 vccd1 vccd1 vssd1 SS_sky130_fd_sc_hd__fill_2
XTAP_TAPCELL_ROW_22_636 vccd1 vssd1 SS_sky130_fd_sc_hd__tapvpwrvgnd_1
XFILLER_3_317 vssd1 vccd1 vssd1 vccd1 SS_sky130_ef_sc_hd__decap_40_12
XFILLER_106_713 vssd1 vccd1 vssd1 vccd1 SS_sky130_ef_sc_hd__decap_40_12
XFILLER_98_29 vssd1 vccd1 vssd1 vccd1 SS_sky130_ef_sc_hd__decap_40_12
XFILLER_98_18 vssd1 vccd1 vccd1 vssd1 SS_sky130_fd_sc_hd__fill_8
XFILLER_106_757 vssd1 vccd1 vssd1 vccd1 SS_sky130_ef_sc_hd__decap_40_12
XFILLER_105_223 vccd1 vssd1 vccd1 vssd1 SS_sky130_fd_sc_hd__fill_1
XFILLER_121_727 vccd1 vssd1 vccd1 vssd1 SS_sky130_fd_sc_hd__fill_1
XFILLER_121_705 vccd1 vssd1 vccd1 vssd1 SS_sky130_fd_sc_hd__fill_1
XTAP_TAPCELL_ROW_93_1690 vccd1 vssd1 SS_sky130_fd_sc_hd__tapvpwrvgnd_1
XFILLER_47_505 vssd1 vccd1 vccd1 vssd1 SS_sky130_fd_sc_hd__fill_2
XFILLER_75_814 vssd1 vccd1 vccd1 vssd1 SS_sky130_fd_sc_hd__fill_4
XFILLER_47_55 vccd1 vssd1 vccd1 vssd1 SS_sky130_fd_sc_hd__fill_1
XFILLER_47_527 vssd1 vccd1 vssd1 vccd1 SS_sky130_ef_sc_hd__decap_40_12
XFILLER_87_685 vssd1 vccd1 vssd1 vccd1 SS_sky130_ef_sc_hd__decap_40_12
XFILLER_28_752 vssd1 vccd1 vccd1 vssd1 SS_sky130_fd_sc_hd__fill_4
XFILLER_74_357 vssd1 vccd1 vccd1 vssd1 SS_sky130_fd_sc_hd__fill_4
XFILLER_86_195 vccd1 vssd1 vccd1 vssd1 SS_sky130_fd_sc_hd__fill_1
XFILLER_101_495 vssd1 vccd1 vccd1 vssd1 SS_sky130_fd_sc_hd__fill_8
XFILLER_27_273 vssd1 vccd1 vccd1 vssd1 SS_sky130_fd_sc_hd__fill_4
XFILLER_42_221 vssd1 vccd1 vssd1 vccd1 SS_sky130_ef_sc_hd__decap_40_12
XFILLER_63_54 vssd1 vccd1 vccd1 vssd1 SS_sky130_fd_sc_hd__fill_2
XTAP_TAPCELL_ROW_41_912 vccd1 vssd1 SS_sky130_fd_sc_hd__tapvpwrvgnd_1
XFILLER_42_265 vssd1 vccd1 vssd1 vccd1 SS_sky130_ef_sc_hd__decap_40_12
XFILLER_70_585 vssd1 vccd1 vccd1 vssd1 SS_sky130_fd_sc_hd__fill_2
XTAP_TAPCELL_ROW_120_2097 vccd1 vssd1 SS_sky130_fd_sc_hd__tapvpwrvgnd_1
XFILLER_11_641 vssd1 vccd1 vssd1 vccd1 SS_sky130_ef_sc_hd__decap_40_12
XFILLER_11_685 vssd1 vccd1 vssd1 vccd1 SS_sky130_ef_sc_hd__decap_40_12
XFILLER_6_133 vssd1 vccd1 vccd1 vssd1 SS_sky130_fd_sc_hd__fill_4
XFILLER_10_195 vccd1 vssd1 vccd1 vssd1 SS_sky130_fd_sc_hd__fill_1
XFILLER_6_177 vssd1 vccd1 vssd1 vccd1 SS_sky130_ef_sc_hd__decap_40_12
XFILLER_136_392 vssd1 vccd1 vssd1 vccd1 SS_sky130_ef_sc_hd__decap_40_12
XFILLER_97_405 vssd1 vccd1 vssd1 vccd1 SS_sky130_ef_sc_hd__decap_40_12
XFILLER_2_361 vssd1 vccd1 vccd1 vssd1 SS_sky130_fd_sc_hd__fill_2
XFILLER_124_587 vccd1 vssd1 vccd1 vssd1 SS_sky130_fd_sc_hd__fill_1
XFILLER_111_237 vssd1 vccd1 vssd1 vccd1 SS_sky130_ef_sc_hd__decap_40_12
XFILLER_97_449 vssd1 vccd1 vssd1 vccd1 SS_sky130_ef_sc_hd__decap_40_12
XFILLER_26_6 vssd1 vccd1 vssd1 vccd1 SS_sky130_ef_sc_hd__decap_40_12
XFILLER_78_641 vssd1 vccd1 vccd1 vssd1 SS_sky130_fd_sc_hd__fill_2
XTAP_TAPCELL_ROW_127_2207 vccd1 vssd1 SS_sky130_fd_sc_hd__tapvpwrvgnd_1
X_1200_ vccd1 vssd1 vccd1 vssd1 _1200_/X _1200_/A _1208_/B SS_sky130_fd_sc_hd__or2_2
XFILLER_120_793 vssd1 vccd1 vssd1 vccd1 SS_sky130_ef_sc_hd__decap_40_12
XFILLER_19_741 vssd1 vccd1 vccd1 vssd1 SS_sky130_fd_sc_hd__fill_4
X_1131_ vssd1 vccd1 vccd1 vssd1 _1141_/A2 input37/X _1596_/D _1329_/C1 _1130_/X SS_sky130_fd_sc_hd__o211a_2
XTAP_TAPCELL_ROW_109_1940 vccd1 vssd1 SS_sky130_fd_sc_hd__tapvpwrvgnd_1
XFILLER_92_121 vssd1 vccd1 vssd1 vccd1 SS_sky130_ef_sc_hd__decap_40_12
XFILLER_18_251 vccd1 vssd1 vccd1 vssd1 SS_sky130_fd_sc_hd__fill_1
XFILLER_19_785 vssd1 vccd1 vccd1 vssd1 SS_sky130_fd_sc_hd__fill_8
XFILLER_80_305 vssd1 vccd1 vccd1 vssd1 SS_sky130_fd_sc_hd__fill_2
X_1062_ vccd1 vssd1 vccd1 vssd1 _1062_/X _1563_/Q _1076_/B SS_sky130_fd_sc_hd__or2_2
XFILLER_93_699 vccd1 vssd1 vccd1 vssd1 SS_sky130_fd_sc_hd__fill_1
XFILLER_92_165 vssd1 vccd1 vssd1 vccd1 SS_sky130_ef_sc_hd__decap_40_12
XFILLER_33_221 vssd1 vccd1 vccd1 vssd1 SS_sky130_fd_sc_hd__fill_2
XFILLER_34_755 vccd1 vssd1 vccd1 vssd1 SS_sky130_fd_sc_hd__fill_1
XFILLER_73_390 vssd1 vccd1 vccd1 vssd1 SS_sky130_fd_sc_hd__fill_2
XFILLER_21_405 vssd1 vccd1 vssd1 vccd1 SS_sky130_ef_sc_hd__decap_40_12
XFILLER_61_585 vssd1 vccd1 vssd1 vccd1 SS_sky130_ef_sc_hd__decap_40_12
XFILLER_21_449 vssd1 vccd1 vssd1 vccd1 SS_sky130_ef_sc_hd__decap_40_12
X_0915_ vccd1 vssd1 vccd1 vssd1 _1566_/Q _1012_/A _1598_/Q wire445/A _0915_/X SS_sky130_fd_sc_hd__a22o_2
XTAP_TAPCELL_ROW_138_2369 vccd1 vssd1 SS_sky130_fd_sc_hd__tapvpwrvgnd_1
XFILLER_119_337 vssd1 vccd1 vssd1 vccd1 SS_sky130_ef_sc_hd__decap_40_12
XTAP_TAPCELL_ROW_60_1199 vccd1 vssd1 SS_sky130_fd_sc_hd__tapvpwrvgnd_1
X_1895_ vccd1 vssd1 _1895_/X _1895_/A vccd1 vssd1 SS_sky130_fd_sc_hd__buf_2
XFILLER_119_359 vssd1 vccd1 vssd1 vccd1 SS_sky130_ef_sc_hd__decap_40_12
X_0846_ vccd1 vssd1 vccd1 vssd1 _1650_/Q _0894_/B1 _1714_/Q _1343_/A _0846_/X SS_sky130_fd_sc_hd__a22o_2
XFILLER_134_307 vccd1 vssd1 vccd1 vssd1 SS_sky130_fd_sc_hd__fill_1
X_0777_ vccd1 vssd1 vccd1 vssd1 _1830_/A wire424/X _1882_/A wire454/X _0777_/X SS_sky130_fd_sc_hd__a22o_2
XFILLER_115_532 vssd1 vccd1 vssd1 vccd1 SS_sky130_ef_sc_hd__decap_40_12
XFILLER_0_309 vssd1 vccd1 vssd1 vccd1 SS_sky130_ef_sc_hd__decap_40_12
XFILLER_69_641 vssd1 vccd1 vssd1 vccd1 SS_sky130_ef_sc_hd__decap_40_12
XFILLER_124_27 vccd1 vssd1 vccd1 vssd1 SS_sky130_fd_sc_hd__fill_1
XFILLER_29_505 vssd1 vccd1 vssd1 vccd1 SS_sky130_ef_sc_hd__decap_40_12
XFILLER_69_685 vssd1 vccd1 vssd1 vccd1 SS_sky130_ef_sc_hd__decap_40_12
XFILLER_111_771 vssd1 vccd1 vssd1 vccd1 SS_sky130_ef_sc_hd__decap_40_12
XFILLER_68_195 vccd1 vssd1 vccd1 vssd1 SS_sky130_fd_sc_hd__fill_1
X_1329_ vssd1 vccd1 vccd1 vssd1 _1331_/A2 input37/X _1692_/D _1329_/C1 _1328_/X SS_sky130_fd_sc_hd__o211a_2
XTAP_TAPCELL_ROW_27_706 vccd1 vssd1 SS_sky130_fd_sc_hd__tapvpwrvgnd_1
XTAP_TAPCELL_ROW_67_1309 vccd1 vssd1 SS_sky130_fd_sc_hd__tapvpwrvgnd_1
XFILLER_71_305 vssd1 vccd1 vssd1 vccd1 SS_sky130_ef_sc_hd__decap_40_12
XFILLER_83_165 vssd1 vccd1 vccd1 vssd1 SS_sky130_fd_sc_hd__fill_2
XFILLER_17_69 vssd1 vccd1 vssd1 vccd1 SS_sky130_ef_sc_hd__decap_40_12
XFILLER_24_221 vssd1 vccd1 vssd1 vccd1 SS_sky130_ef_sc_hd__decap_40_12
XFILLER_24_265 vssd1 vccd1 vssd1 vccd1 SS_sky130_ef_sc_hd__decap_40_12
XFILLER_33_57 vssd1 vccd1 vssd1 vccd1 SS_sky130_ef_sc_hd__decap_40_12
XFILLER_40_769 vssd1 vccd1 vssd1 vccd1 SS_sky130_ef_sc_hd__decap_40_12
XFILLER_137_189 vccd1 vssd1 vccd1 vssd1 SS_sky130_fd_sc_hd__fill_1
XPHY_EDGE_ROW_104_Left_243 vccd1 vssd1 vccd1 vssd1 SS_sky130_fd_sc_hd__decap_3
XTAP_TAPCELL_ROW_95_1730 vccd1 vssd1 SS_sky130_fd_sc_hd__tapvpwrvgnd_1
XFILLER_3_125 vssd1 vccd1 vssd1 vccd1 SS_sky130_ef_sc_hd__decap_40_12
XFILLER_4_637 vssd1 vccd1 vccd1 vssd1 SS_sky130_fd_sc_hd__fill_4
XFILLER_134_830 vssd1 vccd1 vccd1 vssd1 SS_sky130_fd_sc_hd__fill_4
XFILLER_118_381 vssd1 vccd1 vccd1 vssd1 SS_sky130_fd_sc_hd__fill_2
XFILLER_109_3 vssd1 vccd1 vssd1 vccd1 SS_sky130_ef_sc_hd__decap_40_12
XFILLER_3_169 vssd1 vccd1 vssd1 vccd1 SS_sky130_ef_sc_hd__decap_40_12
XFILLER_106_565 vssd1 vccd1 vssd1 vccd1 SS_sky130_ef_sc_hd__decap_40_12
XFILLER_79_449 vssd1 vccd1 vssd1 vccd1 SS_sky130_ef_sc_hd__decap_40_12
XFILLER_106_587 vccd1 vssd1 vccd1 vssd1 SS_sky130_fd_sc_hd__fill_1
XFILLER_58_65 vssd1 vccd1 vssd1 vccd1 SS_sky130_ef_sc_hd__decap_40_12
XFILLER_94_419 vccd1 vssd1 vccd1 vssd1 SS_sky130_fd_sc_hd__fill_1
XFILLER_47_335 vccd1 vssd1 vccd1 vssd1 SS_sky130_fd_sc_hd__fill_1
XFILLER_74_121 vssd1 vccd1 vssd1 vccd1 SS_sky130_ef_sc_hd__decap_40_12
XPHY_EDGE_ROW_113_Left_252 vccd1 vssd1 vccd1 vssd1 SS_sky130_fd_sc_hd__decap_3
XFILLER_102_793 vssd1 vccd1 vccd1 vssd1 SS_sky130_fd_sc_hd__fill_4
XFILLER_101_281 vssd1 vccd1 vssd1 vccd1 SS_sky130_ef_sc_hd__decap_40_12
XFILLER_62_305 vssd1 vccd1 vccd1 vssd1 SS_sky130_fd_sc_hd__fill_2
XFILLER_74_165 vssd1 vccd1 vssd1 vccd1 SS_sky130_ef_sc_hd__decap_40_12
XFILLER_74_53 vssd1 vccd1 vssd1 vccd1 SS_sky130_ef_sc_hd__decap_40_12
XFILLER_90_625 vssd1 vccd1 vssd1 vccd1 SS_sky130_ef_sc_hd__decap_40_12
XTAP_TAPCELL_ROW_122_2137 vccd1 vssd1 SS_sky130_fd_sc_hd__tapvpwrvgnd_1
XTAP_TAPCELL_ROW_122_2126 vccd1 vssd1 SS_sky130_fd_sc_hd__tapvpwrvgnd_1
XFILLER_15_221 vssd1 vccd1 vccd1 vssd1 SS_sky130_fd_sc_hd__fill_2
XFILLER_16_755 vccd1 vssd1 vccd1 vssd1 SS_sky130_fd_sc_hd__fill_1
XFILLER_74_97 vssd1 vccd1 vssd1 vccd1 SS_sky130_ef_sc_hd__decap_40_12
XFILLER_90_669 vssd1 vccd1 vccd1 vssd1 SS_sky130_fd_sc_hd__fill_2
XFILLER_130_81 vssd1 vccd1 vccd1 vssd1 SS_sky130_fd_sc_hd__fill_2
XFILLER_90_41 vssd1 vccd1 vssd1 vccd1 SS_sky130_ef_sc_hd__decap_40_12
XFILLER_90_85 vssd1 vccd1 vssd1 vccd1 SS_sky130_ef_sc_hd__decap_40_12
XPHY_EDGE_ROW_122_Left_261 vccd1 vssd1 vccd1 vssd1 SS_sky130_fd_sc_hd__decap_3
XTAP_TAPCELL_ROW_13_488 vccd1 vssd1 SS_sky130_fd_sc_hd__tapvpwrvgnd_1
XTAP_TAPCELL_ROW_13_499 vccd1 vssd1 SS_sky130_fd_sc_hd__tapvpwrvgnd_1
Xwire340 vccd1 vssd1 vssd1 vccd1 wire340/A analog_ctrl[38] SS_sky130_fd_sc_hd__buf_12
XFILLER_129_657 vssd1 vccd1 vssd1 vccd1 SS_sky130_ef_sc_hd__decap_40_12
XFILLER_117_819 vccd1 vssd1 vccd1 vssd1 SS_sky130_fd_sc_hd__fill_1
X_1680_ _1680_/Q clkload5/A _1680_/D vccd1 vssd1 vccd1 vssd1 SS_sky130_fd_sc_hd__dfxtp_2
Xwire373 vccd1 vssd1 vssd1 vccd1 wire373/A wbs_dat_o[1] SS_sky130_fd_sc_hd__buf_12
Xwire384 vccd1 vssd1 vssd1 vccd1 wire384/A wbs_dat_o[0] SS_sky130_fd_sc_hd__buf_12
Xwire362 vccd1 vssd1 vssd1 vccd1 wire362/A wbs_dat_o[2] SS_sky130_fd_sc_hd__buf_12
XFILLER_116_318 vssd1 vccd1 vssd1 vccd1 SS_sky130_ef_sc_hd__decap_40_12
XFILLER_116_307 vccd1 vssd1 vccd1 vssd1 SS_sky130_fd_sc_hd__fill_1
XFILLER_7_497 vssd1 vccd1 vccd1 vssd1 SS_sky130_fd_sc_hd__fill_4
XFILLER_128_189 vssd1 vccd1 vccd1 vssd1 SS_sky130_fd_sc_hd__fill_4
XFILLER_125_841 vccd1 vssd1 vccd1 vssd1 SS_sky130_fd_sc_hd__fill_1
Xwire395 vccd1 vssd1 vssd1 vccd1 wire395/A analog_ctrl[86] SS_sky130_fd_sc_hd__buf_12
XTAP_TAPCELL_ROW_133_2288 vccd1 vssd1 SS_sky130_fd_sc_hd__tapvpwrvgnd_1
XTAP_TAPCELL_ROW_133_2299 vccd1 vssd1 SS_sky130_fd_sc_hd__tapvpwrvgnd_1
XFILLER_124_362 vssd1 vccd1 vccd1 vssd1 SS_sky130_fd_sc_hd__fill_2
XFILLER_112_513 vssd1 vccd1 vccd1 vssd1 SS_sky130_fd_sc_hd__fill_8
XFILLER_98_736 vssd1 vccd1 vssd1 vccd1 SS_sky130_ef_sc_hd__decap_40_12
XFILLER_98_769 vssd1 vccd1 vssd1 vccd1 SS_sky130_ef_sc_hd__decap_40_12
XFILLER_24_3 vssd1 vccd1 vssd1 vccd1 SS_sky130_ef_sc_hd__decap_40_12
XPHY_EDGE_ROW_131_Left_270 vccd1 vssd1 vccd1 vssd1 SS_sky130_fd_sc_hd__decap_3
XFILLER_97_279 vccd1 vssd1 vccd1 vssd1 SS_sky130_fd_sc_hd__fill_1
XPHY_EDGE_ROW_119_Right_119 vccd1 vssd1 vccd1 vssd1 SS_sky130_fd_sc_hd__decap_3
XFILLER_93_441 vssd1 vccd1 vccd1 vssd1 SS_sky130_fd_sc_hd__fill_4
XFILLER_38_357 vssd1 vccd1 vccd1 vssd1 SS_sky130_fd_sc_hd__fill_4
X_1114_ vccd1 vssd1 vccd1 vssd1 _1114_/X _1114_/A _1116_/B SS_sky130_fd_sc_hd__or2_2
XFILLER_53_305 vssd1 vccd1 vssd1 vccd1 SS_sky130_ef_sc_hd__decap_40_12
XFILLER_65_165 vssd1 vccd1 vccd1 vssd1 SS_sky130_fd_sc_hd__fill_2
XFILLER_93_463 vccd1 vssd1 vccd1 vssd1 SS_sky130_fd_sc_hd__fill_1
XTAP_TAPCELL_ROW_49_1028 vccd1 vssd1 SS_sky130_fd_sc_hd__tapvpwrvgnd_1
XTAP_TAPCELL_ROW_49_1039 vccd1 vssd1 SS_sky130_fd_sc_hd__tapvpwrvgnd_1
XFILLER_93_496 vssd1 vccd1 vccd1 vssd1 SS_sky130_fd_sc_hd__fill_8
XFILLER_0_83 vccd1 vssd1 vccd1 vssd1 SS_sky130_fd_sc_hd__fill_1
XFILLER_53_349 vssd1 vccd1 vssd1 vccd1 SS_sky130_ef_sc_hd__decap_40_12
X_1045_ vssd1 vccd1 vccd1 vssd1 _1065_/A2 input26/X _1554_/D _1441_/C1 _1044_/X SS_sky130_fd_sc_hd__o211a_2
XFILLER_22_725 vssd1 vccd1 vssd1 vccd1 SS_sky130_ef_sc_hd__decap_40_12
XTAP_TAPCELL_ROW_62_1228 vccd1 vssd1 SS_sky130_fd_sc_hd__tapvpwrvgnd_1
XFILLER_110_29 vssd1 vccd1 vssd1 vccd1 SS_sky130_ef_sc_hd__decap_40_12
XFILLER_22_769 vssd1 vccd1 vccd1 vssd1 SS_sky130_fd_sc_hd__fill_8
XFILLER_61_393 vccd1 vssd1 vccd1 vssd1 SS_sky130_fd_sc_hd__fill_1
XFILLER_9_81 vssd1 vccd1 vssd1 vccd1 SS_sky130_ef_sc_hd__decap_40_12
XFILLER_21_279 vccd1 vssd1 vccd1 vssd1 SS_sky130_fd_sc_hd__fill_1
XTAP_TAPCELL_ROW_32_775 vccd1 vssd1 SS_sky130_fd_sc_hd__tapvpwrvgnd_1
XTAP_TAPCELL_ROW_32_786 vccd1 vssd1 SS_sky130_fd_sc_hd__tapvpwrvgnd_1
XFILLER_119_27 vssd1 vccd1 vssd1 vccd1 SS_sky130_ef_sc_hd__decap_40_12
X_1878_ vccd1 vssd1 _1878_/X _1878_/A vccd1 vssd1 SS_sky130_fd_sc_hd__buf_2
XFILLER_119_167 vccd1 vssd1 vccd1 vssd1 SS_sky130_fd_sc_hd__fill_1
X_0829_ vssd1 vccd1 vssd1 vccd1 wire435/A _1907_/A _0865_/B1 _0825_/X _0829_/X _0826_/X
+ SS_sky130_fd_sc_hd__a2111o_2
XFILLER_134_137 vssd1 vccd1 vccd1 vssd1 SS_sky130_fd_sc_hd__fill_2
XFILLER_135_649 vssd1 vccd1 vccd1 vssd1 SS_sky130_fd_sc_hd__fill_4
XFILLER_107_329 vssd1 vccd1 vccd1 vssd1 SS_sky130_fd_sc_hd__fill_4
XTAP_TAPCELL_ROW_77_1460 vccd1 vssd1 SS_sky130_fd_sc_hd__tapvpwrvgnd_1
XFILLER_1_629 vssd1 vccd1 vssd1 vccd1 SS_sky130_ef_sc_hd__decap_40_12
XFILLER_89_725 vssd1 vccd1 vccd1 vssd1 SS_sky130_fd_sc_hd__fill_2
XFILLER_135_15 vssd1 vccd1 vccd1 vssd1 SS_sky130_fd_sc_hd__fill_4
XFILLER_0_139 vccd1 vssd1 vccd1 vssd1 SS_sky130_fd_sc_hd__fill_1
XFILLER_103_557 vssd1 vccd1 vccd1 vssd1 SS_sky130_fd_sc_hd__fill_2
XFILLER_76_419 vccd1 vssd1 vccd1 vssd1 SS_sky130_fd_sc_hd__fill_1
XFILLER_130_365 vssd1 vccd1 vssd1 vccd1 SS_sky130_ef_sc_hd__decap_40_12
XFILLER_29_335 vccd1 vssd1 vccd1 vssd1 SS_sky130_fd_sc_hd__fill_1
XFILLER_56_121 vssd1 vccd1 vssd1 vccd1 SS_sky130_ef_sc_hd__decap_40_12
XFILLER_44_305 vssd1 vccd1 vccd1 vssd1 SS_sky130_fd_sc_hd__fill_2
XFILLER_56_165 vssd1 vccd1 vssd1 vccd1 SS_sky130_ef_sc_hd__decap_40_12
XFILLER_71_113 vssd1 vccd1 vssd1 vccd1 SS_sky130_ef_sc_hd__decap_40_12
XFILLER_25_541 vssd1 vccd1 vssd1 vccd1 SS_sky130_ef_sc_hd__decap_40_12
XFILLER_60_809 vssd1 vccd1 vccd1 vssd1 SS_sky130_fd_sc_hd__fill_2
XFILLER_13_725 vssd1 vccd1 vccd1 vssd1 SS_sky130_fd_sc_hd__fill_2
XFILLER_25_585 vssd1 vccd1 vssd1 vccd1 SS_sky130_ef_sc_hd__decap_40_12
XFILLER_40_533 vssd1 vccd1 vssd1 vccd1 SS_sky130_ef_sc_hd__decap_40_12
XFILLER_9_729 vssd1 vccd1 vssd1 vccd1 SS_sky130_ef_sc_hd__decap_40_12
XFILLER_138_421 vssd1 vccd1 vccd1 vssd1 SS_sky130_fd_sc_hd__fill_2
XTAP_TAPCELL_ROW_10_447 vccd1 vssd1 SS_sky130_fd_sc_hd__tapvpwrvgnd_1
XFILLER_60_77 vssd1 vccd1 vccd1 vssd1 SS_sky130_fd_sc_hd__fill_4
XFILLER_4_401 vssd1 vccd1 vssd1 vccd1 SS_sky130_ef_sc_hd__decap_40_12
XFILLER_126_649 vssd1 vccd1 vccd1 vssd1 SS_sky130_fd_sc_hd__fill_2
XFILLER_125_137 vssd1 vccd1 vssd1 vccd1 SS_sky130_ef_sc_hd__decap_40_12
XFILLER_107_841 vccd1 vssd1 vccd1 vssd1 SS_sky130_fd_sc_hd__fill_1
XFILLER_4_445 vssd1 vccd1 vssd1 vccd1 SS_sky130_ef_sc_hd__decap_40_12
XFILLER_5_39 vssd1 vccd1 vssd1 vccd1 SS_sky130_ef_sc_hd__decap_40_12
XFILLER_4_489 vssd1 vccd1 vssd1 vccd1 SS_sky130_ef_sc_hd__decap_40_12
XFILLER_122_811 vccd1 vssd1 vccd1 vssd1 SS_sky130_fd_sc_hd__fill_1
XFILLER_109_93 vssd1 vccd1 vssd1 vccd1 SS_sky130_ef_sc_hd__decap_40_12
XFILLER_106_362 vssd1 vccd1 vccd1 vssd1 SS_sky130_fd_sc_hd__fill_2
XFILLER_133_181 vssd1 vccd1 vssd1 vccd1 SS_sky130_ef_sc_hd__decap_40_12
XFILLER_0_673 vssd1 vccd1 vssd1 vccd1 SS_sky130_ef_sc_hd__decap_40_12
XFILLER_79_279 vccd1 vssd1 vccd1 vssd1 SS_sky130_fd_sc_hd__fill_1
XFILLER_0_695 vssd1 vccd1 vccd1 vssd1 SS_sky130_fd_sc_hd__fill_4
XFILLER_48_622 vssd1 vccd1 vssd1 vccd1 SS_sky130_ef_sc_hd__decap_40_12
XFILLER_125_81 vssd1 vccd1 vssd1 vccd1 SS_sky130_ef_sc_hd__decap_40_12
XFILLER_94_249 vssd1 vccd1 vccd1 vssd1 SS_sky130_fd_sc_hd__fill_2
XFILLER_35_305 vssd1 vccd1 vssd1 vccd1 SS_sky130_ef_sc_hd__decap_40_12
XFILLER_36_817 vssd1 vccd1 vccd1 vssd1 SS_sky130_fd_sc_hd__fill_2
XFILLER_63_614 vssd1 vccd1 vccd1 vssd1 SS_sky130_fd_sc_hd__fill_2
XFILLER_47_165 vssd1 vccd1 vccd1 vssd1 SS_sky130_fd_sc_hd__fill_2
XFILLER_48_699 vccd1 vssd1 vccd1 vssd1 SS_sky130_fd_sc_hd__fill_1
XFILLER_75_485 vssd1 vccd1 vssd1 vccd1 SS_sky130_ef_sc_hd__decap_40_12
XFILLER_35_349 vssd1 vccd1 vssd1 vccd1 SS_sky130_ef_sc_hd__decap_40_12
XFILLER_90_433 vssd1 vccd1 vssd1 vccd1 SS_sky130_ef_sc_hd__decap_40_12
XFILLER_16_585 vssd1 vccd1 vccd1 vssd1 SS_sky130_fd_sc_hd__fill_2
XTAP_TAPCELL_ROW_18_569 vccd1 vssd1 SS_sky130_fd_sc_hd__tapvpwrvgnd_1
XFILLER_90_477 vssd1 vccd1 vccd1 vssd1 SS_sky130_fd_sc_hd__fill_4
XTAP_TAPCELL_ROW_102_1829 vccd1 vssd1 SS_sky130_fd_sc_hd__tapvpwrvgnd_1
XFILLER_43_393 vssd1 vccd1 vssd1 vccd1 SS_sky130_ef_sc_hd__decap_40_12
XFILLER_93_6 vssd1 vccd1 vssd1 vccd1 SS_sky130_ef_sc_hd__decap_40_12
XTAP_TAPCELL_ROW_135_2328 vccd1 vssd1 SS_sky130_fd_sc_hd__tapvpwrvgnd_1
XFILLER_117_627 vccd1 vssd1 vccd1 vssd1 SS_sky130_fd_sc_hd__fill_1
X_1732_ _1896_/A _1745_/CLK _1732_/D vccd1 vssd1 vccd1 vssd1 SS_sky130_fd_sc_hd__dfxtp_2
XFILLER_7_261 vssd1 vccd1 vssd1 vccd1 SS_sky130_ef_sc_hd__decap_40_12
XFILLER_116_137 vssd1 vccd1 vccd1 vssd1 SS_sky130_fd_sc_hd__fill_2
X_1663_ _1663_/Q _1727_/CLK _1663_/D vccd1 vssd1 vccd1 vssd1 SS_sky130_fd_sc_hd__dfxtp_2
XTAP_TAPCELL_ROW_59_1190 vccd1 vssd1 SS_sky130_fd_sc_hd__tapvpwrvgnd_1
X_1594_ _1594_/Q _1755_/CLK _1594_/D vccd1 vssd1 vccd1 vssd1 SS_sky130_fd_sc_hd__dfxtp_2
XFILLER_113_811 vccd1 vssd1 vccd1 vssd1 SS_sky130_fd_sc_hd__fill_1
XFILLER_98_533 vssd1 vccd1 vssd1 vccd1 SS_sky130_ef_sc_hd__decap_40_12
XPHY_EDGE_ROW_7_Right_7 vccd1 vssd1 vccd1 vssd1 SS_sky130_fd_sc_hd__decap_3
XFILLER_58_419 vccd1 vssd1 vccd1 vssd1 SS_sky130_fd_sc_hd__fill_1
XFILLER_85_205 vssd1 vccd1 vssd1 vccd1 SS_sky130_ef_sc_hd__decap_40_12
XFILLER_86_728 vssd1 vccd1 vssd1 vccd1 SS_sky130_ef_sc_hd__decap_40_12
XFILLER_38_121 vssd1 vccd1 vssd1 vccd1 SS_sky130_ef_sc_hd__decap_40_12
XFILLER_85_249 vssd1 vccd1 vssd1 vccd1 SS_sky130_ef_sc_hd__decap_40_12
XFILLER_112_398 vssd1 vccd1 vssd1 vccd1 SS_sky130_ef_sc_hd__decap_40_12
XFILLER_26_305 vssd1 vccd1 vccd1 vssd1 SS_sky130_fd_sc_hd__fill_2
XFILLER_38_165 vssd1 vccd1 vssd1 vccd1 SS_sky130_ef_sc_hd__decap_40_12
XFILLER_53_113 vssd1 vccd1 vssd1 vccd1 SS_sky130_ef_sc_hd__decap_40_12
XFILLER_54_625 vssd1 vccd1 vssd1 vccd1 SS_sky130_ef_sc_hd__decap_40_12
XFILLER_66_474 vssd1 vccd1 vccd1 vssd1 SS_sky130_fd_sc_hd__fill_2
XFILLER_94_794 vccd1 vssd1 vccd1 vssd1 SS_sky130_fd_sc_hd__fill_1
XTAP_TAPCELL_ROW_37_856 vccd1 vssd1 SS_sky130_fd_sc_hd__tapvpwrvgnd_1
XFILLER_42_809 vssd1 vccd1 vccd1 vssd1 SS_sky130_fd_sc_hd__fill_2
XFILLER_54_669 vssd1 vccd1 vccd1 vssd1 SS_sky130_fd_sc_hd__fill_8
XFILLER_93_293 vssd1 vccd1 vssd1 vccd1 SS_sky130_ef_sc_hd__decap_40_12
X_1028_ vccd1 vssd1 vccd1 vssd1 _1028_/X _1028_/A _1050_/B SS_sky130_fd_sc_hd__or2_2
XFILLER_14_15 vssd1 vccd1 vssd1 vccd1 SS_sky130_ef_sc_hd__decap_40_12
XFILLER_22_533 vssd1 vccd1 vssd1 vccd1 SS_sky130_ef_sc_hd__decap_40_12
XFILLER_135_446 vssd1 vccd1 vccd1 vssd1 SS_sky130_fd_sc_hd__fill_2
XFILLER_107_137 vssd1 vccd1 vssd1 vccd1 SS_sky130_ef_sc_hd__decap_40_12
XTAP_TAPCELL_ROW_75_1419 vccd1 vssd1 SS_sky130_fd_sc_hd__tapvpwrvgnd_1
Xhold773 _1384_/A _1719_/Q vccd1 vssd1 vssd1 vccd1 SS_sky130_fd_sc_hd__dlygate4sd3_1
Xhold762 _0974_/A _1520_/Q vccd1 vssd1 vssd1 vccd1 SS_sky130_fd_sc_hd__dlygate4sd3_1
Xhold751 _1054_/A _1559_/Q vccd1 vssd1 vssd1 vccd1 SS_sky130_fd_sc_hd__dlygate4sd3_1
Xhold740 _1374_/A _1714_/Q vccd1 vssd1 vssd1 vccd1 SS_sky130_fd_sc_hd__dlygate4sd3_1
XFILLER_116_682 vccd1 vssd1 vccd1 vssd1 SS_sky130_fd_sc_hd__fill_1
Xhold784 _0982_/A _1524_/Q vccd1 vssd1 vssd1 vccd1 SS_sky130_fd_sc_hd__dlygate4sd3_1
XFILLER_131_641 vssd1 vccd1 vssd1 vccd1 SS_sky130_ef_sc_hd__decap_40_12
XFILLER_115_181 vssd1 vccd1 vssd1 vccd1 SS_sky130_ef_sc_hd__decap_40_12
Xhold795 _1503_/D _0926_/X vccd1 vssd1 vssd1 vccd1 SS_sky130_fd_sc_hd__dlygate4sd3_1
XFILLER_131_685 vssd1 vccd1 vssd1 vccd1 SS_sky130_ef_sc_hd__decap_40_12
XFILLER_76_249 vssd1 vccd1 vccd1 vssd1 SS_sky130_fd_sc_hd__fill_2
XFILLER_130_195 vccd1 vssd1 vccd1 vssd1 SS_sky130_fd_sc_hd__fill_1
Xclkbuf_leaf_18_wb_clk_i _1741_/CLK clkbuf_leaf_7_wb_clk_i/A vccd1 vssd1 vssd1 vccd1
+ SS_sky130_fd_sc_hd__clkbuf_8
XFILLER_45_603 vssd1 vccd1 vssd1 vccd1 SS_sky130_ef_sc_hd__decap_40_12
XFILLER_57_441 vssd1 vccd1 vccd1 vssd1 SS_sky130_fd_sc_hd__fill_4
XFILLER_17_305 vssd1 vccd1 vssd1 vccd1 SS_sky130_ef_sc_hd__decap_40_12
XFILLER_29_165 vssd1 vccd1 vccd1 vssd1 SS_sky130_fd_sc_hd__fill_2
XFILLER_72_411 vssd1 vccd1 vccd1 vssd1 SS_sky130_fd_sc_hd__fill_8
XFILLER_17_349 vssd1 vccd1 vssd1 vccd1 SS_sky130_ef_sc_hd__decap_40_12
XFILLER_45_669 vssd1 vccd1 vccd1 vssd1 SS_sky130_fd_sc_hd__fill_2
XFILLER_55_55 vccd1 vssd1 vccd1 vssd1 SS_sky130_fd_sc_hd__fill_1
XFILLER_72_455 vssd1 vccd1 vssd1 vccd1 SS_sky130_ef_sc_hd__decap_40_12
XFILLER_72_477 vssd1 vccd1 vccd1 vssd1 SS_sky130_fd_sc_hd__fill_2
XTAP_TAPCELL_ROW_15_528 vccd1 vssd1 SS_sky130_fd_sc_hd__tapvpwrvgnd_1
XFILLER_25_393 vssd1 vccd1 vssd1 vccd1 SS_sky130_ef_sc_hd__decap_40_12
XFILLER_40_363 vccd1 vssd1 vccd1 vssd1 SS_sky130_fd_sc_hd__fill_1
XFILLER_71_54 vssd1 vccd1 vccd1 vssd1 SS_sky130_fd_sc_hd__fill_2
XFILLER_9_559 vccd1 vssd1 vccd1 vssd1 SS_sky130_fd_sc_hd__fill_1
XFILLER_138_251 vccd1 vssd1 vccd1 vssd1 SS_sky130_fd_sc_hd__fill_1
XFILLER_5_721 vssd1 vccd1 vccd1 vssd1 SS_sky130_fd_sc_hd__fill_4
XTAP_TAPCELL_ROW_117_2058 vccd1 vssd1 SS_sky130_fd_sc_hd__tapvpwrvgnd_1
XFILLER_5_765 vssd1 vccd1 vssd1 vccd1 SS_sky130_ef_sc_hd__decap_40_12
XFILLER_114_619 vccd1 vssd1 vccd1 vssd1 SS_sky130_fd_sc_hd__fill_1
XFILLER_4_253 vssd1 vccd1 vssd1 vccd1 SS_sky130_ef_sc_hd__decap_40_12
XTAP_TAPCELL_ROW_130_2247 vccd1 vssd1 SS_sky130_fd_sc_hd__tapvpwrvgnd_1
XFILLER_107_682 vssd1 vccd1 vccd1 vssd1 SS_sky130_fd_sc_hd__fill_4
XFILLER_107_671 vccd1 vssd1 vccd1 vssd1 SS_sky130_fd_sc_hd__fill_1
XFILLER_67_205 vssd1 vccd1 vssd1 vccd1 SS_sky130_ef_sc_hd__decap_40_12
XTAP_TAPCELL_ROW_112_1980 vccd1 vssd1 SS_sky130_fd_sc_hd__tapvpwrvgnd_1
XFILLER_110_825 vssd1 vccd1 vccd1 vssd1 SS_sky130_fd_sc_hd__fill_8
XFILLER_95_503 vccd1 vssd1 vccd1 vssd1 SS_sky130_fd_sc_hd__fill_1
XFILLER_67_249 vssd1 vccd1 vssd1 vccd1 SS_sky130_ef_sc_hd__decap_40_12
XFILLER_95_558 vssd1 vccd1 vccd1 vssd1 SS_sky130_fd_sc_hd__fill_2
XFILLER_48_463 vssd1 vccd1 vccd1 vssd1 SS_sky130_fd_sc_hd__fill_2
XFILLER_83_709 vssd1 vccd1 vccd1 vssd1 SS_sky130_fd_sc_hd__fill_4
XFILLER_35_113 vssd1 vccd1 vssd1 vccd1 SS_sky130_ef_sc_hd__decap_40_12
XFILLER_48_474 vssd1 vccd1 vccd1 vssd1 SS_sky130_fd_sc_hd__fill_2
XFILLER_36_669 vssd1 vccd1 vssd1 vccd1 SS_sky130_ef_sc_hd__decap_40_12
XFILLER_75_293 vssd1 vccd1 vssd1 vccd1 SS_sky130_ef_sc_hd__decap_40_12
XTAP_TAPCELL_ROW_34_804 vccd1 vssd1 SS_sky130_fd_sc_hd__tapvpwrvgnd_1
XTAP_TAPCELL_ROW_34_815 vccd1 vssd1 SS_sky130_fd_sc_hd__tapvpwrvgnd_1
XFILLER_51_617 vssd1 vccd1 vssd1 vccd1 SS_sky130_ef_sc_hd__decap_40_12
XFILLER_31_385 vssd1 vccd1 vccd1 vssd1 SS_sky130_fd_sc_hd__fill_4
XFILLER_8_581 vssd1 vccd1 vccd1 vssd1 SS_sky130_fd_sc_hd__fill_4
XFILLER_129_273 vssd1 vccd1 vccd1 vssd1 SS_sky130_fd_sc_hd__fill_4
XFILLER_117_413 vssd1 vccd1 vssd1 vccd1 SS_sky130_ef_sc_hd__decap_40_12
X_1715_ _1715_/Q _1747_/CLK _1715_/D vccd1 vssd1 vccd1 vssd1 SS_sky130_fd_sc_hd__dfxtp_2
XTAP_TAPCELL_ROW_57_1149 vccd1 vssd1 SS_sky130_fd_sc_hd__tapvpwrvgnd_1
X_1646_ _1646_/Q _1751_/CLK _1646_/D vccd1 vssd1 vccd1 vssd1 SS_sky130_fd_sc_hd__dfxtp_2
XFILLER_132_416 vssd1 vccd1 vccd1 vssd1 SS_sky130_fd_sc_hd__fill_4
X_1577_ _1851_/A _1610_/CLK _1577_/D vccd1 vssd1 vccd1 vssd1 SS_sky130_fd_sc_hd__dfxtp_2
XFILLER_113_685 vssd1 vccd1 vssd1 vccd1 SS_sky130_ef_sc_hd__decap_40_12
XFILLER_58_249 vssd1 vccd1 vccd1 vssd1 SS_sky130_fd_sc_hd__fill_2
XTAP_TAPCELL_ROW_70_1349 vccd1 vssd1 SS_sky130_fd_sc_hd__tapvpwrvgnd_1
XFILLER_86_525 vssd1 vccd1 vccd1 vssd1 SS_sky130_fd_sc_hd__fill_4
XFILLER_112_195 vccd1 vssd1 vccd1 vssd1 SS_sky130_fd_sc_hd__fill_1
XFILLER_39_441 vssd1 vccd1 vccd1 vssd1 SS_sky130_fd_sc_hd__fill_4
XFILLER_132_27 vccd1 vssd1 vccd1 vssd1 SS_sky130_fd_sc_hd__fill_1
XFILLER_100_357 vssd1 vccd1 vccd1 vssd1 SS_sky130_fd_sc_hd__fill_4
XFILLER_67_783 vccd1 vssd1 vccd1 vssd1 SS_sky130_fd_sc_hd__fill_1
XFILLER_15_809 vssd1 vccd1 vccd1 vssd1 SS_sky130_fd_sc_hd__fill_8
XFILLER_27_669 vssd1 vccd1 vccd1 vssd1 SS_sky130_fd_sc_hd__fill_2
XFILLER_54_433 vssd1 vccd1 vssd1 vccd1 SS_sky130_ef_sc_hd__decap_40_12
XFILLER_82_731 vccd1 vssd1 vccd1 vssd1 SS_sky130_fd_sc_hd__fill_1
XFILLER_41_105 vssd1 vccd1 vccd1 vssd1 SS_sky130_fd_sc_hd__fill_4
XFILLER_54_477 vssd1 vccd1 vssd1 vccd1 SS_sky130_ef_sc_hd__decap_40_12
XFILLER_82_786 vssd1 vccd1 vssd1 vccd1 SS_sky130_ef_sc_hd__decap_40_12
XFILLER_25_69 vssd1 vccd1 vssd1 vccd1 SS_sky130_ef_sc_hd__decap_40_12
XTAP_TAPCELL_ROW_85_1570 vccd1 vssd1 SS_sky130_fd_sc_hd__tapvpwrvgnd_1
XTAP_TAPCELL_ROW_85_1581 vccd1 vssd1 SS_sky130_fd_sc_hd__tapvpwrvgnd_1
XFILLER_41_149 vssd1 vccd1 vssd1 vccd1 SS_sky130_ef_sc_hd__decap_40_12
XFILLER_10_525 vssd1 vccd1 vccd1 vssd1 SS_sky130_fd_sc_hd__fill_4
XFILLER_22_363 vccd1 vssd1 vccd1 vssd1 SS_sky130_fd_sc_hd__fill_1
XFILLER_10_569 vssd1 vccd1 vssd1 vccd1 SS_sky130_ef_sc_hd__decap_40_12
XFILLER_41_57 vssd1 vccd1 vssd1 vccd1 SS_sky130_ef_sc_hd__decap_40_12
XFILLER_6_529 vssd1 vccd1 vccd1 vssd1 SS_sky130_fd_sc_hd__fill_2
XFILLER_108_413 vssd1 vccd1 vccd1 vssd1 SS_sky130_fd_sc_hd__fill_2
XTAP_TAPCELL_ROW_20_597 vccd1 vssd1 SS_sky130_fd_sc_hd__tapvpwrvgnd_1
XFILLER_135_221 vssd1 vccd1 vccd1 vssd1 SS_sky130_fd_sc_hd__fill_2
XFILLER_2_713 vssd1 vccd1 vssd1 vccd1 SS_sky130_ef_sc_hd__decap_40_12
XFILLER_136_788 vssd1 vccd1 vssd1 vccd1 SS_sky130_ef_sc_hd__decap_40_12
XFILLER_123_405 vssd1 vccd1 vssd1 vccd1 SS_sky130_ef_sc_hd__decap_40_12
XFILLER_1_223 vccd1 vssd1 vccd1 vssd1 SS_sky130_fd_sc_hd__fill_1
XFILLER_2_757 vssd1 vccd1 vssd1 vccd1 SS_sky130_ef_sc_hd__decap_40_12
Xhold581 _1154_/A _1867_/A vccd1 vssd1 vssd1 vccd1 SS_sky130_fd_sc_hd__dlygate4sd3_1
Xhold570 input45/A wbs_dat_i[3] vccd1 vssd1 vssd1 vccd1 SS_sky130_fd_sc_hd__dlygate4sd3_1
XFILLER_104_630 vccd1 vssd1 vccd1 vssd1 SS_sky130_fd_sc_hd__fill_1
XFILLER_49_205 vssd1 vccd1 vssd1 vccd1 SS_sky130_ef_sc_hd__decap_40_12
Xhold592 _1410_/A _1895_/A vccd1 vssd1 vssd1 vccd1 SS_sky130_fd_sc_hd__dlygate4sd3_1
XFILLER_77_503 vccd1 vssd1 vccd1 vssd1 SS_sky130_fd_sc_hd__fill_1
XFILLER_2_29 vssd1 vccd1 vssd1 vccd1 SS_sky130_ef_sc_hd__decap_40_12
XFILLER_49_249 vssd1 vccd1 vssd1 vccd1 SS_sky130_ef_sc_hd__decap_40_12
XFILLER_65_709 vssd1 vccd1 vssd1 vccd1 SS_sky130_ef_sc_hd__decap_40_12
XFILLER_106_83 vccd1 vssd1 vccd1 vssd1 SS_sky130_fd_sc_hd__fill_1
XFILLER_18_625 vssd1 vccd1 vssd1 vccd1 SS_sky130_ef_sc_hd__decap_40_12
XFILLER_66_65 vssd1 vccd1 vssd1 vccd1 SS_sky130_ef_sc_hd__decap_40_12
XFILLER_17_113 vssd1 vccd1 vssd1 vccd1 SS_sky130_ef_sc_hd__decap_40_12
XFILLER_18_669 vssd1 vccd1 vssd1 vccd1 SS_sky130_ef_sc_hd__decap_40_12
XFILLER_57_293 vssd1 vccd1 vssd1 vccd1 SS_sky130_ef_sc_hd__decap_40_12
XFILLER_73_753 vssd1 vccd1 vssd1 vccd1 SS_sky130_ef_sc_hd__decap_40_12
XFILLER_33_617 vssd1 vccd1 vssd1 vccd1 SS_sky130_ef_sc_hd__decap_40_12
XFILLER_73_797 vssd1 vccd1 vssd1 vccd1 SS_sky130_ef_sc_hd__decap_40_12
XFILLER_82_53 vssd1 vccd1 vssd1 vccd1 SS_sky130_ef_sc_hd__decap_40_12
XFILLER_82_97 vssd1 vccd1 vssd1 vccd1 SS_sky130_ef_sc_hd__decap_40_12
XFILLER_13_385 vssd1 vccd1 vccd1 vssd1 SS_sky130_fd_sc_hd__fill_4
XFILLER_40_193 vssd1 vccd1 vccd1 vssd1 SS_sky130_fd_sc_hd__fill_2
XFILLER_9_389 vssd1 vccd1 vccd1 vssd1 SS_sky130_fd_sc_hd__fill_2
XFILLER_127_733 vssd1 vccd1 vccd1 vssd1 SS_sky130_fd_sc_hd__fill_2
XFILLER_126_221 vssd1 vccd1 vssd1 vccd1 SS_sky130_ef_sc_hd__decap_40_12
XFILLER_5_573 vssd1 vccd1 vssd1 vccd1 SS_sky130_ef_sc_hd__decap_40_12
Xoutput108 vccd1 vssd1 wire336/A _1866_/X vccd1 vssd1 SS_sky130_fd_sc_hd__buf_4
XFILLER_56_6 vssd1 vccd1 vssd1 vccd1 SS_sky130_ef_sc_hd__decap_40_12
Xoutput119 vccd1 vssd1 wire325/A _1876_/X vccd1 vssd1 SS_sky130_fd_sc_hd__buf_4
X_1500_ _1500_/Q _1692_/CLK _1500_/D vccd1 vssd1 vccd1 vssd1 SS_sky130_fd_sc_hd__dfxtp_2
XFILLER_126_265 vssd1 vccd1 vssd1 vccd1 SS_sky130_ef_sc_hd__decap_40_12
XFILLER_99_105 vssd1 vccd1 vccd1 vssd1 SS_sky130_fd_sc_hd__fill_4
XFILLER_99_149 vssd1 vccd1 vssd1 vccd1 SS_sky130_ef_sc_hd__decap_40_12
X_1431_ vssd1 vccd1 vccd1 vssd1 _1439_/A2 wire501/X _1741_/D _1431_/C1 _1430_/X SS_sky130_fd_sc_hd__o211a_2
Xoutput90 vccd1 vssd1 wire270/A _1850_/X vccd1 vssd1 SS_sky130_fd_sc_hd__buf_4
XFILLER_68_525 vssd1 vccd1 vccd1 vssd1 SS_sky130_fd_sc_hd__fill_4
X_1362_ vccd1 vssd1 vccd1 vssd1 _1362_/X _1362_/A _1404_/B SS_sky130_fd_sc_hd__or2_2
XTAP_TAPCELL_ROW_52_1079 vccd1 vssd1 SS_sky130_fd_sc_hd__tapvpwrvgnd_1
X_1293_ vssd1 vccd1 vccd1 vssd1 _1337_/A2 wire496/X _1674_/D _1425_/C1 _1292_/X SS_sky130_fd_sc_hd__o211a_2
XFILLER_68_569 vssd1 vccd1 vssd1 vccd1 SS_sky130_ef_sc_hd__decap_40_12
XFILLER_49_783 vccd1 vssd1 vccd1 vssd1 SS_sky130_fd_sc_hd__fill_1
XFILLER_110_688 vssd1 vccd1 vccd1 vssd1 SS_sky130_fd_sc_hd__fill_2
XFILLER_36_433 vssd1 vccd1 vssd1 vccd1 SS_sky130_ef_sc_hd__decap_40_12
XFILLER_36_477 vssd1 vccd1 vssd1 vccd1 SS_sky130_ef_sc_hd__decap_40_12
XFILLER_91_561 vssd1 vccd1 vssd1 vccd1 SS_sky130_ef_sc_hd__decap_40_12
XFILLER_23_105 vssd1 vccd1 vccd1 vssd1 SS_sky130_fd_sc_hd__fill_4
XFILLER_51_425 vssd1 vccd1 vssd1 vccd1 SS_sky130_ef_sc_hd__decap_40_12
XFILLER_51_447 vccd1 vssd1 vccd1 vssd1 SS_sky130_fd_sc_hd__fill_1
XFILLER_23_149 vssd1 vccd1 vssd1 vccd1 SS_sky130_ef_sc_hd__decap_40_12
XFILLER_32_661 vssd1 vccd1 vccd1 vssd1 SS_sky130_fd_sc_hd__fill_8
XFILLER_31_193 vssd1 vccd1 vssd1 vccd1 SS_sky130_ef_sc_hd__decap_40_12
XFILLER_117_221 vssd1 vccd1 vccd1 vssd1 SS_sky130_fd_sc_hd__fill_2
XFILLER_133_714 vssd1 vccd1 vccd1 vssd1 SS_sky130_fd_sc_hd__fill_2
XFILLER_133_725 vssd1 vccd1 vccd1 vssd1 SS_sky130_fd_sc_hd__fill_2
XFILLER_127_27 vssd1 vccd1 vssd1 vccd1 SS_sky130_ef_sc_hd__decap_40_12
XFILLER_105_405 vssd1 vccd1 vssd1 vccd1 SS_sky130_ef_sc_hd__decap_40_12
X_1629_ _1629_/Q _1760_/CLK _1629_/D vccd1 vssd1 vccd1 vssd1 SS_sky130_fd_sc_hd__dfxtp_2
XFILLER_105_449 vssd1 vccd1 vssd1 vccd1 SS_sky130_ef_sc_hd__decap_40_12
XFILLER_120_419 vccd1 vssd1 vccd1 vssd1 SS_sky130_fd_sc_hd__fill_1
XFILLER_99_661 vssd1 vccd1 vccd1 vssd1 SS_sky130_fd_sc_hd__fill_2
XFILLER_47_709 vssd1 vccd1 vssd1 vccd1 SS_sky130_ef_sc_hd__decap_40_12
XFILLER_100_121 vssd1 vccd1 vssd1 vccd1 SS_sky130_ef_sc_hd__decap_40_12
XFILLER_98_193 vssd1 vccd1 vccd1 vssd1 SS_sky130_fd_sc_hd__fill_2
XTAP_TAPCELL_ROW_87_1610 vccd1 vssd1 SS_sky130_fd_sc_hd__tapvpwrvgnd_1
XFILLER_100_165 vssd1 vccd1 vssd1 vccd1 SS_sky130_ef_sc_hd__decap_40_12
XFILLER_39_293 vssd1 vccd1 vssd1 vccd1 SS_sky130_ef_sc_hd__decap_40_12
XFILLER_55_753 vssd1 vccd1 vssd1 vccd1 SS_sky130_ef_sc_hd__decap_40_12
XFILLER_15_617 vssd1 vccd1 vssd1 vccd1 SS_sky130_ef_sc_hd__decap_40_12
XFILLER_70_701 vssd1 vccd1 vssd1 vccd1 SS_sky130_ef_sc_hd__decap_40_12
XFILLER_82_572 vssd1 vccd1 vssd1 vccd1 SS_sky130_ef_sc_hd__decap_40_12
XFILLER_55_797 vssd1 vccd1 vssd1 vccd1 SS_sky130_ef_sc_hd__decap_40_12
XFILLER_23_661 vssd1 vccd1 vccd1 vssd1 SS_sky130_fd_sc_hd__fill_8
XTAP_TAPCELL_ROW_25_678 vccd1 vssd1 SS_sky130_fd_sc_hd__tapvpwrvgnd_1
XFILLER_10_333 vssd1 vccd1 vssd1 vccd1 SS_sky130_ef_sc_hd__decap_40_12
XFILLER_22_193 vssd1 vccd1 vccd1 vssd1 SS_sky130_fd_sc_hd__fill_2
XFILLER_109_700 vccd1 vssd1 vccd1 vssd1 SS_sky130_fd_sc_hd__fill_1
XFILLER_10_377 vssd1 vccd1 vssd1 vccd1 SS_sky130_ef_sc_hd__decap_40_12
XTAP_TAPCELL_ROW_114_2017 vccd1 vssd1 SS_sky130_fd_sc_hd__tapvpwrvgnd_1
XTAP_TAPCELL_ROW_114_2006 vccd1 vssd1 SS_sky130_fd_sc_hd__tapvpwrvgnd_1
XFILLER_108_221 vssd1 vccd1 vssd1 vccd1 SS_sky130_ef_sc_hd__decap_40_12
XTAP_TAPCELL_ROW_98_1772 vccd1 vssd1 SS_sky130_fd_sc_hd__tapvpwrvgnd_1
XFILLER_136_585 vssd1 vccd1 vccd1 vssd1 SS_sky130_fd_sc_hd__fill_2
XFILLER_109_777 vssd1 vccd1 vccd1 vssd1 SS_sky130_fd_sc_hd__fill_4
XFILLER_108_265 vssd1 vccd1 vssd1 vccd1 SS_sky130_ef_sc_hd__decap_40_12
Xclkbuf_leaf_33_wb_clk_i _1742_/CLK clkload0/A vccd1 vssd1 vssd1 vccd1 SS_sky130_fd_sc_hd__clkbuf_8
XFILLER_124_769 vssd1 vccd1 vssd1 vccd1 SS_sky130_ef_sc_hd__decap_40_12
XFILLER_123_279 vccd1 vssd1 vccd1 vssd1 SS_sky130_fd_sc_hd__fill_1
XFILLER_2_587 vccd1 vssd1 vccd1 vssd1 SS_sky130_fd_sc_hd__fill_1
XFILLER_117_93 vssd1 vccd1 vssd1 vccd1 SS_sky130_ef_sc_hd__decap_40_12
XFILLER_77_355 vssd1 vccd1 vssd1 vccd1 SS_sky130_ef_sc_hd__decap_40_12
XFILLER_89_193 vssd1 vccd1 vssd1 vccd1 SS_sky130_ef_sc_hd__decap_40_12
XTAP_TAPCELL_ROW_5_370 vccd1 vssd1 SS_sky130_fd_sc_hd__tapvpwrvgnd_1
XTAP_TAPCELL_ROW_5_381 vccd1 vssd1 SS_sky130_fd_sc_hd__tapvpwrvgnd_1
XFILLER_18_433 vssd1 vccd1 vssd1 vccd1 SS_sky130_ef_sc_hd__decap_40_12
XFILLER_133_81 vssd1 vccd1 vssd1 vccd1 SS_sky130_ef_sc_hd__decap_40_12
XTAP_TAPCELL_ROW_125_2168 vccd1 vssd1 SS_sky130_fd_sc_hd__tapvpwrvgnd_1
XFILLER_93_30 vssd1 vccd1 vssd1 vccd1 SS_sky130_ef_sc_hd__decap_40_12
XFILLER_18_477 vssd1 vccd1 vssd1 vccd1 SS_sky130_ef_sc_hd__decap_40_12
XFILLER_73_561 vssd1 vccd1 vssd1 vccd1 SS_sky130_ef_sc_hd__decap_40_12
XTAP_TAPCELL_ROW_125_2179 vccd1 vssd1 SS_sky130_fd_sc_hd__tapvpwrvgnd_1
XFILLER_21_609 vssd1 vccd1 vccd1 vssd1 SS_sky130_fd_sc_hd__fill_4
XFILLER_33_447 vccd1 vssd1 vccd1 vssd1 SS_sky130_fd_sc_hd__fill_1
XTAP_TAPCELL_ROW_44_954 vccd1 vssd1 SS_sky130_fd_sc_hd__tapvpwrvgnd_1
XTAP_TAPCELL_ROW_44_965 vccd1 vssd1 SS_sky130_fd_sc_hd__tapvpwrvgnd_1
XFILLER_60_233 vssd1 vccd1 vssd1 vccd1 SS_sky130_ef_sc_hd__decap_40_12
XFILLER_60_277 vssd1 vccd1 vssd1 vccd1 SS_sky130_ef_sc_hd__decap_40_12
X_0931_ vssd1 vccd1 vccd1 vssd1 _0931_/B _0931_/C _0943_/A _0931_/X SS_sky130_fd_sc_hd__or3_2
XFILLER_13_193 vssd1 vccd1 vssd1 vccd1 SS_sky130_ef_sc_hd__decap_40_12
X_0862_ vssd1 vccd1 vssd1 vccd1 _1145_/A _1182_/A _0861_/X _0862_/X SS_sky130_fd_sc_hd__a21o_2
X_0793_ vssd1 vccd1 vssd1 vccd1 wire421/X _1839_/A _0791_/X _0792_/X _0793_/X wire347/X
+ SS_sky130_fd_sc_hd__a2111o_2
XFILLER_54_3 vssd1 vccd1 vssd1 vccd1 SS_sky130_ef_sc_hd__decap_40_12
XTAP_TAPCELL_ROW_54_1108 vccd1 vssd1 SS_sky130_fd_sc_hd__tapvpwrvgnd_1
XFILLER_130_739 vssd1 vccd1 vssd1 vccd1 SS_sky130_ef_sc_hd__decap_40_12
X_1414_ vccd1 vssd1 vccd1 vssd1 _1414_/X _1897_/A _1466_/B SS_sky130_fd_sc_hd__or2_2
X_1345_ vssd1 vccd1 vccd1 vssd1 _1369_/A2 input20/X _1699_/D _1417_/C1 _1344_/X SS_sky130_fd_sc_hd__o211a_2
XFILLER_68_333 vssd1 vccd1 vssd1 vccd1 SS_sky130_ef_sc_hd__decap_40_12
XFILLER_110_441 vssd1 vccd1 vssd1 vccd1 SS_sky130_ef_sc_hd__decap_40_12
XFILLER_113_18 vssd1 vccd1 vssd1 vccd1 SS_sky130_ef_sc_hd__decap_40_12
XFILLER_96_697 vssd1 vccd1 vccd1 vssd1 SS_sky130_fd_sc_hd__fill_2
XTAP_TAPCELL_ROW_69_1340 vccd1 vssd1 SS_sky130_fd_sc_hd__tapvpwrvgnd_1
X_1276_ vccd1 vssd1 _1277_/A _1340_/B _1409_/B vccd1 vssd1 SS_sky130_fd_sc_hd__and2_2
XFILLER_37_753 vssd1 vccd1 vssd1 vccd1 SS_sky130_ef_sc_hd__decap_40_12
XFILLER_52_701 vssd1 vccd1 vssd1 vccd1 SS_sky130_ef_sc_hd__decap_40_12
XFILLER_37_797 vssd1 vccd1 vccd1 vssd1 SS_sky130_fd_sc_hd__fill_4
XFILLER_64_572 vssd1 vccd1 vccd1 vssd1 SS_sky130_fd_sc_hd__fill_8
XFILLER_24_469 vssd1 vccd1 vccd1 vssd1 SS_sky130_fd_sc_hd__fill_4
XFILLER_52_778 vssd1 vccd1 vccd1 vssd1 SS_sky130_fd_sc_hd__fill_8
XFILLER_91_391 vccd1 vssd1 vccd1 vssd1 SS_sky130_fd_sc_hd__fill_1
XTAP_TAPCELL_ROW_22_626 vccd1 vssd1 SS_sky130_fd_sc_hd__tapvpwrvgnd_1
XFILLER_51_277 vssd1 vccd1 vccd1 vssd1 SS_sky130_fd_sc_hd__fill_2
XFILLER_22_15 vssd1 vccd1 vssd1 vccd1 SS_sky130_ef_sc_hd__decap_40_12
XTAP_TAPCELL_ROW_22_637 vccd1 vssd1 SS_sky130_fd_sc_hd__tapvpwrvgnd_1
XFILLER_138_839 vccd1 vssd1 vccd1 vssd1 SS_sky130_fd_sc_hd__fill_1
XFILLER_137_305 vccd1 vssd1 vccd1 vssd1 SS_sky130_fd_sc_hd__fill_1
XFILLER_118_585 vssd1 vccd1 vccd1 vssd1 SS_sky130_fd_sc_hd__fill_2
XFILLER_106_725 vssd1 vccd1 vssd1 vccd1 SS_sky130_ef_sc_hd__decap_40_12
XFILLER_3_329 vssd1 vccd1 vccd1 vssd1 SS_sky130_fd_sc_hd__fill_4
XFILLER_106_769 vssd1 vccd1 vssd1 vccd1 SS_sky130_ef_sc_hd__decap_40_12
XFILLER_114_791 vssd1 vccd1 vssd1 vccd1 SS_sky130_ef_sc_hd__decap_40_12
XFILLER_105_279 vccd1 vssd1 vccd1 vssd1 SS_sky130_fd_sc_hd__fill_1
XTAP_TAPCELL_ROW_93_1691 vccd1 vssd1 SS_sky130_fd_sc_hd__tapvpwrvgnd_1
XFILLER_59_333 vssd1 vccd1 vccd1 vssd1 SS_sky130_fd_sc_hd__fill_2
XFILLER_86_141 vssd1 vccd1 vssd1 vccd1 SS_sky130_ef_sc_hd__decap_40_12
XFILLER_120_249 vssd1 vccd1 vccd1 vssd1 SS_sky130_fd_sc_hd__fill_2
XFILLER_87_697 vssd1 vccd1 vccd1 vssd1 SS_sky130_fd_sc_hd__fill_4
XFILLER_47_539 vssd1 vccd1 vssd1 vccd1 SS_sky130_ef_sc_hd__decap_40_12
XFILLER_55_561 vssd1 vccd1 vssd1 vccd1 SS_sky130_ef_sc_hd__decap_40_12
XFILLER_15_447 vccd1 vssd1 vccd1 vssd1 SS_sky130_fd_sc_hd__fill_1
XFILLER_42_233 vssd1 vccd1 vssd1 vccd1 SS_sky130_ef_sc_hd__decap_40_12
XFILLER_43_767 vssd1 vccd1 vssd1 vccd1 SS_sky130_ef_sc_hd__decap_40_12
XFILLER_70_531 vccd1 vssd1 vccd1 vssd1 SS_sky130_fd_sc_hd__fill_1
XFILLER_30_417 vssd1 vccd1 vccd1 vssd1 SS_sky130_fd_sc_hd__fill_2
XTAP_TAPCELL_ROW_41_913 vccd1 vssd1 SS_sky130_fd_sc_hd__tapvpwrvgnd_1
XFILLER_42_277 vssd1 vccd1 vssd1 vccd1 SS_sky130_ef_sc_hd__decap_40_12
XTAP_TAPCELL_ROW_120_2098 vccd1 vssd1 SS_sky130_fd_sc_hd__tapvpwrvgnd_1
Xwire500 vccd1 vssd1 wire500/X wire500/A vccd1 vssd1 SS_sky130_fd_sc_hd__buf_4
XFILLER_7_613 vssd1 vccd1 vccd1 vssd1 SS_sky130_fd_sc_hd__fill_2
XFILLER_10_141 vssd1 vccd1 vssd1 vccd1 SS_sky130_ef_sc_hd__decap_40_12
XFILLER_11_653 vssd1 vccd1 vssd1 vccd1 SS_sky130_ef_sc_hd__decap_40_12
XFILLER_11_697 vssd1 vccd1 vssd1 vccd1 SS_sky130_ef_sc_hd__decap_40_12
XFILLER_109_541 vssd1 vccd1 vssd1 vccd1 SS_sky130_ef_sc_hd__decap_40_12
XFILLER_12_81 vssd1 vccd1 vccd1 vssd1 SS_sky130_fd_sc_hd__fill_2
XFILLER_109_574 vssd1 vccd1 vssd1 vccd1 SS_sky130_ef_sc_hd__decap_40_12
XFILLER_6_189 vssd1 vccd1 vccd1 vssd1 SS_sky130_fd_sc_hd__fill_4
XFILLER_128_81 vssd1 vccd1 vccd1 vssd1 SS_sky130_fd_sc_hd__fill_2
XFILLER_124_533 vssd1 vccd1 vssd1 vccd1 SS_sky130_ef_sc_hd__decap_40_12
XFILLER_3_841 vccd1 vssd1 vccd1 vssd1 SS_sky130_fd_sc_hd__fill_1
XFILLER_88_41 vssd1 vccd1 vssd1 vccd1 SS_sky130_ef_sc_hd__decap_40_12
XFILLER_112_717 vccd1 vssd1 vccd1 vssd1 SS_sky130_fd_sc_hd__fill_1
XFILLER_97_417 vssd1 vccd1 vssd1 vccd1 SS_sky130_ef_sc_hd__decap_40_12
XFILLER_88_85 vssd1 vccd1 vssd1 vccd1 SS_sky130_ef_sc_hd__decap_40_12
XFILLER_111_205 vssd1 vccd1 vssd1 vccd1 SS_sky130_ef_sc_hd__decap_40_12
XFILLER_78_653 vccd1 vssd1 vccd1 vssd1 SS_sky130_fd_sc_hd__fill_1
XTAP_TAPCELL_ROW_127_2208 vccd1 vssd1 SS_sky130_fd_sc_hd__tapvpwrvgnd_1
XFILLER_111_249 vssd1 vccd1 vssd1 vccd1 SS_sky130_ef_sc_hd__decap_40_12
X_1130_ vccd1 vssd1 vccd1 vssd1 _1130_/X _1130_/A _1140_/B SS_sky130_fd_sc_hd__or2_2
XFILLER_65_325 vccd1 vssd1 vccd1 vssd1 SS_sky130_fd_sc_hd__fill_1
XTAP_TAPCELL_ROW_109_1941 vccd1 vssd1 SS_sky130_fd_sc_hd__tapvpwrvgnd_1
XTAP_TAPCELL_ROW_109_1930 vccd1 vssd1 SS_sky130_fd_sc_hd__tapvpwrvgnd_1
XFILLER_93_634 vssd1 vccd1 vccd1 vssd1 SS_sky130_fd_sc_hd__fill_2
XFILLER_92_133 vssd1 vccd1 vccd1 vssd1 SS_sky130_fd_sc_hd__fill_4
XFILLER_34_701 vssd1 vccd1 vssd1 vccd1 SS_sky130_ef_sc_hd__decap_40_12
X_1061_ vssd1 vccd1 vccd1 vssd1 _1065_/A2 input35/X _1061_/X _1457_/C1 _1060_/X SS_sky130_fd_sc_hd__o211a_2
XFILLER_92_177 vssd1 vccd1 vssd1 vccd1 SS_sky130_ef_sc_hd__decap_40_12
XFILLER_21_417 vssd1 vccd1 vssd1 vccd1 SS_sky130_ef_sc_hd__decap_40_12
XFILLER_33_277 vssd1 vccd1 vccd1 vssd1 SS_sky130_fd_sc_hd__fill_2
XFILLER_61_597 vssd1 vccd1 vccd1 vssd1 SS_sky130_fd_sc_hd__fill_8
X_0914_ vccd1 vssd1 vssd1 vccd1 _0911_/X _0913_/X _0932_/A2 hold799/X _1501_/D _1329_/C1
+ SS_sky130_fd_sc_hd__o221a_2
X_1894_ vccd1 vssd1 _1894_/X _1894_/A vccd1 vssd1 SS_sky130_fd_sc_hd__buf_2
X_0845_ vssd1 vccd1 vssd1 vccd1 _0947_/A _0978_/A _0844_/X _0845_/X SS_sky130_fd_sc_hd__a21o_2
XFILLER_119_349 vssd1 vccd1 vccd1 vssd1 SS_sky130_fd_sc_hd__fill_4
X_0776_ vccd1 vssd1 vssd1 vccd1 _0774_/X _0775_/X _0878_/A2 _1478_/Q _1478_/D _1219_/C1
+ SS_sky130_fd_sc_hd__o221a_2
XFILLER_127_393 vssd1 vccd1 vccd1 vssd1 SS_sky130_fd_sc_hd__fill_4
XFILLER_115_511 vssd1 vccd1 vssd1 vccd1 SS_sky130_ef_sc_hd__decap_40_12
XFILLER_108_29 vssd1 vccd1 vssd1 vccd1 SS_sky130_ef_sc_hd__decap_40_12
XFILLER_108_18 vssd1 vccd1 vccd1 vssd1 SS_sky130_fd_sc_hd__fill_8
XFILLER_115_544 vssd1 vccd1 vssd1 vccd1 SS_sky130_ef_sc_hd__decap_40_12
XFILLER_88_417 vssd1 vccd1 vccd1 vssd1 SS_sky130_fd_sc_hd__fill_2
XFILLER_69_653 vssd1 vccd1 vssd1 vccd1 SS_sky130_ef_sc_hd__decap_40_12
XFILLER_111_750 vssd1 vccd1 vccd1 vssd1 SS_sky130_fd_sc_hd__fill_8
XFILLER_102_249 vssd1 vccd1 vccd1 vssd1 SS_sky130_fd_sc_hd__fill_2
XFILLER_29_517 vssd1 vccd1 vssd1 vccd1 SS_sky130_ef_sc_hd__decap_40_12
XFILLER_68_141 vssd1 vccd1 vssd1 vccd1 SS_sky130_ef_sc_hd__decap_40_12
XFILLER_69_697 vssd1 vccd1 vccd1 vssd1 SS_sky130_fd_sc_hd__fill_4
XFILLER_84_601 vssd1 vccd1 vccd1 vssd1 SS_sky130_fd_sc_hd__fill_4
XFILLER_111_783 vccd1 vssd1 vccd1 vssd1 SS_sky130_fd_sc_hd__fill_1
XFILLER_96_461 vssd1 vccd1 vssd1 vccd1 SS_sky130_ef_sc_hd__decap_40_12
XFILLER_96_450 vssd1 vccd1 vccd1 vssd1 SS_sky130_fd_sc_hd__fill_4
XFILLER_83_111 vccd1 vssd1 vccd1 vssd1 SS_sky130_fd_sc_hd__fill_1
XFILLER_84_645 vssd1 vccd1 vccd1 vssd1 SS_sky130_fd_sc_hd__fill_8
X_1328_ vccd1 vssd1 vccd1 vssd1 _1328_/X _1328_/A _1330_/B SS_sky130_fd_sc_hd__or2_2
XFILLER_17_15 vssd1 vccd1 vssd1 vccd1 SS_sky130_ef_sc_hd__decap_40_12
XTAP_TAPCELL_ROW_27_707 vccd1 vssd1 SS_sky130_fd_sc_hd__tapvpwrvgnd_1
XFILLER_37_561 vssd1 vccd1 vssd1 vccd1 SS_sky130_ef_sc_hd__decap_40_12
XFILLER_72_818 vssd1 vccd1 vccd1 vssd1 SS_sky130_fd_sc_hd__fill_2
X_1259_ vssd1 vccd1 vccd1 vssd1 _1261_/A2 input35/X _1658_/D _1259_/C1 _1258_/X SS_sky130_fd_sc_hd__o211a_2
XFILLER_71_317 vssd1 vccd1 vccd1 vssd1 SS_sky130_fd_sc_hd__fill_8
XFILLER_24_233 vssd1 vccd1 vssd1 vccd1 SS_sky130_ef_sc_hd__decap_40_12
XFILLER_52_531 vccd1 vssd1 vccd1 vssd1 SS_sky130_fd_sc_hd__fill_1
XFILLER_12_417 vssd1 vccd1 vccd1 vssd1 SS_sky130_fd_sc_hd__fill_2
XFILLER_24_277 vssd1 vccd1 vssd1 vccd1 SS_sky130_ef_sc_hd__decap_40_12
XFILLER_33_69 vssd1 vccd1 vssd1 vccd1 SS_sky130_ef_sc_hd__decap_40_12
XFILLER_137_113 vssd1 vccd1 vccd1 vssd1 SS_sky130_fd_sc_hd__fill_2
XFILLER_123_6 vssd1 vccd1 vssd1 vccd1 SS_sky130_ef_sc_hd__decap_40_12
XTAP_TAPCELL_ROW_95_1731 vccd1 vssd1 SS_sky130_fd_sc_hd__tapvpwrvgnd_1
XTAP_TAPCELL_ROW_95_1720 vccd1 vssd1 SS_sky130_fd_sc_hd__tapvpwrvgnd_1
XFILLER_3_137 vssd1 vccd1 vssd1 vccd1 SS_sky130_ef_sc_hd__decap_40_12
XFILLER_0_811 vccd1 vssd1 vccd1 vssd1 SS_sky130_fd_sc_hd__fill_1
XTAP_TAPCELL_ROW_7_410 vccd1 vssd1 SS_sky130_fd_sc_hd__tapvpwrvgnd_1
XFILLER_133_385 vssd1 vccd1 vccd1 vssd1 SS_sky130_fd_sc_hd__fill_2
XFILLER_121_503 vccd1 vssd1 vccd1 vssd1 SS_sky130_fd_sc_hd__fill_1
XFILLER_106_577 vssd1 vccd1 vccd1 vssd1 SS_sky130_fd_sc_hd__fill_8
XFILLER_58_77 vssd1 vccd1 vccd1 vssd1 SS_sky130_fd_sc_hd__fill_4
XFILLER_87_461 vssd1 vccd1 vssd1 vccd1 SS_sky130_ef_sc_hd__decap_40_12
XFILLER_101_293 vssd1 vccd1 vssd1 vccd1 SS_sky130_ef_sc_hd__decap_40_12
XFILLER_16_701 vssd1 vccd1 vssd1 vccd1 SS_sky130_ef_sc_hd__decap_40_12
XFILLER_74_133 vssd1 vccd1 vccd1 vssd1 SS_sky130_fd_sc_hd__fill_4
XFILLER_114_83 vccd1 vssd1 vccd1 vssd1 SS_sky130_fd_sc_hd__fill_1
XFILLER_74_65 vssd1 vccd1 vssd1 vccd1 SS_sky130_ef_sc_hd__decap_40_12
XFILLER_74_177 vssd1 vccd1 vssd1 vccd1 SS_sky130_ef_sc_hd__decap_40_12
XFILLER_90_637 vssd1 vccd1 vccd1 vssd1 SS_sky130_fd_sc_hd__fill_4
XTAP_TAPCELL_ROW_122_2127 vccd1 vssd1 SS_sky130_fd_sc_hd__tapvpwrvgnd_1
XFILLER_55_391 vccd1 vssd1 vccd1 vssd1 SS_sky130_fd_sc_hd__fill_1
XFILLER_15_277 vssd1 vccd1 vccd1 vssd1 SS_sky130_fd_sc_hd__fill_2
XTAP_TAPCELL_ROW_104_1860 vccd1 vssd1 SS_sky130_fd_sc_hd__tapvpwrvgnd_1
XFILLER_90_53 vssd1 vccd1 vssd1 vccd1 SS_sky130_ef_sc_hd__decap_40_12
XFILLER_90_97 vssd1 vccd1 vssd1 vccd1 SS_sky130_ef_sc_hd__decap_40_12
XFILLER_129_614 vssd1 vccd1 vccd1 vssd1 SS_sky130_fd_sc_hd__fill_2
XFILLER_11_461 vssd1 vccd1 vssd1 vccd1 SS_sky130_ef_sc_hd__decap_40_12
XTAP_TAPCELL_ROW_13_489 vccd1 vssd1 SS_sky130_fd_sc_hd__tapvpwrvgnd_1
Xwire341 vccd1 vssd1 vssd1 vccd1 wire341/A analog_ctrl[37] SS_sky130_fd_sc_hd__buf_12
Xwire330 vccd1 vssd1 vssd1 vccd1 wire330/A analog_ctrl[47] SS_sky130_fd_sc_hd__buf_12
XFILLER_129_669 vssd1 vccd1 vccd1 vssd1 SS_sky130_fd_sc_hd__fill_2
XFILLER_117_809 vssd1 vccd1 vccd1 vssd1 SS_sky130_fd_sc_hd__fill_8
Xwire374 vccd1 vssd1 vssd1 vccd1 wire374/A wbs_dat_o[19] SS_sky130_fd_sc_hd__buf_12
Xwire363 vccd1 vssd1 vssd1 vccd1 wire363/A wbs_dat_o[29] SS_sky130_fd_sc_hd__buf_12
Xwire385 vccd1 vssd1 vssd1 vccd1 wire385/A wbs_ack_o SS_sky130_fd_sc_hd__buf_12
XFILLER_125_820 vssd1 vccd1 vccd1 vssd1 SS_sky130_fd_sc_hd__fill_4
XFILLER_109_393 vssd1 vccd1 vssd1 vccd1 SS_sky130_ef_sc_hd__decap_40_12
XFILLER_99_51 vssd1 vccd1 vccd1 vssd1 SS_sky130_fd_sc_hd__fill_4
Xwire396 vccd1 vssd1 vssd1 vccd1 wire396/A analog_ctrl[85] SS_sky130_fd_sc_hd__buf_12
XTAP_TAPCELL_ROW_133_2289 vccd1 vssd1 SS_sky130_fd_sc_hd__tapvpwrvgnd_1
XFILLER_3_671 vccd1 vssd1 vccd1 vssd1 SS_sky130_fd_sc_hd__fill_1
XFILLER_98_748 vssd1 vccd1 vccd1 vssd1 SS_sky130_fd_sc_hd__fill_8
XFILLER_97_225 vssd1 vccd1 vssd1 vccd1 SS_sky130_ef_sc_hd__decap_40_12
XFILLER_39_815 vccd1 vssd1 vccd1 vssd1 SS_sky130_fd_sc_hd__fill_1
XFILLER_66_601 vssd1 vccd1 vccd1 vssd1 SS_sky130_fd_sc_hd__fill_8
XFILLER_17_3 vssd1 vccd1 vssd1 vccd1 SS_sky130_ef_sc_hd__decap_40_12
XFILLER_65_111 vccd1 vssd1 vccd1 vssd1 SS_sky130_fd_sc_hd__fill_1
XFILLER_66_645 vssd1 vccd1 vssd1 vccd1 SS_sky130_ef_sc_hd__decap_40_12
XFILLER_120_591 vccd1 vssd1 vccd1 vssd1 SS_sky130_fd_sc_hd__fill_1
XFILLER_93_453 vssd1 vccd1 vccd1 vssd1 SS_sky130_fd_sc_hd__fill_2
X_1113_ vssd1 vccd1 vccd1 vssd1 wire241/X input27/X _1587_/D _1381_/C1 _1112_/X SS_sky130_fd_sc_hd__o211a_2
XFILLER_19_561 vssd1 vccd1 vssd1 vccd1 SS_sky130_ef_sc_hd__decap_40_12
XTAP_TAPCELL_ROW_49_1029 vccd1 vssd1 SS_sky130_fd_sc_hd__tapvpwrvgnd_1
XFILLER_53_317 vssd1 vccd1 vssd1 vccd1 SS_sky130_ef_sc_hd__decap_40_12
X_1044_ vccd1 vssd1 vccd1 vssd1 _1044_/X _1044_/A _1076_/B SS_sky130_fd_sc_hd__or2_2
XFILLER_34_531 vccd1 vssd1 vccd1 vssd1 SS_sky130_fd_sc_hd__fill_1
XFILLER_21_225 vssd1 vccd1 vssd1 vccd1 SS_sky130_ef_sc_hd__decap_40_12
XFILLER_22_737 vssd1 vccd1 vssd1 vccd1 SS_sky130_ef_sc_hd__decap_40_12
XTAP_TAPCELL_ROW_62_1229 vccd1 vssd1 SS_sky130_fd_sc_hd__tapvpwrvgnd_1
XTAP_TAPCELL_ROW_32_776 vccd1 vssd1 SS_sky130_fd_sc_hd__tapvpwrvgnd_1
XFILLER_9_93 vssd1 vccd1 vssd1 vccd1 SS_sky130_ef_sc_hd__decap_40_12
XTAP_TAPCELL_ROW_32_787 vccd1 vssd1 SS_sky130_fd_sc_hd__tapvpwrvgnd_1
XFILLER_119_113 vssd1 vccd1 vssd1 vccd1 SS_sky130_ef_sc_hd__decap_40_12
X_1877_ vccd1 vssd1 _1877_/X _1877_/A vccd1 vssd1 SS_sky130_fd_sc_hd__buf_2
XFILLER_119_39 vssd1 vccd1 vssd1 vccd1 SS_sky130_ef_sc_hd__decap_40_12
X_0828_ vccd1 vssd1 vccd1 vssd1 _0827_/X _1875_/A _0828_/B1 _1679_/Q wire448/X _0828_/X
+ SS_sky130_fd_sc_hd__a221o_2
XTAP_TAPCELL_ROW_77_1450 vccd1 vssd1 SS_sky130_fd_sc_hd__tapvpwrvgnd_1
XTAP_TAPCELL_ROW_77_1461 vccd1 vssd1 SS_sky130_fd_sc_hd__tapvpwrvgnd_1
X_0759_ vccd1 vssd1 vccd1 vssd1 _1636_/Q _0894_/B1 _1896_/A wire435/X _0759_/X SS_sky130_fd_sc_hd__a22o_2
XFILLER_103_503 vccd1 vssd1 vccd1 vssd1 SS_sky130_fd_sc_hd__fill_1
XTAP_TAPCELL_ROW_90_1650 vccd1 vssd1 SS_sky130_fd_sc_hd__tapvpwrvgnd_1
XFILLER_69_461 vssd1 vccd1 vssd1 vccd1 SS_sky130_ef_sc_hd__decap_40_12
XFILLER_130_377 vssd1 vccd1 vccd1 vssd1 SS_sky130_fd_sc_hd__fill_4
XFILLER_97_781 vssd1 vccd1 vccd1 vssd1 SS_sky130_fd_sc_hd__fill_2
XFILLER_96_291 vccd1 vssd1 vccd1 vssd1 SS_sky130_fd_sc_hd__fill_1
XFILLER_56_133 vssd1 vccd1 vccd1 vssd1 SS_sky130_fd_sc_hd__fill_4
XFILLER_56_177 vssd1 vccd1 vssd1 vccd1 SS_sky130_ef_sc_hd__decap_40_12
XFILLER_37_391 vccd1 vssd1 vccd1 vssd1 SS_sky130_fd_sc_hd__fill_1
XFILLER_71_125 vssd1 vccd1 vssd1 vccd1 SS_sky130_ef_sc_hd__decap_40_12
XFILLER_25_553 vssd1 vccd1 vccd1 vssd1 SS_sky130_fd_sc_hd__fill_4
XFILLER_40_501 vssd1 vccd1 vssd1 vccd1 SS_sky130_ef_sc_hd__decap_40_12
XFILLER_52_361 vssd1 vccd1 vccd1 vssd1 SS_sky130_fd_sc_hd__fill_2
XFILLER_71_169 vssd1 vccd1 vssd1 vccd1 SS_sky130_ef_sc_hd__decap_40_12
XFILLER_25_597 vssd1 vccd1 vssd1 vccd1 SS_sky130_ef_sc_hd__decap_40_12
XFILLER_40_545 vssd1 vccd1 vssd1 vccd1 SS_sky130_ef_sc_hd__decap_40_12
XFILLER_80_681 vssd1 vccd1 vssd1 vccd1 SS_sky130_ef_sc_hd__decap_40_12
XFILLER_100_41 vssd1 vccd1 vssd1 vccd1 SS_sky130_ef_sc_hd__decap_40_12
XFILLER_21_781 vssd1 vccd1 vccd1 vssd1 SS_sky130_fd_sc_hd__fill_2
XFILLER_40_589 vssd1 vccd1 vssd1 vccd1 SS_sky130_ef_sc_hd__decap_40_12
XFILLER_100_85 vssd1 vccd1 vssd1 vccd1 SS_sky130_ef_sc_hd__decap_40_12
XTAP_TAPCELL_ROW_10_448 vccd1 vssd1 SS_sky130_fd_sc_hd__tapvpwrvgnd_1
XFILLER_138_477 vssd1 vccd1 vccd1 vssd1 SS_sky130_fd_sc_hd__fill_4
XFILLER_4_413 vssd1 vccd1 vccd1 vssd1 SS_sky130_fd_sc_hd__fill_4
XFILLER_138_499 vssd1 vccd1 vccd1 vssd1 SS_sky130_fd_sc_hd__fill_4
XFILLER_125_105 vssd1 vccd1 vccd1 vssd1 SS_sky130_fd_sc_hd__fill_4
XFILLER_4_457 vssd1 vccd1 vssd1 vccd1 SS_sky130_ef_sc_hd__decap_40_12
XFILLER_125_149 vssd1 vccd1 vssd1 vccd1 SS_sky130_ef_sc_hd__decap_40_12
XFILLER_122_801 vssd1 vccd1 vccd1 vssd1 SS_sky130_fd_sc_hd__fill_2
XFILLER_79_225 vssd1 vccd1 vssd1 vccd1 SS_sky130_ef_sc_hd__decap_40_12
XFILLER_133_193 vssd1 vccd1 vssd1 vccd1 SS_sky130_ef_sc_hd__decap_40_12
XFILLER_0_641 vssd1 vccd1 vccd1 vssd1 SS_sky130_fd_sc_hd__fill_2
XFILLER_48_601 vssd1 vccd1 vccd1 vssd1 SS_sky130_fd_sc_hd__fill_4
XFILLER_95_729 vssd1 vccd1 vssd1 vccd1 SS_sky130_ef_sc_hd__decap_40_12
XFILLER_0_685 vssd1 vccd1 vccd1 vssd1 SS_sky130_fd_sc_hd__fill_2
XFILLER_47_111 vccd1 vssd1 vccd1 vssd1 SS_sky130_fd_sc_hd__fill_1
XFILLER_48_634 vssd1 vccd1 vccd1 vssd1 SS_sky130_fd_sc_hd__fill_8
XFILLER_48_645 vssd1 vccd1 vssd1 vccd1 SS_sky130_ef_sc_hd__decap_40_12
XFILLER_88_781 vssd1 vccd1 vssd1 vccd1 SS_sky130_ef_sc_hd__decap_40_12
XFILLER_125_93 vssd1 vccd1 vssd1 vccd1 SS_sky130_ef_sc_hd__decap_40_12
XFILLER_35_317 vssd1 vccd1 vssd1 vccd1 SS_sky130_ef_sc_hd__decap_40_12
XFILLER_75_497 vssd1 vccd1 vccd1 vssd1 SS_sky130_fd_sc_hd__fill_4
XFILLER_16_531 vccd1 vssd1 vccd1 vssd1 SS_sky130_fd_sc_hd__fill_1
XFILLER_90_445 vssd1 vccd1 vssd1 vccd1 SS_sky130_ef_sc_hd__decap_40_12
XFILLER_31_501 vssd1 vccd1 vccd1 vssd1 SS_sky130_fd_sc_hd__fill_2
XFILLER_43_361 vssd1 vccd1 vssd1 vccd1 SS_sky130_ef_sc_hd__decap_40_12
XFILLER_50_309 vssd1 vccd1 vssd1 vccd1 SS_sky130_ef_sc_hd__decap_40_12
XFILLER_71_681 vssd1 vccd1 vccd1 vssd1 SS_sky130_fd_sc_hd__fill_4
XFILLER_71_692 vssd1 vccd1 vssd1 vccd1 SS_sky130_ef_sc_hd__decap_40_12
XFILLER_86_6 vssd1 vccd1 vssd1 vccd1 SS_sky130_ef_sc_hd__decap_40_12
XFILLER_12_781 vssd1 vccd1 vccd1 vssd1 SS_sky130_fd_sc_hd__fill_4
XTAP_TAPCELL_ROW_135_2318 vccd1 vssd1 SS_sky130_fd_sc_hd__tapvpwrvgnd_1
XTAP_TAPCELL_ROW_135_2329 vccd1 vssd1 SS_sky130_fd_sc_hd__tapvpwrvgnd_1
X_1731_ _1895_/A _1731_/CLK _1731_/D vccd1 vssd1 vccd1 vssd1 SS_sky130_fd_sc_hd__dfxtp_2
XFILLER_117_617 vssd1 vccd1 vccd1 vssd1 SS_sky130_fd_sc_hd__fill_8
XFILLER_7_273 vssd1 vccd1 vccd1 vssd1 SS_sky130_fd_sc_hd__fill_4
X_1662_ _1662_/Q _1760_/CLK _1662_/D vccd1 vssd1 vccd1 vssd1 SS_sky130_fd_sc_hd__dfxtp_2
XTAP_TAPCELL_ROW_59_1180 vccd1 vssd1 SS_sky130_fd_sc_hd__tapvpwrvgnd_1
XTAP_TAPCELL_ROW_59_1191 vccd1 vssd1 SS_sky130_fd_sc_hd__tapvpwrvgnd_1
X_1593_ _1593_/Q _1753_/CLK _1593_/D vccd1 vssd1 vccd1 vssd1 SS_sky130_fd_sc_hd__dfxtp_2
XFILLER_124_193 vssd1 vccd1 vccd1 vssd1 SS_sky130_fd_sc_hd__fill_2
XFILLER_98_545 vssd1 vccd1 vssd1 vccd1 SS_sky130_ef_sc_hd__decap_40_12
XTAP_TAPCELL_ROW_72_1380 vccd1 vssd1 SS_sky130_fd_sc_hd__tapvpwrvgnd_1
XFILLER_85_217 vssd1 vccd1 vccd1 vssd1 SS_sky130_fd_sc_hd__fill_4
XFILLER_98_589 vssd1 vccd1 vssd1 vccd1 SS_sky130_ef_sc_hd__decap_40_12
XFILLER_79_781 vssd1 vccd1 vccd1 vssd1 SS_sky130_fd_sc_hd__fill_2
XFILLER_38_133 vssd1 vccd1 vccd1 vssd1 SS_sky130_fd_sc_hd__fill_4
XFILLER_38_177 vssd1 vccd1 vssd1 vccd1 SS_sky130_ef_sc_hd__decap_40_12
XFILLER_54_637 vssd1 vccd1 vccd1 vssd1 SS_sky130_fd_sc_hd__fill_4
XFILLER_93_261 vssd1 vccd1 vssd1 vccd1 SS_sky130_ef_sc_hd__decap_40_12
XFILLER_19_391 vccd1 vssd1 vccd1 vssd1 SS_sky130_fd_sc_hd__fill_1
XTAP_TAPCELL_ROW_37_857 vccd1 vssd1 SS_sky130_fd_sc_hd__tapvpwrvgnd_1
XFILLER_53_125 vssd1 vccd1 vssd1 vccd1 SS_sky130_ef_sc_hd__decap_40_12
XFILLER_81_445 vssd1 vccd1 vccd1 vssd1 SS_sky130_fd_sc_hd__fill_2
XFILLER_121_18 vssd1 vccd1 vssd1 vccd1 SS_sky130_ef_sc_hd__decap_40_12
XFILLER_22_501 vssd1 vccd1 vssd1 vccd1 SS_sky130_ef_sc_hd__decap_40_12
X_1027_ vssd1 vccd1 vccd1 vssd1 _1033_/A2 wire497/X _1545_/D _1099_/C1 _1026_/X SS_sky130_fd_sc_hd__o211a_2
XFILLER_34_361 vssd1 vccd1 vccd1 vssd1 SS_sky130_fd_sc_hd__fill_2
XFILLER_53_169 vssd1 vccd1 vssd1 vccd1 SS_sky130_ef_sc_hd__decap_40_12
XFILLER_14_27 vccd1 vssd1 vccd1 vssd1 SS_sky130_fd_sc_hd__fill_1
XFILLER_22_545 vssd1 vccd1 vssd1 vccd1 SS_sky130_ef_sc_hd__decap_40_12
XFILLER_22_589 vssd1 vccd1 vssd1 vccd1 SS_sky130_ef_sc_hd__decap_40_12
XFILLER_30_15 vssd1 vccd1 vssd1 vccd1 SS_sky130_ef_sc_hd__decap_40_12
XFILLER_135_436 vssd1 vccd1 vccd1 vssd1 SS_sky130_fd_sc_hd__fill_2
XFILLER_107_105 vssd1 vccd1 vccd1 vssd1 SS_sky130_fd_sc_hd__fill_4
Xhold730 _1392_/A _1723_/Q vccd1 vssd1 vssd1 vccd1 SS_sky130_fd_sc_hd__dlygate4sd3_1
XFILLER_107_149 vssd1 vccd1 vssd1 vccd1 SS_sky130_ef_sc_hd__decap_40_12
XFILLER_1_405 vssd1 vccd1 vssd1 vccd1 SS_sky130_ef_sc_hd__decap_40_12
Xhold763 _0988_/A _1527_/Q vccd1 vssd1 vssd1 vccd1 SS_sky130_fd_sc_hd__dlygate4sd3_1
Xhold741 _1308_/A _1682_/Q vccd1 vssd1 vssd1 vccd1 SS_sky130_fd_sc_hd__dlygate4sd3_1
Xhold752 _1450_/A _1751_/Q vccd1 vssd1 vssd1 vccd1 SS_sky130_fd_sc_hd__dlygate4sd3_1
XFILLER_1_449 vssd1 vccd1 vssd1 vccd1 SS_sky130_ef_sc_hd__decap_40_12
Xhold785 _1444_/A _1748_/Q vccd1 vssd1 vssd1 vccd1 SS_sky130_fd_sc_hd__dlygate4sd3_1
XFILLER_89_545 vssd1 vccd1 vssd1 vccd1 SS_sky130_ef_sc_hd__decap_40_12
Xhold774 input28/A wbs_dat_i[17] vccd1 vssd1 vssd1 vccd1 SS_sky130_fd_sc_hd__dlygate4sd3_1
XFILLER_115_193 vssd1 vccd1 vssd1 vccd1 SS_sky130_ef_sc_hd__decap_40_12
Xhold796 hold796/X _1496_/Q vccd1 vssd1 vssd1 vccd1 SS_sky130_fd_sc_hd__dlygate4sd3_1
XFILLER_103_311 vccd1 vssd1 vccd1 vssd1 SS_sky130_fd_sc_hd__fill_1
XFILLER_39_57 vssd1 vccd1 vssd1 vccd1 SS_sky130_ef_sc_hd__decap_40_12
XFILLER_77_729 vssd1 vccd1 vssd1 vccd1 SS_sky130_ef_sc_hd__decap_40_12
XFILLER_130_141 vssd1 vccd1 vssd1 vccd1 SS_sky130_ef_sc_hd__decap_40_12
XFILLER_131_653 vssd1 vccd1 vssd1 vccd1 SS_sky130_ef_sc_hd__decap_40_12
XFILLER_29_111 vccd1 vssd1 vccd1 vssd1 SS_sky130_fd_sc_hd__fill_1
XFILLER_131_697 vssd1 vccd1 vccd1 vssd1 SS_sky130_fd_sc_hd__fill_8
XFILLER_18_807 vccd1 vssd1 vccd1 vssd1 SS_sky130_fd_sc_hd__fill_1
XFILLER_17_317 vssd1 vccd1 vssd1 vccd1 SS_sky130_ef_sc_hd__decap_40_12
XFILLER_45_615 vccd1 vssd1 vccd1 vssd1 SS_sky130_fd_sc_hd__fill_1
XFILLER_13_501 vssd1 vccd1 vccd1 vssd1 SS_sky130_fd_sc_hd__fill_2
XFILLER_25_361 vssd1 vccd1 vssd1 vccd1 SS_sky130_ef_sc_hd__decap_40_12
XFILLER_32_309 vssd1 vccd1 vssd1 vccd1 SS_sky130_ef_sc_hd__decap_40_12
XFILLER_53_670 vssd1 vccd1 vccd1 vssd1 SS_sky130_fd_sc_hd__fill_2
XFILLER_72_467 vssd1 vccd1 vccd1 vssd1 SS_sky130_fd_sc_hd__fill_8
XTAP_TAPCELL_ROW_15_518 vccd1 vssd1 SS_sky130_fd_sc_hd__tapvpwrvgnd_1
XTAP_TAPCELL_ROW_15_529 vccd1 vssd1 SS_sky130_fd_sc_hd__tapvpwrvgnd_1
XFILLER_9_505 vssd1 vccd1 vssd1 vccd1 SS_sky130_ef_sc_hd__decap_40_12
XFILLER_138_241 vssd1 vccd1 vccd1 vssd1 SS_sky130_fd_sc_hd__fill_2
XTAP_TAPCELL_ROW_117_2048 vccd1 vssd1 SS_sky130_fd_sc_hd__tapvpwrvgnd_1
XTAP_TAPCELL_ROW_117_2059 vccd1 vssd1 SS_sky130_fd_sc_hd__tapvpwrvgnd_1
XFILLER_4_221 vssd1 vccd1 vssd1 vccd1 SS_sky130_ef_sc_hd__decap_40_12
XFILLER_4_265 vssd1 vccd1 vssd1 vccd1 SS_sky130_ef_sc_hd__decap_40_12
XFILLER_5_777 vssd1 vccd1 vccd1 vssd1 SS_sky130_fd_sc_hd__fill_4
XTAP_TAPCELL_ROW_130_2248 vccd1 vssd1 SS_sky130_fd_sc_hd__tapvpwrvgnd_1
XFILLER_20_81 vssd1 vccd1 vccd1 vssd1 SS_sky130_fd_sc_hd__fill_2
XFILLER_106_193 vssd1 vccd1 vccd1 vssd1 SS_sky130_fd_sc_hd__fill_2
XTAP_TAPCELL_ROW_112_1981 vccd1 vssd1 SS_sky130_fd_sc_hd__tapvpwrvgnd_1
XFILLER_96_41 vssd1 vccd1 vssd1 vccd1 SS_sky130_ef_sc_hd__decap_40_12
XFILLER_67_217 vssd1 vccd1 vccd1 vssd1 SS_sky130_fd_sc_hd__fill_4
XFILLER_122_697 vssd1 vccd1 vccd1 vssd1 SS_sky130_fd_sc_hd__fill_2
XFILLER_96_85 vssd1 vccd1 vssd1 vccd1 SS_sky130_ef_sc_hd__decap_40_12
XFILLER_75_261 vssd1 vccd1 vssd1 vccd1 SS_sky130_ef_sc_hd__decap_40_12
XFILLER_82_209 vssd1 vccd1 vssd1 vccd1 SS_sky130_ef_sc_hd__decap_40_12
XFILLER_35_125 vssd1 vccd1 vssd1 vccd1 SS_sky130_ef_sc_hd__decap_40_12
XTAP_TAPCELL_ROW_34_805 vccd1 vssd1 SS_sky130_fd_sc_hd__tapvpwrvgnd_1
XTAP_TAPCELL_ROW_34_816 vccd1 vssd1 SS_sky130_fd_sc_hd__tapvpwrvgnd_1
XFILLER_35_169 vssd1 vccd1 vssd1 vccd1 SS_sky130_ef_sc_hd__decap_40_12
XFILLER_51_629 vssd1 vccd1 vccd1 vssd1 SS_sky130_fd_sc_hd__fill_4
XFILLER_90_253 vssd1 vccd1 vssd1 vccd1 SS_sky130_ef_sc_hd__decap_40_12
XFILLER_16_361 vssd1 vccd1 vccd1 vssd1 SS_sky130_fd_sc_hd__fill_2
XFILLER_44_681 vssd1 vccd1 vssd1 vccd1 SS_sky130_ef_sc_hd__decap_40_12
XFILLER_50_139 vccd1 vssd1 vccd1 vssd1 SS_sky130_fd_sc_hd__fill_1
XFILLER_84_3 vssd1 vccd1 vssd1 vccd1 SS_sky130_ef_sc_hd__decap_40_12
X_1714_ _1714_/Q _1717_/CLK _1714_/D vccd1 vssd1 vccd1 vssd1 SS_sky130_fd_sc_hd__dfxtp_2
XFILLER_117_447 vccd1 vssd1 vccd1 vssd1 SS_sky130_fd_sc_hd__fill_1
XFILLER_6_83 vccd1 vssd1 vccd1 vssd1 SS_sky130_fd_sc_hd__fill_1
X_1645_ _1645_/Q clkload7/A _1645_/D vccd1 vssd1 vccd1 vssd1 SS_sky130_fd_sc_hd__dfxtp_2
X_1576_ _1850_/A _1576_/CLK _1576_/D vccd1 vssd1 vccd1 vssd1 SS_sky130_fd_sc_hd__dfxtp_2
XFILLER_116_29 vssd1 vccd1 vssd1 vccd1 SS_sky130_ef_sc_hd__decap_40_12
XFILLER_116_18 vssd1 vccd1 vccd1 vssd1 SS_sky130_fd_sc_hd__fill_8
XFILLER_59_729 vssd1 vccd1 vssd1 vccd1 SS_sky130_ef_sc_hd__decap_40_12
XFILLER_112_141 vssd1 vccd1 vssd1 vccd1 SS_sky130_ef_sc_hd__decap_40_12
XFILLER_98_375 vssd1 vccd1 vssd1 vccd1 SS_sky130_ef_sc_hd__decap_40_12
XFILLER_113_697 vssd1 vccd1 vssd1 vccd1 SS_sky130_ef_sc_hd__decap_40_12
XFILLER_27_615 vccd1 vssd1 vccd1 vssd1 SS_sky130_fd_sc_hd__fill_1
XFILLER_54_401 vssd1 vccd1 vccd1 vssd1 SS_sky130_fd_sc_hd__fill_2
XFILLER_54_445 vssd1 vccd1 vccd1 vssd1 SS_sky130_fd_sc_hd__fill_8
XFILLER_82_743 vssd1 vccd1 vccd1 vssd1 SS_sky130_fd_sc_hd__fill_8
XFILLER_14_309 vssd1 vccd1 vssd1 vccd1 SS_sky130_ef_sc_hd__decap_40_12
XFILLER_25_15 vssd1 vccd1 vssd1 vccd1 SS_sky130_ef_sc_hd__decap_40_12
XFILLER_42_629 vssd1 vccd1 vccd1 vssd1 SS_sky130_fd_sc_hd__fill_2
XFILLER_54_489 vssd1 vccd1 vccd1 vssd1 SS_sky130_fd_sc_hd__fill_2
XFILLER_82_798 vssd1 vccd1 vssd1 vccd1 SS_sky130_ef_sc_hd__decap_40_12
XTAP_TAPCELL_ROW_85_1571 vccd1 vssd1 SS_sky130_fd_sc_hd__tapvpwrvgnd_1
XTAP_TAPCELL_ROW_85_1582 vccd1 vssd1 SS_sky130_fd_sc_hd__tapvpwrvgnd_1
XFILLER_50_673 vssd1 vccd1 vssd1 vccd1 SS_sky130_ef_sc_hd__decap_40_12
XFILLER_136_701 vssd1 vccd1 vssd1 vccd1 SS_sky130_ef_sc_hd__decap_40_12
XFILLER_41_69 vssd1 vccd1 vssd1 vccd1 SS_sky130_ef_sc_hd__decap_40_12
XTAP_TAPCELL_ROW_20_598 vccd1 vssd1 SS_sky130_fd_sc_hd__tapvpwrvgnd_1
XFILLER_135_277 vssd1 vccd1 vccd1 vssd1 SS_sky130_fd_sc_hd__fill_2
XFILLER_123_417 vssd1 vccd1 vccd1 vssd1 SS_sky130_fd_sc_hd__fill_4
XFILLER_2_725 vssd1 vccd1 vssd1 vccd1 SS_sky130_ef_sc_hd__decap_40_12
Xhold571 _1352_/A _1882_/A vccd1 vssd1 vssd1 vccd1 SS_sky130_fd_sc_hd__dlygate4sd3_1
XFILLER_2_769 vssd1 vccd1 vssd1 vccd1 SS_sky130_ef_sc_hd__decap_40_12
Xhold582 _1104_/A _1857_/A vccd1 vssd1 vssd1 vccd1 SS_sky130_fd_sc_hd__dlygate4sd3_1
Xhold593 _1344_/A _1878_/A vccd1 vssd1 vssd1 vccd1 SS_sky130_fd_sc_hd__dlygate4sd3_1
XFILLER_1_279 vccd1 vssd1 vccd1 vssd1 SS_sky130_fd_sc_hd__fill_1
XFILLER_49_217 vssd1 vccd1 vccd1 vssd1 SS_sky130_fd_sc_hd__fill_4
XFILLER_131_461 vssd1 vccd1 vssd1 vccd1 SS_sky130_ef_sc_hd__decap_40_12
XFILLER_104_697 vssd1 vccd1 vccd1 vssd1 SS_sky130_fd_sc_hd__fill_2
XFILLER_57_261 vssd1 vccd1 vssd1 vccd1 SS_sky130_ef_sc_hd__decap_40_12
XFILLER_58_773 vccd1 vssd1 vccd1 vssd1 SS_sky130_fd_sc_hd__fill_1
XFILLER_64_209 vssd1 vccd1 vssd1 vccd1 SS_sky130_ef_sc_hd__decap_40_12
XFILLER_66_77 vssd1 vccd1 vccd1 vssd1 SS_sky130_fd_sc_hd__fill_4
XFILLER_73_721 vssd1 vccd1 vccd1 vssd1 SS_sky130_fd_sc_hd__fill_4
XFILLER_92_529 vssd1 vccd1 vccd1 vssd1 SS_sky130_fd_sc_hd__fill_2
XFILLER_17_125 vssd1 vccd1 vssd1 vccd1 SS_sky130_ef_sc_hd__decap_40_12
XFILLER_18_637 vssd1 vccd1 vccd1 vssd1 SS_sky130_fd_sc_hd__fill_4
XFILLER_17_169 vssd1 vccd1 vssd1 vccd1 SS_sky130_ef_sc_hd__decap_40_12
XFILLER_72_253 vssd1 vccd1 vssd1 vccd1 SS_sky130_ef_sc_hd__decap_40_12
XFILLER_73_765 vssd1 vccd1 vssd1 vccd1 SS_sky130_ef_sc_hd__decap_40_12
XFILLER_122_83 vccd1 vssd1 vccd1 vssd1 SS_sky130_fd_sc_hd__fill_1
XTAP_TAPCELL_ROW_0_290 vccd1 vssd1 SS_sky130_fd_sc_hd__tapvpwrvgnd_1
XFILLER_26_681 vssd1 vccd1 vccd1 vssd1 SS_sky130_fd_sc_hd__fill_2
XFILLER_33_629 vssd1 vccd1 vssd1 vccd1 SS_sky130_ef_sc_hd__decap_40_12
XFILLER_82_65 vssd1 vccd1 vssd1 vccd1 SS_sky130_ef_sc_hd__decap_40_12
XFILLER_32_139 vccd1 vssd1 vccd1 vssd1 SS_sky130_fd_sc_hd__fill_1
XFILLER_41_651 vssd1 vccd1 vssd1 vccd1 SS_sky130_ef_sc_hd__decap_40_12
XFILLER_15_81 vssd1 vccd1 vssd1 vccd1 SS_sky130_ef_sc_hd__decap_40_12
XFILLER_41_673 vssd1 vccd1 vssd1 vccd1 SS_sky130_ef_sc_hd__decap_40_12
XFILLER_9_335 vccd1 vssd1 vccd1 vssd1 SS_sky130_fd_sc_hd__fill_1
XFILLER_5_541 vssd1 vccd1 vssd1 vccd1 SS_sky130_ef_sc_hd__decap_40_12
XFILLER_126_233 vssd1 vccd1 vssd1 vccd1 SS_sky130_ef_sc_hd__decap_40_12
Xoutput109 vccd1 vssd1 wire335/A _1867_/X vccd1 vssd1 SS_sky130_fd_sc_hd__buf_4
XFILLER_126_277 vssd1 vccd1 vssd1 vccd1 SS_sky130_ef_sc_hd__decap_40_12
XFILLER_114_417 vssd1 vccd1 vccd1 vssd1 SS_sky130_fd_sc_hd__fill_2
XFILLER_5_585 vssd1 vccd1 vssd1 vccd1 SS_sky130_ef_sc_hd__decap_40_12
X_1430_ vccd1 vssd1 vccd1 vssd1 _1430_/X _1905_/A _1466_/B SS_sky130_fd_sc_hd__or2_2
X_1361_ vssd1 vccd1 vccd1 vssd1 _1385_/A2 wire495/X _1707_/D _1447_/C1 _1360_/X SS_sky130_fd_sc_hd__o211a_2
XFILLER_96_813 vccd1 vssd1 vccd1 vssd1 SS_sky130_fd_sc_hd__fill_1
Xoutput80 vccd1 vssd1 wire280/A _1841_/X vccd1 vssd1 SS_sky130_fd_sc_hd__buf_4
Xoutput91 vccd1 vssd1 wire269/A _1851_/X vccd1 vssd1 SS_sky130_fd_sc_hd__buf_4
XFILLER_110_601 vssd1 vccd1 vssd1 vccd1 SS_sky130_ef_sc_hd__decap_40_12
XFILLER_95_301 vssd1 vccd1 vccd1 vssd1 SS_sky130_fd_sc_hd__fill_2
X_1292_ vccd1 vssd1 vccd1 vssd1 _1292_/X _1292_/A _1338_/B SS_sky130_fd_sc_hd__or2_2
XFILLER_110_645 vssd1 vccd1 vssd1 vccd1 SS_sky130_ef_sc_hd__decap_40_12
XFILLER_36_401 vssd1 vccd1 vssd1 vccd1 SS_sky130_ef_sc_hd__decap_40_12
XFILLER_36_445 vssd1 vccd1 vssd1 vccd1 SS_sky130_ef_sc_hd__decap_40_12
XFILLER_76_581 vssd1 vccd1 vccd1 vssd1 SS_sky130_fd_sc_hd__fill_4
XFILLER_91_573 vssd1 vccd1 vssd1 vccd1 SS_sky130_ef_sc_hd__decap_40_12
XFILLER_36_489 vssd1 vccd1 vssd1 vccd1 SS_sky130_ef_sc_hd__decap_40_12
XFILLER_51_437 vssd1 vccd1 vccd1 vssd1 SS_sky130_fd_sc_hd__fill_8
Xclkbuf_leaf_3_wb_clk_i _1753_/CLK clkbuf_leaf_9_wb_clk_i/A vccd1 vssd1 vssd1 vccd1
+ SS_sky130_fd_sc_hd__clkbuf_8
XFILLER_20_813 vssd1 vccd1 vccd1 vssd1 SS_sky130_fd_sc_hd__fill_2
XFILLER_31_161 vssd1 vccd1 vccd1 vssd1 SS_sky130_fd_sc_hd__fill_4
XFILLER_118_701 vssd1 vccd1 vssd1 vccd1 SS_sky130_ef_sc_hd__decap_40_12
XFILLER_118_745 vssd1 vccd1 vccd1 vssd1 SS_sky130_fd_sc_hd__fill_2
XFILLER_127_39 vssd1 vccd1 vssd1 vccd1 SS_sky130_ef_sc_hd__decap_40_12
XFILLER_117_277 vssd1 vccd1 vccd1 vssd1 SS_sky130_fd_sc_hd__fill_2
XFILLER_105_417 vssd1 vccd1 vssd1 vccd1 SS_sky130_ef_sc_hd__decap_40_12
X_1628_ _1628_/Q _1756_/CLK _1628_/D vccd1 vssd1 vccd1 vssd1 SS_sky130_fd_sc_hd__dfxtp_2
XFILLER_105_439 vccd1 vssd1 vccd1 vssd1 SS_sky130_fd_sc_hd__fill_1
XFILLER_86_301 vssd1 vccd1 vccd1 vssd1 SS_sky130_fd_sc_hd__fill_4
X_1559_ _1559_/Q _1751_/CLK _1559_/D vccd1 vssd1 vccd1 vssd1 SS_sky130_fd_sc_hd__dfxtp_2
XFILLER_113_461 vssd1 vccd1 vssd1 vccd1 SS_sky130_ef_sc_hd__decap_40_12
XFILLER_101_623 vccd1 vssd1 vccd1 vssd1 SS_sky130_fd_sc_hd__fill_1
XFILLER_59_559 vccd1 vssd1 vccd1 vssd1 SS_sky130_fd_sc_hd__fill_1
XFILLER_100_133 vssd1 vccd1 vccd1 vssd1 SS_sky130_fd_sc_hd__fill_4
XFILLER_39_261 vssd1 vccd1 vssd1 vccd1 SS_sky130_ef_sc_hd__decap_40_12
XFILLER_46_209 vssd1 vccd1 vssd1 vccd1 SS_sky130_ef_sc_hd__decap_40_12
XFILLER_55_710 vssd1 vccd1 vssd1 vccd1 SS_sky130_ef_sc_hd__decap_40_12
XTAP_TAPCELL_ROW_87_1600 vccd1 vssd1 SS_sky130_fd_sc_hd__tapvpwrvgnd_1
XTAP_TAPCELL_ROW_87_1611 vccd1 vssd1 SS_sky130_fd_sc_hd__tapvpwrvgnd_1
XFILLER_100_177 vssd1 vccd1 vssd1 vccd1 SS_sky130_ef_sc_hd__decap_40_12
XFILLER_27_445 vssd1 vccd1 vccd1 vssd1 SS_sky130_fd_sc_hd__fill_2
XFILLER_54_253 vssd1 vccd1 vssd1 vccd1 SS_sky130_ef_sc_hd__decap_40_12
XFILLER_55_765 vssd1 vccd1 vssd1 vccd1 SS_sky130_ef_sc_hd__decap_40_12
XFILLER_70_713 vssd1 vccd1 vssd1 vccd1 SS_sky130_ef_sc_hd__decap_40_12
XFILLER_15_629 vssd1 vccd1 vssd1 vccd1 SS_sky130_ef_sc_hd__decap_40_12
XFILLER_82_584 vssd1 vccd1 vccd1 vssd1 SS_sky130_fd_sc_hd__fill_4
XFILLER_14_139 vccd1 vssd1 vccd1 vssd1 SS_sky130_fd_sc_hd__fill_1
XFILLER_70_757 vssd1 vccd1 vssd1 vccd1 SS_sky130_ef_sc_hd__decap_40_12
XFILLER_70_779 vccd1 vssd1 vccd1 vssd1 SS_sky130_fd_sc_hd__fill_1
XFILLER_10_301 vssd1 vccd1 vccd1 vssd1 SS_sky130_fd_sc_hd__fill_4
XFILLER_23_673 vssd1 vccd1 vssd1 vccd1 SS_sky130_ef_sc_hd__decap_40_12
XTAP_TAPCELL_ROW_25_668 vccd1 vssd1 SS_sky130_fd_sc_hd__tapvpwrvgnd_1
XTAP_TAPCELL_ROW_25_679 vccd1 vssd1 SS_sky130_fd_sc_hd__tapvpwrvgnd_1
XFILLER_6_305 vssd1 vccd1 vccd1 vssd1 SS_sky130_fd_sc_hd__fill_2
XFILLER_10_345 vssd1 vccd1 vssd1 vccd1 SS_sky130_ef_sc_hd__decap_40_12
XFILLER_10_389 vssd1 vccd1 vssd1 vccd1 SS_sky130_ef_sc_hd__decap_40_12
XFILLER_136_531 vccd1 vssd1 vccd1 vssd1 SS_sky130_fd_sc_hd__fill_1
XFILLER_136_542 vssd1 vccd1 vssd1 vccd1 SS_sky130_ef_sc_hd__decap_40_12
XTAP_TAPCELL_ROW_114_2007 vccd1 vssd1 SS_sky130_fd_sc_hd__tapvpwrvgnd_1
XFILLER_108_233 vssd1 vccd1 vssd1 vccd1 SS_sky130_ef_sc_hd__decap_40_12
XTAP_TAPCELL_ROW_98_1773 vccd1 vssd1 SS_sky130_fd_sc_hd__tapvpwrvgnd_1
XFILLER_109_789 vccd1 vssd1 vccd1 vssd1 SS_sky130_fd_sc_hd__fill_1
XFILLER_108_277 vssd1 vccd1 vssd1 vccd1 SS_sky130_ef_sc_hd__decap_40_12
XFILLER_2_533 vssd1 vccd1 vssd1 vccd1 SS_sky130_ef_sc_hd__decap_40_12
XFILLER_123_225 vssd1 vccd1 vssd1 vccd1 SS_sky130_ef_sc_hd__decap_40_12
XFILLER_78_813 vssd1 vccd1 vccd1 vssd1 SS_sky130_fd_sc_hd__fill_4
XFILLER_96_109 vssd1 vccd1 vssd1 vccd1 SS_sky130_ef_sc_hd__decap_40_12
XFILLER_78_824 vssd1 vccd1 vccd1 vssd1 SS_sky130_fd_sc_hd__fill_2
XFILLER_89_161 vssd1 vccd1 vccd1 vssd1 SS_sky130_fd_sc_hd__fill_4
XFILLER_132_781 vssd1 vccd1 vssd1 vccd1 SS_sky130_ef_sc_hd__decap_40_12
XFILLER_77_345 vssd1 vccd1 vccd1 vssd1 SS_sky130_fd_sc_hd__fill_4
XTAP_TAPCELL_ROW_5_371 vccd1 vssd1 SS_sky130_fd_sc_hd__tapvpwrvgnd_1
XTAP_TAPCELL_ROW_5_382 vccd1 vssd1 SS_sky130_fd_sc_hd__tapvpwrvgnd_1
XFILLER_18_401 vssd1 vccd1 vssd1 vccd1 SS_sky130_ef_sc_hd__decap_40_12
XFILLER_77_367 vssd1 vccd1 vssd1 vccd1 SS_sky130_ef_sc_hd__decap_40_12
XFILLER_46_743 vssd1 vccd1 vssd1 vccd1 SS_sky130_ef_sc_hd__decap_40_12
XFILLER_133_93 vssd1 vccd1 vssd1 vccd1 SS_sky130_ef_sc_hd__decap_40_12
XFILLER_93_42 vssd1 vccd1 vssd1 vccd1 SS_sky130_ef_sc_hd__decap_40_12
XFILLER_18_445 vssd1 vccd1 vssd1 vccd1 SS_sky130_ef_sc_hd__decap_40_12
XTAP_TAPCELL_ROW_125_2169 vccd1 vssd1 SS_sky130_fd_sc_hd__tapvpwrvgnd_1
XFILLER_18_489 vssd1 vccd1 vssd1 vccd1 SS_sky130_ef_sc_hd__decap_40_12
XFILLER_73_573 vssd1 vccd1 vccd1 vssd1 SS_sky130_fd_sc_hd__fill_4
XTAP_TAPCELL_ROW_44_955 vccd1 vssd1 SS_sky130_fd_sc_hd__tapvpwrvgnd_1
XTAP_TAPCELL_ROW_44_966 vccd1 vssd1 SS_sky130_fd_sc_hd__tapvpwrvgnd_1
XFILLER_60_245 vssd1 vccd1 vccd1 vssd1 SS_sky130_fd_sc_hd__fill_4
XFILLER_20_109 vssd1 vccd1 vssd1 vccd1 SS_sky130_ef_sc_hd__decap_40_12
XFILLER_60_289 vssd1 vccd1 vssd1 vccd1 SS_sky130_ef_sc_hd__decap_40_12
X_0930_ vccd1 vssd1 vccd1 vssd1 _1536_/Q _0930_/B1 _1696_/Q wire448/A _0931_/C SS_sky130_fd_sc_hd__a22o_2
XFILLER_13_161 vssd1 vccd1 vccd1 vssd1 SS_sky130_fd_sc_hd__fill_4
XFILLER_9_165 vssd1 vccd1 vccd1 vssd1 SS_sky130_fd_sc_hd__fill_2
X_0861_ vccd1 vssd1 vccd1 vssd1 _1653_/Q _0894_/B1 _1717_/Q _1343_/A _0861_/X SS_sky130_fd_sc_hd__a22o_2
X_0792_ vccd1 vssd1 vccd1 vssd1 _1832_/A wire424/X _1641_/Q wire430/X _0792_/X SS_sky130_fd_sc_hd__a22o_2
XFILLER_115_726 vssd1 vccd1 vccd1 vssd1 SS_sky130_fd_sc_hd__fill_2
XTAP_TAPCELL_ROW_54_1109 vccd1 vssd1 SS_sky130_fd_sc_hd__tapvpwrvgnd_1
XFILLER_5_393 vssd1 vccd1 vssd1 vccd1 SS_sky130_ef_sc_hd__decap_40_12
XFILLER_47_3 vssd1 vccd1 vssd1 vccd1 SS_sky130_ef_sc_hd__decap_40_12
XFILLER_87_109 vssd1 vccd1 vccd1 vssd1 SS_sky130_fd_sc_hd__fill_2
XFILLER_68_301 vssd1 vccd1 vccd1 vssd1 SS_sky130_fd_sc_hd__fill_4
XFILLER_123_781 vssd1 vccd1 vccd1 vssd1 SS_sky130_fd_sc_hd__fill_2
X_1413_ vssd1 vccd1 vccd1 vssd1 _1439_/A2 input31/X _1732_/D _1439_/C1 _1412_/X SS_sky130_fd_sc_hd__o211a_2
X_1344_ vccd1 vssd1 vccd1 vssd1 _1344_/X _1344_/A _1404_/B SS_sky130_fd_sc_hd__or2_2
XFILLER_96_665 vssd1 vccd1 vccd1 vssd1 SS_sky130_fd_sc_hd__fill_2
XFILLER_96_643 vccd1 vssd1 vccd1 vssd1 SS_sky130_fd_sc_hd__fill_1
XFILLER_28_209 vssd1 vccd1 vssd1 vccd1 SS_sky130_ef_sc_hd__decap_40_12
XFILLER_56_529 vssd1 vccd1 vccd1 vssd1 SS_sky130_fd_sc_hd__fill_2
X_1275_ vssd1 vccd1 vccd1 vssd1 _1211_/Y input44/X _1666_/D _1473_/C1 _1274_/X SS_sky130_fd_sc_hd__o211a_2
XFILLER_110_475 vccd1 vssd1 vccd1 vssd1 SS_sky130_fd_sc_hd__fill_1
XFILLER_110_453 vssd1 vccd1 vssd1 vccd1 SS_sky130_ef_sc_hd__decap_40_12
XFILLER_37_721 vssd1 vccd1 vccd1 vssd1 SS_sky130_fd_sc_hd__fill_4
XTAP_TAPCELL_ROW_69_1330 vccd1 vssd1 SS_sky130_fd_sc_hd__tapvpwrvgnd_1
XFILLER_83_337 vssd1 vccd1 vssd1 vccd1 SS_sky130_ef_sc_hd__decap_40_12
XFILLER_36_253 vssd1 vccd1 vssd1 vccd1 SS_sky130_ef_sc_hd__decap_40_12
XFILLER_37_765 vssd1 vccd1 vssd1 vccd1 SS_sky130_ef_sc_hd__decap_40_12
XTAP_TAPCELL_ROW_69_1341 vccd1 vssd1 SS_sky130_fd_sc_hd__tapvpwrvgnd_1
XFILLER_52_713 vssd1 vccd1 vssd1 vccd1 SS_sky130_ef_sc_hd__decap_40_12
XFILLER_51_223 vccd1 vssd1 vccd1 vssd1 SS_sky130_fd_sc_hd__fill_1
XTAP_TAPCELL_ROW_82_1530 vccd1 vssd1 SS_sky130_fd_sc_hd__tapvpwrvgnd_1
XFILLER_11_109 vssd1 vccd1 vccd1 vssd1 SS_sky130_fd_sc_hd__fill_2
XFILLER_20_643 vccd1 vssd1 vccd1 vssd1 SS_sky130_fd_sc_hd__fill_1
XTAP_TAPCELL_ROW_22_627 vccd1 vssd1 SS_sky130_fd_sc_hd__tapvpwrvgnd_1
XFILLER_22_27 vccd1 vssd1 vccd1 vssd1 SS_sky130_fd_sc_hd__fill_1
XFILLER_4_809 vssd1 vccd1 vccd1 vssd1 SS_sky130_fd_sc_hd__fill_2
XFILLER_106_737 vccd1 vssd1 vccd1 vssd1 SS_sky130_fd_sc_hd__fill_1
XFILLER_105_225 vssd1 vccd1 vssd1 vccd1 SS_sky130_ef_sc_hd__decap_40_12
XFILLER_78_109 vssd1 vccd1 vssd1 vccd1 SS_sky130_ef_sc_hd__decap_40_12
XFILLER_87_610 vssd1 vccd1 vccd1 vssd1 SS_sky130_fd_sc_hd__fill_4
XFILLER_121_729 vssd1 vccd1 vssd1 vccd1 SS_sky130_ef_sc_hd__decap_40_12
XFILLER_114_781 vssd1 vccd1 vccd1 vssd1 SS_sky130_fd_sc_hd__fill_2
XTAP_TAPCELL_ROW_93_1692 vccd1 vssd1 SS_sky130_fd_sc_hd__tapvpwrvgnd_1
XFILLER_75_805 vccd1 vssd1 vccd1 vssd1 SS_sky130_fd_sc_hd__fill_1
XFILLER_113_291 vccd1 vssd1 vccd1 vssd1 SS_sky130_fd_sc_hd__fill_1
XFILLER_86_153 vssd1 vccd1 vssd1 vccd1 SS_sky130_ef_sc_hd__decap_40_12
XTAP_TAPCELL_ROW_2_330 vccd1 vssd1 SS_sky130_fd_sc_hd__tapvpwrvgnd_1
XFILLER_28_721 vssd1 vccd1 vccd1 vssd1 SS_sky130_fd_sc_hd__fill_2
XPHY_EDGE_ROW_29_Right_29 vccd1 vssd1 vccd1 vssd1 SS_sky130_fd_sc_hd__decap_3
XFILLER_47_57 vssd1 vccd1 vssd1 vccd1 SS_sky130_ef_sc_hd__decap_40_12
XFILLER_86_197 vssd1 vccd1 vssd1 vccd1 SS_sky130_ef_sc_hd__decap_40_12
XFILLER_103_30 vssd1 vccd1 vssd1 vccd1 SS_sky130_ef_sc_hd__decap_40_12
XFILLER_55_573 vssd1 vccd1 vssd1 vccd1 SS_sky130_ef_sc_hd__decap_40_12
XFILLER_42_245 vssd1 vccd1 vccd1 vssd1 SS_sky130_fd_sc_hd__fill_4
XTAP_TAPCELL_ROW_41_914 vccd1 vssd1 SS_sky130_fd_sc_hd__tapvpwrvgnd_1
XFILLER_43_779 vssd1 vccd1 vccd1 vssd1 SS_sky130_fd_sc_hd__fill_4
XFILLER_70_587 vccd1 vssd1 vccd1 vssd1 SS_sky130_fd_sc_hd__fill_1
XFILLER_8_18 vssd1 vccd1 vccd1 vssd1 SS_sky130_fd_sc_hd__fill_8
XFILLER_8_29 vssd1 vccd1 vssd1 vccd1 SS_sky130_ef_sc_hd__decap_40_12
XFILLER_42_289 vssd1 vccd1 vssd1 vccd1 SS_sky130_ef_sc_hd__decap_40_12
XFILLER_129_807 vssd1 vccd1 vccd1 vssd1 SS_sky130_fd_sc_hd__fill_4
XTAP_TAPCELL_ROW_120_2099 vccd1 vssd1 SS_sky130_fd_sc_hd__tapvpwrvgnd_1
XFILLER_11_665 vssd1 vccd1 vccd1 vssd1 SS_sky130_fd_sc_hd__fill_4
XPHY_EDGE_ROW_38_Right_38 vccd1 vssd1 vccd1 vssd1 SS_sky130_fd_sc_hd__decap_3
XFILLER_128_328 vssd1 vccd1 vssd1 vccd1 SS_sky130_ef_sc_hd__decap_40_12
Xwire501 vccd1 vssd1 wire501/X wire501/A vccd1 vssd1 SS_sky130_fd_sc_hd__buf_6
XFILLER_10_153 vssd1 vccd1 vssd1 vccd1 SS_sky130_ef_sc_hd__decap_40_12
XFILLER_7_669 vssd1 vccd1 vccd1 vssd1 SS_sky130_fd_sc_hd__fill_2
XFILLER_10_197 vssd1 vccd1 vssd1 vccd1 SS_sky130_ef_sc_hd__decap_40_12
XFILLER_124_501 vssd1 vccd1 vssd1 vccd1 SS_sky130_ef_sc_hd__decap_40_12
XFILLER_109_553 vssd1 vccd1 vccd1 vssd1 SS_sky130_fd_sc_hd__fill_4
XFILLER_109_586 vssd1 vccd1 vssd1 vccd1 SS_sky130_ef_sc_hd__decap_40_12
XFILLER_88_53 vssd1 vccd1 vssd1 vccd1 SS_sky130_ef_sc_hd__decap_40_12
XFILLER_124_545 vssd1 vccd1 vssd1 vccd1 SS_sky130_ef_sc_hd__decap_40_12
XFILLER_2_363 vccd1 vssd1 vccd1 vssd1 SS_sky130_fd_sc_hd__fill_1
XFILLER_69_109 vssd1 vccd1 vccd1 vssd1 SS_sky130_fd_sc_hd__fill_2
XFILLER_88_97 vssd1 vccd1 vssd1 vccd1 SS_sky130_ef_sc_hd__decap_40_12
XFILLER_124_589 vssd1 vccd1 vssd1 vccd1 SS_sky130_ef_sc_hd__decap_40_12
XFILLER_111_217 vssd1 vccd1 vccd1 vssd1 SS_sky130_fd_sc_hd__fill_4
XFILLER_97_429 vssd1 vccd1 vssd1 vccd1 SS_sky130_ef_sc_hd__decap_40_12
XFILLER_78_643 vccd1 vssd1 vccd1 vssd1 SS_sky130_fd_sc_hd__fill_1
XTAP_TAPCELL_ROW_127_2209 vccd1 vssd1 SS_sky130_fd_sc_hd__tapvpwrvgnd_1
XPHY_EDGE_ROW_47_Right_47 vccd1 vssd1 vccd1 vssd1 SS_sky130_fd_sc_hd__decap_3
XFILLER_19_710 vssd1 vccd1 vccd1 vssd1 SS_sky130_fd_sc_hd__fill_8
XFILLER_65_337 vssd1 vccd1 vccd1 vssd1 SS_sky130_fd_sc_hd__fill_4
XTAP_TAPCELL_ROW_109_1931 vccd1 vssd1 SS_sky130_fd_sc_hd__tapvpwrvgnd_1
XFILLER_80_307 vccd1 vssd1 vccd1 vssd1 SS_sky130_fd_sc_hd__fill_1
X_1060_ vccd1 vssd1 vccd1 vssd1 _1060_/X _1562_/Q _1076_/B SS_sky130_fd_sc_hd__or2_2
XTAP_TAPCELL_ROW_109_1942 vccd1 vssd1 SS_sky130_fd_sc_hd__tapvpwrvgnd_1
XFILLER_18_253 vssd1 vccd1 vssd1 vccd1 SS_sky130_ef_sc_hd__decap_40_12
XFILLER_34_713 vssd1 vccd1 vccd1 vssd1 SS_sky130_fd_sc_hd__fill_8
XFILLER_61_521 vssd1 vccd1 vssd1 vccd1 SS_sky130_ef_sc_hd__decap_40_12
XFILLER_92_189 vssd1 vccd1 vccd1 vssd1 SS_sky130_fd_sc_hd__fill_4
XFILLER_33_223 vccd1 vssd1 vccd1 vssd1 SS_sky130_fd_sc_hd__fill_1
XTAP_TAPCELL_ROW_64_1260 vccd1 vssd1 SS_sky130_fd_sc_hd__tapvpwrvgnd_1
XFILLER_21_429 vssd1 vccd1 vssd1 vccd1 SS_sky130_ef_sc_hd__decap_40_12
XPHY_EDGE_ROW_56_Right_56 vccd1 vssd1 vccd1 vssd1 SS_sky130_fd_sc_hd__decap_3
X_1893_ vccd1 vssd1 _1893_/X _1893_/A vccd1 vssd1 SS_sky130_fd_sc_hd__buf_2
X_0913_ vssd1 vccd1 vccd1 vssd1 _0913_/B _0913_/C _0943_/A _0913_/X SS_sky130_fd_sc_hd__or3_2
X_0844_ vccd1 vssd1 vccd1 vssd1 _1554_/Q _1013_/A _1746_/Q _0874_/A2 _0844_/X SS_sky130_fd_sc_hd__a22o_2
XFILLER_134_309 vssd1 vccd1 vssd1 vccd1 SS_sky130_ef_sc_hd__decap_40_12
X_0775_ vssd1 vccd1 vssd1 vccd1 wire435/X _1898_/A _0865_/B1 _0771_/X _0775_/X _0772_/X
+ SS_sky130_fd_sc_hd__a2111o_2
XFILLER_127_361 vssd1 vccd1 vssd1 vccd1 SS_sky130_ef_sc_hd__decap_40_12
XFILLER_115_523 vccd1 vssd1 vccd1 vssd1 SS_sky130_fd_sc_hd__fill_1
XFILLER_115_556 vssd1 vccd1 vccd1 vssd1 SS_sky130_fd_sc_hd__fill_4
XPHY_EDGE_ROW_65_Right_65 vccd1 vssd1 vccd1 vssd1 SS_sky130_fd_sc_hd__decap_3
XFILLER_115_589 vssd1 vccd1 vccd1 vssd1 SS_sky130_fd_sc_hd__fill_2
XFILLER_103_729 vssd1 vccd1 vssd1 vccd1 SS_sky130_ef_sc_hd__decap_40_12
XFILLER_124_29 vssd1 vccd1 vssd1 vccd1 SS_sky130_ef_sc_hd__decap_40_12
XFILLER_68_153 vssd1 vccd1 vssd1 vccd1 SS_sky130_ef_sc_hd__decap_40_12
XFILLER_69_665 vssd1 vccd1 vccd1 vssd1 SS_sky130_fd_sc_hd__fill_4
XFILLER_96_473 vssd1 vccd1 vccd1 vssd1 SS_sky130_fd_sc_hd__fill_2
XFILLER_29_529 vssd1 vccd1 vssd1 vccd1 SS_sky130_ef_sc_hd__decap_40_12
XFILLER_68_197 vssd1 vccd1 vssd1 vccd1 SS_sky130_ef_sc_hd__decap_40_12
X_1327_ vssd1 vccd1 vccd1 vssd1 _1331_/A2 input36/X _1691_/D _1327_/C1 _1326_/X SS_sky130_fd_sc_hd__o211a_2
XFILLER_17_27 vssd1 vccd1 vssd1 vccd1 SS_sky130_ef_sc_hd__decap_40_12
XTAP_TAPCELL_ROW_27_708 vccd1 vssd1 SS_sky130_fd_sc_hd__tapvpwrvgnd_1
XFILLER_37_540 vssd1 vccd1 vccd1 vssd1 SS_sky130_fd_sc_hd__fill_2
X_1258_ vccd1 vssd1 vccd1 vssd1 _1258_/X _1658_/Q _1264_/B SS_sky130_fd_sc_hd__or2_2
XFILLER_37_573 vssd1 vccd1 vccd1 vssd1 SS_sky130_fd_sc_hd__fill_8
XFILLER_83_167 vccd1 vssd1 vccd1 vssd1 SS_sky130_fd_sc_hd__fill_1
X_1189_ vssd1 vccd1 vccd1 vssd1 _1209_/A2 input33/X _1624_/D _1451_/C1 _1188_/X SS_sky130_fd_sc_hd__o211a_2
XFILLER_24_245 vssd1 vccd1 vccd1 vssd1 SS_sky130_fd_sc_hd__fill_4
XPHY_EDGE_ROW_74_Right_74 vccd1 vssd1 vccd1 vssd1 SS_sky130_fd_sc_hd__decap_3
XFILLER_24_289 vssd1 vccd1 vssd1 vccd1 SS_sky130_ef_sc_hd__decap_40_12
XFILLER_20_473 vssd1 vccd1 vccd1 vssd1 SS_sky130_fd_sc_hd__fill_2
XFILLER_137_169 vssd1 vccd1 vccd1 vssd1 SS_sky130_fd_sc_hd__fill_8
XFILLER_116_6 vssd1 vccd1 vssd1 vccd1 SS_sky130_ef_sc_hd__decap_40_12
XTAP_TAPCELL_ROW_95_1721 vccd1 vssd1 SS_sky130_fd_sc_hd__tapvpwrvgnd_1
XFILLER_3_105 vssd1 vccd1 vccd1 vssd1 SS_sky130_fd_sc_hd__fill_4
XFILLER_118_383 vccd1 vssd1 vccd1 vssd1 SS_sky130_fd_sc_hd__fill_1
XTAP_TAPCELL_ROW_95_1732 vccd1 vssd1 SS_sky130_fd_sc_hd__tapvpwrvgnd_1
XFILLER_3_149 vssd1 vccd1 vssd1 vccd1 SS_sky130_ef_sc_hd__decap_40_12
XPHY_EDGE_ROW_18_Left_157 vccd1 vssd1 vccd1 vssd1 SS_sky130_fd_sc_hd__decap_3
XPHY_EDGE_ROW_83_Right_83 vccd1 vssd1 vccd1 vssd1 SS_sky130_fd_sc_hd__decap_3
XTAP_TAPCELL_ROW_7_400 vccd1 vssd1 SS_sky130_fd_sc_hd__tapvpwrvgnd_1
XTAP_TAPCELL_ROW_7_411 vccd1 vssd1 SS_sky130_fd_sc_hd__tapvpwrvgnd_1
XFILLER_106_589 vssd1 vccd1 vssd1 vccd1 SS_sky130_ef_sc_hd__decap_40_12
XFILLER_87_473 vssd1 vccd1 vssd1 vccd1 SS_sky130_ef_sc_hd__decap_40_12
XFILLER_47_337 vssd1 vccd1 vssd1 vccd1 SS_sky130_ef_sc_hd__decap_40_12
XFILLER_101_261 vssd1 vccd1 vssd1 vccd1 SS_sky130_ef_sc_hd__decap_40_12
XFILLER_16_713 vssd1 vccd1 vssd1 vccd1 SS_sky130_ef_sc_hd__decap_40_12
XFILLER_62_307 vccd1 vssd1 vccd1 vssd1 SS_sky130_fd_sc_hd__fill_1
XFILLER_74_77 vssd1 vccd1 vccd1 vssd1 SS_sky130_fd_sc_hd__fill_4
XFILLER_74_189 vssd1 vccd1 vccd1 vssd1 SS_sky130_fd_sc_hd__fill_4
XTAP_TAPCELL_ROW_122_2128 vccd1 vssd1 SS_sky130_fd_sc_hd__tapvpwrvgnd_1
XFILLER_15_223 vccd1 vssd1 vccd1 vssd1 SS_sky130_fd_sc_hd__fill_1
XFILLER_16_757 vssd1 vccd1 vssd1 vccd1 SS_sky130_ef_sc_hd__decap_40_12
XPHY_EDGE_ROW_27_Left_166 vccd1 vssd1 vccd1 vssd1 SS_sky130_fd_sc_hd__decap_3
XFILLER_71_841 vccd1 vssd1 vccd1 vssd1 SS_sky130_fd_sc_hd__fill_1
XPHY_EDGE_ROW_92_Right_92 vccd1 vssd1 vccd1 vssd1 SS_sky130_fd_sc_hd__decap_3
XPHY_EDGE_ROW_133_Right_133 vccd1 vssd1 vccd1 vssd1 SS_sky130_fd_sc_hd__decap_3
XTAP_TAPCELL_ROW_104_1861 vccd1 vssd1 SS_sky130_fd_sc_hd__tapvpwrvgnd_1
XFILLER_130_83 vccd1 vssd1 vccd1 vssd1 SS_sky130_fd_sc_hd__fill_1
XFILLER_90_65 vssd1 vccd1 vssd1 vccd1 SS_sky130_ef_sc_hd__decap_40_12
XFILLER_11_473 vssd1 vccd1 vssd1 vccd1 SS_sky130_ef_sc_hd__decap_40_12
XFILLER_23_81 vssd1 vccd1 vssd1 vccd1 SS_sky130_ef_sc_hd__decap_40_12
Xwire342 vccd1 vssd1 vssd1 vccd1 wire342/A analog_ctrl[36] SS_sky130_fd_sc_hd__buf_12
Xwire331 vccd1 vssd1 vssd1 vccd1 wire331/A analog_ctrl[46] SS_sky130_fd_sc_hd__buf_12
Xwire320 vccd1 vssd1 vssd1 vccd1 wire320/A analog_ctrl[56] SS_sky130_fd_sc_hd__buf_12
XTAP_TAPCELL_ROW_137_2360 vccd1 vssd1 SS_sky130_fd_sc_hd__tapvpwrvgnd_1
Xwire353 vccd1 vssd1 vssd1 vccd1 wire353/A wbs_dat_o[9] SS_sky130_fd_sc_hd__buf_12
Xwire375 vccd1 vssd1 vssd1 vccd1 wire375/A wbs_dat_o[18] SS_sky130_fd_sc_hd__buf_12
Xwire364 vccd1 vssd1 vssd1 vccd1 wire364/A wbs_dat_o[28] SS_sky130_fd_sc_hd__buf_12
XFILLER_116_309 vccd1 vssd1 vccd1 vssd1 SS_sky130_fd_sc_hd__fill_1
XPHY_EDGE_ROW_36_Left_175 vccd1 vssd1 vccd1 vssd1 SS_sky130_fd_sc_hd__decap_3
XFILLER_137_681 vssd1 vccd1 vccd1 vssd1 SS_sky130_fd_sc_hd__fill_8
XFILLER_109_361 vssd1 vccd1 vssd1 vccd1 SS_sky130_ef_sc_hd__decap_40_12
Xwire386 vccd1 vssd1 vssd1 vccd1 wire386/A analog_ctrl[95] SS_sky130_fd_sc_hd__buf_12
Xwire397 vccd1 vssd1 vssd1 vccd1 wire397/A analog_ctrl[84] SS_sky130_fd_sc_hd__buf_12
XFILLER_136_191 vssd1 vccd1 vccd1 vssd1 SS_sky130_fd_sc_hd__fill_4
XFILLER_98_705 vssd1 vccd1 vccd1 vssd1 SS_sky130_fd_sc_hd__fill_2
XFILLER_31_6 vssd1 vccd1 vssd1 vccd1 SS_sky130_ef_sc_hd__decap_40_12
XFILLER_97_237 vssd1 vccd1 vssd1 vccd1 SS_sky130_ef_sc_hd__decap_40_12
XFILLER_2_193 vssd1 vccd1 vccd1 vssd1 SS_sky130_fd_sc_hd__fill_2
XFILLER_120_581 vssd1 vccd1 vccd1 vssd1 SS_sky130_fd_sc_hd__fill_4
XFILLER_66_657 vssd1 vccd1 vssd1 vccd1 SS_sky130_ef_sc_hd__decap_40_12
X_1112_ vccd1 vssd1 vccd1 vssd1 _1112_/X _1112_/A _1126_/B SS_sky130_fd_sc_hd__or2_2
XFILLER_19_573 vssd1 vccd1 vssd1 vccd1 SS_sky130_ef_sc_hd__decap_40_12
XPHY_EDGE_ROW_45_Left_184 vccd1 vssd1 vccd1 vssd1 SS_sky130_fd_sc_hd__decap_3
XFILLER_53_329 vssd1 vccd1 vccd1 vssd1 SS_sky130_fd_sc_hd__fill_4
XFILLER_65_167 vccd1 vssd1 vccd1 vssd1 SS_sky130_fd_sc_hd__fill_1
X_1043_ vssd1 vccd1 vccd1 vssd1 _1065_/A2 wire498/X _1553_/D _1441_/C1 _1042_/X SS_sky130_fd_sc_hd__o211a_2
XFILLER_81_627 vssd1 vccd1 vssd1 vccd1 SS_sky130_ef_sc_hd__decap_40_12
XFILLER_0_85 vssd1 vccd1 vccd1 vssd1 SS_sky130_fd_sc_hd__fill_8
XFILLER_80_137 vssd1 vccd1 vccd1 vssd1 SS_sky130_fd_sc_hd__fill_2
XFILLER_34_554 vssd1 vccd1 vssd1 vccd1 SS_sky130_ef_sc_hd__decap_40_12
XFILLER_21_237 vssd1 vccd1 vssd1 vccd1 SS_sky130_ef_sc_hd__decap_40_12
XFILLER_22_749 vssd1 vccd1 vccd1 vssd1 SS_sky130_fd_sc_hd__fill_4
XPHY_EDGE_ROW_100_Right_100 vccd1 vssd1 vccd1 vssd1 SS_sky130_fd_sc_hd__decap_3
XFILLER_30_782 vssd1 vccd1 vssd1 vccd1 SS_sky130_ef_sc_hd__decap_40_12
XTAP_TAPCELL_ROW_32_777 vccd1 vssd1 SS_sky130_fd_sc_hd__tapvpwrvgnd_1
XFILLER_119_125 vssd1 vccd1 vssd1 vccd1 SS_sky130_ef_sc_hd__decap_40_12
XPHY_EDGE_ROW_54_Left_193 vccd1 vssd1 vccd1 vssd1 SS_sky130_fd_sc_hd__decap_3
X_1876_ vccd1 vssd1 _1876_/X _1876_/A vccd1 vssd1 SS_sky130_fd_sc_hd__buf_2
XFILLER_119_169 vssd1 vccd1 vssd1 vccd1 SS_sky130_ef_sc_hd__decap_40_12
X_0827_ vccd1 vssd1 vccd1 vssd1 input13/X wire433/X _1857_/A wire445/X _0827_/X SS_sky130_fd_sc_hd__a22o_2
XFILLER_128_681 vssd1 vccd1 vssd1 vccd1 SS_sky130_ef_sc_hd__decap_40_12
XFILLER_116_810 vssd1 vccd1 vccd1 vssd1 SS_sky130_fd_sc_hd__fill_2
X_0758_ vccd1 vssd1 vssd1 vccd1 _0757_/X _0743_/X _0878_/A2 _1475_/Q _1475_/D _1417_/C1
+ SS_sky130_fd_sc_hd__o221a_2
XTAP_TAPCELL_ROW_77_1451 vccd1 vssd1 SS_sky130_fd_sc_hd__tapvpwrvgnd_1
XTAP_TAPCELL_ROW_77_1462 vccd1 vssd1 SS_sky130_fd_sc_hd__tapvpwrvgnd_1
XFILLER_134_139 vccd1 vssd1 vccd1 vssd1 SS_sky130_fd_sc_hd__fill_1
XFILLER_1_609 vssd1 vccd1 vccd1 vssd1 SS_sky130_fd_sc_hd__fill_4
XFILLER_89_727 vccd1 vssd1 vccd1 vssd1 SS_sky130_fd_sc_hd__fill_1
XTAP_TAPCELL_ROW_90_1651 vccd1 vssd1 SS_sky130_fd_sc_hd__tapvpwrvgnd_1
XFILLER_103_559 vccd1 vssd1 vccd1 vssd1 SS_sky130_fd_sc_hd__fill_1
XFILLER_28_26 vssd1 vccd1 vccd1 vssd1 SS_sky130_fd_sc_hd__fill_2
XFILLER_29_337 vssd1 vccd1 vssd1 vccd1 SS_sky130_ef_sc_hd__decap_40_12
XFILLER_69_473 vssd1 vccd1 vssd1 vccd1 SS_sky130_ef_sc_hd__decap_40_12
XFILLER_84_421 vssd1 vccd1 vccd1 vssd1 SS_sky130_fd_sc_hd__fill_2
XFILLER_130_389 vssd1 vccd1 vssd1 vccd1 SS_sky130_ef_sc_hd__decap_40_12
XFILLER_44_307 vccd1 vssd1 vccd1 vssd1 SS_sky130_fd_sc_hd__fill_1
XFILLER_56_189 vssd1 vccd1 vccd1 vssd1 SS_sky130_fd_sc_hd__fill_4
XFILLER_84_498 vccd1 vssd1 vccd1 vssd1 SS_sky130_fd_sc_hd__fill_1
XFILLER_53_841 vccd1 vssd1 vccd1 vssd1 SS_sky130_fd_sc_hd__fill_1
XFILLER_71_137 vssd1 vccd1 vssd1 vccd1 SS_sky130_ef_sc_hd__decap_40_12
XFILLER_9_709 vssd1 vccd1 vssd1 vccd1 SS_sky130_ef_sc_hd__decap_40_12
XFILLER_13_727 vccd1 vssd1 vccd1 vssd1 SS_sky130_fd_sc_hd__fill_1
XFILLER_40_513 vssd1 vccd1 vssd1 vccd1 SS_sky130_ef_sc_hd__decap_40_12
XFILLER_80_693 vssd1 vccd1 vccd1 vssd1 SS_sky130_fd_sc_hd__fill_4
XFILLER_40_557 vssd1 vccd1 vssd1 vccd1 SS_sky130_ef_sc_hd__decap_40_12
XFILLER_100_53 vssd1 vccd1 vssd1 vccd1 SS_sky130_ef_sc_hd__decap_40_12
XFILLER_138_423 vccd1 vssd1 vccd1 vssd1 SS_sky130_fd_sc_hd__fill_1
XFILLER_100_97 vssd1 vccd1 vssd1 vccd1 SS_sky130_ef_sc_hd__decap_40_12
XTAP_TAPCELL_ROW_10_449 vccd1 vssd1 SS_sky130_fd_sc_hd__tapvpwrvgnd_1
XTAP_TAPCELL_ROW_119_2090 vccd1 vssd1 SS_sky130_fd_sc_hd__tapvpwrvgnd_1
XFILLER_114_3 vssd1 vccd1 vssd1 vccd1 SS_sky130_ef_sc_hd__decap_40_12
XFILLER_109_51 vssd1 vccd1 vccd1 vssd1 SS_sky130_fd_sc_hd__fill_4
XFILLER_106_342 vssd1 vccd1 vssd1 vccd1 SS_sky130_ef_sc_hd__decap_40_12
XFILLER_4_469 vssd1 vccd1 vccd1 vssd1 SS_sky130_fd_sc_hd__fill_4
XFILLER_69_55 vccd1 vssd1 vccd1 vssd1 SS_sky130_fd_sc_hd__fill_1
XFILLER_133_161 vssd1 vccd1 vccd1 vssd1 SS_sky130_fd_sc_hd__fill_4
XFILLER_106_375 vssd1 vccd1 vssd1 vccd1 SS_sky130_ef_sc_hd__decap_40_12
XFILLER_79_237 vssd1 vccd1 vssd1 vccd1 SS_sky130_ef_sc_hd__decap_40_12
XFILLER_87_281 vssd1 vccd1 vssd1 vccd1 SS_sky130_ef_sc_hd__decap_40_12
XFILLER_88_793 vssd1 vccd1 vssd1 vccd1 SS_sky130_ef_sc_hd__decap_40_12
XFILLER_36_819 vccd1 vssd1 vccd1 vssd1 SS_sky130_fd_sc_hd__fill_1
XFILLER_48_657 vssd1 vccd1 vssd1 vccd1 SS_sky130_ef_sc_hd__decap_40_12
XFILLER_35_329 vssd1 vccd1 vccd1 vssd1 SS_sky130_fd_sc_hd__fill_4
XFILLER_47_167 vccd1 vssd1 vccd1 vssd1 SS_sky130_fd_sc_hd__fill_1
XFILLER_18_81 vssd1 vccd1 vccd1 vssd1 SS_sky130_fd_sc_hd__fill_2
XFILLER_62_137 vssd1 vccd1 vccd1 vssd1 SS_sky130_fd_sc_hd__fill_2
XFILLER_90_457 vssd1 vccd1 vssd1 vccd1 SS_sky130_ef_sc_hd__decap_40_12
XFILLER_16_587 vccd1 vssd1 vccd1 vssd1 SS_sky130_fd_sc_hd__fill_1
XFILLER_43_373 vssd1 vccd1 vssd1 vccd1 SS_sky130_ef_sc_hd__decap_40_12
XFILLER_31_557 vssd1 vccd1 vccd1 vssd1 SS_sky130_fd_sc_hd__fill_2
XTAP_TAPCELL_ROW_135_2319 vccd1 vssd1 SS_sky130_fd_sc_hd__tapvpwrvgnd_1
XFILLER_8_753 vssd1 vccd1 vccd1 vssd1 SS_sky130_fd_sc_hd__fill_2
XFILLER_11_281 vssd1 vccd1 vssd1 vccd1 SS_sky130_ef_sc_hd__decap_40_12
X_1730_ _1730_/Q _1761_/CLK _1730_/D vccd1 vssd1 vccd1 vssd1 SS_sky130_fd_sc_hd__dfxtp_2
X_1661_ _1661_/Q _1760_/CLK _1661_/D vccd1 vssd1 vccd1 vssd1 SS_sky130_fd_sc_hd__dfxtp_2
XFILLER_116_139 vccd1 vssd1 vccd1 vssd1 SS_sky130_fd_sc_hd__fill_1
XTAP_TAPCELL_ROW_59_1181 vccd1 vssd1 SS_sky130_fd_sc_hd__tapvpwrvgnd_1
XTAP_TAPCELL_ROW_59_1192 vccd1 vssd1 SS_sky130_fd_sc_hd__tapvpwrvgnd_1
XFILLER_131_109 vssd1 vccd1 vccd1 vssd1 SS_sky130_fd_sc_hd__fill_2
XFILLER_125_673 vssd1 vccd1 vssd1 vccd1 SS_sky130_ef_sc_hd__decap_40_12
X_1592_ _1866_/A _1741_/CLK _1592_/D vccd1 vssd1 vccd1 vssd1 SS_sky130_fd_sc_hd__dfxtp_2
XFILLER_98_557 vssd1 vccd1 vssd1 vccd1 SS_sky130_ef_sc_hd__decap_40_12
XFILLER_66_410 vssd1 vccd1 vccd1 vssd1 SS_sky130_fd_sc_hd__fill_8
XFILLER_66_421 vssd1 vccd1 vssd1 vccd1 SS_sky130_ef_sc_hd__decap_40_12
XTAP_TAPCELL_ROW_72_1381 vccd1 vssd1 SS_sky130_fd_sc_hd__tapvpwrvgnd_1
XFILLER_79_793 vccd1 vssd1 vccd1 vssd1 SS_sky130_fd_sc_hd__fill_1
XFILLER_100_529 vssd1 vccd1 vccd1 vssd1 SS_sky130_fd_sc_hd__fill_2
XFILLER_26_307 vccd1 vssd1 vccd1 vssd1 SS_sky130_fd_sc_hd__fill_1
XFILLER_94_774 vssd1 vccd1 vssd1 vccd1 SS_sky130_ef_sc_hd__decap_40_12
XFILLER_93_273 vssd1 vccd1 vccd1 vssd1 SS_sky130_fd_sc_hd__fill_4
XFILLER_35_841 vccd1 vssd1 vccd1 vssd1 SS_sky130_fd_sc_hd__fill_1
XTAP_TAPCELL_ROW_37_858 vccd1 vssd1 SS_sky130_fd_sc_hd__tapvpwrvgnd_1
XFILLER_38_189 vssd1 vccd1 vccd1 vssd1 SS_sky130_fd_sc_hd__fill_4
XFILLER_53_137 vssd1 vccd1 vssd1 vccd1 SS_sky130_ef_sc_hd__decap_40_12
X_1026_ vccd1 vssd1 vccd1 vssd1 _1026_/X _1832_/A _1050_/B SS_sky130_fd_sc_hd__or2_2
XTAP_TAPCELL_ROW_17_560 vccd1 vssd1 SS_sky130_fd_sc_hd__tapvpwrvgnd_1
XFILLER_22_513 vssd1 vccd1 vssd1 vccd1 SS_sky130_ef_sc_hd__decap_40_12
XFILLER_50_811 vccd1 vssd1 vccd1 vssd1 SS_sky130_fd_sc_hd__fill_1
XFILLER_22_557 vssd1 vccd1 vssd1 vccd1 SS_sky130_ef_sc_hd__decap_40_12
XFILLER_61_181 vssd1 vccd1 vssd1 vccd1 SS_sky130_ef_sc_hd__decap_40_12
XPHY_EDGE_ROW_62_Left_201 vccd1 vssd1 vccd1 vssd1 SS_sky130_fd_sc_hd__decap_3
XFILLER_30_27 vccd1 vssd1 vccd1 vssd1 SS_sky130_fd_sc_hd__fill_1
X_1859_ vccd1 vssd1 _1859_/X _1859_/A vccd1 vssd1 SS_sky130_fd_sc_hd__buf_2
Xhold720 _1326_/A _1691_/Q vccd1 vssd1 vssd1 vccd1 SS_sky130_fd_sc_hd__dlygate4sd3_1
XFILLER_1_417 vssd1 vccd1 vssd1 vccd1 SS_sky130_ef_sc_hd__decap_40_12
Xhold764 _1318_/A _1687_/Q vccd1 vssd1 vssd1 vccd1 SS_sky130_fd_sc_hd__dlygate4sd3_1
Xhold753 _0984_/A _1525_/Q vccd1 vssd1 vssd1 vccd1 SS_sky130_fd_sc_hd__dlygate4sd3_1
Xhold742 _1440_/A _1746_/Q vccd1 vssd1 vssd1 vccd1 SS_sky130_fd_sc_hd__dlygate4sd3_1
XFILLER_89_502 vssd1 vccd1 vccd1 vssd1 SS_sky130_fd_sc_hd__fill_2
XFILLER_89_513 vssd1 vccd1 vccd1 vssd1 SS_sky130_fd_sc_hd__fill_4
XFILLER_122_109 vssd1 vccd1 vssd1 vccd1 SS_sky130_ef_sc_hd__decap_40_12
XFILLER_116_673 vccd1 vssd1 vccd1 vssd1 SS_sky130_fd_sc_hd__fill_1
XFILLER_104_813 vccd1 vssd1 vccd1 vssd1 SS_sky130_fd_sc_hd__fill_1
Xhold731 _0980_/A _1523_/Q vccd1 vssd1 vssd1 vccd1 SS_sky130_fd_sc_hd__dlygate4sd3_1
Xhold775 _1180_/A _1620_/Q vccd1 vssd1 vssd1 vccd1 SS_sky130_fd_sc_hd__dlygate4sd3_1
XFILLER_89_557 vssd1 vccd1 vccd1 vssd1 SS_sky130_fd_sc_hd__fill_2
Xhold797 hold797/X _1502_/Q vccd1 vssd1 vssd1 vccd1 SS_sky130_fd_sc_hd__dlygate4sd3_1
Xhold786 input15/A wbs_adr_i[2] vccd1 vssd1 vssd1 vccd1 SS_sky130_fd_sc_hd__dlygate4sd3_1
XFILLER_115_161 vssd1 vccd1 vccd1 vssd1 SS_sky130_fd_sc_hd__fill_4
XPHY_EDGE_ROW_71_Left_210 vccd1 vssd1 vccd1 vssd1 SS_sky130_fd_sc_hd__decap_3
XFILLER_89_579 vssd1 vccd1 vssd1 vccd1 SS_sky130_ef_sc_hd__decap_40_12
XFILLER_130_153 vssd1 vccd1 vssd1 vccd1 SS_sky130_ef_sc_hd__decap_40_12
XFILLER_103_345 vssd1 vccd1 vssd1 vccd1 SS_sky130_ef_sc_hd__decap_40_12
XFILLER_39_69 vssd1 vccd1 vssd1 vccd1 SS_sky130_ef_sc_hd__decap_40_12
XFILLER_69_281 vssd1 vccd1 vssd1 vccd1 SS_sky130_ef_sc_hd__decap_40_12
XFILLER_85_741 vssd1 vccd1 vccd1 vssd1 SS_sky130_fd_sc_hd__fill_8
XFILLER_130_197 vssd1 vccd1 vssd1 vccd1 SS_sky130_ef_sc_hd__decap_40_12
XFILLER_29_167 vccd1 vssd1 vccd1 vssd1 SS_sky130_fd_sc_hd__fill_1
XFILLER_84_251 vccd1 vssd1 vccd1 vssd1 SS_sky130_fd_sc_hd__fill_1
XFILLER_85_785 vssd1 vccd1 vccd1 vssd1 SS_sky130_fd_sc_hd__fill_4
XFILLER_17_329 vssd1 vccd1 vccd1 vssd1 SS_sky130_fd_sc_hd__fill_4
XFILLER_44_137 vssd1 vccd1 vccd1 vssd1 SS_sky130_fd_sc_hd__fill_2
XFILLER_55_57 vssd1 vccd1 vssd1 vccd1 SS_sky130_ef_sc_hd__decap_40_12
XFILLER_111_30 vssd1 vccd1 vssd1 vccd1 SS_sky130_ef_sc_hd__decap_40_12
XTAP_TAPCELL_ROW_15_519 vccd1 vssd1 SS_sky130_fd_sc_hd__tapvpwrvgnd_1
XFILLER_25_373 vssd1 vccd1 vssd1 vccd1 SS_sky130_ef_sc_hd__decap_40_12
XFILLER_41_811 vssd1 vccd1 vccd1 vssd1 SS_sky130_fd_sc_hd__fill_4
XFILLER_9_517 vssd1 vccd1 vssd1 vccd1 SS_sky130_ef_sc_hd__decap_40_12
XFILLER_13_557 vssd1 vccd1 vccd1 vssd1 SS_sky130_fd_sc_hd__fill_2
XFILLER_40_321 vssd1 vccd1 vssd1 vccd1 SS_sky130_ef_sc_hd__decap_40_12
Xclkbuf_leaf_27_wb_clk_i _1608_/CLK clkload1/A vccd1 vssd1 vssd1 vccd1 SS_sky130_fd_sc_hd__clkbuf_8
XTAP_TAPCELL_ROW_101_1820 vccd1 vssd1 SS_sky130_fd_sc_hd__tapvpwrvgnd_1
XFILLER_40_365 vssd1 vccd1 vssd1 vccd1 SS_sky130_ef_sc_hd__decap_40_12
XFILLER_138_253 vssd1 vccd1 vccd1 vssd1 SS_sky130_fd_sc_hd__fill_2
XTAP_TAPCELL_ROW_117_2049 vccd1 vssd1 SS_sky130_fd_sc_hd__tapvpwrvgnd_1
XFILLER_4_233 vssd1 vccd1 vssd1 vccd1 SS_sky130_ef_sc_hd__decap_40_12
XTAP_TAPCELL_ROW_130_2249 vccd1 vssd1 SS_sky130_fd_sc_hd__tapvpwrvgnd_1
XFILLER_113_109 vssd1 vccd1 vccd1 vssd1 SS_sky130_fd_sc_hd__fill_2
XFILLER_107_673 vccd1 vssd1 vccd1 vssd1 SS_sky130_fd_sc_hd__fill_1
XFILLER_4_277 vssd1 vccd1 vssd1 vccd1 SS_sky130_ef_sc_hd__decap_40_12
XFILLER_134_470 vccd1 vssd1 vccd1 vssd1 SS_sky130_fd_sc_hd__fill_1
XFILLER_136_60 vssd1 vccd1 vssd1 vccd1 SS_sky130_ef_sc_hd__decap_40_12
XFILLER_122_643 vccd1 vssd1 vccd1 vssd1 SS_sky130_fd_sc_hd__fill_1
XFILLER_96_53 vssd1 vccd1 vssd1 vccd1 SS_sky130_ef_sc_hd__decap_40_12
XFILLER_95_505 vccd1 vssd1 vccd1 vssd1 SS_sky130_fd_sc_hd__fill_1
XFILLER_0_461 vssd1 vccd1 vssd1 vccd1 SS_sky130_ef_sc_hd__decap_40_12
XTAP_TAPCELL_ROW_112_1982 vccd1 vssd1 SS_sky130_fd_sc_hd__tapvpwrvgnd_1
XFILLER_48_421 vssd1 vccd1 vssd1 vccd1 SS_sky130_ef_sc_hd__decap_40_12
XFILLER_96_97 vssd1 vccd1 vssd1 vccd1 SS_sky130_ef_sc_hd__decap_40_12
XFILLER_48_465 vccd1 vssd1 vccd1 vssd1 SS_sky130_fd_sc_hd__fill_1
XFILLER_75_273 vssd1 vccd1 vccd1 vssd1 SS_sky130_fd_sc_hd__fill_4
XFILLER_17_841 vccd1 vssd1 vccd1 vssd1 SS_sky130_fd_sc_hd__fill_1
XFILLER_35_137 vssd1 vccd1 vssd1 vccd1 SS_sky130_ef_sc_hd__decap_40_12
XFILLER_63_446 vssd1 vccd1 vccd1 vssd1 SS_sky130_fd_sc_hd__fill_2
XFILLER_90_221 vssd1 vccd1 vssd1 vccd1 SS_sky130_ef_sc_hd__decap_40_12
XFILLER_91_744 vssd1 vccd1 vccd1 vssd1 SS_sky130_fd_sc_hd__fill_4
XFILLER_91_733 vssd1 vccd1 vccd1 vssd1 SS_sky130_fd_sc_hd__fill_2
XTAP_TAPCELL_ROW_34_806 vccd1 vssd1 SS_sky130_fd_sc_hd__tapvpwrvgnd_1
XTAP_TAPCELL_ROW_34_817 vccd1 vssd1 SS_sky130_fd_sc_hd__tapvpwrvgnd_1
XFILLER_90_265 vssd1 vccd1 vssd1 vccd1 SS_sky130_ef_sc_hd__decap_40_12
XFILLER_32_811 vccd1 vssd1 vccd1 vssd1 SS_sky130_fd_sc_hd__fill_1
XFILLER_44_693 vssd1 vccd1 vccd1 vssd1 SS_sky130_fd_sc_hd__fill_4
XFILLER_43_181 vssd1 vccd1 vssd1 vccd1 SS_sky130_ef_sc_hd__decap_40_12
XFILLER_77_3 vssd1 vccd1 vssd1 vccd1 SS_sky130_ef_sc_hd__decap_40_12
X_1713_ _1713_/Q _1746_/CLK _1713_/D vccd1 vssd1 vccd1 vssd1 SS_sky130_fd_sc_hd__dfxtp_2
XTAP_TAPCELL_ROW_74_1410 vccd1 vssd1 SS_sky130_fd_sc_hd__tapvpwrvgnd_1
X_1644_ _1644_/Q clkload6/A _1644_/D vccd1 vssd1 vccd1 vssd1 SS_sky130_fd_sc_hd__dfxtp_2
XFILLER_104_109 vssd1 vccd1 vssd1 vccd1 SS_sky130_ef_sc_hd__decap_40_12
X_1575_ _1845_/A _1608_/CLK _1575_/D vccd1 vssd1 vccd1 vssd1 SS_sky130_fd_sc_hd__dfxtp_2
XFILLER_98_321 vssd1 vccd1 vssd1 vccd1 SS_sky130_ef_sc_hd__decap_40_12
XFILLER_98_365 vssd1 vccd1 vccd1 vssd1 SS_sky130_fd_sc_hd__fill_2
XFILLER_112_153 vssd1 vccd1 vssd1 vccd1 SS_sky130_ef_sc_hd__decap_40_12
XFILLER_98_387 vssd1 vccd1 vssd1 vccd1 SS_sky130_ef_sc_hd__decap_40_12
XFILLER_67_741 vssd1 vccd1 vssd1 vccd1 SS_sky130_ef_sc_hd__decap_40_12
XFILLER_112_197 vssd1 vccd1 vssd1 vccd1 SS_sky130_ef_sc_hd__decap_40_12
XFILLER_66_251 vccd1 vssd1 vccd1 vssd1 SS_sky130_fd_sc_hd__fill_1
XFILLER_67_785 vssd1 vccd1 vssd1 vccd1 SS_sky130_ef_sc_hd__decap_40_12
XFILLER_82_711 vccd1 vssd1 vccd1 vssd1 SS_sky130_fd_sc_hd__fill_1
XFILLER_132_29 vssd1 vccd1 vssd1 vccd1 SS_sky130_ef_sc_hd__decap_40_12
XFILLER_26_137 vssd1 vccd1 vccd1 vssd1 SS_sky130_fd_sc_hd__fill_2
XFILLER_81_221 vssd1 vccd1 vccd1 vssd1 SS_sky130_fd_sc_hd__fill_2
XFILLER_94_582 vssd1 vccd1 vccd1 vssd1 SS_sky130_fd_sc_hd__fill_4
XFILLER_25_27 vssd1 vccd1 vssd1 vccd1 SS_sky130_ef_sc_hd__decap_40_12
XFILLER_23_822 vssd1 vccd1 vccd1 vssd1 SS_sky130_fd_sc_hd__fill_2
XFILLER_35_671 vccd1 vssd1 vccd1 vssd1 SS_sky130_fd_sc_hd__fill_1
XTAP_TAPCELL_ROW_85_1572 vccd1 vssd1 SS_sky130_fd_sc_hd__tapvpwrvgnd_1
X_1009_ vssd1 vccd1 vccd1 vssd1 wire253/A input43/X _1537_/D _1401_/C1 _1008_/X SS_sky130_fd_sc_hd__o211a_2
XFILLER_22_321 vssd1 vccd1 vssd1 vccd1 SS_sky130_ef_sc_hd__decap_40_12
XFILLER_22_365 vssd1 vccd1 vssd1 vccd1 SS_sky130_ef_sc_hd__decap_40_12
XFILLER_50_685 vssd1 vccd1 vccd1 vssd1 SS_sky130_fd_sc_hd__fill_2
XFILLER_136_713 vccd1 vssd1 vccd1 vssd1 SS_sky130_fd_sc_hd__fill_1
XTAP_TAPCELL_ROW_20_599 vccd1 vssd1 SS_sky130_fd_sc_hd__tapvpwrvgnd_1
XFILLER_135_223 vccd1 vssd1 vccd1 vssd1 SS_sky130_fd_sc_hd__fill_1
XFILLER_136_757 vssd1 vccd1 vccd1 vssd1 SS_sky130_fd_sc_hd__fill_4
XFILLER_1_225 vssd1 vccd1 vssd1 vccd1 SS_sky130_ef_sc_hd__decap_40_12
XFILLER_2_737 vssd1 vccd1 vssd1 vccd1 SS_sky130_ef_sc_hd__decap_40_12
Xhold572 _1096_/A _1853_/A vccd1 vssd1 vssd1 vccd1 SS_sky130_fd_sc_hd__dlygate4sd3_1
XFILLER_116_481 vssd1 vccd1 vccd1 vssd1 SS_sky130_fd_sc_hd__fill_2
Xhold583 _1170_/A _1875_/A vccd1 vssd1 vssd1 vccd1 SS_sky130_fd_sc_hd__dlygate4sd3_1
Xhold594 _1038_/A _1551_/Q vccd1 vssd1 vssd1 vccd1 SS_sky130_fd_sc_hd__dlygate4sd3_1
XFILLER_77_505 vssd1 vccd1 vssd1 vccd1 SS_sky130_ef_sc_hd__decap_40_12
XFILLER_104_643 vccd1 vssd1 vccd1 vssd1 SS_sky130_fd_sc_hd__fill_1
XFILLER_131_473 vssd1 vccd1 vssd1 vccd1 SS_sky130_ef_sc_hd__decap_40_12
XFILLER_106_41 vssd1 vccd1 vssd1 vccd1 SS_sky130_ef_sc_hd__decap_40_12
XFILLER_106_85 vssd1 vccd1 vssd1 vccd1 SS_sky130_ef_sc_hd__decap_40_12
XFILLER_17_137 vssd1 vccd1 vssd1 vccd1 SS_sky130_ef_sc_hd__decap_40_12
XFILLER_57_273 vssd1 vccd1 vccd1 vssd1 SS_sky130_fd_sc_hd__fill_4
XFILLER_72_221 vssd1 vccd1 vssd1 vccd1 SS_sky130_ef_sc_hd__decap_40_12
XFILLER_45_457 vssd1 vccd1 vssd1 vccd1 SS_sky130_ef_sc_hd__decap_40_12
XFILLER_73_777 vssd1 vccd1 vccd1 vssd1 SS_sky130_fd_sc_hd__fill_4
XTAP_TAPCELL_ROW_0_280 vccd1 vssd1 SS_sky130_fd_sc_hd__tapvpwrvgnd_1
XFILLER_14_811 vccd1 vssd1 vccd1 vssd1 SS_sky130_fd_sc_hd__fill_1
XFILLER_72_265 vssd1 vccd1 vssd1 vccd1 SS_sky130_ef_sc_hd__decap_40_12
XTAP_TAPCELL_ROW_0_291 vccd1 vssd1 SS_sky130_fd_sc_hd__tapvpwrvgnd_1
XFILLER_25_181 vssd1 vccd1 vssd1 vccd1 SS_sky130_ef_sc_hd__decap_40_12
XFILLER_53_490 vssd1 vccd1 vccd1 vssd1 SS_sky130_fd_sc_hd__fill_4
XFILLER_82_77 vssd1 vccd1 vccd1 vssd1 SS_sky130_fd_sc_hd__fill_4
XFILLER_15_93 vssd1 vccd1 vssd1 vccd1 SS_sky130_ef_sc_hd__decap_40_12
XFILLER_41_663 vssd1 vccd1 vccd1 vssd1 SS_sky130_fd_sc_hd__fill_8
XFILLER_41_685 vssd1 vccd1 vccd1 vssd1 SS_sky130_fd_sc_hd__fill_4
XFILLER_40_195 vccd1 vssd1 vccd1 vssd1 SS_sky130_fd_sc_hd__fill_1
XFILLER_5_553 vssd1 vccd1 vccd1 vssd1 SS_sky130_fd_sc_hd__fill_4
XFILLER_31_81 vssd1 vccd1 vssd1 vccd1 SS_sky130_ef_sc_hd__decap_40_12
XFILLER_126_245 vssd1 vccd1 vccd1 vssd1 SS_sky130_fd_sc_hd__fill_4
XFILLER_5_597 vssd1 vccd1 vssd1 vccd1 SS_sky130_ef_sc_hd__decap_40_12
XTAP_TAPCELL_ROW_56_1140 vccd1 vssd1 SS_sky130_fd_sc_hd__tapvpwrvgnd_1
XFILLER_126_289 vssd1 vccd1 vssd1 vccd1 SS_sky130_ef_sc_hd__decap_40_12
X_1360_ vccd1 vssd1 vccd1 vssd1 _1360_/X _1360_/A _1396_/B SS_sky130_fd_sc_hd__or2_2
Xoutput70 vccd1 vssd1 wire290/A _1905_/X vccd1 vssd1 SS_sky130_fd_sc_hd__buf_4
XFILLER_1_781 vssd1 vccd1 vccd1 vssd1 SS_sky130_fd_sc_hd__fill_2
Xoutput81 vccd1 vssd1 wire279/A _1842_/X vccd1 vssd1 SS_sky130_fd_sc_hd__buf_4
Xoutput92 vccd1 vssd1 wire268/A _1852_/X vccd1 vssd1 SS_sky130_fd_sc_hd__buf_4
XFILLER_110_613 vssd1 vccd1 vssd1 vccd1 SS_sky130_ef_sc_hd__decap_40_12
X_1291_ vssd1 vccd1 vccd1 vssd1 _1337_/A2 wire497/X _1673_/D _1299_/C1 _1290_/X SS_sky130_fd_sc_hd__o211a_2
XFILLER_110_657 vssd1 vccd1 vccd1 vssd1 SS_sky130_fd_sc_hd__fill_4
XFILLER_48_251 vccd1 vssd1 vccd1 vssd1 SS_sky130_fd_sc_hd__fill_1
XFILLER_49_785 vssd1 vccd1 vccd1 vssd1 SS_sky130_fd_sc_hd__fill_4
XFILLER_36_413 vssd1 vccd1 vccd1 vssd1 SS_sky130_fd_sc_hd__fill_4
XFILLER_63_221 vssd1 vccd1 vccd1 vssd1 SS_sky130_fd_sc_hd__fill_2
XFILLER_36_457 vssd1 vccd1 vssd1 vccd1 SS_sky130_ef_sc_hd__decap_40_12
XFILLER_64_755 vccd1 vssd1 vccd1 vssd1 SS_sky130_fd_sc_hd__fill_1
XFILLER_91_541 vssd1 vccd1 vssd1 vccd1 SS_sky130_ef_sc_hd__decap_40_12
XFILLER_17_671 vccd1 vssd1 vccd1 vssd1 SS_sky130_fd_sc_hd__fill_1
XFILLER_51_405 vssd1 vccd1 vccd1 vssd1 SS_sky130_fd_sc_hd__fill_2
XFILLER_91_585 vssd1 vccd1 vssd1 vccd1 SS_sky130_ef_sc_hd__decap_40_12
XFILLER_51_449 vssd1 vccd1 vssd1 vccd1 SS_sky130_ef_sc_hd__decap_40_12
XFILLER_118_713 vssd1 vccd1 vssd1 vccd1 SS_sky130_ef_sc_hd__decap_40_12
XFILLER_11_18 vssd1 vccd1 vssd1 vccd1 SS_sky130_ef_sc_hd__decap_40_12
XFILLER_117_223 vccd1 vssd1 vccd1 vssd1 SS_sky130_fd_sc_hd__fill_1
XFILLER_133_727 vccd1 vssd1 vccd1 vssd1 SS_sky130_fd_sc_hd__fill_1
X_1627_ _1627_/Q _1692_/CLK _1627_/D vccd1 vssd1 vccd1 vssd1 SS_sky130_fd_sc_hd__dfxtp_2
XFILLER_105_429 vssd1 vccd1 vccd1 vssd1 SS_sky130_fd_sc_hd__fill_8
XFILLER_99_641 vssd1 vccd1 vssd1 vccd1 SS_sky130_ef_sc_hd__decap_40_12
XFILLER_59_505 vssd1 vccd1 vccd1 vssd1 SS_sky130_fd_sc_hd__fill_4
Xfanout348 vssd1 vccd1 vccd1 vssd1 _0753_/A _0878_/A2 SS_sky130_fd_sc_hd__clkdlybuf4s25_1
XFILLER_113_473 vssd1 vccd1 vssd1 vccd1 SS_sky130_ef_sc_hd__decap_40_12
X_1558_ _1558_/Q _1724_/CLK _1558_/D vccd1 vssd1 vccd1 vssd1 SS_sky130_fd_sc_hd__dfxtp_2
XFILLER_101_613 vssd1 vccd1 vccd1 vssd1 SS_sky130_fd_sc_hd__fill_2
X_1489_ _1489_/Q _1717_/CLK _1489_/D vccd1 vssd1 vccd1 vssd1 SS_sky130_fd_sc_hd__dfxtp_2
XFILLER_98_195 vccd1 vssd1 vccd1 vssd1 SS_sky130_fd_sc_hd__fill_1
XFILLER_74_508 vssd1 vccd1 vssd1 vccd1 SS_sky130_ef_sc_hd__decap_40_12
XTAP_TAPCELL_ROW_87_1601 vccd1 vssd1 SS_sky130_fd_sc_hd__tapvpwrvgnd_1
XTAP_TAPCELL_ROW_87_1612 vccd1 vssd1 SS_sky130_fd_sc_hd__tapvpwrvgnd_1
XFILLER_36_26 vssd1 vccd1 vccd1 vssd1 SS_sky130_fd_sc_hd__fill_2
XFILLER_39_273 vssd1 vccd1 vccd1 vssd1 SS_sky130_fd_sc_hd__fill_4
XFILLER_54_221 vssd1 vccd1 vssd1 vccd1 SS_sky130_ef_sc_hd__decap_40_12
XFILLER_55_722 vssd1 vccd1 vccd1 vssd1 SS_sky130_fd_sc_hd__fill_4
XFILLER_100_189 vssd1 vccd1 vccd1 vssd1 SS_sky130_fd_sc_hd__fill_4
XFILLER_55_777 vssd1 vccd1 vccd1 vssd1 SS_sky130_fd_sc_hd__fill_4
XFILLER_54_265 vssd1 vccd1 vssd1 vccd1 SS_sky130_ef_sc_hd__decap_40_12
XFILLER_70_725 vssd1 vccd1 vssd1 vccd1 SS_sky130_ef_sc_hd__decap_40_12
XFILLER_23_641 vssd1 vccd1 vssd1 vccd1 SS_sky130_ef_sc_hd__decap_40_12
XFILLER_42_449 vssd1 vccd1 vssd1 vccd1 SS_sky130_ef_sc_hd__decap_40_12
XFILLER_70_769 vssd1 vccd1 vccd1 vssd1 SS_sky130_fd_sc_hd__fill_8
XTAP_TAPCELL_ROW_25_669 vccd1 vssd1 SS_sky130_fd_sc_hd__tapvpwrvgnd_1
XFILLER_10_357 vssd1 vccd1 vccd1 vssd1 SS_sky130_fd_sc_hd__fill_4
XFILLER_22_195 vccd1 vssd1 vccd1 vssd1 SS_sky130_fd_sc_hd__fill_1
XTAP_TAPCELL_ROW_114_2008 vccd1 vssd1 SS_sky130_fd_sc_hd__tapvpwrvgnd_1
XTAP_TAPCELL_ROW_98_1774 vccd1 vssd1 SS_sky130_fd_sc_hd__tapvpwrvgnd_1
XTAP_TAPCELL_ROW_98_1763 vccd1 vssd1 SS_sky130_fd_sc_hd__tapvpwrvgnd_1
XFILLER_136_576 vssd1 vccd1 vccd1 vssd1 SS_sky130_fd_sc_hd__fill_2
XFILLER_108_245 vssd1 vccd1 vccd1 vssd1 SS_sky130_fd_sc_hd__fill_4
XFILLER_2_501 vssd1 vccd1 vssd1 vccd1 SS_sky130_ef_sc_hd__decap_40_12
XFILLER_136_587 vccd1 vssd1 vccd1 vssd1 SS_sky130_fd_sc_hd__fill_1
XFILLER_108_289 vssd1 vccd1 vssd1 vccd1 SS_sky130_ef_sc_hd__decap_40_12
XFILLER_2_545 vssd1 vccd1 vssd1 vccd1 SS_sky130_ef_sc_hd__decap_40_12
XFILLER_7_3 vssd1 vccd1 vssd1 vccd1 SS_sky130_ef_sc_hd__decap_40_12
XFILLER_123_237 vssd1 vccd1 vssd1 vccd1 SS_sky130_ef_sc_hd__decap_40_12
XFILLER_117_51 vssd1 vccd1 vccd1 vssd1 SS_sky130_fd_sc_hd__fill_4
XFILLER_2_589 vssd1 vccd1 vssd1 vccd1 SS_sky130_ef_sc_hd__decap_40_12
XFILLER_77_55 vccd1 vssd1 vccd1 vssd1 SS_sky130_fd_sc_hd__fill_1
XFILLER_77_313 vssd1 vccd1 vccd1 vssd1 SS_sky130_fd_sc_hd__fill_2
XFILLER_132_793 vssd1 vccd1 vccd1 vssd1 SS_sky130_fd_sc_hd__fill_4
XFILLER_77_324 vssd1 vccd1 vssd1 vccd1 SS_sky130_ef_sc_hd__decap_40_12
XTAP_TAPCELL_ROW_129_2240 vccd1 vssd1 SS_sky130_fd_sc_hd__tapvpwrvgnd_1
XFILLER_131_281 vssd1 vccd1 vssd1 vccd1 SS_sky130_ef_sc_hd__decap_40_12
XTAP_TAPCELL_ROW_5_372 vccd1 vssd1 SS_sky130_fd_sc_hd__tapvpwrvgnd_1
XTAP_TAPCELL_ROW_51_1070 vccd1 vssd1 SS_sky130_fd_sc_hd__tapvpwrvgnd_1
XFILLER_77_379 vssd1 vccd1 vssd1 vccd1 SS_sky130_ef_sc_hd__decap_40_12
XFILLER_92_305 vssd1 vccd1 vccd1 vssd1 SS_sky130_fd_sc_hd__fill_2
XFILLER_18_413 vssd1 vccd1 vccd1 vssd1 SS_sky130_fd_sc_hd__fill_4
XFILLER_46_733 vssd1 vccd1 vccd1 vssd1 SS_sky130_fd_sc_hd__fill_2
XFILLER_18_457 vssd1 vccd1 vssd1 vccd1 SS_sky130_ef_sc_hd__decap_40_12
XFILLER_45_221 vssd1 vccd1 vccd1 vssd1 SS_sky130_fd_sc_hd__fill_2
XFILLER_46_755 vccd1 vssd1 vccd1 vssd1 SS_sky130_fd_sc_hd__fill_1
XFILLER_93_54 vssd1 vccd1 vccd1 vssd1 SS_sky130_fd_sc_hd__fill_2
XFILLER_33_405 vssd1 vccd1 vssd1 vccd1 SS_sky130_ef_sc_hd__decap_40_12
XFILLER_61_725 vssd1 vccd1 vccd1 vssd1 SS_sky130_fd_sc_hd__fill_2
XFILLER_14_641 vssd1 vccd1 vccd1 vssd1 SS_sky130_fd_sc_hd__fill_2
XFILLER_26_81 vssd1 vccd1 vccd1 vssd1 SS_sky130_fd_sc_hd__fill_2
XFILLER_33_449 vssd1 vccd1 vssd1 vccd1 SS_sky130_ef_sc_hd__decap_40_12
XTAP_TAPCELL_ROW_44_956 vccd1 vssd1 SS_sky130_fd_sc_hd__tapvpwrvgnd_1
XTAP_TAPCELL_ROW_44_967 vccd1 vssd1 SS_sky130_fd_sc_hd__tapvpwrvgnd_1
XFILLER_9_111 vccd1 vssd1 vccd1 vssd1 SS_sky130_fd_sc_hd__fill_1
XFILLER_41_493 vssd1 vccd1 vccd1 vssd1 SS_sky130_fd_sc_hd__fill_2
X_0860_ vccd1 vssd1 vssd1 vccd1 _0856_/X _0859_/X _0860_/A2 hold813/X _1492_/D _1295_/C1
+ SS_sky130_fd_sc_hd__o221a_2
X_0791_ vccd1 vssd1 vccd1 vssd1 input9/X _0815_/B1 _1851_/A wire443/X _0791_/X SS_sky130_fd_sc_hd__a22o_2
XFILLER_61_6 vssd1 vccd1 vssd1 vccd1 SS_sky130_ef_sc_hd__decap_40_12
XFILLER_5_361 vssd1 vccd1 vssd1 vccd1 SS_sky130_ef_sc_hd__decap_40_12
XFILLER_127_587 vssd1 vccd1 vssd1 vccd1 SS_sky130_ef_sc_hd__decap_40_12
X_1412_ vccd1 vssd1 vccd1 vssd1 _1412_/X _1412_/A _1466_/B SS_sky130_fd_sc_hd__or2_2
XFILLER_3_30 vssd1 vccd1 vssd1 vccd1 SS_sky130_ef_sc_hd__decap_40_12
X_1343_ vccd1 vssd1 vssd1 vccd1 _1343_/Y _1343_/A _1409_/B SS_sky130_fd_sc_hd__nand2_2
XFILLER_83_305 vssd1 vccd1 vccd1 vssd1 SS_sky130_fd_sc_hd__fill_2
XFILLER_84_817 vccd1 vssd1 vccd1 vssd1 SS_sky130_fd_sc_hd__fill_1
X_1274_ vccd1 vssd1 vccd1 vssd1 _1274_/X _1666_/Q _1274_/B SS_sky130_fd_sc_hd__or2_2
XFILLER_110_465 vssd1 vccd1 vccd1 vssd1 SS_sky130_fd_sc_hd__fill_8
XFILLER_96_699 vccd1 vssd1 vccd1 vssd1 SS_sky130_fd_sc_hd__fill_1
XFILLER_95_165 vssd1 vccd1 vccd1 vssd1 SS_sky130_fd_sc_hd__fill_2
XTAP_TAPCELL_ROW_69_1331 vccd1 vssd1 SS_sky130_fd_sc_hd__tapvpwrvgnd_1
XFILLER_83_316 vssd1 vccd1 vssd1 vccd1 SS_sky130_ef_sc_hd__decap_40_12
XFILLER_83_349 vssd1 vccd1 vssd1 vccd1 SS_sky130_ef_sc_hd__decap_40_12
XFILLER_36_221 vssd1 vccd1 vssd1 vccd1 SS_sky130_ef_sc_hd__decap_40_12
XFILLER_37_777 vssd1 vccd1 vccd1 vssd1 SS_sky130_fd_sc_hd__fill_4
XTAP_TAPCELL_ROW_69_1342 vccd1 vssd1 SS_sky130_fd_sc_hd__tapvpwrvgnd_1
XFILLER_36_265 vssd1 vccd1 vssd1 vccd1 SS_sky130_ef_sc_hd__decap_40_12
XFILLER_52_725 vssd1 vccd1 vssd1 vccd1 SS_sky130_ef_sc_hd__decap_40_12
XTAP_TAPCELL_ROW_82_1531 vccd1 vssd1 SS_sky130_fd_sc_hd__tapvpwrvgnd_1
XFILLER_91_393 vssd1 vccd1 vssd1 vccd1 SS_sky130_ef_sc_hd__decap_40_12
XFILLER_51_279 vccd1 vssd1 vccd1 vssd1 SS_sky130_fd_sc_hd__fill_1
XTAP_TAPCELL_ROW_22_628 vccd1 vssd1 SS_sky130_fd_sc_hd__tapvpwrvgnd_1
X_0989_ vssd1 vccd1 vccd1 vssd1 _0989_/A2 input32/X _1527_/D wire467/X _0988_/X SS_sky130_fd_sc_hd__o211a_2
XFILLER_118_587 vccd1 vssd1 vccd1 vssd1 SS_sky130_fd_sc_hd__fill_1
XFILLER_105_237 vssd1 vccd1 vssd1 vccd1 SS_sky130_ef_sc_hd__decap_40_12
XFILLER_87_622 vssd1 vccd1 vssd1 vccd1 SS_sky130_ef_sc_hd__decap_40_12
XFILLER_121_719 vssd1 vccd1 vccd1 vssd1 SS_sky130_fd_sc_hd__fill_8
XTAP_TAPCELL_ROW_93_1693 vccd1 vssd1 SS_sky130_fd_sc_hd__tapvpwrvgnd_1
XFILLER_59_335 vccd1 vssd1 vccd1 vssd1 SS_sky130_fd_sc_hd__fill_1
XFILLER_86_121 vssd1 vccd1 vssd1 vccd1 SS_sky130_ef_sc_hd__decap_40_12
XFILLER_113_281 vssd1 vccd1 vccd1 vssd1 SS_sky130_fd_sc_hd__fill_8
XFILLER_101_410 vssd1 vccd1 vssd1 vccd1 SS_sky130_ef_sc_hd__decap_40_12
XFILLER_99_482 vssd1 vccd1 vccd1 vssd1 SS_sky130_fd_sc_hd__fill_4
XFILLER_74_305 vssd1 vccd1 vccd1 vssd1 SS_sky130_fd_sc_hd__fill_2
XFILLER_86_165 vssd1 vccd1 vssd1 vccd1 SS_sky130_ef_sc_hd__decap_40_12
XFILLER_101_465 vccd1 vssd1 vccd1 vssd1 SS_sky130_fd_sc_hd__fill_1
XTAP_TAPCELL_ROW_2_331 vccd1 vssd1 SS_sky130_fd_sc_hd__tapvpwrvgnd_1
XFILLER_47_69 vssd1 vccd1 vssd1 vccd1 SS_sky130_ef_sc_hd__decap_40_12
XPHY_EDGE_ROW_114_Right_114 vccd1 vssd1 vccd1 vssd1 SS_sky130_fd_sc_hd__decap_3
XFILLER_27_221 vssd1 vccd1 vccd1 vssd1 SS_sky130_fd_sc_hd__fill_2
XFILLER_103_42 vssd1 vccd1 vssd1 vccd1 SS_sky130_ef_sc_hd__decap_40_12
XFILLER_15_405 vssd1 vccd1 vssd1 vccd1 SS_sky130_ef_sc_hd__decap_40_12
XFILLER_55_585 vssd1 vccd1 vssd1 vccd1 SS_sky130_ef_sc_hd__decap_40_12
XFILLER_15_449 vssd1 vccd1 vssd1 vccd1 SS_sky130_ef_sc_hd__decap_40_12
XFILLER_63_57 vssd1 vccd1 vssd1 vccd1 SS_sky130_ef_sc_hd__decap_40_12
XFILLER_70_533 vssd1 vccd1 vssd1 vccd1 SS_sky130_ef_sc_hd__decap_40_12
XFILLER_30_419 vccd1 vssd1 vccd1 vssd1 SS_sky130_fd_sc_hd__fill_1
XTAP_TAPCELL_ROW_41_915 vccd1 vssd1 SS_sky130_fd_sc_hd__tapvpwrvgnd_1
XFILLER_7_615 vccd1 vssd1 vccd1 vssd1 SS_sky130_fd_sc_hd__fill_1
XFILLER_10_121 vssd1 vccd1 vssd1 vccd1 SS_sky130_ef_sc_hd__decap_40_12
XFILLER_10_165 vssd1 vccd1 vssd1 vccd1 SS_sky130_ef_sc_hd__decap_40_12
XFILLER_137_841 vccd1 vssd1 vccd1 vssd1 SS_sky130_fd_sc_hd__fill_1
XFILLER_3_821 vssd1 vccd1 vssd1 vccd1 SS_sky130_ef_sc_hd__decap_40_12
XFILLER_12_83 vccd1 vssd1 vccd1 vssd1 SS_sky130_fd_sc_hd__fill_1
XFILLER_136_373 vssd1 vccd1 vccd1 vssd1 SS_sky130_fd_sc_hd__fill_2
XFILLER_124_513 vssd1 vccd1 vssd1 vccd1 SS_sky130_ef_sc_hd__decap_40_12
XFILLER_109_598 vssd1 vccd1 vssd1 vccd1 SS_sky130_ef_sc_hd__decap_40_12
XFILLER_128_83 vccd1 vssd1 vccd1 vssd1 SS_sky130_fd_sc_hd__fill_1
XFILLER_124_557 vssd1 vccd1 vssd1 vccd1 SS_sky130_ef_sc_hd__decap_40_12
XFILLER_88_65 vssd1 vccd1 vssd1 vccd1 SS_sky130_ef_sc_hd__decap_40_12
XFILLER_105_760 vssd1 vccd1 vssd1 vccd1 SS_sky130_ef_sc_hd__decap_40_12
XFILLER_19_700 vssd1 vccd1 vccd1 vssd1 SS_sky130_fd_sc_hd__fill_2
XFILLER_65_305 vssd1 vccd1 vssd1 vccd1 SS_sky130_ef_sc_hd__decap_40_12
XFILLER_66_817 vssd1 vccd1 vccd1 vssd1 SS_sky130_fd_sc_hd__fill_2
XFILLER_77_165 vssd1 vccd1 vccd1 vssd1 SS_sky130_fd_sc_hd__fill_2
XFILLER_93_603 vssd1 vccd1 vssd1 vccd1 SS_sky130_ef_sc_hd__decap_40_12
XFILLER_78_699 vccd1 vssd1 vccd1 vssd1 SS_sky130_fd_sc_hd__fill_1
XFILLER_18_221 vssd1 vccd1 vssd1 vccd1 SS_sky130_ef_sc_hd__decap_40_12
XFILLER_65_349 vssd1 vccd1 vccd1 vssd1 SS_sky130_fd_sc_hd__fill_4
XFILLER_81_809 vssd1 vccd1 vccd1 vssd1 SS_sky130_fd_sc_hd__fill_4
XTAP_TAPCELL_ROW_109_1932 vccd1 vssd1 SS_sky130_fd_sc_hd__tapvpwrvgnd_1
XFILLER_18_265 vssd1 vccd1 vssd1 vccd1 SS_sky130_ef_sc_hd__decap_40_12
XFILLER_61_533 vssd1 vccd1 vssd1 vccd1 SS_sky130_ef_sc_hd__decap_40_12
XFILLER_73_393 vssd1 vccd1 vssd1 vccd1 SS_sky130_ef_sc_hd__decap_40_12
XFILLER_33_279 vccd1 vssd1 vccd1 vssd1 SS_sky130_fd_sc_hd__fill_1
XTAP_TAPCELL_ROW_64_1261 vccd1 vssd1 SS_sky130_fd_sc_hd__tapvpwrvgnd_1
X_0912_ vccd1 vssd1 vccd1 vssd1 _1661_/Q _1211_/A _1629_/Q _0927_/A2 _0913_/C SS_sky130_fd_sc_hd__a22o_2
X_1892_ vccd1 vssd1 _1892_/X _1892_/A vccd1 vssd1 SS_sky130_fd_sc_hd__buf_2
X_0843_ vccd1 vssd1 vccd1 vssd1 _1860_/A wire443/A _1682_/Q _0891_/B1 _0843_/X SS_sky130_fd_sc_hd__a22o_2
XFILLER_6_681 vssd1 vccd1 vssd1 vccd1 SS_sky130_ef_sc_hd__decap_40_12
X_0774_ vccd1 vssd1 vccd1 vssd1 _0773_/X _1638_/Q wire430/X _1894_/A wire448/X _0774_/X
+ SS_sky130_fd_sc_hd__a221o_2
XFILLER_127_373 vssd1 vccd1 vssd1 vccd1 SS_sky130_ef_sc_hd__decap_40_12
XFILLER_88_419 vccd1 vssd1 vccd1 vssd1 SS_sky130_fd_sc_hd__fill_1
XFILLER_68_121 vssd1 vccd1 vssd1 vccd1 SS_sky130_ef_sc_hd__decap_40_12
XFILLER_123_590 vssd1 vccd1 vssd1 vccd1 SS_sky130_ef_sc_hd__decap_40_12
XFILLER_56_305 vssd1 vccd1 vccd1 vssd1 SS_sky130_fd_sc_hd__fill_2
X_1326_ vccd1 vssd1 vccd1 vssd1 _1326_/X _1326_/A _1330_/B SS_sky130_fd_sc_hd__or2_2
XFILLER_110_251 vccd1 vssd1 vccd1 vssd1 SS_sky130_fd_sc_hd__fill_1
XFILLER_68_165 vssd1 vccd1 vssd1 vccd1 SS_sky130_ef_sc_hd__decap_40_12
XFILLER_83_113 vssd1 vccd1 vssd1 vccd1 SS_sky130_ef_sc_hd__decap_40_12
XFILLER_111_785 vssd1 vccd1 vssd1 vccd1 SS_sky130_ef_sc_hd__decap_40_12
XTAP_TAPCELL_ROW_27_709 vccd1 vssd1 SS_sky130_fd_sc_hd__tapvpwrvgnd_1
X_1257_ vssd1 vccd1 vccd1 vssd1 _1261_/A2 input34/X _1657_/D _1461_/C1 _1256_/X SS_sky130_fd_sc_hd__o211a_2
XFILLER_17_39 vssd1 vccd1 vssd1 vccd1 SS_sky130_ef_sc_hd__decap_40_12
XFILLER_25_725 vssd1 vccd1 vccd1 vssd1 SS_sky130_fd_sc_hd__fill_2
X_1188_ vccd1 vssd1 vccd1 vssd1 _1188_/X _1188_/A _1208_/B SS_sky130_fd_sc_hd__or2_2
XFILLER_25_736 vssd1 vccd1 vccd1 vssd1 SS_sky130_fd_sc_hd__fill_8
XFILLER_52_533 vssd1 vccd1 vccd1 vssd1 SS_sky130_fd_sc_hd__fill_4
XFILLER_12_419 vccd1 vssd1 vccd1 vssd1 SS_sky130_fd_sc_hd__fill_1
XFILLER_25_769 vssd1 vccd1 vssd1 vccd1 SS_sky130_ef_sc_hd__decap_40_12
XFILLER_138_649 vssd1 vccd1 vccd1 vssd1 SS_sky130_fd_sc_hd__fill_2
XFILLER_119_841 vccd1 vssd1 vccd1 vssd1 SS_sky130_fd_sc_hd__fill_1
XFILLER_137_159 vssd1 vccd1 vccd1 vssd1 SS_sky130_fd_sc_hd__fill_2
XTAP_TAPCELL_ROW_95_1722 vccd1 vssd1 SS_sky130_fd_sc_hd__tapvpwrvgnd_1
XFILLER_118_362 vssd1 vccd1 vccd1 vssd1 SS_sky130_fd_sc_hd__fill_2
XFILLER_0_813 vssd1 vccd1 vccd1 vssd1 SS_sky130_fd_sc_hd__fill_4
XTAP_TAPCELL_ROW_7_401 vccd1 vssd1 SS_sky130_fd_sc_hd__tapvpwrvgnd_1
XTAP_TAPCELL_ROW_7_412 vccd1 vssd1 SS_sky130_fd_sc_hd__tapvpwrvgnd_1
XFILLER_121_505 vssd1 vccd1 vssd1 vccd1 SS_sky130_ef_sc_hd__decap_40_12
XFILLER_102_741 vssd1 vccd1 vssd1 vccd1 SS_sky130_ef_sc_hd__decap_40_12
XFILLER_47_305 vssd1 vccd1 vssd1 vccd1 SS_sky130_ef_sc_hd__decap_40_12
XFILLER_59_165 vssd1 vccd1 vccd1 vssd1 SS_sky130_fd_sc_hd__fill_2
XFILLER_87_485 vssd1 vccd1 vccd1 vssd1 SS_sky130_fd_sc_hd__fill_4
XFILLER_114_41 vssd1 vccd1 vssd1 vccd1 SS_sky130_ef_sc_hd__decap_40_12
XFILLER_101_273 vssd1 vccd1 vccd1 vssd1 SS_sky130_fd_sc_hd__fill_4
XFILLER_47_349 vssd1 vccd1 vssd1 vccd1 SS_sky130_ef_sc_hd__decap_40_12
XFILLER_75_669 vssd1 vccd1 vccd1 vssd1 SS_sky130_fd_sc_hd__fill_2
XFILLER_114_85 vssd1 vccd1 vssd1 vccd1 SS_sky130_ef_sc_hd__decap_40_12
XFILLER_16_725 vssd1 vccd1 vssd1 vccd1 SS_sky130_ef_sc_hd__decap_40_12
XFILLER_28_585 vssd1 vccd1 vccd1 vssd1 SS_sky130_fd_sc_hd__fill_2
XTAP_TAPCELL_ROW_122_2129 vccd1 vssd1 SS_sky130_fd_sc_hd__tapvpwrvgnd_1
XFILLER_55_393 vssd1 vccd1 vssd1 vccd1 SS_sky130_ef_sc_hd__decap_40_12
XFILLER_16_769 vssd1 vccd1 vssd1 vccd1 SS_sky130_ef_sc_hd__decap_40_12
XFILLER_70_363 vccd1 vssd1 vccd1 vssd1 SS_sky130_fd_sc_hd__fill_1
XTAP_TAPCELL_ROW_104_1862 vccd1 vssd1 SS_sky130_fd_sc_hd__tapvpwrvgnd_1
XFILLER_15_279 vccd1 vssd1 vccd1 vssd1 SS_sky130_fd_sc_hd__fill_1
XFILLER_11_441 vssd1 vccd1 vccd1 vssd1 SS_sky130_fd_sc_hd__fill_4
XFILLER_30_249 vssd1 vccd1 vccd1 vssd1 SS_sky130_fd_sc_hd__fill_2
XFILLER_90_77 vssd1 vccd1 vccd1 vssd1 SS_sky130_fd_sc_hd__fill_4
Xwire310 vccd1 vssd1 vssd1 vccd1 wire310/A analog_ctrl[8] SS_sky130_fd_sc_hd__buf_12
Xwire332 vccd1 vssd1 vssd1 vccd1 wire332/A analog_ctrl[45] SS_sky130_fd_sc_hd__buf_12
Xwire321 vccd1 vssd1 vssd1 vccd1 wire321/A analog_ctrl[55] SS_sky130_fd_sc_hd__buf_12
XFILLER_128_137 vssd1 vccd1 vccd1 vssd1 SS_sky130_fd_sc_hd__fill_2
XTAP_TAPCELL_ROW_137_2361 vccd1 vssd1 SS_sky130_fd_sc_hd__tapvpwrvgnd_1
XTAP_TAPCELL_ROW_137_2350 vccd1 vssd1 SS_sky130_fd_sc_hd__tapvpwrvgnd_1
XFILLER_7_445 vssd1 vccd1 vccd1 vssd1 SS_sky130_fd_sc_hd__fill_2
XFILLER_11_485 vssd1 vccd1 vssd1 vccd1 SS_sky130_ef_sc_hd__decap_40_12
XFILLER_23_93 vssd1 vccd1 vssd1 vccd1 SS_sky130_ef_sc_hd__decap_40_12
Xwire343 vccd1 vssd1 vssd1 vccd1 wire343/A analog_ctrl[35] SS_sky130_fd_sc_hd__buf_12
Xwire354 vccd1 vssd1 vssd1 vccd1 wire354/A wbs_dat_o[8] SS_sky130_fd_sc_hd__buf_12
Xwire365 vccd1 vssd1 vssd1 vccd1 wire365/A wbs_dat_o[27] SS_sky130_fd_sc_hd__buf_12
Xwire376 vccd1 vssd1 vssd1 vccd1 wire376/A wbs_dat_o[17] SS_sky130_fd_sc_hd__buf_12
XFILLER_109_373 vssd1 vccd1 vssd1 vccd1 SS_sky130_ef_sc_hd__decap_40_12
Xwire387 vccd1 vssd1 vssd1 vccd1 wire387/A analog_ctrl[94] SS_sky130_fd_sc_hd__buf_12
Xwire398 vccd1 vssd1 vssd1 vccd1 wire398/A analog_ctrl[83] SS_sky130_fd_sc_hd__buf_12
XFILLER_124_321 vssd1 vccd1 vssd1 vccd1 SS_sky130_ef_sc_hd__decap_40_12
XFILLER_3_673 vssd1 vccd1 vssd1 vccd1 SS_sky130_ef_sc_hd__decap_40_12
XFILLER_124_365 vssd1 vccd1 vssd1 vccd1 SS_sky130_ef_sc_hd__decap_40_12
XFILLER_97_205 vssd1 vccd1 vssd1 vccd1 SS_sky130_ef_sc_hd__decap_40_12
XFILLER_97_249 vssd1 vccd1 vssd1 vccd1 SS_sky130_ef_sc_hd__decap_40_12
XFILLER_38_305 vssd1 vccd1 vccd1 vssd1 SS_sky130_fd_sc_hd__fill_2
XFILLER_65_113 vssd1 vccd1 vssd1 vccd1 SS_sky130_ef_sc_hd__decap_40_12
XFILLER_120_560 vssd1 vccd1 vssd1 vccd1 SS_sky130_ef_sc_hd__decap_40_12
XFILLER_19_541 vssd1 vccd1 vssd1 vccd1 SS_sky130_ef_sc_hd__decap_40_12
XFILLER_54_809 vssd1 vccd1 vccd1 vssd1 SS_sky130_fd_sc_hd__fill_2
XFILLER_66_669 vssd1 vccd1 vccd1 vssd1 SS_sky130_fd_sc_hd__fill_4
X_1111_ vssd1 vccd1 vccd1 vssd1 wire239/A input26/X _1586_/D _1309_/C1 _1110_/X SS_sky130_fd_sc_hd__o211a_2
XFILLER_0_53 vssd1 vccd1 vccd1 vssd1 SS_sky130_fd_sc_hd__fill_2
X_1042_ vccd1 vssd1 vccd1 vssd1 _1042_/X _1042_/A _1076_/B SS_sky130_fd_sc_hd__or2_2
XFILLER_81_617 vssd1 vccd1 vccd1 vssd1 SS_sky130_fd_sc_hd__fill_2
XFILLER_81_639 vssd1 vccd1 vssd1 vccd1 SS_sky130_ef_sc_hd__decap_40_12
XFILLER_19_585 vssd1 vccd1 vssd1 vccd1 SS_sky130_ef_sc_hd__decap_40_12
XFILLER_34_533 vssd1 vccd1 vccd1 vssd1 SS_sky130_fd_sc_hd__fill_4
XFILLER_34_566 vssd1 vccd1 vccd1 vssd1 SS_sky130_fd_sc_hd__fill_2
XFILLER_21_205 vssd1 vccd1 vssd1 vccd1 SS_sky130_ef_sc_hd__decap_40_12
XFILLER_9_51 vssd1 vccd1 vccd1 vssd1 SS_sky130_fd_sc_hd__fill_4
XFILLER_21_249 vssd1 vccd1 vssd1 vccd1 SS_sky130_ef_sc_hd__decap_40_12
XTAP_TAPCELL_ROW_32_778 vccd1 vssd1 SS_sky130_fd_sc_hd__tapvpwrvgnd_1
XTAP_TAPCELL_ROW_12_480 vccd1 vssd1 SS_sky130_fd_sc_hd__tapvpwrvgnd_1
XFILLER_30_794 vssd1 vccd1 vssd1 vccd1 SS_sky130_ef_sc_hd__decap_40_12
X_1875_ vccd1 vssd1 _1875_/X _1875_/A vccd1 vssd1 SS_sky130_fd_sc_hd__buf_2
XFILLER_119_137 vssd1 vccd1 vssd1 vccd1 SS_sky130_ef_sc_hd__decap_40_12
X_0826_ vccd1 vssd1 vccd1 vssd1 _1551_/Q _0754_/X _1711_/Q wire454/X _0826_/X SS_sky130_fd_sc_hd__a22o_2
X_0757_ vccd1 vssd1 vccd1 vssd1 _0757_/B _0757_/D _0943_/A _0757_/A _0757_/X SS_sky130_fd_sc_hd__or4_2
XTAP_TAPCELL_ROW_77_1452 vccd1 vssd1 SS_sky130_fd_sc_hd__tapvpwrvgnd_1
XFILLER_128_693 vssd1 vccd1 vccd1 vssd1 SS_sky130_fd_sc_hd__fill_4
XFILLER_127_181 vssd1 vccd1 vssd1 vccd1 SS_sky130_ef_sc_hd__decap_40_12
XFILLER_0_109 vssd1 vccd1 vccd1 vssd1 SS_sky130_fd_sc_hd__fill_2
XFILLER_103_505 vssd1 vccd1 vssd1 vccd1 SS_sky130_ef_sc_hd__decap_40_12
XFILLER_88_249 vssd1 vccd1 vccd1 vssd1 SS_sky130_fd_sc_hd__fill_2
XTAP_TAPCELL_ROW_90_1652 vccd1 vssd1 SS_sky130_fd_sc_hd__tapvpwrvgnd_1
XFILLER_69_441 vssd1 vccd1 vccd1 vssd1 SS_sky130_fd_sc_hd__fill_4
XFILLER_29_305 vssd1 vccd1 vssd1 vccd1 SS_sky130_ef_sc_hd__decap_40_12
XFILLER_57_614 vssd1 vccd1 vccd1 vssd1 SS_sky130_fd_sc_hd__fill_2
XFILLER_69_485 vssd1 vccd1 vssd1 vccd1 SS_sky130_ef_sc_hd__decap_40_12
XFILLER_97_783 vccd1 vssd1 vccd1 vssd1 SS_sky130_fd_sc_hd__fill_1
XFILLER_29_349 vssd1 vccd1 vssd1 vccd1 SS_sky130_ef_sc_hd__decap_40_12
XFILLER_57_669 vssd1 vccd1 vccd1 vssd1 SS_sky130_fd_sc_hd__fill_2
X_1309_ vssd1 vccd1 vccd1 vssd1 _1319_/A2 input26/X _1682_/D _1309_/C1 _1308_/X SS_sky130_fd_sc_hd__o211a_2
XFILLER_71_105 vssd1 vccd1 vccd1 vssd1 SS_sky130_fd_sc_hd__fill_4
XFILLER_72_606 vssd1 vccd1 vssd1 vccd1 SS_sky130_ef_sc_hd__decap_40_12
XFILLER_84_477 vssd1 vccd1 vssd1 vccd1 SS_sky130_ef_sc_hd__decap_40_12
XFILLER_37_393 vssd1 vccd1 vssd1 vccd1 SS_sky130_ef_sc_hd__decap_40_12
XFILLER_44_15 vssd1 vccd1 vssd1 vccd1 SS_sky130_ef_sc_hd__decap_40_12
XFILLER_71_149 vssd1 vccd1 vssd1 vccd1 SS_sky130_ef_sc_hd__decap_40_12
XFILLER_40_525 vssd1 vccd1 vccd1 vssd1 SS_sky130_fd_sc_hd__fill_4
XFILLER_52_363 vccd1 vssd1 vccd1 vssd1 SS_sky130_fd_sc_hd__fill_1
XFILLER_8_209 vssd1 vccd1 vssd1 vccd1 SS_sky130_ef_sc_hd__decap_40_12
XFILLER_12_249 vssd1 vccd1 vccd1 vssd1 SS_sky130_fd_sc_hd__fill_2
XFILLER_40_569 vssd1 vccd1 vssd1 vccd1 SS_sky130_ef_sc_hd__decap_40_12
XFILLER_21_783 vccd1 vssd1 vccd1 vssd1 SS_sky130_fd_sc_hd__fill_1
XFILLER_100_65 vssd1 vccd1 vssd1 vccd1 SS_sky130_ef_sc_hd__decap_40_12
XTAP_TAPCELL_ROW_119_2080 vccd1 vssd1 SS_sky130_fd_sc_hd__tapvpwrvgnd_1
XTAP_TAPCELL_ROW_119_2091 vccd1 vssd1 SS_sky130_fd_sc_hd__tapvpwrvgnd_1
XFILLER_119_671 vccd1 vssd1 vccd1 vssd1 SS_sky130_fd_sc_hd__fill_1
XFILLER_107_811 vssd1 vccd1 vssd1 vccd1 SS_sky130_ef_sc_hd__decap_40_12
XFILLER_134_641 vssd1 vccd1 vccd1 vssd1 SS_sky130_fd_sc_hd__fill_2
XFILLER_107_3 vssd1 vccd1 vssd1 vccd1 SS_sky130_ef_sc_hd__decap_40_12
XFILLER_79_205 vssd1 vccd1 vssd1 vccd1 SS_sky130_ef_sc_hd__decap_40_12
XTAP_TAPCELL_ROW_132_2280 vccd1 vssd1 SS_sky130_fd_sc_hd__tapvpwrvgnd_1
XFILLER_122_825 vccd1 vssd1 vccd1 vssd1 SS_sky130_fd_sc_hd__fill_1
XFILLER_106_365 vssd1 vccd1 vccd1 vssd1 SS_sky130_fd_sc_hd__fill_2
XFILLER_106_354 vssd1 vccd1 vccd1 vssd1 SS_sky130_fd_sc_hd__fill_8
XFILLER_79_249 vssd1 vccd1 vssd1 vccd1 SS_sky130_ef_sc_hd__decap_40_12
XFILLER_106_387 vssd1 vccd1 vssd1 vccd1 SS_sky130_ef_sc_hd__decap_40_12
XFILLER_0_643 vccd1 vssd1 vccd1 vssd1 SS_sky130_fd_sc_hd__fill_1
XFILLER_125_51 vssd1 vccd1 vccd1 vssd1 SS_sky130_fd_sc_hd__fill_4
XFILLER_121_346 vssd1 vccd1 vccd1 vssd1 SS_sky130_fd_sc_hd__fill_4
XFILLER_95_709 vssd1 vccd1 vssd1 vccd1 SS_sky130_ef_sc_hd__decap_40_12
XFILLER_47_113 vssd1 vccd1 vssd1 vccd1 SS_sky130_ef_sc_hd__decap_40_12
XFILLER_36_809 vssd1 vccd1 vccd1 vssd1 SS_sky130_fd_sc_hd__fill_2
XFILLER_48_669 vssd1 vccd1 vssd1 vccd1 SS_sky130_ef_sc_hd__decap_40_12
XFILLER_85_55 vccd1 vssd1 vccd1 vssd1 SS_sky130_fd_sc_hd__fill_1
XFILLER_87_293 vssd1 vccd1 vssd1 vccd1 SS_sky130_ef_sc_hd__decap_40_12
XFILLER_63_606 vssd1 vccd1 vccd1 vssd1 SS_sky130_fd_sc_hd__fill_8
XFILLER_63_617 vssd1 vccd1 vssd1 vccd1 SS_sky130_ef_sc_hd__decap_40_12
XFILLER_16_533 vssd1 vccd1 vssd1 vccd1 SS_sky130_ef_sc_hd__decap_40_12
XTAP_TAPCELL_ROW_48_1020 vccd1 vssd1 SS_sky130_fd_sc_hd__tapvpwrvgnd_1
XFILLER_90_469 vssd1 vccd1 vccd1 vssd1 SS_sky130_fd_sc_hd__fill_4
XFILLER_31_503 vccd1 vssd1 vccd1 vssd1 SS_sky130_fd_sc_hd__fill_1
XFILLER_43_385 vssd1 vccd1 vccd1 vssd1 SS_sky130_fd_sc_hd__fill_4
XFILLER_34_81 vssd1 vccd1 vccd1 vssd1 SS_sky130_fd_sc_hd__fill_2
XTAP_TAPCELL_ROW_61_1220 vccd1 vssd1 SS_sky130_fd_sc_hd__tapvpwrvgnd_1
XFILLER_70_193 vssd1 vccd1 vccd1 vssd1 SS_sky130_fd_sc_hd__fill_2
XFILLER_11_293 vssd1 vccd1 vssd1 vccd1 SS_sky130_ef_sc_hd__decap_40_12
XFILLER_129_446 vssd1 vccd1 vccd1 vssd1 SS_sky130_fd_sc_hd__fill_2
X_1660_ _1660_/Q _1724_/CLK _1660_/D vccd1 vssd1 vccd1 vssd1 SS_sky130_fd_sc_hd__dfxtp_2
X_1591_ _1865_/A clkload4/A _1591_/D vccd1 vssd1 vccd1 vssd1 SS_sky130_fd_sc_hd__dfxtp_2
XFILLER_125_641 vssd1 vccd1 vccd1 vssd1 SS_sky130_fd_sc_hd__fill_8
XFILLER_109_181 vssd1 vccd1 vssd1 vccd1 SS_sky130_ef_sc_hd__decap_40_12
XTAP_TAPCELL_ROW_59_1182 vccd1 vssd1 SS_sky130_fd_sc_hd__tapvpwrvgnd_1
XFILLER_125_685 vssd1 vccd1 vssd1 vccd1 SS_sky130_ef_sc_hd__decap_40_12
XFILLER_124_195 vccd1 vssd1 vccd1 vssd1 SS_sky130_fd_sc_hd__fill_1
XFILLER_98_569 vssd1 vccd1 vssd1 vccd1 SS_sky130_ef_sc_hd__decap_40_12
XPHY_EDGE_ROW_0_Left_139 vccd1 vssd1 vccd1 vssd1 SS_sky130_fd_sc_hd__decap_3
XFILLER_22_3 vssd1 vccd1 vssd1 vccd1 SS_sky130_ef_sc_hd__decap_40_12
XFILLER_39_614 vssd1 vccd1 vccd1 vssd1 SS_sky130_fd_sc_hd__fill_2
XTAP_TAPCELL_ROW_72_1382 vccd1 vssd1 SS_sky130_fd_sc_hd__tapvpwrvgnd_1
XFILLER_79_783 vccd1 vssd1 vccd1 vssd1 SS_sky130_fd_sc_hd__fill_1
XFILLER_112_379 vssd1 vccd1 vccd1 vssd1 SS_sky130_fd_sc_hd__fill_2
XFILLER_27_809 vssd1 vccd1 vccd1 vssd1 SS_sky130_fd_sc_hd__fill_4
XFILLER_39_669 vssd1 vccd1 vccd1 vssd1 SS_sky130_fd_sc_hd__fill_2
XFILLER_66_433 vssd1 vccd1 vssd1 vccd1 SS_sky130_ef_sc_hd__decap_40_12
XFILLER_53_105 vssd1 vccd1 vccd1 vssd1 SS_sky130_fd_sc_hd__fill_4
XFILLER_66_477 vssd1 vccd1 vssd1 vccd1 SS_sky130_ef_sc_hd__decap_40_12
XFILLER_94_786 vccd1 vssd1 vccd1 vssd1 SS_sky130_fd_sc_hd__fill_1
XFILLER_19_393 vssd1 vccd1 vssd1 vccd1 SS_sky130_ef_sc_hd__decap_40_12
XTAP_TAPCELL_ROW_37_848 vccd1 vssd1 SS_sky130_fd_sc_hd__tapvpwrvgnd_1
XFILLER_81_447 vccd1 vssd1 vccd1 vssd1 SS_sky130_fd_sc_hd__fill_1
X_1025_ vssd1 vccd1 vccd1 vssd1 _1033_/A2 input47/X _1544_/D _1099_/C1 _1024_/X SS_sky130_fd_sc_hd__o211a_2
XTAP_TAPCELL_ROW_37_859 vccd1 vssd1 SS_sky130_fd_sc_hd__tapvpwrvgnd_1
XFILLER_53_149 vssd1 vccd1 vssd1 vccd1 SS_sky130_ef_sc_hd__decap_40_12
XTAP_TAPCELL_ROW_17_550 vccd1 vssd1 SS_sky130_fd_sc_hd__tapvpwrvgnd_1
XTAP_TAPCELL_ROW_17_561 vccd1 vssd1 SS_sky130_fd_sc_hd__tapvpwrvgnd_1
XFILLER_22_525 vssd1 vccd1 vccd1 vssd1 SS_sky130_fd_sc_hd__fill_4
XFILLER_34_363 vccd1 vssd1 vccd1 vssd1 SS_sky130_fd_sc_hd__fill_1
XFILLER_14_29 vssd1 vccd1 vssd1 vccd1 SS_sky130_ef_sc_hd__decap_40_12
XFILLER_22_569 vssd1 vccd1 vssd1 vccd1 SS_sky130_ef_sc_hd__decap_40_12
XFILLER_61_193 vssd1 vccd1 vssd1 vccd1 SS_sky130_ef_sc_hd__decap_40_12
X_1858_ vccd1 vssd1 _1858_/X _1858_/A vccd1 vssd1 SS_sky130_fd_sc_hd__buf_2
XFILLER_135_405 vssd1 vccd1 vccd1 vssd1 SS_sky130_fd_sc_hd__fill_4
X_0809_ vccd1 vssd1 vccd1 vssd1 _1676_/Q wire448/X _1887_/A wire454/X _0809_/X SS_sky130_fd_sc_hd__a22o_2
XFILLER_135_449 vssd1 vccd1 vccd1 vssd1 SS_sky130_fd_sc_hd__fill_8
Xhold721 _1458_/A _1755_/Q vccd1 vssd1 vssd1 vccd1 SS_sky130_fd_sc_hd__dlygate4sd3_1
Xhold710 _1402_/A _1728_/Q vccd1 vssd1 vssd1 vccd1 SS_sky130_fd_sc_hd__dlygate4sd3_1
Xhold754 _1116_/A _1863_/A vccd1 vssd1 vssd1 vccd1 SS_sky130_fd_sc_hd__dlygate4sd3_1
Xhold743 input32/A wbs_dat_i[20] vccd1 vssd1 vssd1 vccd1 SS_sky130_fd_sc_hd__dlygate4sd3_1
Xhold732 input29/A wbs_dat_i[18] vccd1 vssd1 vssd1 vccd1 SS_sky130_fd_sc_hd__dlygate4sd3_1
XFILLER_1_429 vssd1 vccd1 vssd1 vccd1 SS_sky130_ef_sc_hd__decap_40_12
XFILLER_39_15 vssd1 vccd1 vssd1 vccd1 SS_sky130_ef_sc_hd__decap_40_12
Xhold765 _1172_/A _1876_/A vccd1 vssd1 vssd1 vccd1 SS_sky130_fd_sc_hd__dlygate4sd3_1
Xhold787 hold787/X _0740_/X vccd1 vssd1 vssd1 vccd1 SS_sky130_fd_sc_hd__dlygate4sd3_1
Xhold776 _1192_/A _1626_/Q vccd1 vssd1 vssd1 vccd1 SS_sky130_fd_sc_hd__dlygate4sd3_1
XFILLER_77_709 vssd1 vccd1 vssd1 vccd1 SS_sky130_ef_sc_hd__decap_40_12
XFILLER_89_569 vssd1 vccd1 vccd1 vssd1 SS_sky130_fd_sc_hd__fill_2
XFILLER_130_121 vssd1 vccd1 vssd1 vccd1 SS_sky130_ef_sc_hd__decap_40_12
Xhold798 hold798/X _1504_/Q vccd1 vssd1 vssd1 vccd1 SS_sky130_fd_sc_hd__dlygate4sd3_1
XFILLER_103_357 vssd1 vccd1 vssd1 vccd1 SS_sky130_ef_sc_hd__decap_40_12
XFILLER_130_165 vssd1 vccd1 vssd1 vccd1 SS_sky130_ef_sc_hd__decap_40_12
XFILLER_29_113 vssd1 vccd1 vssd1 vccd1 SS_sky130_ef_sc_hd__decap_40_12
XFILLER_69_293 vssd1 vccd1 vssd1 vccd1 SS_sky130_ef_sc_hd__decap_40_12
XFILLER_45_617 vssd1 vccd1 vssd1 vccd1 SS_sky130_ef_sc_hd__decap_40_12
XFILLER_55_69 vssd1 vccd1 vssd1 vccd1 SS_sky130_ef_sc_hd__decap_40_12
XFILLER_41_801 vssd1 vccd1 vccd1 vssd1 SS_sky130_fd_sc_hd__fill_2
XFILLER_13_503 vccd1 vssd1 vccd1 vssd1 SS_sky130_fd_sc_hd__fill_1
XFILLER_25_385 vssd1 vccd1 vccd1 vssd1 SS_sky130_fd_sc_hd__fill_4
XFILLER_111_42 vssd1 vccd1 vssd1 vccd1 SS_sky130_ef_sc_hd__decap_40_12
XFILLER_40_333 vssd1 vccd1 vssd1 vccd1 SS_sky130_ef_sc_hd__decap_40_12
XFILLER_52_193 vssd1 vccd1 vccd1 vssd1 SS_sky130_fd_sc_hd__fill_2
XTAP_TAPCELL_ROW_101_1821 vccd1 vssd1 SS_sky130_fd_sc_hd__tapvpwrvgnd_1
XTAP_TAPCELL_ROW_101_1810 vccd1 vssd1 SS_sky130_fd_sc_hd__tapvpwrvgnd_1
XFILLER_9_529 vssd1 vccd1 vssd1 vccd1 SS_sky130_ef_sc_hd__decap_40_12
XFILLER_40_377 vssd1 vccd1 vssd1 vccd1 SS_sky130_ef_sc_hd__decap_40_12
XFILLER_71_57 vssd1 vccd1 vssd1 vccd1 SS_sky130_ef_sc_hd__decap_40_12
XFILLER_138_221 vssd1 vccd1 vccd1 vssd1 SS_sky130_fd_sc_hd__fill_2
XFILLER_107_641 vssd1 vccd1 vssd1 vccd1 SS_sky130_ef_sc_hd__decap_40_12
XFILLER_4_245 vssd1 vccd1 vccd1 vssd1 SS_sky130_fd_sc_hd__fill_4
XFILLER_4_289 vssd1 vccd1 vssd1 vccd1 SS_sky130_ef_sc_hd__decap_40_12
XFILLER_20_83 vccd1 vssd1 vccd1 vssd1 SS_sky130_fd_sc_hd__fill_1
XFILLER_68_709 vssd1 vccd1 vssd1 vccd1 SS_sky130_ef_sc_hd__decap_40_12
XFILLER_136_72 vssd1 vccd1 vssd1 vccd1 SS_sky130_ef_sc_hd__decap_40_12
XFILLER_106_195 vccd1 vssd1 vccd1 vssd1 SS_sky130_fd_sc_hd__fill_1
XFILLER_0_473 vssd1 vccd1 vccd1 vssd1 SS_sky130_fd_sc_hd__fill_2
XFILLER_122_699 vccd1 vssd1 vccd1 vssd1 SS_sky130_fd_sc_hd__fill_1
XFILLER_121_165 vssd1 vccd1 vccd1 vssd1 SS_sky130_fd_sc_hd__fill_2
XTAP_TAPCELL_ROW_112_1983 vccd1 vssd1 SS_sky130_fd_sc_hd__tapvpwrvgnd_1
XFILLER_96_65 vssd1 vccd1 vssd1 vccd1 SS_sky130_ef_sc_hd__decap_40_12
XFILLER_95_517 vccd1 vssd1 vccd1 vssd1 SS_sky130_fd_sc_hd__fill_1
XFILLER_48_433 vssd1 vccd1 vssd1 vccd1 SS_sky130_ef_sc_hd__decap_40_12
XFILLER_29_81 vssd1 vccd1 vssd1 vccd1 SS_sky130_ef_sc_hd__decap_40_12
XFILLER_48_477 vssd1 vccd1 vssd1 vccd1 SS_sky130_ef_sc_hd__decap_40_12
XFILLER_63_403 vssd1 vccd1 vssd1 vccd1 SS_sky130_ef_sc_hd__decap_40_12
XFILLER_35_105 vssd1 vccd1 vccd1 vssd1 SS_sky130_fd_sc_hd__fill_4
XFILLER_63_436 vssd1 vccd1 vccd1 vssd1 SS_sky130_fd_sc_hd__fill_2
XFILLER_91_756 vssd1 vccd1 vssd1 vccd1 SS_sky130_ef_sc_hd__decap_40_12
XTAP_TAPCELL_ROW_34_807 vccd1 vssd1 SS_sky130_fd_sc_hd__tapvpwrvgnd_1
XFILLER_35_149 vssd1 vccd1 vssd1 vccd1 SS_sky130_ef_sc_hd__decap_40_12
XFILLER_90_233 vssd1 vccd1 vssd1 vccd1 SS_sky130_ef_sc_hd__decap_40_12
XFILLER_16_363 vccd1 vssd1 vccd1 vssd1 SS_sky130_fd_sc_hd__fill_1
XFILLER_90_277 vssd1 vccd1 vssd1 vccd1 SS_sky130_ef_sc_hd__decap_40_12
XFILLER_31_333 vssd1 vccd1 vccd1 vssd1 SS_sky130_fd_sc_hd__fill_2
XFILLER_43_193 vssd1 vccd1 vssd1 vccd1 SS_sky130_ef_sc_hd__decap_40_12
XFILLER_91_6 vssd1 vccd1 vssd1 vccd1 SS_sky130_ef_sc_hd__decap_40_12
XFILLER_129_221 vssd1 vccd1 vccd1 vssd1 SS_sky130_fd_sc_hd__fill_2
X_1712_ _1712_/Q _1748_/CLK _1712_/D vccd1 vssd1 vccd1 vssd1 SS_sky130_fd_sc_hd__dfxtp_2
XFILLER_6_41 vssd1 vccd1 vssd1 vccd1 SS_sky130_ef_sc_hd__decap_40_12
XANTENNA_1 _1856_/X vssd1 vccd1 vccd1 vssd1 SS_sky130_fd_sc_hd__diode_2
X_1643_ _1643_/Q _1751_/CLK _1643_/D vccd1 vssd1 vccd1 vssd1 SS_sky130_fd_sc_hd__dfxtp_2
XFILLER_117_449 vssd1 vccd1 vccd1 vssd1 SS_sky130_fd_sc_hd__fill_4
XFILLER_6_85 vssd1 vccd1 vssd1 vccd1 SS_sky130_ef_sc_hd__decap_40_12
XTAP_TAPCELL_ROW_74_1411 vccd1 vssd1 SS_sky130_fd_sc_hd__tapvpwrvgnd_1
X_1574_ _1844_/A _1576_/CLK _1574_/D vccd1 vssd1 vccd1 vssd1 SS_sky130_fd_sc_hd__dfxtp_2
XFILLER_125_471 vccd1 vssd1 vccd1 vssd1 SS_sky130_fd_sc_hd__fill_1
XFILLER_112_121 vssd1 vccd1 vssd1 vccd1 SS_sky130_ef_sc_hd__decap_40_12
XFILLER_98_333 vssd1 vccd1 vssd1 vccd1 SS_sky130_ef_sc_hd__decap_40_12
XFILLER_112_165 vssd1 vccd1 vssd1 vccd1 SS_sky130_ef_sc_hd__decap_40_12
XFILLER_100_305 vssd1 vccd1 vccd1 vssd1 SS_sky130_fd_sc_hd__fill_2
XFILLER_98_399 vssd1 vccd1 vssd1 vccd1 SS_sky130_ef_sc_hd__decap_40_12
XFILLER_67_753 vssd1 vccd1 vssd1 vccd1 SS_sky130_ef_sc_hd__decap_40_12
XFILLER_27_617 vssd1 vccd1 vssd1 vccd1 SS_sky130_ef_sc_hd__decap_40_12
XFILLER_82_701 vssd1 vccd1 vccd1 vssd1 SS_sky130_fd_sc_hd__fill_8
XFILLER_94_550 vssd1 vccd1 vssd1 vccd1 SS_sky130_ef_sc_hd__decap_40_12
XFILLER_67_797 vssd1 vccd1 vssd1 vccd1 SS_sky130_ef_sc_hd__decap_40_12
XFILLER_54_469 vssd1 vccd1 vccd1 vssd1 SS_sky130_fd_sc_hd__fill_4
XFILLER_25_39 vssd1 vccd1 vssd1 vccd1 SS_sky130_ef_sc_hd__decap_40_12
XFILLER_81_277 vssd1 vccd1 vccd1 vssd1 SS_sky130_fd_sc_hd__fill_2
XTAP_TAPCELL_ROW_85_1573 vccd1 vssd1 SS_sky130_fd_sc_hd__tapvpwrvgnd_1
X_1008_ vccd1 vssd1 vccd1 vssd1 _1008_/X _1008_/A _1008_/B SS_sky130_fd_sc_hd__or2_2
XFILLER_22_333 vssd1 vccd1 vssd1 vccd1 SS_sky130_ef_sc_hd__decap_40_12
XFILLER_34_193 vssd1 vccd1 vccd1 vssd1 SS_sky130_fd_sc_hd__fill_2
XFILLER_22_377 vssd1 vccd1 vssd1 vccd1 SS_sky130_ef_sc_hd__decap_40_12
XFILLER_50_653 vssd1 vccd1 vccd1 vssd1 SS_sky130_fd_sc_hd__fill_2
XFILLER_50_697 vssd1 vccd1 vccd1 vssd1 SS_sky130_fd_sc_hd__fill_2
XFILLER_135_279 vccd1 vssd1 vccd1 vssd1 SS_sky130_fd_sc_hd__fill_1
XFILLER_2_749 vssd1 vccd1 vccd1 vssd1 SS_sky130_fd_sc_hd__fill_4
XFILLER_1_237 vssd1 vccd1 vssd1 vccd1 SS_sky130_ef_sc_hd__decap_40_12
Xhold595 _1102_/A _1856_/A vccd1 vssd1 vssd1 vccd1 SS_sky130_fd_sc_hd__dlygate4sd3_1
Xhold573 _0964_/A _1515_/Q vccd1 vssd1 vssd1 vccd1 SS_sky130_fd_sc_hd__dlygate4sd3_1
Xhold584 input31/A wbs_dat_i[1] vccd1 vssd1 vssd1 vccd1 SS_sky130_fd_sc_hd__dlygate4sd3_1
XFILLER_77_517 vssd1 vccd1 vssd1 vccd1 SS_sky130_ef_sc_hd__decap_40_12
XFILLER_131_485 vssd1 vccd1 vccd1 vssd1 SS_sky130_fd_sc_hd__fill_2
XFILLER_106_53 vssd1 vccd1 vssd1 vccd1 SS_sky130_ef_sc_hd__decap_40_12
XFILLER_104_699 vccd1 vssd1 vccd1 vssd1 SS_sky130_fd_sc_hd__fill_1
XFILLER_103_165 vssd1 vccd1 vccd1 vssd1 SS_sky130_fd_sc_hd__fill_2
XFILLER_58_753 vssd1 vccd1 vccd1 vssd1 SS_sky130_fd_sc_hd__fill_2
XFILLER_106_97 vssd1 vccd1 vssd1 vccd1 SS_sky130_ef_sc_hd__decap_40_12
XFILLER_17_105 vssd1 vccd1 vccd1 vssd1 SS_sky130_fd_sc_hd__fill_4
XFILLER_45_425 vssd1 vccd1 vccd1 vssd1 SS_sky130_fd_sc_hd__fill_4
XFILLER_122_41 vssd1 vccd1 vssd1 vccd1 SS_sky130_ef_sc_hd__decap_40_12
XFILLER_17_149 vssd1 vccd1 vssd1 vccd1 SS_sky130_ef_sc_hd__decap_40_12
XFILLER_33_609 vssd1 vccd1 vccd1 vssd1 SS_sky130_fd_sc_hd__fill_4
XFILLER_45_469 vssd1 vccd1 vssd1 vccd1 SS_sky130_ef_sc_hd__decap_40_12
XFILLER_72_233 vssd1 vccd1 vssd1 vccd1 SS_sky130_ef_sc_hd__decap_40_12
XTAP_TAPCELL_ROW_0_281 vccd1 vssd1 SS_sky130_fd_sc_hd__tapvpwrvgnd_1
XFILLER_72_277 vssd1 vccd1 vssd1 vccd1 SS_sky130_ef_sc_hd__decap_40_12
XFILLER_122_85 vssd1 vccd1 vssd1 vccd1 SS_sky130_ef_sc_hd__decap_40_12
XTAP_TAPCELL_ROW_0_292 vccd1 vssd1 SS_sky130_fd_sc_hd__tapvpwrvgnd_1
XFILLER_13_333 vssd1 vccd1 vccd1 vssd1 SS_sky130_fd_sc_hd__fill_2
XFILLER_25_193 vssd1 vccd1 vssd1 vccd1 SS_sky130_ef_sc_hd__decap_40_12
XFILLER_40_141 vssd1 vccd1 vssd1 vccd1 SS_sky130_ef_sc_hd__decap_40_12
XFILLER_9_337 vssd1 vccd1 vssd1 vccd1 SS_sky130_ef_sc_hd__decap_40_12
XFILLER_41_697 vssd1 vccd1 vssd1 vccd1 SS_sky130_ef_sc_hd__decap_40_12
XFILLER_127_725 vssd1 vccd1 vccd1 vssd1 SS_sky130_fd_sc_hd__fill_2
XFILLER_31_93 vssd1 vccd1 vssd1 vccd1 SS_sky130_ef_sc_hd__decap_40_12
XTAP_TAPCELL_ROW_56_1141 vccd1 vssd1 SS_sky130_fd_sc_hd__tapvpwrvgnd_1
XPHY_EDGE_ROW_128_Right_128 vccd1 vssd1 vccd1 vssd1 SS_sky130_fd_sc_hd__decap_3
XFILLER_114_419 vccd1 vssd1 vccd1 vssd1 SS_sky130_fd_sc_hd__fill_1
Xoutput60 vccd1 vssd1 wire300/A _1896_/X vccd1 vssd1 SS_sky130_fd_sc_hd__buf_4
Xoutput82 vccd1 vssd1 wire278/A _1843_/X vccd1 vssd1 SS_sky130_fd_sc_hd__buf_4
Xoutput93 vccd1 vssd1 wire267/A _1853_/X vccd1 vssd1 SS_sky130_fd_sc_hd__buf_4
Xoutput71 vccd1 vssd1 wire289/A _1906_/X vccd1 vssd1 SS_sky130_fd_sc_hd__buf_4
XFILLER_122_474 vssd1 vccd1 vccd1 vssd1 SS_sky130_fd_sc_hd__fill_2
XFILLER_110_625 vssd1 vccd1 vssd1 vccd1 SS_sky130_ef_sc_hd__decap_40_12
XFILLER_0_281 vssd1 vccd1 vccd1 vssd1 SS_sky130_fd_sc_hd__fill_8
X_1290_ vccd1 vssd1 vccd1 vssd1 _1290_/X _1290_/A _1338_/B SS_sky130_fd_sc_hd__or2_2
XFILLER_64_701 vssd1 vccd1 vssd1 vccd1 SS_sky130_ef_sc_hd__decap_40_12
XFILLER_64_745 vssd1 vccd1 vccd1 vssd1 SS_sky130_fd_sc_hd__fill_2
XFILLER_36_469 vssd1 vccd1 vccd1 vssd1 SS_sky130_fd_sc_hd__fill_4
XPHY_EDGE_ROW_90_Left_229 vccd1 vssd1 vccd1 vssd1 SS_sky130_fd_sc_hd__decap_3
XFILLER_91_553 vssd1 vccd1 vccd1 vssd1 SS_sky130_fd_sc_hd__fill_4
XTAP_TAPCELL_ROW_47_998 vccd1 vssd1 SS_sky130_fd_sc_hd__tapvpwrvgnd_1
XFILLER_63_277 vssd1 vccd1 vccd1 vssd1 SS_sky130_fd_sc_hd__fill_2
XFILLER_91_597 vccd1 vssd1 vccd1 vssd1 SS_sky130_fd_sc_hd__fill_1
XFILLER_16_193 vssd1 vccd1 vccd1 vssd1 SS_sky130_fd_sc_hd__fill_2
XFILLER_20_815 vccd1 vssd1 vccd1 vssd1 SS_sky130_fd_sc_hd__fill_1
XFILLER_32_686 vssd1 vccd1 vssd1 vccd1 SS_sky130_ef_sc_hd__decap_40_12
XFILLER_118_725 vssd1 vccd1 vssd1 vccd1 SS_sky130_ef_sc_hd__decap_40_12
XFILLER_118_747 vccd1 vssd1 vccd1 vssd1 SS_sky130_fd_sc_hd__fill_1
XFILLER_133_706 vssd1 vccd1 vccd1 vssd1 SS_sky130_fd_sc_hd__fill_8
XFILLER_117_279 vccd1 vssd1 vccd1 vssd1 SS_sky130_fd_sc_hd__fill_1
X_1626_ _1626_/Q _1747_/CLK _1626_/D vccd1 vssd1 vccd1 vssd1 SS_sky130_fd_sc_hd__dfxtp_2
X_1557_ _1557_/Q clkload2/A _1557_/D vccd1 vssd1 vccd1 vssd1 SS_sky130_fd_sc_hd__dfxtp_2
XFILLER_132_249 vssd1 vccd1 vccd1 vssd1 SS_sky130_fd_sc_hd__fill_2
XFILLER_113_441 vssd1 vccd1 vccd1 vssd1 SS_sky130_fd_sc_hd__fill_4
XFILLER_99_653 vssd1 vccd1 vccd1 vssd1 SS_sky130_fd_sc_hd__fill_8
XFILLER_59_517 vssd1 vccd1 vssd1 vccd1 SS_sky130_ef_sc_hd__decap_40_12
XFILLER_98_141 vssd1 vccd1 vssd1 vccd1 SS_sky130_ef_sc_hd__decap_40_12
X_1488_ _1488_/Q clkload5/A _1488_/D vccd1 vssd1 vccd1 vssd1 SS_sky130_fd_sc_hd__dfxtp_2
XFILLER_113_485 vssd1 vccd1 vssd1 vccd1 SS_sky130_ef_sc_hd__decap_40_12
XFILLER_67_550 vssd1 vccd1 vccd1 vssd1 SS_sky130_fd_sc_hd__fill_8
XFILLER_67_561 vssd1 vccd1 vssd1 vccd1 SS_sky130_ef_sc_hd__decap_40_12
XTAP_TAPCELL_ROW_87_1602 vccd1 vssd1 SS_sky130_fd_sc_hd__tapvpwrvgnd_1
XPHY_EDGE_ROW_129_Left_268 vccd1 vssd1 vccd1 vssd1 SS_sky130_fd_sc_hd__decap_3
XFILLER_15_609 vssd1 vccd1 vccd1 vssd1 SS_sky130_fd_sc_hd__fill_4
XFILLER_27_447 vccd1 vssd1 vccd1 vssd1 SS_sky130_fd_sc_hd__fill_1
XFILLER_54_233 vssd1 vccd1 vssd1 vccd1 SS_sky130_ef_sc_hd__decap_40_12
XFILLER_82_531 vccd1 vssd1 vccd1 vssd1 SS_sky130_fd_sc_hd__fill_1
XFILLER_42_417 vssd1 vccd1 vccd1 vssd1 SS_sky130_fd_sc_hd__fill_2
XFILLER_54_277 vssd1 vccd1 vssd1 vccd1 SS_sky130_ef_sc_hd__decap_40_12
XFILLER_70_737 vssd1 vccd1 vccd1 vssd1 SS_sky130_fd_sc_hd__fill_2
XFILLER_52_15 vssd1 vccd1 vssd1 vccd1 SS_sky130_ef_sc_hd__decap_40_12
XFILLER_22_141 vssd1 vccd1 vssd1 vccd1 SS_sky130_ef_sc_hd__decap_40_12
XFILLER_50_483 vssd1 vccd1 vssd1 vccd1 SS_sky130_ef_sc_hd__decap_40_12
XFILLER_6_307 vccd1 vssd1 vccd1 vssd1 SS_sky130_fd_sc_hd__fill_1
XPHY_EDGE_ROW_138_Left_277 vccd1 vssd1 vccd1 vssd1 SS_sky130_fd_sc_hd__decap_3
XFILLER_136_533 vssd1 vccd1 vccd1 vssd1 SS_sky130_fd_sc_hd__fill_2
XTAP_TAPCELL_ROW_114_2009 vccd1 vssd1 SS_sky130_fd_sc_hd__tapvpwrvgnd_1
XTAP_TAPCELL_ROW_98_1764 vccd1 vssd1 SS_sky130_fd_sc_hd__tapvpwrvgnd_1
XTAP_TAPCELL_ROW_98_1775 vccd1 vssd1 SS_sky130_fd_sc_hd__tapvpwrvgnd_1
XFILLER_2_513 vssd1 vccd1 vssd1 vccd1 SS_sky130_ef_sc_hd__decap_40_12
XFILLER_123_205 vssd1 vccd1 vssd1 vccd1 SS_sky130_ef_sc_hd__decap_40_12
XFILLER_2_557 vssd1 vccd1 vssd1 vccd1 SS_sky130_ef_sc_hd__decap_40_12
XFILLER_123_249 vssd1 vccd1 vssd1 vccd1 SS_sky130_ef_sc_hd__decap_40_12
XFILLER_104_474 vssd1 vccd1 vccd1 vssd1 SS_sky130_fd_sc_hd__fill_2
XTAP_TAPCELL_ROW_129_2230 vccd1 vssd1 SS_sky130_fd_sc_hd__tapvpwrvgnd_1
XTAP_TAPCELL_ROW_129_2241 vccd1 vssd1 SS_sky130_fd_sc_hd__tapvpwrvgnd_1
XFILLER_131_293 vssd1 vccd1 vccd1 vssd1 SS_sky130_fd_sc_hd__fill_2
XTAP_TAPCELL_ROW_5_373 vccd1 vssd1 SS_sky130_fd_sc_hd__tapvpwrvgnd_1
XFILLER_46_701 vssd1 vccd1 vssd1 vccd1 SS_sky130_ef_sc_hd__decap_40_12
XTAP_TAPCELL_ROW_51_1060 vccd1 vssd1 SS_sky130_fd_sc_hd__tapvpwrvgnd_1
XTAP_TAPCELL_ROW_51_1071 vccd1 vssd1 SS_sky130_fd_sc_hd__tapvpwrvgnd_1
XFILLER_100_680 vccd1 vssd1 vccd1 vssd1 SS_sky130_fd_sc_hd__fill_1
XFILLER_18_469 vssd1 vccd1 vccd1 vssd1 SS_sky130_fd_sc_hd__fill_4
XFILLER_33_417 vssd1 vccd1 vssd1 vccd1 SS_sky130_ef_sc_hd__decap_40_12
XFILLER_45_277 vssd1 vccd1 vccd1 vssd1 SS_sky130_fd_sc_hd__fill_2
XTAP_TAPCELL_ROW_44_957 vccd1 vssd1 SS_sky130_fd_sc_hd__tapvpwrvgnd_1
XFILLER_14_697 vssd1 vccd1 vccd1 vssd1 SS_sky130_fd_sc_hd__fill_2
XFILLER_41_461 vssd1 vccd1 vccd1 vssd1 SS_sky130_fd_sc_hd__fill_8
Xclkbuf_leaf_11_wb_clk_i _1760_/CLK clkbuf_leaf_7_wb_clk_i/A vccd1 vssd1 vssd1 vccd1
+ SS_sky130_fd_sc_hd__clkbuf_8
XFILLER_9_167 vccd1 vssd1 vccd1 vssd1 SS_sky130_fd_sc_hd__fill_1
XFILLER_42_81 vssd1 vccd1 vccd1 vssd1 SS_sky130_fd_sc_hd__fill_2
X_0790_ vccd1 vssd1 vccd1 vssd1 _0789_/X _1901_/A wire435/A _1869_/A _0828_/B1 _0790_/X
+ SS_sky130_fd_sc_hd__a221o_2
XFILLER_115_706 vssd1 vccd1 vssd1 vccd1 SS_sky130_ef_sc_hd__decap_40_12
XFILLER_5_373 vssd1 vccd1 vssd1 vccd1 SS_sky130_ef_sc_hd__decap_40_12
XFILLER_127_599 vssd1 vccd1 vccd1 vssd1 SS_sky130_fd_sc_hd__fill_2
X_1411_ vssd1 vccd1 vccd1 vssd1 _1439_/A2 input20/X _1731_/D _1417_/C1 _1410_/X SS_sky130_fd_sc_hd__o211a_2
XFILLER_114_249 vssd1 vccd1 vccd1 vssd1 SS_sky130_fd_sc_hd__fill_2
XFILLER_123_783 vccd1 vssd1 vccd1 vssd1 SS_sky130_fd_sc_hd__fill_1
XFILLER_3_42 vssd1 vccd1 vssd1 vccd1 SS_sky130_ef_sc_hd__decap_40_12
X_1342_ vccd1 vssd1 _1343_/A _1406_/B _1409_/B vccd1 vssd1 SS_sky130_fd_sc_hd__and2_2
XFILLER_110_411 vccd1 vssd1 vccd1 vssd1 SS_sky130_fd_sc_hd__fill_1
XFILLER_96_645 vssd1 vccd1 vssd1 vccd1 SS_sky130_ef_sc_hd__decap_40_12
XFILLER_95_111 vccd1 vssd1 vccd1 vssd1 SS_sky130_fd_sc_hd__fill_1
XFILLER_49_561 vssd1 vccd1 vssd1 vccd1 SS_sky130_ef_sc_hd__decap_40_12
X_1273_ vssd1 vccd1 vccd1 vssd1 _1273_/A2 input43/X _1665_/D _1473_/C1 _1272_/X SS_sky130_fd_sc_hd__o211a_2
XFILLER_83_328 vssd1 vccd1 vccd1 vssd1 SS_sky130_fd_sc_hd__fill_8
XFILLER_110_477 vssd1 vccd1 vccd1 vssd1 SS_sky130_fd_sc_hd__fill_4
XFILLER_36_233 vssd1 vccd1 vssd1 vccd1 SS_sky130_ef_sc_hd__decap_40_12
XFILLER_64_553 vssd1 vccd1 vccd1 vssd1 SS_sky130_fd_sc_hd__fill_2
XTAP_TAPCELL_ROW_69_1332 vccd1 vssd1 SS_sky130_fd_sc_hd__tapvpwrvgnd_1
XFILLER_24_417 vssd1 vccd1 vccd1 vssd1 SS_sky130_fd_sc_hd__fill_2
XFILLER_36_277 vssd1 vccd1 vssd1 vccd1 SS_sky130_ef_sc_hd__decap_40_12
XFILLER_91_361 vssd1 vccd1 vssd1 vccd1 SS_sky130_ef_sc_hd__decap_40_12
XFILLER_51_225 vssd1 vccd1 vssd1 vccd1 SS_sky130_ef_sc_hd__decap_40_12
XFILLER_52_737 vssd1 vccd1 vssd1 vccd1 SS_sky130_ef_sc_hd__decap_40_12
XTAP_TAPCELL_ROW_82_1532 vccd1 vssd1 SS_sky130_fd_sc_hd__tapvpwrvgnd_1
XFILLER_20_601 vssd1 vccd1 vssd1 vccd1 SS_sky130_ef_sc_hd__decap_40_12
XTAP_TAPCELL_ROW_22_629 vccd1 vssd1 SS_sky130_fd_sc_hd__tapvpwrvgnd_1
XFILLER_20_645 vssd1 vccd1 vssd1 vccd1 SS_sky130_ef_sc_hd__decap_40_12
XFILLER_22_29 vssd1 vccd1 vssd1 vccd1 SS_sky130_ef_sc_hd__decap_40_12
X_0988_ vccd1 vssd1 vccd1 vssd1 _0988_/X _0988_/A _0988_/B SS_sky130_fd_sc_hd__or2_2
XFILLER_118_533 vssd1 vccd1 vssd1 vccd1 SS_sky130_ef_sc_hd__decap_40_12
XFILLER_133_525 vssd1 vccd1 vccd1 vssd1 SS_sky130_fd_sc_hd__fill_2
XFILLER_105_205 vssd1 vccd1 vssd1 vccd1 SS_sky130_ef_sc_hd__decap_40_12
XFILLER_105_249 vssd1 vccd1 vssd1 vccd1 SS_sky130_ef_sc_hd__decap_40_12
X_1609_ _1869_/A clkload9/A _1609_/D vccd1 vssd1 vccd1 vssd1 SS_sky130_fd_sc_hd__dfxtp_2
XFILLER_99_461 vssd1 vccd1 vccd1 vssd1 SS_sky130_fd_sc_hd__fill_4
XTAP_TAPCELL_ROW_93_1694 vccd1 vssd1 SS_sky130_fd_sc_hd__tapvpwrvgnd_1
XFILLER_87_634 vssd1 vccd1 vssd1 vccd1 SS_sky130_ef_sc_hd__decap_40_12
XFILLER_47_15 vssd1 vccd1 vssd1 vccd1 SS_sky130_ef_sc_hd__decap_40_12
XFILLER_86_133 vssd1 vccd1 vccd1 vssd1 SS_sky130_fd_sc_hd__fill_4
XTAP_TAPCELL_ROW_2_332 vccd1 vssd1 SS_sky130_fd_sc_hd__tapvpwrvgnd_1
XFILLER_28_701 vssd1 vccd1 vssd1 vccd1 SS_sky130_ef_sc_hd__decap_40_12
XFILLER_86_177 vssd1 vccd1 vssd1 vccd1 SS_sky130_ef_sc_hd__decap_40_12
XFILLER_55_531 vssd1 vccd1 vssd1 vccd1 SS_sky130_ef_sc_hd__decap_40_12
XFILLER_15_417 vssd1 vccd1 vssd1 vccd1 SS_sky130_ef_sc_hd__decap_40_12
XFILLER_27_277 vssd1 vccd1 vccd1 vssd1 SS_sky130_fd_sc_hd__fill_2
XFILLER_43_726 vssd1 vccd1 vccd1 vssd1 SS_sky130_fd_sc_hd__fill_2
XFILLER_70_501 vssd1 vccd1 vssd1 vccd1 SS_sky130_ef_sc_hd__decap_40_12
XFILLER_82_361 vssd1 vccd1 vccd1 vssd1 SS_sky130_fd_sc_hd__fill_2
XTAP_TAPCELL_ROW_124_2160 vccd1 vssd1 SS_sky130_fd_sc_hd__tapvpwrvgnd_1
XFILLER_103_54 vssd1 vccd1 vccd1 vssd1 SS_sky130_fd_sc_hd__fill_2
XFILLER_43_759 vssd1 vccd1 vccd1 vssd1 SS_sky130_fd_sc_hd__fill_2
XFILLER_55_597 vssd1 vccd1 vssd1 vccd1 SS_sky130_ef_sc_hd__decap_40_12
XFILLER_70_545 vssd1 vccd1 vssd1 vccd1 SS_sky130_ef_sc_hd__decap_40_12
XTAP_TAPCELL_ROW_41_916 vccd1 vssd1 SS_sky130_fd_sc_hd__tapvpwrvgnd_1
XFILLER_63_69 vssd1 vccd1 vssd1 vccd1 SS_sky130_ef_sc_hd__decap_40_12
XFILLER_23_461 vssd1 vccd1 vssd1 vccd1 SS_sky130_ef_sc_hd__decap_40_12
XFILLER_51_781 vssd1 vccd1 vccd1 vssd1 SS_sky130_fd_sc_hd__fill_2
XFILLER_70_589 vssd1 vccd1 vssd1 vccd1 SS_sky130_ef_sc_hd__decap_40_12
XFILLER_10_133 vssd1 vccd1 vccd1 vssd1 SS_sky130_fd_sc_hd__fill_4
XFILLER_137_3 vssd1 vccd1 vssd1 vccd1 SS_sky130_ef_sc_hd__decap_40_12
XFILLER_10_177 vssd1 vccd1 vssd1 vccd1 SS_sky130_ef_sc_hd__decap_40_12
XFILLER_6_137 vssd1 vccd1 vccd1 vssd1 SS_sky130_fd_sc_hd__fill_2
XFILLER_136_363 vccd1 vssd1 vccd1 vssd1 SS_sky130_fd_sc_hd__fill_1
XFILLER_124_525 vssd1 vccd1 vccd1 vssd1 SS_sky130_fd_sc_hd__fill_4
XFILLER_2_321 vssd1 vccd1 vssd1 vccd1 SS_sky130_ef_sc_hd__decap_40_12
XFILLER_3_833 vssd1 vccd1 vccd1 vssd1 SS_sky130_fd_sc_hd__fill_4
XFILLER_2_365 vssd1 vccd1 vssd1 vccd1 SS_sky130_ef_sc_hd__decap_40_12
XTAP_TAPCELL_ROW_53_1100 vccd1 vssd1 SS_sky130_fd_sc_hd__tapvpwrvgnd_1
XFILLER_78_601 vssd1 vccd1 vssd1 vccd1 SS_sky130_ef_sc_hd__decap_40_12
XFILLER_88_77 vssd1 vccd1 vccd1 vssd1 SS_sky130_fd_sc_hd__fill_4
XFILLER_124_569 vssd1 vccd1 vssd1 vccd1 SS_sky130_ef_sc_hd__decap_40_12
XFILLER_105_772 vssd1 vccd1 vssd1 vccd1 SS_sky130_ef_sc_hd__decap_40_12
XFILLER_77_111 vccd1 vssd1 vccd1 vssd1 SS_sky130_fd_sc_hd__fill_1
XFILLER_78_645 vssd1 vccd1 vccd1 vssd1 SS_sky130_fd_sc_hd__fill_8
XFILLER_120_753 vssd1 vccd1 vccd1 vssd1 SS_sky130_fd_sc_hd__fill_2
XFILLER_65_317 vssd1 vccd1 vccd1 vssd1 SS_sky130_fd_sc_hd__fill_8
XFILLER_93_615 vccd1 vssd1 vccd1 vssd1 SS_sky130_fd_sc_hd__fill_1
XFILLER_18_233 vssd1 vccd1 vssd1 vccd1 SS_sky130_ef_sc_hd__decap_40_12
XFILLER_19_745 vccd1 vssd1 vccd1 vssd1 SS_sky130_fd_sc_hd__fill_1
XFILLER_19_767 vssd1 vccd1 vssd1 vccd1 SS_sky130_ef_sc_hd__decap_40_12
XTAP_TAPCELL_ROW_29_740 vccd1 vssd1 SS_sky130_fd_sc_hd__tapvpwrvgnd_1
XFILLER_46_520 vssd1 vccd1 vssd1 vccd1 SS_sky130_ef_sc_hd__decap_40_12
XTAP_TAPCELL_ROW_109_1933 vccd1 vssd1 SS_sky130_fd_sc_hd__tapvpwrvgnd_1
XFILLER_18_277 vssd1 vccd1 vssd1 vccd1 SS_sky130_ef_sc_hd__decap_40_12
XFILLER_37_81 vssd1 vccd1 vssd1 vccd1 SS_sky130_ef_sc_hd__decap_40_12
XFILLER_80_309 vssd1 vccd1 vssd1 vccd1 SS_sky130_ef_sc_hd__decap_40_12
XFILLER_33_225 vssd1 vccd1 vssd1 vccd1 SS_sky130_ef_sc_hd__decap_40_12
XFILLER_61_545 vssd1 vccd1 vccd1 vssd1 SS_sky130_fd_sc_hd__fill_2
XTAP_TAPCELL_ROW_64_1262 vccd1 vssd1 SS_sky130_fd_sc_hd__tapvpwrvgnd_1
X_1891_ vccd1 vssd1 _1891_/X _1891_/A vccd1 vssd1 SS_sky130_fd_sc_hd__buf_2
X_0911_ vccd1 vssd1 vccd1 vssd1 _0909_/X _1533_/Q _0947_/A _1757_/Q _1409_/A _0911_/X
+ SS_sky130_fd_sc_hd__a221o_2
X_0842_ vccd1 vssd1 vssd1 vccd1 _0838_/X _0841_/X _0878_/A2 hold806/X _1489_/D _1381_/C1
+ SS_sky130_fd_sc_hd__o221a_2
X_0773_ vccd1 vssd1 vccd1 vssd1 input6/X _0815_/B1 _1844_/A wire443/X _0773_/X SS_sky130_fd_sc_hd__a22o_2
XFILLER_52_3 vssd1 vccd1 vssd1 vccd1 SS_sky130_ef_sc_hd__decap_40_12
XFILLER_127_385 vssd1 vccd1 vccd1 vssd1 SS_sky130_fd_sc_hd__fill_4
XFILLER_5_181 vssd1 vccd1 vssd1 vccd1 SS_sky130_ef_sc_hd__decap_40_12
XFILLER_6_693 vssd1 vccd1 vccd1 vssd1 SS_sky130_fd_sc_hd__fill_4
XFILLER_130_506 vssd1 vccd1 vssd1 vccd1 SS_sky130_ef_sc_hd__decap_40_12
XFILLER_103_709 vssd1 vccd1 vccd1 vssd1 SS_sky130_fd_sc_hd__fill_4
XFILLER_68_133 vssd1 vccd1 vccd1 vssd1 SS_sky130_fd_sc_hd__fill_4
X_1325_ vssd1 vccd1 vccd1 vssd1 _1325_/A2 input35/X _1690_/D _1441_/C1 _1324_/X SS_sky130_fd_sc_hd__o211a_2
XFILLER_68_177 vssd1 vccd1 vssd1 vccd1 SS_sky130_ef_sc_hd__decap_40_12
XFILLER_111_797 vssd1 vccd1 vssd1 vccd1 SS_sky130_ef_sc_hd__decap_40_12
XFILLER_96_475 vccd1 vssd1 vccd1 vssd1 SS_sky130_fd_sc_hd__fill_1
XFILLER_49_391 vccd1 vssd1 vccd1 vssd1 SS_sky130_fd_sc_hd__fill_1
XFILLER_83_125 vssd1 vccd1 vssd1 vccd1 SS_sky130_ef_sc_hd__decap_40_12
X_1256_ vccd1 vssd1 vccd1 vssd1 _1256_/X _1657_/Q _1264_/B SS_sky130_fd_sc_hd__or2_2
X_1187_ vssd1 vccd1 vccd1 vssd1 wire233/X input32/X _1623_/D _1425_/C1 _1186_/X SS_sky130_fd_sc_hd__o211a_2
XFILLER_64_361 vssd1 vccd1 vccd1 vssd1 SS_sky130_fd_sc_hd__fill_2
XFILLER_83_169 vssd1 vccd1 vssd1 vccd1 SS_sky130_ef_sc_hd__decap_40_12
XFILLER_33_781 vssd1 vccd1 vccd1 vssd1 SS_sky130_fd_sc_hd__fill_2
XFILLER_52_589 vssd1 vccd1 vssd1 vccd1 SS_sky130_ef_sc_hd__decap_40_12
XFILLER_138_617 vssd1 vccd1 vccd1 vssd1 SS_sky130_fd_sc_hd__fill_2
XFILLER_20_475 vccd1 vssd1 vccd1 vssd1 SS_sky130_fd_sc_hd__fill_1
XFILLER_137_127 vssd1 vccd1 vccd1 vssd1 SS_sky130_fd_sc_hd__fill_4
XFILLER_137_105 vssd1 vccd1 vccd1 vssd1 SS_sky130_fd_sc_hd__fill_4
XFILLER_119_820 vssd1 vccd1 vccd1 vssd1 SS_sky130_fd_sc_hd__fill_4
XTAP_TAPCELL_ROW_95_1723 vccd1 vssd1 SS_sky130_fd_sc_hd__tapvpwrvgnd_1
XTAP_TAPCELL_ROW_7_402 vccd1 vssd1 SS_sky130_fd_sc_hd__tapvpwrvgnd_1
XFILLER_121_517 vssd1 vccd1 vssd1 vccd1 SS_sky130_ef_sc_hd__decap_40_12
XFILLER_59_111 vccd1 vssd1 vccd1 vssd1 SS_sky130_fd_sc_hd__fill_1
XFILLER_133_399 vssd1 vccd1 vssd1 vccd1 SS_sky130_ef_sc_hd__decap_40_12
XFILLER_102_753 vssd1 vccd1 vccd1 vssd1 SS_sky130_fd_sc_hd__fill_2
XFILLER_47_317 vssd1 vccd1 vssd1 vccd1 SS_sky130_ef_sc_hd__decap_40_12
XFILLER_102_797 vssd1 vccd1 vccd1 vssd1 SS_sky130_fd_sc_hd__fill_2
XFILLER_28_531 vccd1 vssd1 vccd1 vssd1 SS_sky130_fd_sc_hd__fill_1
XFILLER_114_53 vssd1 vccd1 vssd1 vccd1 SS_sky130_ef_sc_hd__decap_40_12
XFILLER_62_309 vssd1 vccd1 vssd1 vccd1 SS_sky130_ef_sc_hd__decap_40_12
XFILLER_83_670 vssd1 vccd1 vccd1 vssd1 SS_sky130_fd_sc_hd__fill_2
XFILLER_114_97 vssd1 vccd1 vssd1 vccd1 SS_sky130_ef_sc_hd__decap_40_12
XFILLER_15_225 vssd1 vccd1 vssd1 vccd1 SS_sky130_ef_sc_hd__decap_40_12
XFILLER_16_737 vssd1 vccd1 vssd1 vccd1 SS_sky130_ef_sc_hd__decap_40_12
XFILLER_43_556 vssd1 vccd1 vccd1 vssd1 SS_sky130_fd_sc_hd__fill_4
XFILLER_130_41 vssd1 vccd1 vssd1 vccd1 SS_sky130_ef_sc_hd__decap_40_12
XFILLER_24_781 vssd1 vccd1 vssd1 vccd1 SS_sky130_ef_sc_hd__decap_40_12
XFILLER_31_729 vssd1 vccd1 vssd1 vccd1 SS_sky130_ef_sc_hd__decap_40_12
XFILLER_130_85 vssd1 vccd1 vssd1 vccd1 SS_sky130_ef_sc_hd__decap_40_12
XTAP_TAPCELL_ROW_104_1863 vccd1 vssd1 SS_sky130_fd_sc_hd__tapvpwrvgnd_1
XFILLER_129_617 vssd1 vccd1 vssd1 vccd1 SS_sky130_ef_sc_hd__decap_40_12
Xwire311 vccd1 vssd1 vssd1 vccd1 wire311/A analog_ctrl[6] SS_sky130_fd_sc_hd__buf_12
Xwire333 vccd1 vssd1 vssd1 vccd1 wire333/A analog_ctrl[44] SS_sky130_fd_sc_hd__buf_12
Xwire322 vccd1 vssd1 vssd1 vccd1 wire322/A analog_ctrl[54] SS_sky130_fd_sc_hd__buf_12
XTAP_TAPCELL_ROW_137_2362 vccd1 vssd1 SS_sky130_fd_sc_hd__tapvpwrvgnd_1
XTAP_TAPCELL_ROW_137_2351 vccd1 vssd1 SS_sky130_fd_sc_hd__tapvpwrvgnd_1
Xwire300 vccd1 vssd1 vssd1 vccd1 wire300/A analog_ctrl[109] SS_sky130_fd_sc_hd__buf_12
XFILLER_11_497 vssd1 vccd1 vccd1 vssd1 SS_sky130_fd_sc_hd__fill_4
Xwire344 vccd1 vssd1 vssd1 vccd1 wire344/A analog_ctrl[34] SS_sky130_fd_sc_hd__buf_12
Xwire366 vccd1 vssd1 vssd1 vccd1 wire366/A wbs_dat_o[26] SS_sky130_fd_sc_hd__buf_12
Xwire355 vccd1 vssd1 vssd1 vccd1 wire355/A wbs_dat_o[7] SS_sky130_fd_sc_hd__buf_12
XFILLER_109_341 vssd1 vccd1 vccd1 vssd1 SS_sky130_fd_sc_hd__fill_2
Xwire377 vccd1 vssd1 vssd1 vccd1 wire377/A wbs_dat_o[16] SS_sky130_fd_sc_hd__buf_12
XFILLER_137_661 vssd1 vccd1 vccd1 vssd1 SS_sky130_fd_sc_hd__fill_2
XFILLER_125_801 vssd1 vccd1 vccd1 vssd1 SS_sky130_fd_sc_hd__fill_2
Xwire388 vccd1 vssd1 vssd1 vccd1 wire388/A analog_ctrl[93] SS_sky130_fd_sc_hd__buf_12
Xwire399 vccd1 vssd1 vssd1 vccd1 wire399/A analog_ctrl[82] SS_sky130_fd_sc_hd__buf_12
XFILLER_124_333 vssd1 vccd1 vssd1 vccd1 SS_sky130_ef_sc_hd__decap_40_12
XFILLER_109_385 vssd1 vccd1 vccd1 vssd1 SS_sky130_fd_sc_hd__fill_4
XFILLER_3_641 vssd1 vccd1 vssd1 vccd1 SS_sky130_ef_sc_hd__decap_40_12
XFILLER_124_377 vssd1 vccd1 vccd1 vssd1 SS_sky130_fd_sc_hd__fill_2
XFILLER_3_685 vssd1 vccd1 vssd1 vccd1 SS_sky130_ef_sc_hd__decap_40_12
XFILLER_124_388 vssd1 vccd1 vssd1 vccd1 SS_sky130_ef_sc_hd__decap_40_12
XFILLER_97_217 vssd1 vccd1 vccd1 vssd1 SS_sky130_fd_sc_hd__fill_4
XFILLER_2_195 vccd1 vssd1 vccd1 vssd1 SS_sky130_fd_sc_hd__fill_1
XFILLER_105_591 vssd1 vccd1 vccd1 vssd1 SS_sky130_fd_sc_hd__fill_8
X_1110_ vccd1 vssd1 vccd1 vssd1 _1110_/X _1860_/A _1116_/B SS_sky130_fd_sc_hd__or2_2
XFILLER_120_572 vccd1 vssd1 vccd1 vssd1 SS_sky130_fd_sc_hd__fill_1
XFILLER_65_125 vssd1 vccd1 vssd1 vccd1 SS_sky130_ef_sc_hd__decap_40_12
XFILLER_93_445 vssd1 vccd1 vccd1 vssd1 SS_sky130_fd_sc_hd__fill_2
XFILLER_19_553 vssd1 vccd1 vccd1 vssd1 SS_sky130_fd_sc_hd__fill_4
XFILLER_34_501 vssd1 vccd1 vssd1 vccd1 SS_sky130_ef_sc_hd__decap_40_12
XFILLER_46_361 vssd1 vccd1 vccd1 vssd1 SS_sky130_fd_sc_hd__fill_2
X_1041_ vssd1 vccd1 vccd1 vssd1 _1051_/A2 input24/X _1552_/D _1437_/C1 _1040_/X SS_sky130_fd_sc_hd__o211a_2
XFILLER_65_169 vssd1 vccd1 vssd1 vccd1 SS_sky130_ef_sc_hd__decap_40_12
XFILLER_81_607 vssd1 vccd1 vccd1 vssd1 SS_sky130_fd_sc_hd__fill_4
XFILLER_19_597 vssd1 vccd1 vssd1 vccd1 SS_sky130_ef_sc_hd__decap_40_12
XFILLER_74_681 vssd1 vccd1 vssd1 vccd1 SS_sky130_ef_sc_hd__decap_40_12
XFILLER_80_139 vccd1 vssd1 vccd1 vssd1 SS_sky130_fd_sc_hd__fill_1
XFILLER_15_781 vssd1 vccd1 vccd1 vssd1 SS_sky130_fd_sc_hd__fill_2
XFILLER_21_217 vssd1 vccd1 vccd1 vssd1 SS_sky130_fd_sc_hd__fill_4
XFILLER_34_589 vssd1 vccd1 vssd1 vccd1 SS_sky130_ef_sc_hd__decap_40_12
XFILLER_30_773 vccd1 vssd1 vccd1 vssd1 SS_sky130_fd_sc_hd__fill_1
XTAP_TAPCELL_ROW_32_779 vccd1 vssd1 SS_sky130_fd_sc_hd__tapvpwrvgnd_1
XFILLER_119_105 vssd1 vccd1 vccd1 vssd1 SS_sky130_fd_sc_hd__fill_4
XTAP_TAPCELL_ROW_12_481 vccd1 vssd1 SS_sky130_fd_sc_hd__tapvpwrvgnd_1
X_1874_ vccd1 vssd1 _1874_/X _1874_/A vccd1 vssd1 SS_sky130_fd_sc_hd__buf_2
XFILLER_119_149 vssd1 vccd1 vssd1 vccd1 SS_sky130_ef_sc_hd__decap_40_12
X_0825_ vccd1 vssd1 vccd1 vssd1 _1519_/Q wire421/A _1647_/Q _0894_/B1 _0825_/X SS_sky130_fd_sc_hd__a22o_2
X_0756_ vccd1 vssd1 vccd1 vssd1 _1835_/A wire421/X _1826_/A wire424/X _0757_/D SS_sky130_fd_sc_hd__a22o_2
XTAP_TAPCELL_ROW_77_1453 vccd1 vssd1 SS_sky130_fd_sc_hd__tapvpwrvgnd_1
XFILLER_127_193 vssd1 vccd1 vssd1 vccd1 SS_sky130_ef_sc_hd__decap_40_12
XFILLER_89_729 vssd1 vccd1 vssd1 vccd1 SS_sky130_ef_sc_hd__decap_40_12
XFILLER_135_19 vccd1 vssd1 vccd1 vssd1 SS_sky130_fd_sc_hd__fill_1
XFILLER_103_517 vssd1 vccd1 vssd1 vccd1 SS_sky130_ef_sc_hd__decap_40_12
XFILLER_130_325 vssd1 vccd1 vccd1 vssd1 SS_sky130_fd_sc_hd__fill_2
XFILLER_130_336 vssd1 vccd1 vssd1 vccd1 SS_sky130_ef_sc_hd__decap_40_12
XTAP_TAPCELL_ROW_90_1653 vccd1 vssd1 SS_sky130_fd_sc_hd__tapvpwrvgnd_1
XFILLER_29_317 vssd1 vccd1 vssd1 vccd1 SS_sky130_ef_sc_hd__decap_40_12
XFILLER_84_401 vssd1 vccd1 vssd1 vccd1 SS_sky130_ef_sc_hd__decap_40_12
XFILLER_111_561 vssd1 vccd1 vssd1 vccd1 SS_sky130_ef_sc_hd__decap_40_12
XFILLER_69_497 vssd1 vccd1 vccd1 vssd1 SS_sky130_fd_sc_hd__fill_4
X_1308_ vccd1 vssd1 vccd1 vssd1 _1308_/X _1308_/A _1318_/B SS_sky130_fd_sc_hd__or2_2
XFILLER_84_423 vccd1 vssd1 vccd1 vssd1 SS_sky130_fd_sc_hd__fill_1
XFILLER_25_501 vssd1 vccd1 vccd1 vssd1 SS_sky130_fd_sc_hd__fill_2
XFILLER_44_309 vssd1 vccd1 vssd1 vccd1 SS_sky130_ef_sc_hd__decap_40_12
XFILLER_72_618 vssd1 vccd1 vssd1 vccd1 SS_sky130_ef_sc_hd__decap_40_12
X_1239_ vssd1 vccd1 vccd1 vssd1 _1261_/A2 input24/X _1648_/D _1445_/C1 _1238_/X SS_sky130_fd_sc_hd__o211a_2
XFILLER_84_489 vssd1 vccd1 vccd1 vssd1 SS_sky130_fd_sc_hd__fill_4
XFILLER_37_361 vssd1 vccd1 vssd1 vccd1 SS_sky130_ef_sc_hd__decap_40_12
XFILLER_44_27 vccd1 vssd1 vccd1 vssd1 SS_sky130_fd_sc_hd__fill_1
XFILLER_13_729 vssd1 vccd1 vssd1 vccd1 SS_sky130_ef_sc_hd__decap_40_12
XFILLER_60_15 vssd1 vccd1 vssd1 vccd1 SS_sky130_ef_sc_hd__decap_40_12
XFILLER_100_77 vssd1 vccd1 vccd1 vssd1 SS_sky130_fd_sc_hd__fill_4
XFILLER_121_6 vssd1 vccd1 vssd1 vccd1 SS_sky130_ef_sc_hd__decap_40_12
XTAP_TAPCELL_ROW_119_2081 vccd1 vssd1 SS_sky130_fd_sc_hd__tapvpwrvgnd_1
XTAP_TAPCELL_ROW_119_2092 vccd1 vssd1 SS_sky130_fd_sc_hd__tapvpwrvgnd_1
XFILLER_107_823 vccd1 vssd1 vccd1 vssd1 SS_sky130_fd_sc_hd__fill_1
XFILLER_118_193 vssd1 vccd1 vccd1 vssd1 SS_sky130_fd_sc_hd__fill_2
XFILLER_69_57 vssd1 vccd1 vssd1 vccd1 SS_sky130_ef_sc_hd__decap_40_12
XTAP_TAPCELL_ROW_132_2281 vccd1 vssd1 SS_sky130_fd_sc_hd__tapvpwrvgnd_1
XFILLER_79_217 vssd1 vccd1 vccd1 vssd1 SS_sky130_fd_sc_hd__fill_4
XFILLER_106_399 vssd1 vccd1 vssd1 vccd1 SS_sky130_ef_sc_hd__decap_40_12
XFILLER_121_358 vssd1 vccd1 vssd1 vccd1 SS_sky130_ef_sc_hd__decap_40_12
XFILLER_0_699 vccd1 vssd1 vccd1 vssd1 SS_sky130_fd_sc_hd__fill_1
XFILLER_87_261 vssd1 vccd1 vssd1 vccd1 SS_sky130_ef_sc_hd__decap_40_12
XFILLER_94_209 vssd1 vccd1 vssd1 vccd1 SS_sky130_ef_sc_hd__decap_40_12
XFILLER_47_125 vssd1 vccd1 vssd1 vccd1 SS_sky130_ef_sc_hd__decap_40_12
XFILLER_75_445 vssd1 vccd1 vccd1 vssd1 SS_sky130_fd_sc_hd__fill_2
XFILLER_47_169 vssd1 vccd1 vssd1 vccd1 SS_sky130_ef_sc_hd__decap_40_12
XFILLER_63_629 vssd1 vccd1 vccd1 vssd1 SS_sky130_fd_sc_hd__fill_8
XFILLER_90_404 vssd1 vccd1 vssd1 vccd1 SS_sky130_ef_sc_hd__decap_40_12
XFILLER_16_501 vssd1 vccd1 vssd1 vccd1 SS_sky130_ef_sc_hd__decap_40_12
XFILLER_18_83 vccd1 vssd1 vccd1 vssd1 SS_sky130_fd_sc_hd__fill_1
XFILLER_28_361 vssd1 vccd1 vccd1 vssd1 SS_sky130_fd_sc_hd__fill_2
XTAP_TAPCELL_ROW_39_890 vccd1 vssd1 SS_sky130_fd_sc_hd__tapvpwrvgnd_1
XTAP_TAPCELL_ROW_48_1021 vccd1 vssd1 SS_sky130_fd_sc_hd__tapvpwrvgnd_1
XFILLER_56_681 vssd1 vccd1 vssd1 vccd1 SS_sky130_ef_sc_hd__decap_40_12
XFILLER_62_139 vccd1 vssd1 vccd1 vssd1 SS_sky130_fd_sc_hd__fill_1
XFILLER_16_545 vssd1 vccd1 vssd1 vccd1 SS_sky130_ef_sc_hd__decap_40_12
XFILLER_16_589 vssd1 vccd1 vssd1 vccd1 SS_sky130_ef_sc_hd__decap_40_12
XFILLER_31_559 vccd1 vssd1 vccd1 vssd1 SS_sky130_fd_sc_hd__fill_1
XTAP_TAPCELL_ROW_61_1210 vccd1 vssd1 SS_sky130_fd_sc_hd__tapvpwrvgnd_1
XTAP_TAPCELL_ROW_61_1221 vccd1 vssd1 SS_sky130_fd_sc_hd__tapvpwrvgnd_1
XFILLER_7_221 vssd1 vccd1 vccd1 vssd1 SS_sky130_fd_sc_hd__fill_2
XFILLER_8_755 vccd1 vssd1 vccd1 vssd1 SS_sky130_fd_sc_hd__fill_1
XFILLER_11_261 vssd1 vccd1 vssd1 vccd1 SS_sky130_ef_sc_hd__decap_40_12
XFILLER_117_609 vssd1 vccd1 vccd1 vssd1 SS_sky130_fd_sc_hd__fill_4
XFILLER_50_81 vssd1 vccd1 vccd1 vssd1 SS_sky130_fd_sc_hd__fill_2
X_1590_ _1864_/A _1686_/CLK _1590_/D vccd1 vssd1 vccd1 vssd1 SS_sky130_fd_sc_hd__dfxtp_2
XTAP_TAPCELL_ROW_59_1183 vccd1 vssd1 SS_sky130_fd_sc_hd__tapvpwrvgnd_1
XFILLER_124_141 vssd1 vccd1 vssd1 vccd1 SS_sky130_ef_sc_hd__decap_40_12
XFILLER_109_193 vssd1 vccd1 vssd1 vccd1 SS_sky130_ef_sc_hd__decap_40_12
XFILLER_112_347 vssd1 vccd1 vssd1 vccd1 SS_sky130_ef_sc_hd__decap_40_12
XTAP_TAPCELL_ROW_72_1383 vccd1 vssd1 SS_sky130_fd_sc_hd__tapvpwrvgnd_1
XFILLER_15_3 vssd1 vccd1 vssd1 vccd1 SS_sky130_ef_sc_hd__decap_40_12
XFILLER_39_637 vssd1 vccd1 vssd1 vccd1 SS_sky130_ef_sc_hd__decap_40_12
XFILLER_66_445 vssd1 vccd1 vccd1 vssd1 SS_sky130_fd_sc_hd__fill_8
XFILLER_26_309 vssd1 vccd1 vssd1 vccd1 SS_sky130_ef_sc_hd__decap_40_12
XFILLER_19_361 vssd1 vccd1 vssd1 vccd1 SS_sky130_ef_sc_hd__decap_40_12
X_1024_ vccd1 vssd1 vccd1 vssd1 _1024_/X _1831_/A _1050_/B SS_sky130_fd_sc_hd__or2_2
XTAP_TAPCELL_ROW_37_849 vccd1 vssd1 SS_sky130_fd_sc_hd__tapvpwrvgnd_1
XFILLER_66_489 vssd1 vccd1 vccd1 vssd1 SS_sky130_fd_sc_hd__fill_2
XTAP_TAPCELL_ROW_17_551 vccd1 vssd1 SS_sky130_fd_sc_hd__tapvpwrvgnd_1
XTAP_TAPCELL_ROW_17_562 vccd1 vssd1 SS_sky130_fd_sc_hd__tapvpwrvgnd_1
XFILLER_61_161 vssd1 vccd1 vccd1 vssd1 SS_sky130_fd_sc_hd__fill_4
XFILLER_30_581 vssd1 vccd1 vccd1 vssd1 SS_sky130_fd_sc_hd__fill_4
XFILLER_30_29 vssd1 vccd1 vssd1 vccd1 SS_sky130_ef_sc_hd__decap_40_12
X_1857_ vccd1 vssd1 _1857_/X _1857_/A vccd1 vssd1 SS_sky130_fd_sc_hd__buf_2
X_0808_ vccd1 vssd1 vccd1 vssd1 _0807_/X _1548_/Q wire424/X _1872_/A _0828_/B1 _0808_/X
+ SS_sky130_fd_sc_hd__a221o_2
Xhold711 _1072_/A _1568_/Q vccd1 vssd1 vssd1 vccd1 SS_sky130_fd_sc_hd__dlygate4sd3_1
Xhold700 _1724_/D _1395_/X vccd1 vssd1 vssd1 vccd1 SS_sky130_fd_sc_hd__dlygate4sd3_1
Xhold755 _1050_/A _1557_/Q vccd1 vssd1 vssd1 vccd1 SS_sky130_fd_sc_hd__dlygate4sd3_1
Xhold733 _1182_/A _1621_/Q vccd1 vssd1 vssd1 vccd1 SS_sky130_fd_sc_hd__dlygate4sd3_1
Xhold722 input27/A wbs_dat_i[16] vccd1 vssd1 vssd1 vccd1 SS_sky130_fd_sc_hd__dlygate4sd3_1
XFILLER_116_642 vssd1 vccd1 vccd1 vssd1 SS_sky130_fd_sc_hd__fill_2
Xhold744 _1124_/A _1593_/Q vccd1 vssd1 vssd1 vccd1 SS_sky130_fd_sc_hd__dlygate4sd3_1
Xhold766 _1370_/A _1712_/Q vccd1 vssd1 vssd1 vccd1 SS_sky130_fd_sc_hd__dlygate4sd3_1
Xhold788 hold788/X _0935_/X vccd1 vssd1 vssd1 vccd1 SS_sky130_fd_sc_hd__dlygate4sd3_1
X_0739_ vssd1 vccd1 vssd1 vccd1 _0755_/A _0754_/D _0755_/C _0739_/Y _0755_/B SS_sky130_fd_sc_hd__nor4b_2
Xhold777 _1324_/A _1690_/Q vccd1 vssd1 vssd1 vccd1 SS_sky130_fd_sc_hd__dlygate4sd3_1
XFILLER_103_325 vssd1 vccd1 vccd1 vssd1 SS_sky130_fd_sc_hd__fill_2
XFILLER_39_27 vssd1 vccd1 vssd1 vccd1 SS_sky130_ef_sc_hd__decap_40_12
XFILLER_89_559 vccd1 vssd1 vccd1 vssd1 SS_sky130_fd_sc_hd__fill_1
XFILLER_130_133 vssd1 vccd1 vccd1 vssd1 SS_sky130_fd_sc_hd__fill_4
Xhold799 hold799/X _1501_/Q vccd1 vssd1 vssd1 vccd1 SS_sky130_fd_sc_hd__dlygate4sd3_1
XFILLER_69_261 vssd1 vccd1 vssd1 vccd1 SS_sky130_ef_sc_hd__decap_40_12
XFILLER_76_209 vssd1 vccd1 vssd1 vccd1 SS_sky130_ef_sc_hd__decap_40_12
XFILLER_85_721 vssd1 vccd1 vccd1 vssd1 SS_sky130_fd_sc_hd__fill_4
XFILLER_130_177 vssd1 vccd1 vssd1 vccd1 SS_sky130_ef_sc_hd__decap_40_12
XPHY_EDGE_ROW_110_Left_249 vccd1 vssd1 vccd1 vssd1 SS_sky130_fd_sc_hd__decap_3
XFILLER_103_369 vccd1 vssd1 vccd1 vssd1 SS_sky130_fd_sc_hd__fill_1
XFILLER_29_125 vssd1 vccd1 vssd1 vccd1 SS_sky130_ef_sc_hd__decap_40_12
XFILLER_57_445 vssd1 vccd1 vccd1 vssd1 SS_sky130_fd_sc_hd__fill_2
XFILLER_29_169 vssd1 vccd1 vssd1 vccd1 SS_sky130_ef_sc_hd__decap_40_12
XFILLER_55_15 vssd1 vccd1 vssd1 vccd1 SS_sky130_ef_sc_hd__decap_40_12
XFILLER_84_253 vssd1 vccd1 vssd1 vccd1 SS_sky130_ef_sc_hd__decap_40_12
XFILLER_38_681 vssd1 vccd1 vssd1 vccd1 SS_sky130_ef_sc_hd__decap_40_12
XFILLER_45_629 vssd1 vccd1 vssd1 vccd1 SS_sky130_ef_sc_hd__decap_40_12
XFILLER_44_139 vccd1 vssd1 vccd1 vssd1 SS_sky130_fd_sc_hd__fill_1
XFILLER_40_301 vssd1 vccd1 vccd1 vssd1 SS_sky130_fd_sc_hd__fill_4
XFILLER_53_673 vssd1 vccd1 vccd1 vssd1 SS_sky130_fd_sc_hd__fill_4
XFILLER_111_54 vssd1 vccd1 vccd1 vssd1 SS_sky130_fd_sc_hd__fill_2
XFILLER_13_559 vccd1 vssd1 vccd1 vssd1 SS_sky130_fd_sc_hd__fill_1
XTAP_TAPCELL_ROW_101_1822 vccd1 vssd1 SS_sky130_fd_sc_hd__tapvpwrvgnd_1
XTAP_TAPCELL_ROW_101_1811 vccd1 vssd1 SS_sky130_fd_sc_hd__tapvpwrvgnd_1
XFILLER_40_345 vssd1 vccd1 vssd1 vccd1 SS_sky130_ef_sc_hd__decap_40_12
XFILLER_71_69 vssd1 vccd1 vssd1 vccd1 SS_sky130_ef_sc_hd__decap_40_12
XFILLER_40_389 vssd1 vccd1 vssd1 vccd1 SS_sky130_ef_sc_hd__decap_40_12
XTAP_TAPCELL_ROW_134_2310 vccd1 vssd1 SS_sky130_fd_sc_hd__tapvpwrvgnd_1
XPHY_EDGE_ROW_109_Right_109 vccd1 vssd1 vccd1 vssd1 SS_sky130_fd_sc_hd__decap_3
XFILLER_138_255 vccd1 vssd1 vccd1 vssd1 SS_sky130_fd_sc_hd__fill_1
XFILLER_5_725 vssd1 vccd1 vccd1 vssd1 SS_sky130_fd_sc_hd__fill_2
XFILLER_107_653 vssd1 vccd1 vccd1 vssd1 SS_sky130_fd_sc_hd__fill_8
XFILLER_106_141 vssd1 vccd1 vssd1 vccd1 SS_sky130_ef_sc_hd__decap_40_12
XFILLER_122_601 vssd1 vccd1 vssd1 vccd1 SS_sky130_ef_sc_hd__decap_40_12
XFILLER_107_686 vccd1 vssd1 vccd1 vssd1 SS_sky130_fd_sc_hd__fill_1
XFILLER_134_494 vssd1 vccd1 vssd1 vccd1 SS_sky130_ef_sc_hd__decap_40_12
XFILLER_122_645 vssd1 vccd1 vccd1 vssd1 SS_sky130_fd_sc_hd__fill_4
XFILLER_121_111 vccd1 vssd1 vccd1 vssd1 SS_sky130_fd_sc_hd__fill_1
XFILLER_110_807 vssd1 vccd1 vccd1 vssd1 SS_sky130_fd_sc_hd__fill_4
XFILLER_48_401 vssd1 vccd1 vssd1 vccd1 SS_sky130_ef_sc_hd__decap_40_12
XTAP_TAPCELL_ROW_112_1984 vccd1 vssd1 SS_sky130_fd_sc_hd__tapvpwrvgnd_1
XTAP_TAPCELL_ROW_112_1973 vccd1 vssd1 SS_sky130_fd_sc_hd__tapvpwrvgnd_1
XFILLER_96_77 vssd1 vccd1 vccd1 vssd1 SS_sky130_fd_sc_hd__fill_4
XFILLER_48_445 vssd1 vccd1 vssd1 vccd1 SS_sky130_ef_sc_hd__decap_40_12
XFILLER_29_93 vssd1 vccd1 vssd1 vccd1 SS_sky130_ef_sc_hd__decap_40_12
XFILLER_29_670 vssd1 vccd1 vccd1 vssd1 SS_sky130_fd_sc_hd__fill_2
XFILLER_48_489 vssd1 vccd1 vssd1 vccd1 SS_sky130_ef_sc_hd__decap_40_12
XFILLER_63_415 vssd1 vccd1 vssd1 vccd1 SS_sky130_ef_sc_hd__decap_40_12
XFILLER_76_798 vccd1 vssd1 vccd1 vssd1 SS_sky130_fd_sc_hd__fill_1
XFILLER_91_735 vccd1 vssd1 vccd1 vssd1 SS_sky130_fd_sc_hd__fill_1
XTAP_TAPCELL_ROW_34_808 vccd1 vssd1 SS_sky130_fd_sc_hd__tapvpwrvgnd_1
XFILLER_90_245 vssd1 vccd1 vccd1 vssd1 SS_sky130_fd_sc_hd__fill_4
XFILLER_91_768 vssd1 vccd1 vssd1 vccd1 SS_sky130_ef_sc_hd__decap_40_12
XFILLER_43_161 vssd1 vccd1 vccd1 vssd1 SS_sky130_fd_sc_hd__fill_4
XFILLER_45_81 vssd1 vccd1 vssd1 vccd1 SS_sky130_ef_sc_hd__decap_40_12
XFILLER_50_109 vssd1 vccd1 vssd1 vccd1 SS_sky130_ef_sc_hd__decap_40_12
XFILLER_90_289 vssd1 vccd1 vssd1 vccd1 SS_sky130_ef_sc_hd__decap_40_12
XTAP_TAPCELL_ROW_14_510 vccd1 vssd1 SS_sky130_fd_sc_hd__tapvpwrvgnd_1
XFILLER_71_481 vccd1 vssd1 vccd1 vssd1 SS_sky130_fd_sc_hd__fill_1
XFILLER_12_581 vssd1 vccd1 vccd1 vssd1 SS_sky130_fd_sc_hd__fill_4
XFILLER_31_389 vssd1 vccd1 vccd1 vssd1 SS_sky130_fd_sc_hd__fill_2
X_1711_ _1711_/Q clkload2/A _1711_/D vccd1 vssd1 vccd1 vssd1 SS_sky130_fd_sc_hd__dfxtp_2
XFILLER_129_277 vssd1 vccd1 vccd1 vssd1 SS_sky130_fd_sc_hd__fill_2
XFILLER_8_585 vssd1 vccd1 vccd1 vssd1 SS_sky130_fd_sc_hd__fill_2
X_1642_ _1642_/Q clkload2/A _1642_/D vccd1 vssd1 vccd1 vssd1 SS_sky130_fd_sc_hd__dfxtp_2
XANTENNA_2 _1643_/Q vssd1 vccd1 vccd1 vssd1 SS_sky130_fd_sc_hd__diode_2
XFILLER_6_53 vssd1 vccd1 vssd1 vccd1 SS_sky130_ef_sc_hd__decap_40_12
XTAP_TAPCELL_ROW_74_1412 vccd1 vssd1 SS_sky130_fd_sc_hd__tapvpwrvgnd_1
XFILLER_6_97 vssd1 vccd1 vssd1 vccd1 SS_sky130_ef_sc_hd__decap_40_12
X_1573_ _1843_/A _1573_/CLK _1573_/D vccd1 vssd1 vccd1 vssd1 SS_sky130_fd_sc_hd__dfxtp_2
XFILLER_98_301 vssd1 vccd1 vccd1 vssd1 SS_sky130_fd_sc_hd__fill_4
XFILLER_112_133 vssd1 vccd1 vccd1 vssd1 SS_sky130_fd_sc_hd__fill_4
XFILLER_98_345 vssd1 vccd1 vssd1 vccd1 SS_sky130_ef_sc_hd__decap_40_12
XFILLER_58_209 vssd1 vccd1 vssd1 vccd1 SS_sky130_ef_sc_hd__decap_40_12
XFILLER_86_529 vssd1 vccd1 vccd1 vssd1 SS_sky130_fd_sc_hd__fill_2
XFILLER_112_177 vssd1 vccd1 vssd1 vccd1 SS_sky130_ef_sc_hd__decap_40_12
XFILLER_39_445 vssd1 vccd1 vccd1 vssd1 SS_sky130_fd_sc_hd__fill_2
XFILLER_66_253 vssd1 vccd1 vssd1 vccd1 SS_sky130_ef_sc_hd__decap_40_12
XFILLER_67_765 vssd1 vccd1 vssd1 vccd1 SS_sky130_ef_sc_hd__decap_40_12
XFILLER_94_562 vssd1 vccd1 vccd1 vssd1 SS_sky130_fd_sc_hd__fill_4
XFILLER_27_629 vssd1 vccd1 vssd1 vccd1 SS_sky130_ef_sc_hd__decap_40_12
XFILLER_26_139 vccd1 vssd1 vccd1 vssd1 SS_sky130_fd_sc_hd__fill_1
XFILLER_54_459 vssd1 vccd1 vccd1 vssd1 SS_sky130_fd_sc_hd__fill_2
XFILLER_81_223 vccd1 vssd1 vccd1 vssd1 SS_sky130_fd_sc_hd__fill_1
XFILLER_22_301 vssd1 vccd1 vccd1 vssd1 SS_sky130_fd_sc_hd__fill_4
XFILLER_35_673 vssd1 vccd1 vssd1 vccd1 SS_sky130_ef_sc_hd__decap_40_12
XFILLER_41_109 vssd1 vccd1 vccd1 vssd1 SS_sky130_fd_sc_hd__fill_2
XTAP_TAPCELL_ROW_85_1574 vccd1 vssd1 SS_sky130_fd_sc_hd__tapvpwrvgnd_1
X_1007_ vssd1 vccd1 vccd1 vssd1 wire253/X input41/X _1536_/D _1431_/C1 _1006_/X SS_sky130_fd_sc_hd__o211a_2
XFILLER_50_643 vccd1 vssd1 vccd1 vssd1 SS_sky130_fd_sc_hd__fill_1
XFILLER_22_345 vssd1 vccd1 vssd1 vccd1 SS_sky130_ef_sc_hd__decap_40_12
XFILLER_10_529 vssd1 vccd1 vccd1 vssd1 SS_sky130_fd_sc_hd__fill_2
XFILLER_22_389 vssd1 vccd1 vssd1 vccd1 SS_sky130_ef_sc_hd__decap_40_12
XFILLER_50_687 vccd1 vssd1 vccd1 vssd1 SS_sky130_fd_sc_hd__fill_1
X_1909_ vccd1 vssd1 _1909_/X _1909_/A vccd1 vssd1 SS_sky130_fd_sc_hd__buf_2
XFILLER_135_225 vssd1 vccd1 vssd1 vccd1 SS_sky130_ef_sc_hd__decap_40_12
XTAP_TAPCELL_ROW_116_2040 vccd1 vssd1 SS_sky130_fd_sc_hd__tapvpwrvgnd_1
XFILLER_1_205 vssd1 vccd1 vssd1 vccd1 SS_sky130_ef_sc_hd__decap_40_12
XFILLER_104_612 vssd1 vccd1 vccd1 vssd1 SS_sky130_fd_sc_hd__fill_4
XFILLER_104_601 vssd1 vccd1 vccd1 vssd1 SS_sky130_fd_sc_hd__fill_2
XFILLER_1_249 vssd1 vccd1 vssd1 vccd1 SS_sky130_ef_sc_hd__decap_40_12
Xhold596 _1302_/A _1679_/Q vccd1 vssd1 vssd1 vccd1 SS_sky130_fd_sc_hd__dlygate4sd3_1
Xhold574 _1220_/A _1639_/Q vccd1 vssd1 vssd1 vccd1 SS_sky130_fd_sc_hd__dlygate4sd3_1
XFILLER_89_334 vssd1 vccd1 vccd1 vssd1 SS_sky130_fd_sc_hd__fill_2
XFILLER_89_345 vssd1 vccd1 vssd1 vccd1 SS_sky130_ef_sc_hd__decap_40_12
XFILLER_104_645 vssd1 vccd1 vssd1 vccd1 SS_sky130_ef_sc_hd__decap_40_12
XFILLER_103_111 vccd1 vssd1 vccd1 vssd1 SS_sky130_fd_sc_hd__fill_1
Xhold585 _1668_/D _1281_/X vccd1 vssd1 vssd1 vccd1 SS_sky130_fd_sc_hd__dlygate4sd3_1
XFILLER_77_529 vssd1 vccd1 vccd1 vssd1 SS_sky130_fd_sc_hd__fill_4
XFILLER_58_721 vssd1 vccd1 vssd1 vccd1 SS_sky130_ef_sc_hd__decap_40_12
XFILLER_106_65 vssd1 vccd1 vssd1 vccd1 SS_sky130_ef_sc_hd__decap_40_12
XFILLER_72_245 vssd1 vccd1 vccd1 vssd1 SS_sky130_fd_sc_hd__fill_4
XFILLER_122_53 vssd1 vccd1 vssd1 vccd1 SS_sky130_ef_sc_hd__decap_40_12
XFILLER_14_813 vssd1 vccd1 vccd1 vssd1 SS_sky130_fd_sc_hd__fill_4
XFILLER_32_109 vssd1 vccd1 vssd1 vccd1 SS_sky130_ef_sc_hd__decap_40_12
XFILLER_60_407 vssd1 vccd1 vssd1 vccd1 SS_sky130_ef_sc_hd__decap_40_12
XFILLER_72_289 vssd1 vccd1 vssd1 vccd1 SS_sky130_ef_sc_hd__decap_40_12
XFILLER_122_97 vssd1 vccd1 vssd1 vccd1 SS_sky130_ef_sc_hd__decap_40_12
XTAP_TAPCELL_ROW_0_282 vccd1 vssd1 SS_sky130_fd_sc_hd__tapvpwrvgnd_1
XTAP_TAPCELL_ROW_0_293 vccd1 vssd1 SS_sky130_fd_sc_hd__tapvpwrvgnd_1
XFILLER_25_161 vssd1 vccd1 vccd1 vssd1 SS_sky130_fd_sc_hd__fill_4
XFILLER_9_305 vssd1 vccd1 vssd1 vccd1 SS_sky130_ef_sc_hd__decap_40_12
XFILLER_15_51 vssd1 vccd1 vccd1 vssd1 SS_sky130_fd_sc_hd__fill_4
XFILLER_40_153 vssd1 vccd1 vssd1 vccd1 SS_sky130_ef_sc_hd__decap_40_12
XFILLER_9_349 vssd1 vccd1 vssd1 vccd1 SS_sky130_ef_sc_hd__decap_40_12
XFILLER_13_389 vssd1 vccd1 vccd1 vssd1 SS_sky130_fd_sc_hd__fill_2
XFILLER_40_197 vssd1 vccd1 vssd1 vccd1 SS_sky130_ef_sc_hd__decap_40_12
XFILLER_127_748 vssd1 vccd1 vssd1 vccd1 SS_sky130_ef_sc_hd__decap_40_12
XFILLER_107_461 vssd1 vccd1 vccd1 vssd1 SS_sky130_fd_sc_hd__fill_8
XFILLER_99_109 vssd1 vccd1 vccd1 vssd1 SS_sky130_fd_sc_hd__fill_2
Xoutput61 vccd1 vssd1 wire299/A _1835_/X vccd1 vssd1 SS_sky130_fd_sc_hd__buf_4
XTAP_TAPCELL_ROW_56_1142 vccd1 vssd1 SS_sky130_fd_sc_hd__tapvpwrvgnd_1
XFILLER_96_805 vssd1 vccd1 vccd1 vssd1 SS_sky130_fd_sc_hd__fill_2
Xoutput72 vccd1 vssd1 wire288/A _1836_/X vccd1 vssd1 SS_sky130_fd_sc_hd__buf_4
Xoutput83 vccd1 vssd1 wire277/A _1844_/X vccd1 vssd1 SS_sky130_fd_sc_hd__buf_4
Xoutput94 vccd1 vssd1 wire266/A _1854_/X vccd1 vssd1 SS_sky130_fd_sc_hd__buf_4
XFILLER_68_529 vssd1 vccd1 vccd1 vssd1 SS_sky130_fd_sc_hd__fill_2
XFILLER_1_783 vccd1 vssd1 vccd1 vssd1 SS_sky130_fd_sc_hd__fill_1
XFILLER_49_710 vssd1 vccd1 vccd1 vssd1 SS_sky130_fd_sc_hd__fill_2
XFILLER_49_721 vssd1 vccd1 vccd1 vssd1 SS_sky130_fd_sc_hd__fill_4
XFILLER_110_637 vssd1 vccd1 vccd1 vssd1 SS_sky130_fd_sc_hd__fill_4
XFILLER_95_337 vssd1 vccd1 vssd1 vccd1 SS_sky130_ef_sc_hd__decap_40_12
XFILLER_48_253 vssd1 vccd1 vssd1 vccd1 SS_sky130_ef_sc_hd__decap_40_12
XFILLER_49_765 vssd1 vccd1 vssd1 vccd1 SS_sky130_ef_sc_hd__decap_40_12
XFILLER_64_713 vssd1 vccd1 vssd1 vccd1 SS_sky130_ef_sc_hd__decap_40_12
XFILLER_63_223 vccd1 vssd1 vccd1 vssd1 SS_sky130_fd_sc_hd__fill_1
XFILLER_64_757 vssd1 vccd1 vssd1 vccd1 SS_sky130_ef_sc_hd__decap_40_12
XFILLER_17_673 vssd1 vccd1 vssd1 vccd1 SS_sky130_ef_sc_hd__decap_40_12
XFILLER_23_109 vssd1 vccd1 vccd1 vssd1 SS_sky130_fd_sc_hd__fill_2
XTAP_TAPCELL_ROW_47_999 vccd1 vssd1 SS_sky130_fd_sc_hd__tapvpwrvgnd_1
XFILLER_51_407 vccd1 vssd1 vccd1 vssd1 SS_sky130_fd_sc_hd__fill_1
XFILLER_32_698 vssd1 vccd1 vccd1 vssd1 SS_sky130_fd_sc_hd__fill_2
XFILLER_82_3 vssd1 vccd1 vssd1 vccd1 SS_sky130_ef_sc_hd__decap_40_12
XTAP_TAPCELL_ROW_80_1493 vccd1 vssd1 SS_sky130_fd_sc_hd__tapvpwrvgnd_1
XFILLER_118_737 vssd1 vccd1 vccd1 vssd1 SS_sky130_fd_sc_hd__fill_8
XFILLER_117_225 vssd1 vccd1 vssd1 vccd1 SS_sky130_ef_sc_hd__decap_40_12
XFILLER_133_729 vssd1 vccd1 vssd1 vccd1 SS_sky130_ef_sc_hd__decap_40_12
X_1625_ _1625_/Q _1753_/CLK _1625_/D vccd1 vssd1 vccd1 vssd1 SS_sky130_fd_sc_hd__dfxtp_2
X_1556_ _1556_/Q _1742_/CLK _1556_/D vccd1 vssd1 vccd1 vssd1 SS_sky130_fd_sc_hd__dfxtp_2
XFILLER_125_291 vccd1 vssd1 vccd1 vssd1 SS_sky130_fd_sc_hd__fill_1
XFILLER_59_529 vssd1 vccd1 vccd1 vssd1 SS_sky130_fd_sc_hd__fill_4
XFILLER_101_615 vccd1 vssd1 vccd1 vssd1 SS_sky130_fd_sc_hd__fill_1
XFILLER_98_153 vssd1 vccd1 vssd1 vccd1 SS_sky130_ef_sc_hd__decap_40_12
X_1487_ _1487_/Q _1738_/CLK _1487_/D vccd1 vssd1 vccd1 vssd1 SS_sky130_fd_sc_hd__dfxtp_2
XFILLER_113_497 vssd1 vccd1 vccd1 vssd1 SS_sky130_fd_sc_hd__fill_4
XFILLER_98_197 vssd1 vccd1 vssd1 vccd1 SS_sky130_ef_sc_hd__decap_40_12
XFILLER_67_540 vssd1 vccd1 vccd1 vssd1 SS_sky130_fd_sc_hd__fill_2
XTAP_TAPCELL_ROW_87_1603 vccd1 vssd1 SS_sky130_fd_sc_hd__tapvpwrvgnd_1
XFILLER_67_573 vssd1 vccd1 vssd1 vccd1 SS_sky130_ef_sc_hd__decap_40_12
XFILLER_54_245 vssd1 vccd1 vccd1 vssd1 SS_sky130_fd_sc_hd__fill_4
XFILLER_14_109 vssd1 vccd1 vssd1 vccd1 SS_sky130_ef_sc_hd__decap_40_12
XFILLER_54_289 vssd1 vccd1 vssd1 vccd1 SS_sky130_ef_sc_hd__decap_40_12
XFILLER_52_27 vccd1 vssd1 vccd1 vssd1 SS_sky130_fd_sc_hd__fill_1
XFILLER_22_153 vssd1 vccd1 vssd1 vccd1 SS_sky130_ef_sc_hd__decap_40_12
XFILLER_50_473 vssd1 vccd1 vccd1 vssd1 SS_sky130_fd_sc_hd__fill_2
XFILLER_7_809 vssd1 vccd1 vssd1 vccd1 SS_sky130_ef_sc_hd__decap_40_12
XFILLER_22_197 vssd1 vccd1 vssd1 vccd1 SS_sky130_ef_sc_hd__decap_40_12
XFILLER_50_495 vssd1 vccd1 vssd1 vccd1 SS_sky130_ef_sc_hd__decap_40_12
XFILLER_109_726 vssd1 vccd1 vccd1 vssd1 SS_sky130_fd_sc_hd__fill_2
XTAP_TAPCELL_ROW_98_1765 vccd1 vssd1 SS_sky130_fd_sc_hd__tapvpwrvgnd_1
XTAP_TAPCELL_ROW_98_1776 vccd1 vssd1 SS_sky130_fd_sc_hd__tapvpwrvgnd_1
XFILLER_136_578 vccd1 vssd1 vccd1 vssd1 SS_sky130_fd_sc_hd__fill_1
XFILLER_136_589 vssd1 vccd1 vssd1 vccd1 SS_sky130_ef_sc_hd__decap_40_12
XFILLER_123_217 vssd1 vccd1 vccd1 vssd1 SS_sky130_fd_sc_hd__fill_4
XFILLER_2_525 vssd1 vccd1 vccd1 vssd1 SS_sky130_fd_sc_hd__fill_4
XFILLER_2_569 vssd1 vccd1 vssd1 vccd1 SS_sky130_ef_sc_hd__decap_40_12
XFILLER_77_57 vssd1 vccd1 vssd1 vccd1 SS_sky130_ef_sc_hd__decap_40_12
XFILLER_77_315 vccd1 vssd1 vccd1 vssd1 SS_sky130_fd_sc_hd__fill_1
XTAP_TAPCELL_ROW_129_2231 vccd1 vssd1 SS_sky130_fd_sc_hd__tapvpwrvgnd_1
XTAP_TAPCELL_ROW_129_2242 vccd1 vssd1 SS_sky130_fd_sc_hd__tapvpwrvgnd_1
XFILLER_131_261 vssd1 vccd1 vccd1 vssd1 SS_sky130_fd_sc_hd__fill_4
XTAP_TAPCELL_ROW_51_1061 vccd1 vssd1 SS_sky130_fd_sc_hd__tapvpwrvgnd_1
XFILLER_133_30 vssd1 vccd1 vssd1 vccd1 SS_sky130_ef_sc_hd__decap_40_12
XFILLER_92_307 vccd1 vssd1 vccd1 vssd1 SS_sky130_fd_sc_hd__fill_1
XTAP_TAPCELL_ROW_5_374 vccd1 vssd1 SS_sky130_fd_sc_hd__tapvpwrvgnd_1
XFILLER_46_713 vssd1 vccd1 vssd1 vccd1 SS_sky130_ef_sc_hd__decap_40_12
XTAP_TAPCELL_ROW_51_1072 vccd1 vssd1 SS_sky130_fd_sc_hd__tapvpwrvgnd_1
XFILLER_45_223 vccd1 vssd1 vccd1 vssd1 SS_sky130_fd_sc_hd__fill_1
XFILLER_46_757 vssd1 vccd1 vssd1 vccd1 SS_sky130_ef_sc_hd__decap_40_12
XFILLER_61_727 vccd1 vssd1 vccd1 vssd1 SS_sky130_fd_sc_hd__fill_1
XFILLER_26_83 vccd1 vssd1 vccd1 vssd1 SS_sky130_fd_sc_hd__fill_1
XFILLER_33_429 vssd1 vccd1 vssd1 vccd1 SS_sky130_ef_sc_hd__decap_40_12
XTAP_TAPCELL_ROW_44_958 vccd1 vssd1 SS_sky130_fd_sc_hd__tapvpwrvgnd_1
XFILLER_61_749 vssd1 vccd1 vccd1 vssd1 SS_sky130_fd_sc_hd__fill_2
XFILLER_14_643 vccd1 vssd1 vccd1 vssd1 SS_sky130_fd_sc_hd__fill_1
XFILLER_9_113 vssd1 vccd1 vssd1 vccd1 SS_sky130_ef_sc_hd__decap_40_12
XTAP_TAPCELL_ROW_24_660 vccd1 vssd1 SS_sky130_fd_sc_hd__tapvpwrvgnd_1
XFILLER_127_534 vssd1 vccd1 vssd1 vccd1 SS_sky130_ef_sc_hd__decap_40_12
XFILLER_115_729 vssd1 vccd1 vssd1 vccd1 SS_sky130_ef_sc_hd__decap_40_12
XFILLER_115_718 vssd1 vccd1 vccd1 vssd1 SS_sky130_fd_sc_hd__fill_8
XFILLER_108_781 vssd1 vccd1 vssd1 vccd1 SS_sky130_ef_sc_hd__decap_40_12
XFILLER_5_385 vssd1 vccd1 vccd1 vssd1 SS_sky130_fd_sc_hd__fill_4
X_1410_ vccd1 vssd1 vccd1 vssd1 _1410_/X _1410_/A _1466_/B SS_sky130_fd_sc_hd__or2_2
XFILLER_3_54 vssd1 vccd1 vccd1 vssd1 SS_sky130_fd_sc_hd__fill_2
X_1341_ vssd1 vccd1 vccd1 vssd1 _1277_/Y input44/X _1698_/D _1471_/C1 _1340_/X SS_sky130_fd_sc_hd__o211a_2
XFILLER_84_808 vssd1 vccd1 vccd1 vssd1 SS_sky130_fd_sc_hd__fill_4
X_1272_ vccd1 vssd1 vccd1 vssd1 _1272_/X _1665_/Q _1272_/B SS_sky130_fd_sc_hd__or2_2
XFILLER_96_657 vssd1 vccd1 vccd1 vssd1 SS_sky130_fd_sc_hd__fill_8
XFILLER_49_573 vssd1 vccd1 vssd1 vccd1 SS_sky130_ef_sc_hd__decap_40_12
XFILLER_83_307 vccd1 vssd1 vccd1 vssd1 SS_sky130_fd_sc_hd__fill_1
XFILLER_95_167 vccd1 vssd1 vccd1 vssd1 SS_sky130_fd_sc_hd__fill_1
XTAP_TAPCELL_ROW_69_1333 vccd1 vssd1 SS_sky130_fd_sc_hd__tapvpwrvgnd_1
XFILLER_36_245 vssd1 vccd1 vccd1 vssd1 SS_sky130_fd_sc_hd__fill_4
XFILLER_36_289 vssd1 vccd1 vssd1 vccd1 SS_sky130_ef_sc_hd__decap_40_12
XFILLER_51_237 vssd1 vccd1 vssd1 vccd1 SS_sky130_ef_sc_hd__decap_40_12
XFILLER_52_749 vssd1 vccd1 vccd1 vssd1 SS_sky130_fd_sc_hd__fill_4
XTAP_TAPCELL_ROW_82_1533 vccd1 vssd1 SS_sky130_fd_sc_hd__tapvpwrvgnd_1
XFILLER_20_613 vssd1 vccd1 vssd1 vccd1 SS_sky130_ef_sc_hd__decap_40_12
XFILLER_32_473 vssd1 vccd1 vccd1 vssd1 SS_sky130_fd_sc_hd__fill_2
XFILLER_20_657 vssd1 vccd1 vssd1 vccd1 SS_sky130_ef_sc_hd__decap_40_12
XFILLER_138_19 vccd1 vssd1 vccd1 vssd1 SS_sky130_fd_sc_hd__fill_1
XFILLER_118_512 vssd1 vccd1 vssd1 vccd1 SS_sky130_ef_sc_hd__decap_40_12
X_0987_ vssd1 vccd1 vccd1 vssd1 wire253/X input30/X _1526_/D _1381_/C1 _0986_/X SS_sky130_fd_sc_hd__o211a_2
XFILLER_118_545 vssd1 vccd1 vssd1 vccd1 SS_sky130_ef_sc_hd__decap_40_12
XFILLER_118_589 vssd1 vccd1 vssd1 vccd1 SS_sky130_ef_sc_hd__decap_40_12
XFILLER_105_217 vssd1 vccd1 vccd1 vssd1 SS_sky130_fd_sc_hd__fill_4
X_1608_ _1868_/A _1608_/CLK _1608_/D vccd1 vssd1 vccd1 vssd1 SS_sky130_fd_sc_hd__dfxtp_2
XFILLER_120_209 vssd1 vccd1 vssd1 vccd1 SS_sky130_ef_sc_hd__decap_40_12
XTAP_TAPCELL_ROW_93_1695 vccd1 vssd1 SS_sky130_fd_sc_hd__tapvpwrvgnd_1
X_1539_ _1826_/A _1573_/CLK _1539_/D vccd1 vssd1 vccd1 vssd1 SS_sky130_fd_sc_hd__dfxtp_2
XFILLER_59_337 vssd1 vccd1 vssd1 vccd1 SS_sky130_ef_sc_hd__decap_40_12
XFILLER_87_646 vssd1 vccd1 vssd1 vccd1 SS_sky130_ef_sc_hd__decap_40_12
XFILLER_113_261 vssd1 vccd1 vssd1 vccd1 SS_sky130_ef_sc_hd__decap_40_12
XFILLER_47_27 vssd1 vccd1 vssd1 vccd1 SS_sky130_ef_sc_hd__decap_40_12
XFILLER_28_713 vssd1 vccd1 vccd1 vssd1 SS_sky130_fd_sc_hd__fill_8
XFILLER_74_307 vccd1 vssd1 vccd1 vssd1 SS_sky130_fd_sc_hd__fill_1
XFILLER_86_189 vssd1 vccd1 vccd1 vssd1 SS_sky130_fd_sc_hd__fill_4
XTAP_TAPCELL_ROW_2_333 vccd1 vssd1 SS_sky130_fd_sc_hd__tapvpwrvgnd_1
XFILLER_27_223 vccd1 vssd1 vccd1 vssd1 SS_sky130_fd_sc_hd__fill_1
XFILLER_28_757 vssd1 vccd1 vccd1 vssd1 SS_sky130_fd_sc_hd__fill_2
XFILLER_55_543 vssd1 vccd1 vssd1 vccd1 SS_sky130_ef_sc_hd__decap_40_12
XFILLER_83_841 vccd1 vssd1 vccd1 vssd1 SS_sky130_fd_sc_hd__fill_1
XTAP_TAPCELL_ROW_124_2161 vccd1 vssd1 SS_sky130_fd_sc_hd__tapvpwrvgnd_1
XFILLER_15_429 vssd1 vccd1 vssd1 vccd1 SS_sky130_ef_sc_hd__decap_40_12
XFILLER_43_749 vssd1 vccd1 vccd1 vssd1 SS_sky130_fd_sc_hd__fill_4
XFILLER_70_513 vssd1 vccd1 vssd1 vccd1 SS_sky130_ef_sc_hd__decap_40_12
XFILLER_70_557 vssd1 vccd1 vssd1 vccd1 SS_sky130_ef_sc_hd__decap_40_12
XFILLER_11_613 vssd1 vccd1 vccd1 vssd1 SS_sky130_fd_sc_hd__fill_2
XFILLER_23_473 vssd1 vccd1 vssd1 vccd1 SS_sky130_ef_sc_hd__decap_40_12
XTAP_TAPCELL_ROW_41_917 vccd1 vssd1 SS_sky130_fd_sc_hd__tapvpwrvgnd_1
XFILLER_128_309 vssd1 vccd1 vccd1 vssd1 SS_sky130_fd_sc_hd__fill_2
XFILLER_7_617 vssd1 vccd1 vssd1 vccd1 SS_sky130_ef_sc_hd__decap_40_12
XFILLER_109_501 vssd1 vccd1 vccd1 vssd1 SS_sky130_fd_sc_hd__fill_2
XFILLER_10_189 vssd1 vccd1 vccd1 vssd1 SS_sky130_fd_sc_hd__fill_4
XFILLER_12_41 vssd1 vccd1 vssd1 vccd1 SS_sky130_ef_sc_hd__decap_40_12
XFILLER_12_85 vssd1 vccd1 vssd1 vccd1 SS_sky130_ef_sc_hd__decap_40_12
XFILLER_128_41 vssd1 vccd1 vssd1 vccd1 SS_sky130_ef_sc_hd__decap_40_12
XFILLER_136_375 vccd1 vssd1 vccd1 vssd1 SS_sky130_fd_sc_hd__fill_1
XFILLER_128_85 vssd1 vccd1 vssd1 vccd1 SS_sky130_ef_sc_hd__decap_40_12
XFILLER_2_333 vssd1 vccd1 vssd1 vccd1 SS_sky130_ef_sc_hd__decap_40_12
XTAP_TAPCELL_ROW_53_1101 vccd1 vssd1 SS_sky130_fd_sc_hd__tapvpwrvgnd_1
XFILLER_2_377 vssd1 vccd1 vssd1 vccd1 SS_sky130_ef_sc_hd__decap_40_12
XFILLER_78_613 vssd1 vccd1 vssd1 vccd1 SS_sky130_ef_sc_hd__decap_40_12
XFILLER_66_819 vccd1 vssd1 vccd1 vssd1 SS_sky130_fd_sc_hd__fill_1
XFILLER_77_167 vccd1 vssd1 vccd1 vssd1 SS_sky130_fd_sc_hd__fill_1
XTAP_TAPCELL_ROW_29_730 vccd1 vssd1 SS_sky130_fd_sc_hd__tapvpwrvgnd_1
XTAP_TAPCELL_ROW_109_1934 vccd1 vssd1 SS_sky130_fd_sc_hd__tapvpwrvgnd_1
XFILLER_92_137 vssd1 vccd1 vccd1 vssd1 SS_sky130_fd_sc_hd__fill_2
XPHY_EDGE_ROW_16_Right_16 vccd1 vssd1 vccd1 vssd1 SS_sky130_fd_sc_hd__decap_3
XFILLER_18_245 vssd1 vccd1 vccd1 vssd1 SS_sky130_fd_sc_hd__fill_4
XFILLER_19_779 vssd1 vccd1 vccd1 vssd1 SS_sky130_fd_sc_hd__fill_4
XTAP_TAPCELL_ROW_29_741 vccd1 vssd1 SS_sky130_fd_sc_hd__tapvpwrvgnd_1
XFILLER_37_93 vssd1 vccd1 vssd1 vccd1 SS_sky130_ef_sc_hd__decap_40_12
XFILLER_61_502 vssd1 vccd1 vccd1 vssd1 SS_sky130_fd_sc_hd__fill_2
XFILLER_18_289 vssd1 vccd1 vssd1 vccd1 SS_sky130_ef_sc_hd__decap_40_12
XFILLER_46_587 vccd1 vssd1 vccd1 vssd1 SS_sky130_fd_sc_hd__fill_1
XFILLER_33_237 vssd1 vccd1 vssd1 vccd1 SS_sky130_ef_sc_hd__decap_40_12
XFILLER_61_557 vssd1 vccd1 vccd1 vssd1 SS_sky130_fd_sc_hd__fill_2
XFILLER_14_473 vssd1 vccd1 vccd1 vssd1 SS_sky130_fd_sc_hd__fill_2
XFILLER_53_81 vssd1 vccd1 vssd1 vccd1 SS_sky130_ef_sc_hd__decap_40_12
XTAP_TAPCELL_ROW_64_1263 vccd1 vssd1 SS_sky130_fd_sc_hd__tapvpwrvgnd_1
X_0910_ vccd1 vssd1 vccd1 vssd1 _1693_/Q _1277_/A _1725_/Q wire452/X _0913_/B SS_sky130_fd_sc_hd__a22o_2
XFILLER_41_281 vssd1 vccd1 vssd1 vccd1 SS_sky130_ef_sc_hd__decap_40_12
X_1890_ vccd1 vssd1 _1890_/X _1890_/A vccd1 vssd1 SS_sky130_fd_sc_hd__buf_2
X_0841_ vssd1 vccd1 vssd1 vccd1 _0927_/A2 _1877_/A _0751_/X _0839_/X _0841_/X _0840_/X
+ SS_sky130_fd_sc_hd__a2111o_2
XPHY_EDGE_ROW_25_Right_25 vccd1 vssd1 vccd1 vssd1 SS_sky130_fd_sc_hd__decap_3
X_0772_ vccd1 vssd1 vccd1 vssd1 _1829_/A wire424/X _1881_/A wire454/X _0772_/X SS_sky130_fd_sc_hd__a22o_2
XFILLER_127_397 vccd1 vssd1 vccd1 vssd1 SS_sky130_fd_sc_hd__fill_1
XFILLER_5_193 vssd1 vccd1 vssd1 vccd1 SS_sky130_ef_sc_hd__decap_40_12
XFILLER_45_3 vssd1 vccd1 vssd1 vccd1 SS_sky130_ef_sc_hd__decap_40_12
XFILLER_130_518 vssd1 vccd1 vssd1 vccd1 SS_sky130_ef_sc_hd__decap_40_12
XFILLER_102_209 vssd1 vccd1 vssd1 vccd1 SS_sky130_ef_sc_hd__decap_40_12
XFILLER_69_613 vssd1 vccd1 vccd1 vssd1 SS_sky130_fd_sc_hd__fill_2
XFILLER_111_721 vssd1 vccd1 vccd1 vssd1 SS_sky130_fd_sc_hd__fill_4
XFILLER_57_819 vccd1 vssd1 vccd1 vssd1 SS_sky130_fd_sc_hd__fill_1
XFILLER_84_605 vccd1 vssd1 vccd1 vssd1 SS_sky130_fd_sc_hd__fill_1
X_1324_ vccd1 vssd1 vccd1 vssd1 _1324_/X _1324_/A _1330_/B SS_sky130_fd_sc_hd__or2_2
XFILLER_96_454 vccd1 vssd1 vccd1 vssd1 SS_sky130_fd_sc_hd__fill_1
XFILLER_56_307 vccd1 vssd1 vccd1 vssd1 SS_sky130_fd_sc_hd__fill_1
XFILLER_56_329 vssd1 vccd1 vccd1 vssd1 SS_sky130_fd_sc_hd__fill_2
XFILLER_68_189 vssd1 vccd1 vccd1 vssd1 SS_sky130_fd_sc_hd__fill_4
XFILLER_110_253 vssd1 vccd1 vssd1 vccd1 SS_sky130_ef_sc_hd__decap_40_12
XPHY_EDGE_ROW_34_Right_34 vccd1 vssd1 vccd1 vssd1 SS_sky130_fd_sc_hd__decap_3
XFILLER_37_521 vssd1 vccd1 vccd1 vssd1 SS_sky130_fd_sc_hd__fill_2
XFILLER_37_532 vssd1 vccd1 vccd1 vssd1 SS_sky130_fd_sc_hd__fill_8
XFILLER_65_841 vccd1 vssd1 vccd1 vssd1 SS_sky130_fd_sc_hd__fill_1
XFILLER_83_137 vssd1 vccd1 vssd1 vccd1 SS_sky130_ef_sc_hd__decap_40_12
X_1255_ vssd1 vccd1 vccd1 vssd1 _1267_/A2 input33/X _1656_/D _1387_/C1 _1254_/X SS_sky130_fd_sc_hd__o211a_2
X_1186_ vccd1 vssd1 vccd1 vssd1 _1186_/X _1186_/A _1186_/B SS_sky130_fd_sc_hd__or2_2
XFILLER_25_727 vccd1 vssd1 vccd1 vssd1 SS_sky130_fd_sc_hd__fill_1
XFILLER_52_513 vssd1 vccd1 vssd1 vccd1 SS_sky130_ef_sc_hd__decap_40_12
XFILLER_91_181 vssd1 vccd1 vssd1 vccd1 SS_sky130_ef_sc_hd__decap_40_12
XFILLER_52_568 vssd1 vccd1 vssd1 vccd1 SS_sky130_ef_sc_hd__decap_40_12
XFILLER_33_18 vssd1 vccd1 vssd1 vccd1 SS_sky130_ef_sc_hd__decap_40_12
XFILLER_20_421 vssd1 vccd1 vssd1 vccd1 SS_sky130_ef_sc_hd__decap_40_12
XFILLER_33_793 vccd1 vssd1 vccd1 vssd1 SS_sky130_fd_sc_hd__fill_1
XPHY_EDGE_ROW_43_Right_43 vccd1 vssd1 vccd1 vssd1 SS_sky130_fd_sc_hd__decap_3
XTAP_TAPCELL_ROW_95_1724 vccd1 vssd1 SS_sky130_fd_sc_hd__tapvpwrvgnd_1
XTAP_TAPCELL_ROW_7_403 vccd1 vssd1 SS_sky130_fd_sc_hd__tapvpwrvgnd_1
XFILLER_58_26 vssd1 vccd1 vccd1 vssd1 SS_sky130_fd_sc_hd__fill_2
XFILLER_121_529 vssd1 vccd1 vccd1 vssd1 SS_sky130_fd_sc_hd__fill_4
XFILLER_99_281 vssd1 vccd1 vssd1 vccd1 SS_sky130_ef_sc_hd__decap_40_12
XFILLER_47_329 vssd1 vccd1 vccd1 vssd1 SS_sky130_fd_sc_hd__fill_4
XPHY_EDGE_ROW_52_Right_52 vccd1 vssd1 vccd1 vssd1 SS_sky130_fd_sc_hd__decap_3
XFILLER_59_167 vccd1 vssd1 vccd1 vssd1 SS_sky130_fd_sc_hd__fill_1
XFILLER_75_605 vssd1 vccd1 vccd1 vssd1 SS_sky130_fd_sc_hd__fill_2
XFILLER_74_137 vssd1 vccd1 vccd1 vssd1 SS_sky130_fd_sc_hd__fill_2
XFILLER_114_65 vssd1 vccd1 vssd1 vccd1 SS_sky130_ef_sc_hd__decap_40_12
XFILLER_71_800 vssd1 vccd1 vssd1 vccd1 SS_sky130_ef_sc_hd__decap_40_12
XFILLER_16_749 vssd1 vccd1 vccd1 vssd1 SS_sky130_fd_sc_hd__fill_4
XFILLER_28_587 vccd1 vssd1 vccd1 vssd1 SS_sky130_fd_sc_hd__fill_1
XFILLER_15_237 vssd1 vccd1 vssd1 vccd1 SS_sky130_ef_sc_hd__decap_40_12
XFILLER_130_53 vssd1 vccd1 vssd1 vccd1 SS_sky130_ef_sc_hd__decap_40_12
XFILLER_70_365 vssd1 vccd1 vssd1 vccd1 SS_sky130_ef_sc_hd__decap_40_12
XFILLER_130_97 vssd1 vccd1 vssd1 vccd1 SS_sky130_ef_sc_hd__decap_40_12
XTAP_TAPCELL_ROW_104_1864 vccd1 vssd1 SS_sky130_fd_sc_hd__tapvpwrvgnd_1
XTAP_TAPCELL_ROW_104_1853 vccd1 vssd1 SS_sky130_fd_sc_hd__tapvpwrvgnd_1
XFILLER_23_281 vssd1 vccd1 vssd1 vccd1 SS_sky130_ef_sc_hd__decap_40_12
XFILLER_24_793 vssd1 vccd1 vccd1 vssd1 SS_sky130_fd_sc_hd__fill_4
XPHY_EDGE_ROW_61_Right_61 vccd1 vssd1 vccd1 vssd1 SS_sky130_fd_sc_hd__decap_3
Xwire323 vccd1 vssd1 vssd1 vccd1 wire323/A analog_ctrl[53] SS_sky130_fd_sc_hd__buf_12
Xwire312 vccd1 vssd1 vssd1 vccd1 wire312/A analog_ctrl[63] SS_sky130_fd_sc_hd__buf_12
XFILLER_129_629 vssd1 vccd1 vccd1 vssd1 SS_sky130_fd_sc_hd__fill_2
XTAP_TAPCELL_ROW_137_2352 vccd1 vssd1 SS_sky130_fd_sc_hd__tapvpwrvgnd_1
Xwire301 vccd1 vssd1 vssd1 vccd1 wire301/A analog_ctrl[108] SS_sky130_fd_sc_hd__buf_12
XFILLER_7_447 vccd1 vssd1 vccd1 vssd1 SS_sky130_fd_sc_hd__fill_1
Xwire334 vccd1 vssd1 vssd1 vccd1 wire334/A analog_ctrl[43] SS_sky130_fd_sc_hd__buf_12
XFILLER_128_139 vccd1 vssd1 vccd1 vssd1 SS_sky130_fd_sc_hd__fill_1
Xwire356 vccd1 vssd1 vssd1 vccd1 wire356/A wbs_dat_o[6] SS_sky130_fd_sc_hd__buf_12
Xwire378 vccd1 vssd1 vssd1 vccd1 wire378/A wbs_dat_o[15] SS_sky130_fd_sc_hd__buf_12
Xwire367 vccd1 vssd1 vssd1 vccd1 wire367/A wbs_dat_o[25] SS_sky130_fd_sc_hd__buf_12
Xwire389 vccd1 vssd1 vssd1 vccd1 wire389/A analog_ctrl[92] SS_sky130_fd_sc_hd__buf_12
XFILLER_99_55 vccd1 vssd1 vccd1 vssd1 SS_sky130_fd_sc_hd__fill_1
XFILLER_136_161 vccd1 vssd1 vccd1 vssd1 SS_sky130_fd_sc_hd__fill_1
XFILLER_3_653 vssd1 vccd1 vssd1 vccd1 SS_sky130_ef_sc_hd__decap_40_12
XFILLER_2_141 vssd1 vccd1 vssd1 vccd1 SS_sky130_ef_sc_hd__decap_40_12
XFILLER_3_697 vssd1 vccd1 vssd1 vccd1 SS_sky130_ef_sc_hd__decap_40_12
XPHY_EDGE_ROW_70_Right_70 vccd1 vssd1 vccd1 vssd1 SS_sky130_fd_sc_hd__decap_3
XFILLER_78_421 vssd1 vccd1 vccd1 vssd1 SS_sky130_fd_sc_hd__fill_4
XFILLER_38_307 vccd1 vssd1 vccd1 vssd1 SS_sky130_fd_sc_hd__fill_1
XFILLER_47_841 vccd1 vssd1 vccd1 vssd1 SS_sky130_fd_sc_hd__fill_1
XFILLER_48_81 vssd1 vccd1 vccd1 vssd1 SS_sky130_fd_sc_hd__fill_2
XFILLER_65_137 vssd1 vccd1 vssd1 vccd1 SS_sky130_ef_sc_hd__decap_40_12
X_1040_ vccd1 vssd1 vccd1 vssd1 _1040_/X _1040_/A _1050_/B SS_sky130_fd_sc_hd__or2_2
XFILLER_0_55 vccd1 vssd1 vccd1 vssd1 SS_sky130_fd_sc_hd__fill_1
XFILLER_34_513 vssd1 vccd1 vssd1 vccd1 SS_sky130_ef_sc_hd__decap_40_12
XFILLER_62_811 vccd1 vssd1 vccd1 vssd1 SS_sky130_fd_sc_hd__fill_1
XFILLER_74_693 vssd1 vccd1 vccd1 vssd1 SS_sky130_fd_sc_hd__fill_4
XFILLER_73_181 vssd1 vccd1 vssd1 vccd1 SS_sky130_ef_sc_hd__decap_40_12
XPHY_EDGE_ROW_14_Left_153 vccd1 vssd1 vccd1 vssd1 SS_sky130_fd_sc_hd__decap_3
X_1873_ vccd1 vssd1 _1873_/X _1873_/A vccd1 vssd1 SS_sky130_fd_sc_hd__buf_2
X_0824_ vccd1 vssd1 vssd1 vccd1 _0820_/X _0823_/X _0860_/A2 _1486_/Q _1486_/D _1447_/C1
+ SS_sky130_fd_sc_hd__o221a_2
XTAP_TAPCELL_ROW_12_482 vccd1 vssd1 SS_sky130_fd_sc_hd__tapvpwrvgnd_1
XFILLER_134_109 vssd1 vccd1 vssd1 vccd1 SS_sky130_ef_sc_hd__decap_40_12
XFILLER_116_813 vssd1 vccd1 vccd1 vssd1 SS_sky130_fd_sc_hd__fill_4
XTAP_TAPCELL_ROW_77_1454 vccd1 vssd1 SS_sky130_fd_sc_hd__tapvpwrvgnd_1
XFILLER_127_161 vssd1 vccd1 vccd1 vssd1 SS_sky130_fd_sc_hd__fill_4
X_0755_ vccd1 vssd1 vssd1 vccd1 _0755_/B _0754_/D _0755_/A _0755_/C _0755_/Y SS_sky130_fd_sc_hd__nor4b_4
XPHY_EDGE_ROW_23_Left_162 vccd1 vssd1 vccd1 vssd1 SS_sky130_fd_sc_hd__decap_3
XFILLER_131_805 vccd1 vssd1 vccd1 vssd1 SS_sky130_fd_sc_hd__fill_1
XFILLER_115_356 vssd1 vccd1 vssd1 vccd1 SS_sky130_ef_sc_hd__decap_40_12
XTAP_TAPCELL_ROW_90_1643 vccd1 vssd1 SS_sky130_fd_sc_hd__tapvpwrvgnd_1
XFILLER_115_378 vssd1 vccd1 vssd1 vccd1 SS_sky130_ef_sc_hd__decap_40_12
XFILLER_103_529 vssd1 vccd1 vssd1 vccd1 SS_sky130_ef_sc_hd__decap_40_12
XTAP_TAPCELL_ROW_90_1654 vccd1 vssd1 SS_sky130_fd_sc_hd__tapvpwrvgnd_1
XFILLER_130_348 vssd1 vccd1 vssd1 vccd1 SS_sky130_ef_sc_hd__decap_40_12
XFILLER_97_741 vssd1 vccd1 vssd1 vccd1 SS_sky130_ef_sc_hd__decap_40_12
XFILLER_28_18 vssd1 vccd1 vccd1 vssd1 SS_sky130_fd_sc_hd__fill_8
XFILLER_28_29 vssd1 vccd1 vssd1 vccd1 SS_sky130_ef_sc_hd__decap_40_12
XFILLER_84_413 vssd1 vccd1 vccd1 vssd1 SS_sky130_fd_sc_hd__fill_4
XFILLER_111_573 vssd1 vccd1 vccd1 vssd1 SS_sky130_fd_sc_hd__fill_4
XFILLER_97_785 vssd1 vccd1 vssd1 vccd1 SS_sky130_ef_sc_hd__decap_40_12
XFILLER_96_251 vccd1 vssd1 vccd1 vssd1 SS_sky130_fd_sc_hd__fill_1
XFILLER_29_329 vssd1 vccd1 vccd1 vssd1 SS_sky130_fd_sc_hd__fill_4
XFILLER_56_137 vssd1 vccd1 vccd1 vssd1 SS_sky130_fd_sc_hd__fill_2
X_1307_ vssd1 vccd1 vccd1 vssd1 _1319_/A2 wire498/X _1681_/D _1441_/C1 _1306_/X SS_sky130_fd_sc_hd__o211a_2
X_1238_ vccd1 vssd1 vccd1 vssd1 _1238_/X _1648_/Q _1264_/B SS_sky130_fd_sc_hd__or2_2
XFILLER_37_373 vssd1 vccd1 vssd1 vccd1 SS_sky130_ef_sc_hd__decap_40_12
XFILLER_65_671 vccd1 vssd1 vccd1 vssd1 SS_sky130_fd_sc_hd__fill_1
XTAP_TAPCELL_ROW_121_2120 vccd1 vssd1 SS_sky130_fd_sc_hd__tapvpwrvgnd_1
XFILLER_25_557 vssd1 vccd1 vccd1 vssd1 SS_sky130_fd_sc_hd__fill_2
XPHY_EDGE_ROW_32_Left_171 vccd1 vssd1 vccd1 vssd1 SS_sky130_fd_sc_hd__decap_3
XFILLER_52_321 vssd1 vccd1 vssd1 vccd1 SS_sky130_ef_sc_hd__decap_40_12
X_1169_ vssd1 vccd1 vccd1 vssd1 wire233/A wire500/X _1614_/D _1447_/C1 _1168_/X SS_sky130_fd_sc_hd__o211a_2
XFILLER_80_641 vssd1 vccd1 vccd1 vssd1 SS_sky130_fd_sc_hd__fill_2
XFILLER_52_365 vssd1 vccd1 vssd1 vccd1 SS_sky130_ef_sc_hd__decap_40_12
XFILLER_21_741 vssd1 vccd1 vssd1 vccd1 SS_sky130_ef_sc_hd__decap_40_12
XFILLER_20_251 vccd1 vssd1 vccd1 vssd1 SS_sky130_fd_sc_hd__fill_1
XFILLER_60_27 vccd1 vssd1 vccd1 vssd1 SS_sky130_fd_sc_hd__fill_1
XFILLER_21_785 vssd1 vccd1 vssd1 vccd1 SS_sky130_ef_sc_hd__decap_40_12
XFILLER_125_109 vssd1 vccd1 vccd1 vssd1 SS_sky130_fd_sc_hd__fill_2
XFILLER_119_673 vssd1 vccd1 vssd1 vccd1 SS_sky130_ef_sc_hd__decap_40_12
XTAP_TAPCELL_ROW_119_2082 vccd1 vssd1 SS_sky130_fd_sc_hd__tapvpwrvgnd_1
XFILLER_4_417 vssd1 vccd1 vccd1 vssd1 SS_sky130_fd_sc_hd__fill_2
XPHY_EDGE_ROW_41_Left_180 vccd1 vssd1 vccd1 vssd1 SS_sky130_fd_sc_hd__decap_3
XFILLER_106_301 vssd1 vccd1 vccd1 vssd1 SS_sky130_fd_sc_hd__fill_4
XTAP_TAPCELL_ROW_132_2282 vccd1 vssd1 SS_sky130_fd_sc_hd__tapvpwrvgnd_1
XFILLER_134_643 vccd1 vssd1 vccd1 vssd1 SS_sky130_fd_sc_hd__fill_1
XFILLER_106_334 vssd1 vccd1 vccd1 vssd1 SS_sky130_fd_sc_hd__fill_2
XFILLER_0_601 vssd1 vccd1 vssd1 vccd1 SS_sky130_ef_sc_hd__decap_40_12
XFILLER_69_69 vssd1 vccd1 vssd1 vccd1 SS_sky130_ef_sc_hd__decap_40_12
XFILLER_134_698 vssd1 vccd1 vccd1 vssd1 SS_sky130_fd_sc_hd__fill_2
XFILLER_0_645 vssd1 vccd1 vssd1 vccd1 SS_sky130_ef_sc_hd__decap_40_12
XFILLER_121_337 vssd1 vccd1 vccd1 vssd1 SS_sky130_fd_sc_hd__fill_2
XFILLER_75_413 vssd1 vccd1 vssd1 vccd1 SS_sky130_ef_sc_hd__decap_40_12
XFILLER_102_573 vccd1 vssd1 vccd1 vssd1 SS_sky130_fd_sc_hd__fill_1
XFILLER_29_841 vccd1 vssd1 vccd1 vssd1 SS_sky130_fd_sc_hd__fill_1
XFILLER_47_137 vssd1 vccd1 vssd1 vccd1 SS_sky130_ef_sc_hd__decap_40_12
XFILLER_85_57 vssd1 vccd1 vssd1 vccd1 SS_sky130_ef_sc_hd__decap_40_12
XFILLER_87_273 vssd1 vccd1 vccd1 vssd1 SS_sky130_fd_sc_hd__fill_4
XFILLER_16_513 vssd1 vccd1 vssd1 vccd1 SS_sky130_ef_sc_hd__decap_40_12
XTAP_TAPCELL_ROW_39_880 vccd1 vssd1 SS_sky130_fd_sc_hd__tapvpwrvgnd_1
XTAP_TAPCELL_ROW_48_1022 vccd1 vssd1 SS_sky130_fd_sc_hd__tapvpwrvgnd_1
XFILLER_56_693 vssd1 vccd1 vccd1 vssd1 SS_sky130_fd_sc_hd__fill_4
XFILLER_90_416 vssd1 vccd1 vccd1 vssd1 SS_sky130_fd_sc_hd__fill_4
XFILLER_16_557 vssd1 vccd1 vssd1 vccd1 SS_sky130_ef_sc_hd__decap_40_12
XTAP_TAPCELL_ROW_39_891 vccd1 vssd1 SS_sky130_fd_sc_hd__tapvpwrvgnd_1
XFILLER_55_181 vssd1 vccd1 vssd1 vccd1 SS_sky130_ef_sc_hd__decap_40_12
XFILLER_31_505 vssd1 vccd1 vssd1 vccd1 SS_sky130_ef_sc_hd__decap_40_12
XFILLER_71_685 vssd1 vccd1 vccd1 vssd1 SS_sky130_fd_sc_hd__fill_2
XTAP_TAPCELL_ROW_61_1211 vccd1 vssd1 SS_sky130_fd_sc_hd__tapvpwrvgnd_1
XTAP_TAPCELL_ROW_61_1222 vccd1 vssd1 SS_sky130_fd_sc_hd__tapvpwrvgnd_1
XFILLER_70_195 vccd1 vssd1 vccd1 vssd1 SS_sky130_fd_sc_hd__fill_1
XFILLER_8_701 vssd1 vccd1 vssd1 vccd1 SS_sky130_ef_sc_hd__decap_40_12
XFILLER_34_83 vccd1 vssd1 vccd1 vssd1 SS_sky130_fd_sc_hd__fill_1
XFILLER_11_273 vssd1 vccd1 vccd1 vssd1 SS_sky130_fd_sc_hd__fill_4
XFILLER_12_785 vccd1 vssd1 vccd1 vssd1 SS_sky130_fd_sc_hd__fill_1
XFILLER_116_109 vssd1 vccd1 vssd1 vccd1 SS_sky130_ef_sc_hd__decap_40_12
XFILLER_7_277 vssd1 vccd1 vccd1 vssd1 SS_sky130_fd_sc_hd__fill_2
XFILLER_109_161 vssd1 vccd1 vccd1 vssd1 SS_sky130_fd_sc_hd__fill_4
XTAP_TAPCELL_ROW_59_1184 vccd1 vssd1 SS_sky130_fd_sc_hd__tapvpwrvgnd_1
XFILLER_3_461 vssd1 vccd1 vssd1 vccd1 SS_sky130_ef_sc_hd__decap_40_12
XFILLER_124_153 vssd1 vccd1 vssd1 vccd1 SS_sky130_ef_sc_hd__decap_40_12
XFILLER_79_741 vssd1 vccd1 vssd1 vccd1 SS_sky130_ef_sc_hd__decap_40_12
XFILLER_124_197 vssd1 vccd1 vssd1 vccd1 SS_sky130_ef_sc_hd__decap_40_12
XFILLER_112_359 vssd1 vccd1 vccd1 vssd1 SS_sky130_fd_sc_hd__fill_4
XTAP_TAPCELL_ROW_72_1373 vccd1 vssd1 SS_sky130_fd_sc_hd__tapvpwrvgnd_1
XTAP_TAPCELL_ROW_72_1384 vccd1 vssd1 SS_sky130_fd_sc_hd__tapvpwrvgnd_1
XFILLER_78_251 vccd1 vssd1 vccd1 vssd1 SS_sky130_fd_sc_hd__fill_1
XFILLER_79_785 vssd1 vccd1 vccd1 vssd1 SS_sky130_fd_sc_hd__fill_8
XFILLER_38_137 vssd1 vccd1 vccd1 vssd1 SS_sky130_fd_sc_hd__fill_2
XFILLER_39_649 vssd1 vccd1 vssd1 vccd1 SS_sky130_ef_sc_hd__decap_40_12
XFILLER_93_221 vssd1 vccd1 vccd1 vssd1 SS_sky130_fd_sc_hd__fill_2
XFILLER_81_405 vssd1 vccd1 vssd1 vccd1 SS_sky130_ef_sc_hd__decap_40_12
XFILLER_19_373 vssd1 vccd1 vssd1 vccd1 SS_sky130_ef_sc_hd__decap_40_12
X_1023_ vssd1 vccd1 vccd1 vssd1 _1033_/A2 input46/X _1543_/D _1151_/C1 _1022_/X SS_sky130_fd_sc_hd__o211a_2
XFILLER_47_671 vccd1 vssd1 vccd1 vssd1 SS_sky130_fd_sc_hd__fill_1
XFILLER_34_321 vssd1 vccd1 vssd1 vccd1 SS_sky130_ef_sc_hd__decap_40_12
XFILLER_62_641 vssd1 vccd1 vccd1 vssd1 SS_sky130_fd_sc_hd__fill_2
XFILLER_81_449 vssd1 vccd1 vssd1 vccd1 SS_sky130_ef_sc_hd__decap_40_12
XTAP_TAPCELL_ROW_17_552 vccd1 vssd1 SS_sky130_fd_sc_hd__tapvpwrvgnd_1
XFILLER_34_365 vssd1 vccd1 vssd1 vccd1 SS_sky130_ef_sc_hd__decap_40_12
XFILLER_50_825 vccd1 vssd1 vccd1 vssd1 SS_sky130_fd_sc_hd__fill_1
Xclkbuf_leaf_6_wb_clk_i _1686_/CLK clkbuf_leaf_9_wb_clk_i/A vccd1 vssd1 vssd1 vccd1
+ SS_sky130_fd_sc_hd__clkbuf_8
X_1856_ vccd1 vssd1 _1856_/X _1856_/A vccd1 vssd1 SS_sky130_fd_sc_hd__buf_2
XFILLER_107_109 vssd1 vccd1 vccd1 vssd1 SS_sky130_fd_sc_hd__fill_2
X_0807_ vccd1 vssd1 vccd1 vssd1 input12/X _0815_/B1 _1854_/A wire443/X _0807_/X SS_sky130_fd_sc_hd__a22o_2
XFILLER_128_481 vssd1 vccd1 vccd1 vssd1 SS_sky130_fd_sc_hd__fill_2
Xhold701 _1132_/A _1597_/Q vccd1 vssd1 vssd1 vccd1 SS_sky130_fd_sc_hd__dlygate4sd3_1
Xhold712 _1138_/A _1600_/Q vccd1 vssd1 vssd1 vccd1 SS_sky130_fd_sc_hd__dlygate4sd3_1
Xhold734 _1380_/A _1717_/Q vccd1 vssd1 vssd1 vccd1 SS_sky130_fd_sc_hd__dlygate4sd3_1
X_0738_ vccd1 vssd1 vssd1 vccd1 _1474_/Q _0945_/B _0945_/C _0738_/D _1474_/D SS_sky130_fd_sc_hd__and4b_2
Xhold745 _1058_/A _1561_/Q vccd1 vssd1 vssd1 vccd1 SS_sky130_fd_sc_hd__dlygate4sd3_1
Xhold723 _1555_/D _1047_/X vccd1 vssd1 vssd1 vccd1 SS_sky130_fd_sc_hd__dlygate4sd3_1
Xhold756 _1314_/A _1685_/Q vccd1 vssd1 vssd1 vccd1 SS_sky130_fd_sc_hd__dlygate4sd3_1
Xhold767 input35/A wbs_dat_i[23] vccd1 vssd1 vssd1 vccd1 SS_sky130_fd_sc_hd__dlygate4sd3_1
Xhold778 _1390_/A _1722_/Q vccd1 vssd1 vssd1 vccd1 SS_sky130_fd_sc_hd__dlygate4sd3_1
XFILLER_39_39 vssd1 vccd1 vssd1 vccd1 SS_sky130_ef_sc_hd__decap_40_12
Xhold789 _1505_/D _0938_/X vccd1 vssd1 vssd1 vccd1 SS_sky130_fd_sc_hd__dlygate4sd3_1
XFILLER_69_273 vssd1 vccd1 vccd1 vssd1 SS_sky130_fd_sc_hd__fill_4
XFILLER_84_221 vssd1 vccd1 vssd1 vccd1 SS_sky130_ef_sc_hd__decap_40_12
XFILLER_130_189 vssd1 vccd1 vccd1 vssd1 SS_sky130_fd_sc_hd__fill_4
XFILLER_111_381 vssd1 vccd1 vccd1 vssd1 SS_sky130_fd_sc_hd__fill_2
XPHY_EDGE_ROW_2_Right_2 vccd1 vssd1 vccd1 vssd1 SS_sky130_fd_sc_hd__decap_3
XFILLER_29_137 vssd1 vccd1 vssd1 vccd1 SS_sky130_ef_sc_hd__decap_40_12
XFILLER_55_27 vssd1 vccd1 vssd1 vccd1 SS_sky130_ef_sc_hd__decap_40_12
XFILLER_84_265 vssd1 vccd1 vssd1 vccd1 SS_sky130_ef_sc_hd__decap_40_12
XFILLER_37_181 vssd1 vccd1 vssd1 vccd1 SS_sky130_ef_sc_hd__decap_40_12
XFILLER_38_693 vssd1 vccd1 vccd1 vssd1 SS_sky130_fd_sc_hd__fill_4
XFILLER_53_630 vssd1 vccd1 vssd1 vccd1 SS_sky130_ef_sc_hd__decap_40_12
XFILLER_13_505 vssd1 vccd1 vssd1 vccd1 SS_sky130_ef_sc_hd__decap_40_12
XFILLER_80_471 vssd1 vccd1 vccd1 vssd1 SS_sky130_fd_sc_hd__fill_4
XFILLER_52_195 vccd1 vssd1 vccd1 vssd1 SS_sky130_fd_sc_hd__fill_1
XTAP_TAPCELL_ROW_101_1812 vccd1 vssd1 SS_sky130_fd_sc_hd__tapvpwrvgnd_1
XFILLER_40_357 vssd1 vccd1 vccd1 vssd1 SS_sky130_fd_sc_hd__fill_4
XFILLER_138_223 vccd1 vssd1 vccd1 vssd1 SS_sky130_fd_sc_hd__fill_1
XTAP_TAPCELL_ROW_134_2311 vccd1 vssd1 SS_sky130_fd_sc_hd__tapvpwrvgnd_1
XFILLER_126_429 vssd1 vccd1 vssd1 vccd1 SS_sky130_ef_sc_hd__decap_40_12
XFILLER_112_3 vssd1 vccd1 vssd1 vccd1 SS_sky130_ef_sc_hd__decap_40_12
XFILLER_20_41 vssd1 vccd1 vssd1 vccd1 SS_sky130_ef_sc_hd__decap_40_12
XFILLER_20_85 vssd1 vccd1 vssd1 vccd1 SS_sky130_ef_sc_hd__decap_40_12
XFILLER_106_153 vssd1 vccd1 vssd1 vccd1 SS_sky130_ef_sc_hd__decap_40_12
XFILLER_0_431 vssd1 vccd1 vssd1 vccd1 SS_sky130_ef_sc_hd__decap_40_12
XFILLER_136_85 vssd1 vccd1 vssd1 vccd1 SS_sky130_ef_sc_hd__decap_40_12
XFILLER_122_635 vssd1 vccd1 vccd1 vssd1 SS_sky130_fd_sc_hd__fill_8
XFILLER_106_197 vssd1 vccd1 vssd1 vccd1 SS_sky130_ef_sc_hd__decap_40_12
XFILLER_121_167 vccd1 vssd1 vccd1 vssd1 SS_sky130_fd_sc_hd__fill_1
XTAP_TAPCELL_ROW_112_1985 vccd1 vssd1 SS_sky130_fd_sc_hd__tapvpwrvgnd_1
XTAP_TAPCELL_ROW_112_1974 vccd1 vssd1 SS_sky130_fd_sc_hd__tapvpwrvgnd_1
XFILLER_0_475 vccd1 vssd1 vccd1 vssd1 SS_sky130_fd_sc_hd__fill_1
XFILLER_0_497 vssd1 vccd1 vccd1 vssd1 SS_sky130_fd_sc_hd__fill_4
XFILLER_48_413 vssd1 vccd1 vccd1 vssd1 SS_sky130_fd_sc_hd__fill_4
XFILLER_75_221 vssd1 vccd1 vccd1 vssd1 SS_sky130_fd_sc_hd__fill_2
XFILLER_48_457 vccd1 vssd1 vccd1 vssd1 SS_sky130_fd_sc_hd__fill_1
XFILLER_76_766 vssd1 vccd1 vssd1 vccd1 SS_sky130_ef_sc_hd__decap_40_12
XFILLER_63_427 vssd1 vccd1 vccd1 vssd1 SS_sky130_fd_sc_hd__fill_4
XFILLER_91_725 vssd1 vccd1 vccd1 vssd1 SS_sky130_fd_sc_hd__fill_2
XFILLER_16_321 vssd1 vccd1 vssd1 vccd1 SS_sky130_ef_sc_hd__decap_40_12
XFILLER_44_641 vssd1 vccd1 vccd1 vssd1 SS_sky130_fd_sc_hd__fill_2
XFILLER_63_449 vssd1 vccd1 vssd1 vccd1 SS_sky130_ef_sc_hd__decap_40_12
XFILLER_16_365 vssd1 vccd1 vssd1 vccd1 SS_sky130_ef_sc_hd__decap_40_12
XTAP_TAPCELL_ROW_34_809 vccd1 vssd1 SS_sky130_fd_sc_hd__tapvpwrvgnd_1
XTAP_TAPCELL_ROW_14_511 vccd1 vssd1 SS_sky130_fd_sc_hd__tapvpwrvgnd_1
XFILLER_31_335 vccd1 vssd1 vccd1 vssd1 SS_sky130_fd_sc_hd__fill_1
XFILLER_45_93 vssd1 vccd1 vssd1 vccd1 SS_sky130_ef_sc_hd__decap_40_12
XFILLER_8_531 vccd1 vssd1 vccd1 vssd1 SS_sky130_fd_sc_hd__fill_1
XFILLER_129_223 vccd1 vssd1 vccd1 vssd1 SS_sky130_fd_sc_hd__fill_1
X_1710_ _1710_/Q _1748_/CLK _1710_/D vccd1 vssd1 vccd1 vssd1 SS_sky130_fd_sc_hd__dfxtp_2
XFILLER_61_81 vssd1 vccd1 vssd1 vccd1 SS_sky130_ef_sc_hd__decap_40_12
X_1641_ _1641_/Q clkload7/A _1641_/D vccd1 vssd1 vccd1 vssd1 SS_sky130_fd_sc_hd__dfxtp_2
XANTENNA_3 _1655_/Q vssd1 vccd1 vccd1 vssd1 SS_sky130_fd_sc_hd__diode_2
XFILLER_6_65 vssd1 vccd1 vssd1 vccd1 SS_sky130_ef_sc_hd__decap_40_12
XTAP_TAPCELL_ROW_74_1413 vccd1 vssd1 SS_sky130_fd_sc_hd__tapvpwrvgnd_1
X_1572_ _1842_/A _1576_/CLK _1572_/D vccd1 vssd1 vccd1 vssd1 SS_sky130_fd_sc_hd__dfxtp_2
XFILLER_4_781 vssd1 vccd1 vssd1 vccd1 SS_sky130_ef_sc_hd__decap_40_12
XFILLER_113_635 vssd1 vccd1 vccd1 vssd1 SS_sky130_fd_sc_hd__fill_2
XFILLER_98_357 vssd1 vccd1 vccd1 vssd1 SS_sky130_fd_sc_hd__fill_2
XFILLER_67_711 vssd1 vccd1 vssd1 vccd1 SS_sky130_ef_sc_hd__decap_40_12
XFILLER_100_307 vccd1 vssd1 vccd1 vssd1 SS_sky130_fd_sc_hd__fill_1
XFILLER_79_582 vssd1 vccd1 vssd1 vccd1 SS_sky130_ef_sc_hd__decap_40_12
XFILLER_112_189 vssd1 vccd1 vccd1 vssd1 SS_sky130_fd_sc_hd__fill_4
XFILLER_39_457 vccd1 vssd1 vccd1 vssd1 SS_sky130_fd_sc_hd__fill_1
XFILLER_66_221 vssd1 vccd1 vssd1 vccd1 SS_sky130_ef_sc_hd__decap_40_12
XFILLER_67_777 vssd1 vccd1 vccd1 vssd1 SS_sky130_fd_sc_hd__fill_4
XFILLER_66_265 vssd1 vccd1 vssd1 vccd1 SS_sky130_ef_sc_hd__decap_40_12
XFILLER_19_181 vssd1 vccd1 vssd1 vccd1 SS_sky130_ef_sc_hd__decap_40_12
XFILLER_35_641 vssd1 vccd1 vssd1 vccd1 SS_sky130_ef_sc_hd__decap_40_12
XFILLER_81_279 vccd1 vssd1 vccd1 vssd1 SS_sky130_fd_sc_hd__fill_1
XTAP_TAPCELL_ROW_85_1575 vccd1 vssd1 SS_sky130_fd_sc_hd__tapvpwrvgnd_1
X_1006_ vccd1 vssd1 vccd1 vssd1 _1006_/X _1006_/A _1006_/B SS_sky130_fd_sc_hd__or2_2
XFILLER_35_685 vssd1 vccd1 vssd1 vccd1 SS_sky130_ef_sc_hd__decap_40_12
XFILLER_22_357 vssd1 vccd1 vccd1 vssd1 SS_sky130_fd_sc_hd__fill_4
XFILLER_34_195 vccd1 vssd1 vccd1 vssd1 SS_sky130_fd_sc_hd__fill_1
XFILLER_50_655 vccd1 vssd1 vccd1 vssd1 SS_sky130_fd_sc_hd__fill_1
XFILLER_41_18 vssd1 vccd1 vssd1 vccd1 SS_sky130_ef_sc_hd__decap_40_12
XFILLER_50_699 vccd1 vssd1 vccd1 vssd1 SS_sky130_fd_sc_hd__fill_1
X_1908_ vccd1 vssd1 _1908_/X _1908_/A vccd1 vssd1 SS_sky130_fd_sc_hd__buf_2
X_1839_ vccd1 vssd1 _1839_/X _1839_/A vccd1 vssd1 SS_sky130_fd_sc_hd__buf_2
XTAP_TAPCELL_ROW_116_2041 vccd1 vssd1 SS_sky130_fd_sc_hd__tapvpwrvgnd_1
XFILLER_135_237 vssd1 vccd1 vssd1 vccd1 SS_sky130_ef_sc_hd__decap_40_12
XFILLER_116_451 vccd1 vssd1 vccd1 vssd1 SS_sky130_fd_sc_hd__fill_1
XFILLER_1_217 vssd1 vccd1 vccd1 vssd1 SS_sky130_fd_sc_hd__fill_4
Xhold597 _0970_/A _1518_/Q vccd1 vssd1 vssd1 vccd1 SS_sky130_fd_sc_hd__dlygate4sd3_1
Xhold586 _1416_/A _1898_/A vccd1 vssd1 vssd1 vccd1 SS_sky130_fd_sc_hd__dlygate4sd3_1
XFILLER_131_432 vssd1 vccd1 vssd1 vccd1 SS_sky130_ef_sc_hd__decap_40_12
Xhold564 input50/A wbs_dat_i[8] vccd1 vssd1 vssd1 vccd1 SS_sky130_fd_sc_hd__dlygate4sd3_1
Xhold575 input42/A wbs_dat_i[2] vccd1 vssd1 vssd1 vccd1 SS_sky130_fd_sc_hd__dlygate4sd3_1
XFILLER_104_657 vssd1 vccd1 vssd1 vccd1 SS_sky130_ef_sc_hd__decap_40_12
XFILLER_104_624 vssd1 vccd1 vccd1 vssd1 SS_sky130_fd_sc_hd__fill_4
XFILLER_89_357 vssd1 vccd1 vssd1 vccd1 SS_sky130_ef_sc_hd__decap_40_12
XFILLER_103_167 vccd1 vssd1 vccd1 vssd1 SS_sky130_fd_sc_hd__fill_1
XFILLER_58_733 vssd1 vccd1 vssd1 vccd1 SS_sky130_ef_sc_hd__decap_40_12
XFILLER_66_26 vssd1 vccd1 vccd1 vssd1 SS_sky130_fd_sc_hd__fill_2
XFILLER_131_487 vccd1 vssd1 vccd1 vssd1 SS_sky130_fd_sc_hd__fill_1
XFILLER_106_77 vssd1 vccd1 vccd1 vssd1 SS_sky130_fd_sc_hd__fill_4
XFILLER_57_221 vssd1 vccd1 vccd1 vssd1 SS_sky130_fd_sc_hd__fill_2
XFILLER_58_755 vccd1 vssd1 vccd1 vssd1 SS_sky130_fd_sc_hd__fill_1
XFILLER_45_405 vssd1 vccd1 vssd1 vccd1 SS_sky130_ef_sc_hd__decap_40_12
XFILLER_73_725 vssd1 vccd1 vccd1 vssd1 SS_sky130_fd_sc_hd__fill_2
XFILLER_122_65 vssd1 vccd1 vssd1 vccd1 SS_sky130_ef_sc_hd__decap_40_12
XFILLER_60_419 vccd1 vssd1 vccd1 vssd1 SS_sky130_fd_sc_hd__fill_1
XTAP_TAPCELL_ROW_0_283 vccd1 vssd1 SS_sky130_fd_sc_hd__tapvpwrvgnd_1
XTAP_TAPCELL_ROW_0_294 vccd1 vssd1 SS_sky130_fd_sc_hd__tapvpwrvgnd_1
XFILLER_13_335 vccd1 vssd1 vccd1 vssd1 SS_sky130_fd_sc_hd__fill_1
XFILLER_40_121 vssd1 vccd1 vssd1 vccd1 SS_sky130_ef_sc_hd__decap_40_12
XFILLER_9_317 vssd1 vccd1 vssd1 vccd1 SS_sky130_ef_sc_hd__decap_40_12
XFILLER_40_165 vssd1 vccd1 vssd1 vccd1 SS_sky130_ef_sc_hd__decap_40_12
XFILLER_5_501 vssd1 vccd1 vccd1 vssd1 SS_sky130_fd_sc_hd__fill_2
XFILLER_127_727 vccd1 vssd1 vccd1 vssd1 SS_sky130_fd_sc_hd__fill_1
XFILLER_135_782 vssd1 vccd1 vccd1 vssd1 SS_sky130_fd_sc_hd__fill_2
XTAP_TAPCELL_ROW_56_1143 vccd1 vssd1 SS_sky130_fd_sc_hd__tapvpwrvgnd_1
XFILLER_122_421 vssd1 vccd1 vssd1 vccd1 SS_sky130_ef_sc_hd__decap_40_12
Xoutput84 vccd1 vssd1 wire276/A _1827_/X vccd1 vssd1 SS_sky130_fd_sc_hd__buf_4
Xoutput73 vccd1 vssd1 wire287/A _1907_/X vccd1 vssd1 SS_sky130_fd_sc_hd__buf_4
XFILLER_122_454 vssd1 vccd1 vssd1 vccd1 SS_sky130_ef_sc_hd__decap_40_12
Xoutput62 vccd1 vssd1 wire298/A _1897_/X vccd1 vssd1 SS_sky130_fd_sc_hd__buf_4
Xoutput95 vccd1 vssd1 wire265/A _1828_/X vccd1 vssd1 SS_sky130_fd_sc_hd__buf_4
XFILLER_48_221 vssd1 vccd1 vssd1 vccd1 SS_sky130_ef_sc_hd__decap_40_12
XFILLER_49_777 vssd1 vccd1 vccd1 vssd1 SS_sky130_fd_sc_hd__fill_4
XFILLER_95_349 vssd1 vccd1 vssd1 vccd1 SS_sky130_ef_sc_hd__decap_40_12
XFILLER_48_265 vssd1 vccd1 vssd1 vccd1 SS_sky130_ef_sc_hd__decap_40_12
XFILLER_64_725 vssd1 vccd1 vssd1 vccd1 SS_sky130_ef_sc_hd__decap_40_12
XFILLER_76_585 vssd1 vccd1 vccd1 vssd1 SS_sky130_fd_sc_hd__fill_2
XFILLER_17_641 vssd1 vccd1 vssd1 vccd1 SS_sky130_ef_sc_hd__decap_40_12
XFILLER_56_81 vssd1 vccd1 vccd1 vssd1 SS_sky130_fd_sc_hd__fill_2
XFILLER_64_747 vccd1 vssd1 vccd1 vssd1 SS_sky130_fd_sc_hd__fill_1
XFILLER_64_769 vssd1 vccd1 vssd1 vccd1 SS_sky130_ef_sc_hd__decap_40_12
XFILLER_63_279 vccd1 vssd1 vccd1 vssd1 SS_sky130_fd_sc_hd__fill_1
XFILLER_17_685 vssd1 vccd1 vssd1 vccd1 SS_sky130_ef_sc_hd__decap_40_12
XFILLER_32_633 vccd1 vssd1 vccd1 vssd1 SS_sky130_fd_sc_hd__fill_1
XFILLER_44_471 vssd1 vccd1 vccd1 vssd1 SS_sky130_fd_sc_hd__fill_4
XFILLER_72_780 vccd1 vssd1 vccd1 vssd1 SS_sky130_fd_sc_hd__fill_1
XFILLER_16_195 vccd1 vssd1 vccd1 vssd1 SS_sky130_fd_sc_hd__fill_1
XFILLER_20_806 vssd1 vccd1 vccd1 vssd1 SS_sky130_fd_sc_hd__fill_4
XFILLER_31_165 vssd1 vccd1 vccd1 vssd1 SS_sky130_fd_sc_hd__fill_2
XFILLER_75_3 vssd1 vccd1 vssd1 vccd1 SS_sky130_ef_sc_hd__decap_40_12
XTAP_TAPCELL_ROW_80_1494 vccd1 vssd1 SS_sky130_fd_sc_hd__tapvpwrvgnd_1
XFILLER_8_361 vssd1 vccd1 vccd1 vssd1 SS_sky130_fd_sc_hd__fill_2
XFILLER_117_237 vssd1 vccd1 vssd1 vccd1 SS_sky130_ef_sc_hd__decap_40_12
X_1624_ _1624_/Q _1724_/CLK _1624_/D vccd1 vssd1 vccd1 vssd1 SS_sky130_fd_sc_hd__dfxtp_2
XFILLER_125_281 vssd1 vccd1 vccd1 vssd1 SS_sky130_fd_sc_hd__fill_8
XPHY_EDGE_ROW_99_Right_99 vccd1 vssd1 vccd1 vssd1 SS_sky130_fd_sc_hd__decap_3
XFILLER_98_121 vssd1 vccd1 vssd1 vccd1 SS_sky130_ef_sc_hd__decap_40_12
X_1555_ _1555_/Q _1747_/CLK _1555_/D vccd1 vssd1 vccd1 vssd1 SS_sky130_fd_sc_hd__dfxtp_2
XFILLER_86_305 vssd1 vccd1 vccd1 vssd1 SS_sky130_fd_sc_hd__fill_2
XFILLER_87_817 vccd1 vssd1 vccd1 vssd1 SS_sky130_fd_sc_hd__fill_1
XFILLER_98_165 vssd1 vccd1 vssd1 vccd1 SS_sky130_ef_sc_hd__decap_40_12
X_1486_ _1486_/Q clkload4/A _1486_/D vccd1 vssd1 vccd1 vssd1 SS_sky130_fd_sc_hd__dfxtp_2
XFILLER_39_221 vssd1 vccd1 vccd1 vssd1 SS_sky130_fd_sc_hd__fill_2
XFILLER_67_530 vccd1 vssd1 vccd1 vssd1 SS_sky130_fd_sc_hd__fill_1
XFILLER_100_137 vssd1 vccd1 vccd1 vssd1 SS_sky130_fd_sc_hd__fill_2
XFILLER_27_405 vssd1 vccd1 vssd1 vccd1 SS_sky130_ef_sc_hd__decap_40_12
XFILLER_36_18 vssd1 vccd1 vccd1 vssd1 SS_sky130_fd_sc_hd__fill_8
XFILLER_67_585 vssd1 vccd1 vssd1 vccd1 SS_sky130_ef_sc_hd__decap_40_12
XTAP_TAPCELL_ROW_87_1604 vccd1 vssd1 SS_sky130_fd_sc_hd__tapvpwrvgnd_1
XPHY_EDGE_ROW_6_Left_145 vccd1 vssd1 vccd1 vssd1 SS_sky130_fd_sc_hd__decap_3
XFILLER_27_449 vssd1 vccd1 vssd1 vccd1 SS_sky130_ef_sc_hd__decap_40_12
XFILLER_36_29 vssd1 vccd1 vssd1 vccd1 SS_sky130_ef_sc_hd__decap_40_12
XFILLER_82_533 vssd1 vccd1 vssd1 vccd1 SS_sky130_ef_sc_hd__decap_40_12
XFILLER_42_419 vccd1 vssd1 vccd1 vssd1 SS_sky130_fd_sc_hd__fill_1
XFILLER_63_780 vssd1 vccd1 vccd1 vssd1 SS_sky130_fd_sc_hd__fill_4
XFILLER_22_121 vssd1 vccd1 vssd1 vccd1 SS_sky130_ef_sc_hd__decap_40_12
XFILLER_10_305 vssd1 vccd1 vccd1 vssd1 SS_sky130_fd_sc_hd__fill_2
XFILLER_11_817 vccd1 vssd1 vccd1 vssd1 SS_sky130_fd_sc_hd__fill_1
XFILLER_22_165 vssd1 vccd1 vssd1 vccd1 SS_sky130_ef_sc_hd__decap_40_12
XFILLER_6_309 vssd1 vccd1 vssd1 vccd1 SS_sky130_ef_sc_hd__decap_40_12
XFILLER_136_513 vssd1 vccd1 vssd1 vccd1 SS_sky130_ef_sc_hd__decap_40_12
XFILLER_136_535 vccd1 vssd1 vccd1 vssd1 SS_sky130_fd_sc_hd__fill_1
XTAP_TAPCELL_ROW_98_1777 vccd1 vssd1 SS_sky130_fd_sc_hd__tapvpwrvgnd_1
XTAP_TAPCELL_ROW_98_1766 vccd1 vssd1 SS_sky130_fd_sc_hd__tapvpwrvgnd_1
XFILLER_117_782 vssd1 vccd1 vccd1 vssd1 SS_sky130_fd_sc_hd__fill_2
XFILLER_104_421 vssd1 vccd1 vccd1 vssd1 SS_sky130_fd_sc_hd__fill_4
XFILLER_77_305 vssd1 vccd1 vccd1 vssd1 SS_sky130_fd_sc_hd__fill_8
XFILLER_78_817 vccd1 vssd1 vccd1 vssd1 SS_sky130_fd_sc_hd__fill_1
XFILLER_104_465 vssd1 vccd1 vccd1 vssd1 SS_sky130_fd_sc_hd__fill_2
XFILLER_77_69 vssd1 vccd1 vssd1 vccd1 SS_sky130_ef_sc_hd__decap_40_12
XFILLER_89_165 vssd1 vccd1 vccd1 vssd1 SS_sky130_fd_sc_hd__fill_2
XTAP_TAPCELL_ROW_129_2232 vccd1 vssd1 SS_sky130_fd_sc_hd__tapvpwrvgnd_1
XTAP_TAPCELL_ROW_51_1062 vccd1 vssd1 SS_sky130_fd_sc_hd__tapvpwrvgnd_1
XFILLER_77_349 vccd1 vssd1 vccd1 vssd1 SS_sky130_fd_sc_hd__fill_1
XFILLER_131_295 vccd1 vssd1 vccd1 vssd1 SS_sky130_fd_sc_hd__fill_1
XTAP_TAPCELL_ROW_5_375 vccd1 vssd1 SS_sky130_fd_sc_hd__tapvpwrvgnd_1
XFILLER_46_725 vssd1 vccd1 vccd1 vssd1 SS_sky130_fd_sc_hd__fill_8
XFILLER_133_42 vssd1 vccd1 vssd1 vccd1 SS_sky130_ef_sc_hd__decap_40_12
XFILLER_46_769 vssd1 vccd1 vssd1 vccd1 SS_sky130_ef_sc_hd__decap_40_12
XFILLER_85_393 vssd1 vccd1 vssd1 vccd1 SS_sky130_ef_sc_hd__decap_40_12
XFILLER_93_57 vssd1 vccd1 vssd1 vccd1 SS_sky130_ef_sc_hd__decap_40_12
XFILLER_73_555 vssd1 vccd1 vccd1 vssd1 SS_sky130_fd_sc_hd__fill_4
XFILLER_73_577 vssd1 vccd1 vccd1 vssd1 SS_sky130_fd_sc_hd__fill_2
XFILLER_45_279 vccd1 vssd1 vccd1 vssd1 SS_sky130_fd_sc_hd__fill_1
XFILLER_41_441 vssd1 vccd1 vccd1 vssd1 SS_sky130_fd_sc_hd__fill_4
XTAP_TAPCELL_ROW_44_959 vccd1 vssd1 SS_sky130_fd_sc_hd__tapvpwrvgnd_1
XFILLER_60_249 vssd1 vccd1 vccd1 vssd1 SS_sky130_fd_sc_hd__fill_2
XFILLER_9_125 vssd1 vccd1 vssd1 vccd1 SS_sky130_ef_sc_hd__decap_40_12
XFILLER_13_165 vssd1 vccd1 vccd1 vssd1 SS_sky130_fd_sc_hd__fill_2
XFILLER_14_699 vccd1 vssd1 vccd1 vssd1 SS_sky130_fd_sc_hd__fill_1
XTAP_TAPCELL_ROW_24_661 vccd1 vssd1 SS_sky130_fd_sc_hd__tapvpwrvgnd_1
XFILLER_9_169 vssd1 vccd1 vssd1 vccd1 SS_sky130_ef_sc_hd__decap_40_12
XFILLER_42_83 vccd1 vssd1 vccd1 vssd1 SS_sky130_fd_sc_hd__fill_1
XFILLER_127_524 vssd1 vccd1 vccd1 vssd1 SS_sky130_fd_sc_hd__fill_2
XFILLER_127_513 vssd1 vccd1 vccd1 vssd1 SS_sky130_fd_sc_hd__fill_2
XFILLER_127_546 vssd1 vccd1 vssd1 vccd1 SS_sky130_ef_sc_hd__decap_40_12
XFILLER_108_793 vssd1 vccd1 vccd1 vssd1 SS_sky130_fd_sc_hd__fill_2
XFILLER_107_281 vssd1 vccd1 vssd1 vccd1 SS_sky130_ef_sc_hd__decap_40_12
XFILLER_69_817 vccd1 vssd1 vccd1 vssd1 SS_sky130_fd_sc_hd__fill_1
X_1340_ vccd1 vssd1 vccd1 vssd1 _1340_/X _1340_/A _1340_/B SS_sky130_fd_sc_hd__or2_2
XFILLER_123_741 vssd1 vccd1 vssd1 vccd1 SS_sky130_ef_sc_hd__decap_40_12
XFILLER_68_305 vssd1 vccd1 vccd1 vssd1 SS_sky130_fd_sc_hd__fill_2
Xclkbuf_leaf_20_wb_clk_i _1751_/CLK clkbuf_leaf_9_wb_clk_i/A vccd1 vssd1 vssd1 vccd1
+ SS_sky130_fd_sc_hd__clkbuf_8
XFILLER_123_785 vssd1 vccd1 vssd1 vccd1 SS_sky130_ef_sc_hd__decap_40_12
XFILLER_122_251 vccd1 vssd1 vccd1 vssd1 SS_sky130_fd_sc_hd__fill_1
XFILLER_96_614 vssd1 vccd1 vssd1 vccd1 SS_sky130_ef_sc_hd__decap_40_12
XFILLER_95_113 vssd1 vccd1 vssd1 vccd1 SS_sky130_ef_sc_hd__decap_40_12
XFILLER_49_541 vssd1 vccd1 vssd1 vccd1 SS_sky130_ef_sc_hd__decap_40_12
X_1271_ vssd1 vccd1 vccd1 vssd1 _1273_/A2 input41/X _1664_/D _1439_/C1 _1270_/X SS_sky130_fd_sc_hd__o211a_2
XFILLER_37_725 vssd1 vccd1 vccd1 vssd1 SS_sky130_fd_sc_hd__fill_2
XFILLER_49_585 vssd1 vccd1 vssd1 vccd1 SS_sky130_ef_sc_hd__decap_40_12
XFILLER_64_500 vssd1 vccd1 vssd1 vccd1 SS_sky130_ef_sc_hd__decap_40_12
XFILLER_64_533 vssd1 vccd1 vssd1 vccd1 SS_sky130_ef_sc_hd__decap_40_12
XTAP_TAPCELL_ROW_69_1334 vccd1 vssd1 SS_sky130_fd_sc_hd__tapvpwrvgnd_1
XFILLER_64_555 vccd1 vssd1 vccd1 vssd1 SS_sky130_fd_sc_hd__fill_1
XFILLER_24_419 vccd1 vssd1 vccd1 vssd1 SS_sky130_fd_sc_hd__fill_1
XFILLER_51_205 vssd1 vccd1 vssd1 vccd1 SS_sky130_ef_sc_hd__decap_40_12
XTAP_TAPCELL_ROW_82_1523 vccd1 vssd1 SS_sky130_fd_sc_hd__tapvpwrvgnd_1
XFILLER_51_249 vssd1 vccd1 vssd1 vccd1 SS_sky130_ef_sc_hd__decap_40_12
XTAP_TAPCELL_ROW_82_1534 vccd1 vssd1 SS_sky130_fd_sc_hd__tapvpwrvgnd_1
XFILLER_20_625 vssd1 vccd1 vssd1 vccd1 SS_sky130_ef_sc_hd__decap_40_12
XFILLER_20_669 vssd1 vccd1 vssd1 vccd1 SS_sky130_ef_sc_hd__decap_40_12
XFILLER_118_524 vssd1 vccd1 vccd1 vssd1 SS_sky130_fd_sc_hd__fill_8
X_0986_ vccd1 vssd1 vccd1 vssd1 _0986_/X _0986_/A _1006_/B SS_sky130_fd_sc_hd__or2_2
XFILLER_118_557 vssd1 vccd1 vssd1 vccd1 SS_sky130_ef_sc_hd__decap_40_12
XTAP_TAPCELL_ROW_113_2000 vccd1 vssd1 SS_sky130_fd_sc_hd__tapvpwrvgnd_1
XFILLER_133_505 vssd1 vccd1 vssd1 vccd1 SS_sky130_ef_sc_hd__decap_40_12
X_1607_ _1867_/A _1608_/CLK _1607_/D vccd1 vssd1 vccd1 vssd1 SS_sky130_fd_sc_hd__dfxtp_2
XFILLER_99_441 vssd1 vccd1 vccd1 vssd1 SS_sky130_fd_sc_hd__fill_4
XFILLER_59_305 vssd1 vccd1 vssd1 vccd1 SS_sky130_ef_sc_hd__decap_40_12
XFILLER_87_614 vssd1 vccd1 vccd1 vssd1 SS_sky130_fd_sc_hd__fill_2
X_1538_ _1538_/Q _1761_/CLK _1538_/D vccd1 vssd1 vccd1 vssd1 SS_sky130_fd_sc_hd__dfxtp_2
XFILLER_113_273 vssd1 vccd1 vccd1 vssd1 SS_sky130_fd_sc_hd__fill_4
XTAP_TAPCELL_ROW_93_1696 vccd1 vssd1 SS_sky130_fd_sc_hd__tapvpwrvgnd_1
XFILLER_59_349 vssd1 vccd1 vssd1 vccd1 SS_sky130_ef_sc_hd__decap_40_12
XFILLER_87_658 vssd1 vccd1 vccd1 vssd1 SS_sky130_fd_sc_hd__fill_4
X_1469_ vssd1 vccd1 vccd1 vssd1 _1409_/Y input41/X _1469_/X _1471_/C1 _1468_/X SS_sky130_fd_sc_hd__o211a_2
XTAP_TAPCELL_ROW_2_323 vccd1 vssd1 SS_sky130_fd_sc_hd__tapvpwrvgnd_1
XFILLER_47_39 vssd1 vccd1 vssd1 vccd1 SS_sky130_ef_sc_hd__decap_40_12
XTAP_TAPCELL_ROW_2_334 vccd1 vssd1 SS_sky130_fd_sc_hd__tapvpwrvgnd_1
XFILLER_55_555 vssd1 vccd1 vccd1 vssd1 SS_sky130_fd_sc_hd__fill_4
XFILLER_82_363 vccd1 vssd1 vccd1 vssd1 SS_sky130_fd_sc_hd__fill_1
XTAP_TAPCELL_ROW_124_2162 vccd1 vssd1 SS_sky130_fd_sc_hd__tapvpwrvgnd_1
XFILLER_27_279 vccd1 vssd1 vccd1 vssd1 SS_sky130_fd_sc_hd__fill_1
XFILLER_70_525 vccd1 vssd1 vccd1 vssd1 SS_sky130_fd_sc_hd__fill_1
XFILLER_23_441 vssd1 vccd1 vccd1 vssd1 SS_sky130_fd_sc_hd__fill_4
XFILLER_42_249 vssd1 vccd1 vccd1 vssd1 SS_sky130_fd_sc_hd__fill_2
XFILLER_70_569 vssd1 vccd1 vssd1 vccd1 SS_sky130_ef_sc_hd__decap_40_12
XTAP_TAPCELL_ROW_41_918 vccd1 vssd1 SS_sky130_fd_sc_hd__tapvpwrvgnd_1
XFILLER_51_783 vccd1 vssd1 vccd1 vssd1 SS_sky130_fd_sc_hd__fill_1
XTAP_TAPCELL_ROW_21_620 vccd1 vssd1 SS_sky130_fd_sc_hd__tapvpwrvgnd_1
XFILLER_23_485 vssd1 vccd1 vssd1 vccd1 SS_sky130_ef_sc_hd__decap_40_12
XFILLER_7_629 vssd1 vccd1 vssd1 vccd1 SS_sky130_ef_sc_hd__decap_40_12
XFILLER_11_669 vssd1 vccd1 vccd1 vssd1 SS_sky130_fd_sc_hd__fill_2
XFILLER_6_139 vccd1 vssd1 vccd1 vssd1 SS_sky130_fd_sc_hd__fill_1
XFILLER_12_53 vssd1 vccd1 vssd1 vccd1 SS_sky130_ef_sc_hd__decap_40_12
XFILLER_136_321 vccd1 vssd1 vccd1 vssd1 SS_sky130_fd_sc_hd__fill_1
XFILLER_109_557 vssd1 vccd1 vccd1 vssd1 SS_sky130_fd_sc_hd__fill_2
XFILLER_12_97 vssd1 vccd1 vssd1 vccd1 SS_sky130_ef_sc_hd__decap_40_12
XFILLER_128_53 vssd1 vccd1 vssd1 vccd1 SS_sky130_ef_sc_hd__decap_40_12
XFILLER_2_301 vssd1 vccd1 vccd1 vssd1 SS_sky130_fd_sc_hd__fill_4
XFILLER_128_97 vssd1 vccd1 vssd1 vccd1 SS_sky130_ef_sc_hd__decap_40_12
XFILLER_2_345 vssd1 vccd1 vssd1 vccd1 SS_sky130_ef_sc_hd__decap_40_12
XFILLER_5_3 vssd1 vccd1 vssd1 vccd1 SS_sky130_ef_sc_hd__decap_40_12
XTAP_TAPCELL_ROW_53_1102 vccd1 vssd1 SS_sky130_fd_sc_hd__tapvpwrvgnd_1
XFILLER_105_741 vssd1 vccd1 vccd1 vssd1 SS_sky130_fd_sc_hd__fill_2
XFILLER_2_389 vssd1 vccd1 vssd1 vccd1 SS_sky130_ef_sc_hd__decap_40_12
XFILLER_77_113 vssd1 vccd1 vssd1 vccd1 SS_sky130_ef_sc_hd__decap_40_12
XFILLER_78_625 vssd1 vccd1 vssd1 vccd1 SS_sky130_ef_sc_hd__decap_40_12
XFILLER_132_582 vssd1 vccd1 vccd1 vssd1 SS_sky130_fd_sc_hd__fill_4
XFILLER_105_785 vssd1 vccd1 vssd1 vccd1 SS_sky130_ef_sc_hd__decap_40_12
XFILLER_104_251 vccd1 vssd1 vccd1 vssd1 SS_sky130_fd_sc_hd__fill_1
XFILLER_120_755 vccd1 vssd1 vccd1 vssd1 SS_sky130_fd_sc_hd__fill_1
XPHY_EDGE_ROW_69_Left_208 vccd1 vssd1 vccd1 vssd1 SS_sky130_fd_sc_hd__decap_3
XFILLER_93_617 vssd1 vccd1 vssd1 vccd1 SS_sky130_ef_sc_hd__decap_40_12
XTAP_TAPCELL_ROW_29_731 vccd1 vssd1 SS_sky130_fd_sc_hd__tapvpwrvgnd_1
XFILLER_46_533 vssd1 vccd1 vssd1 vccd1 SS_sky130_ef_sc_hd__decap_40_12
XTAP_TAPCELL_ROW_109_1935 vccd1 vssd1 SS_sky130_fd_sc_hd__tapvpwrvgnd_1
XTAP_TAPCELL_ROW_29_742 vccd1 vssd1 SS_sky130_fd_sc_hd__tapvpwrvgnd_1
Xafe_wb_560 afe_wb_560/LO analog_io_oeb[24] vccd1 vssd1 vssd1 vccd1 SS_sky130_fd_sc_hd__conb_1
XFILLER_33_205 vssd1 vccd1 vssd1 vccd1 SS_sky130_ef_sc_hd__decap_40_12
XFILLER_33_249 vssd1 vccd1 vssd1 vccd1 SS_sky130_ef_sc_hd__decap_40_12
XFILLER_61_547 vccd1 vssd1 vccd1 vssd1 SS_sky130_fd_sc_hd__fill_1
XTAP_TAPCELL_ROW_64_1253 vccd1 vssd1 SS_sky130_fd_sc_hd__tapvpwrvgnd_1
XTAP_TAPCELL_ROW_64_1264 vccd1 vssd1 SS_sky130_fd_sc_hd__tapvpwrvgnd_1
XFILLER_41_293 vssd1 vccd1 vssd1 vccd1 SS_sky130_ef_sc_hd__decap_40_12
XFILLER_53_93 vssd1 vccd1 vssd1 vccd1 SS_sky130_ef_sc_hd__decap_40_12
XPHY_EDGE_ROW_78_Left_217 vccd1 vssd1 vccd1 vssd1 SS_sky130_fd_sc_hd__decap_3
X_0840_ vccd1 vssd1 vccd1 vssd1 _1521_/Q _0930_/B1 _1909_/A wire435/X _0840_/X SS_sky130_fd_sc_hd__a22o_2
X_0771_ vccd1 vssd1 vccd1 vssd1 _1834_/A wire421/X _1849_/A _0828_/B1 _0771_/X SS_sky130_fd_sc_hd__a22o_2
XFILLER_5_161 vssd1 vccd1 vccd1 vssd1 SS_sky130_fd_sc_hd__fill_4
XPHY_EDGE_ROW_87_Left_226 vccd1 vssd1 vccd1 vssd1 SS_sky130_fd_sc_hd__decap_3
XFILLER_123_571 vccd1 vssd1 vccd1 vssd1 SS_sky130_fd_sc_hd__fill_1
XFILLER_96_411 vccd1 vssd1 vccd1 vssd1 SS_sky130_fd_sc_hd__fill_1
XFILLER_69_669 vssd1 vccd1 vccd1 vssd1 SS_sky130_fd_sc_hd__fill_2
X_1323_ vssd1 vccd1 vccd1 vssd1 _1331_/A2 input34/X _1323_/X _1457_/C1 _1322_/X SS_sky130_fd_sc_hd__o211a_2
XFILLER_111_733 vccd1 vssd1 vccd1 vssd1 SS_sky130_fd_sc_hd__fill_1
XFILLER_110_221 vssd1 vccd1 vssd1 vccd1 SS_sky130_ef_sc_hd__decap_40_12
XFILLER_83_105 vssd1 vccd1 vccd1 vssd1 SS_sky130_fd_sc_hd__fill_4
XFILLER_110_265 vssd1 vccd1 vssd1 vccd1 SS_sky130_ef_sc_hd__decap_40_12
X_1254_ vccd1 vssd1 vccd1 vssd1 _1254_/X _1656_/Q _1272_/B SS_sky130_fd_sc_hd__or2_2
XFILLER_96_477 vssd1 vccd1 vssd1 vccd1 SS_sky130_ef_sc_hd__decap_40_12
XFILLER_49_393 vssd1 vccd1 vssd1 vccd1 SS_sky130_ef_sc_hd__decap_40_12
XFILLER_65_831 vssd1 vccd1 vccd1 vssd1 SS_sky130_fd_sc_hd__fill_2
XFILLER_64_352 vccd1 vssd1 vccd1 vssd1 SS_sky130_fd_sc_hd__fill_1
XFILLER_83_149 vssd1 vccd1 vssd1 vccd1 SS_sky130_ef_sc_hd__decap_40_12
X_1185_ vssd1 vccd1 vccd1 vssd1 _1195_/A2 input30/X _1622_/D _1381_/C1 _1184_/X SS_sky130_fd_sc_hd__o211a_2
XFILLER_37_599 vssd1 vccd1 vssd1 vccd1 SS_sky130_ef_sc_hd__decap_40_12
XFILLER_52_525 vssd1 vccd1 vccd1 vssd1 SS_sky130_fd_sc_hd__fill_4
XFILLER_64_363 vccd1 vssd1 vccd1 vssd1 SS_sky130_fd_sc_hd__fill_1
XFILLER_24_249 vssd1 vccd1 vccd1 vssd1 SS_sky130_fd_sc_hd__fill_2
XFILLER_40_709 vssd1 vccd1 vssd1 vccd1 SS_sky130_ef_sc_hd__decap_40_12
XFILLER_91_193 vssd1 vccd1 vssd1 vccd1 SS_sky130_ef_sc_hd__decap_40_12
XFILLER_33_783 vccd1 vssd1 vccd1 vssd1 SS_sky130_fd_sc_hd__fill_1
XPHY_EDGE_ROW_96_Left_235 vccd1 vssd1 vccd1 vssd1 SS_sky130_fd_sc_hd__decap_3
XFILLER_20_433 vssd1 vccd1 vssd1 vccd1 SS_sky130_ef_sc_hd__decap_40_12
XFILLER_20_477 vssd1 vccd1 vssd1 vccd1 SS_sky130_ef_sc_hd__decap_40_12
X_0969_ vssd1 vccd1 vccd1 vssd1 _0985_/A2 wire501/X _1517_/D _1299_/C1 _0968_/X SS_sky130_fd_sc_hd__o211a_2
XFILLER_118_365 vssd1 vccd1 vssd1 vccd1 SS_sky130_ef_sc_hd__decap_40_12
XTAP_TAPCELL_ROW_95_1725 vccd1 vssd1 SS_sky130_fd_sc_hd__tapvpwrvgnd_1
XFILLER_3_109 vssd1 vccd1 vccd1 vssd1 SS_sky130_fd_sc_hd__fill_2
XTAP_TAPCELL_ROW_7_404 vccd1 vssd1 SS_sky130_fd_sc_hd__tapvpwrvgnd_1
XFILLER_0_827 vssd1 vccd1 vssd1 vccd1 SS_sky130_ef_sc_hd__decap_40_12
XFILLER_48_809 vssd1 vccd1 vccd1 vssd1 SS_sky130_fd_sc_hd__fill_2
XFILLER_59_113 vssd1 vccd1 vssd1 vccd1 SS_sky130_ef_sc_hd__decap_40_12
XFILLER_102_755 vccd1 vssd1 vccd1 vssd1 SS_sky130_fd_sc_hd__fill_1
XFILLER_101_221 vssd1 vccd1 vccd1 vssd1 SS_sky130_fd_sc_hd__fill_2
XFILLER_99_293 vssd1 vccd1 vssd1 vccd1 SS_sky130_ef_sc_hd__decap_40_12
XFILLER_75_617 vssd1 vccd1 vssd1 vccd1 SS_sky130_ef_sc_hd__decap_40_12
XFILLER_28_533 vssd1 vccd1 vssd1 vccd1 SS_sky130_ef_sc_hd__decap_40_12
XFILLER_74_15 vssd1 vccd1 vssd1 vccd1 SS_sky130_ef_sc_hd__decap_40_12
XFILLER_87_499 vssd1 vccd1 vccd1 vssd1 SS_sky130_fd_sc_hd__fill_4
XFILLER_83_650 vssd1 vccd1 vccd1 vssd1 SS_sky130_fd_sc_hd__fill_2
XFILLER_114_77 vssd1 vccd1 vccd1 vssd1 SS_sky130_fd_sc_hd__fill_4
XFILLER_15_205 vssd1 vccd1 vssd1 vccd1 SS_sky130_ef_sc_hd__decap_40_12
XFILLER_43_514 vssd1 vccd1 vssd1 vccd1 SS_sky130_ef_sc_hd__decap_40_12
XFILLER_71_812 vssd1 vccd1 vccd1 vssd1 SS_sky130_fd_sc_hd__fill_4
XFILLER_15_249 vssd1 vccd1 vssd1 vccd1 SS_sky130_ef_sc_hd__decap_40_12
XFILLER_43_569 vssd1 vccd1 vssd1 vccd1 SS_sky130_ef_sc_hd__decap_40_12
XFILLER_82_193 vssd1 vccd1 vccd1 vssd1 SS_sky130_fd_sc_hd__fill_2
XFILLER_70_377 vssd1 vccd1 vssd1 vccd1 SS_sky130_ef_sc_hd__decap_40_12
XFILLER_130_65 vssd1 vccd1 vssd1 vccd1 SS_sky130_ef_sc_hd__decap_40_12
XTAP_TAPCELL_ROW_104_1865 vccd1 vssd1 SS_sky130_fd_sc_hd__tapvpwrvgnd_1
XTAP_TAPCELL_ROW_104_1854 vccd1 vssd1 SS_sky130_fd_sc_hd__tapvpwrvgnd_1
XFILLER_23_30 vssd1 vccd1 vssd1 vccd1 SS_sky130_ef_sc_hd__decap_40_12
XFILLER_23_293 vssd1 vccd1 vssd1 vccd1 SS_sky130_ef_sc_hd__decap_40_12
Xwire324 vccd1 vssd1 vssd1 vccd1 wire324/A analog_ctrl[52] SS_sky130_fd_sc_hd__buf_12
Xwire313 vccd1 vssd1 vssd1 vccd1 wire313/A analog_ctrl[62] SS_sky130_fd_sc_hd__buf_12
XTAP_TAPCELL_ROW_137_2353 vccd1 vssd1 SS_sky130_fd_sc_hd__tapvpwrvgnd_1
Xwire302 vccd1 vssd1 vssd1 vccd1 wire302/A analog_ctrl[107] SS_sky130_fd_sc_hd__buf_12
Xwire335 vccd1 vssd1 vssd1 vccd1 wire335/A analog_ctrl[42] SS_sky130_fd_sc_hd__buf_12
Xwire357 vccd1 vssd1 vssd1 vccd1 wire357/A wbs_dat_o[5] SS_sky130_fd_sc_hd__buf_12
XFILLER_137_641 vssd1 vccd1 vccd1 vssd1 SS_sky130_fd_sc_hd__fill_2
Xwire379 vccd1 vssd1 vssd1 vccd1 wire379/A wbs_dat_o[14] SS_sky130_fd_sc_hd__buf_12
Xwire368 vccd1 vssd1 vssd1 vccd1 wire368/A wbs_dat_o[24] SS_sky130_fd_sc_hd__buf_12
XFILLER_137_663 vccd1 vssd1 vccd1 vssd1 SS_sky130_fd_sc_hd__fill_1
XFILLER_136_195 vccd1 vssd1 vccd1 vssd1 SS_sky130_fd_sc_hd__fill_1
XFILLER_2_153 vssd1 vccd1 vssd1 vccd1 SS_sky130_ef_sc_hd__decap_40_12
XFILLER_3_665 vssd1 vccd1 vccd1 vssd1 SS_sky130_fd_sc_hd__fill_4
XFILLER_124_379 vccd1 vssd1 vccd1 vssd1 SS_sky130_fd_sc_hd__fill_1
XFILLER_2_197 vssd1 vccd1 vssd1 vccd1 SS_sky130_ef_sc_hd__decap_40_12
XFILLER_65_105 vssd1 vccd1 vccd1 vssd1 SS_sky130_fd_sc_hd__fill_4
XFILLER_78_477 vssd1 vccd1 vssd1 vccd1 SS_sky130_ef_sc_hd__decap_40_12
XFILLER_120_585 vssd1 vccd1 vccd1 vssd1 SS_sky130_fd_sc_hd__fill_2
XFILLER_93_447 vccd1 vssd1 vccd1 vssd1 SS_sky130_fd_sc_hd__fill_1
XFILLER_65_149 vssd1 vccd1 vssd1 vccd1 SS_sky130_ef_sc_hd__decap_40_12
XFILLER_34_525 vssd1 vccd1 vccd1 vssd1 SS_sky130_fd_sc_hd__fill_4
XFILLER_46_363 vccd1 vssd1 vccd1 vssd1 SS_sky130_fd_sc_hd__fill_1
XFILLER_64_81 vssd1 vccd1 vccd1 vssd1 SS_sky130_fd_sc_hd__fill_2
XFILLER_73_193 vssd1 vccd1 vssd1 vccd1 SS_sky130_ef_sc_hd__decap_40_12
XFILLER_15_783 vccd1 vssd1 vccd1 vssd1 SS_sky130_fd_sc_hd__fill_1
XFILLER_30_753 vssd1 vccd1 vccd1 vssd1 SS_sky130_fd_sc_hd__fill_2
X_1872_ vccd1 vssd1 _1872_/X _1872_/A vccd1 vssd1 SS_sky130_fd_sc_hd__buf_2
X_0823_ vssd1 vccd1 vssd1 vccd1 wire421/X _0970_/A _0821_/X _0822_/X _0823_/X wire347/X
+ SS_sky130_fd_sc_hd__a2111o_2
XTAP_TAPCELL_ROW_12_483 vccd1 vssd1 SS_sky130_fd_sc_hd__tapvpwrvgnd_1
XTAP_TAPCELL_ROW_77_1455 vccd1 vssd1 SS_sky130_fd_sc_hd__tapvpwrvgnd_1
X_0754_ vssd1 vccd1 vssd1 vccd1 _0755_/B _0754_/X _0755_/A _0754_/D _0755_/C SS_sky130_fd_sc_hd__and4bb_2
XFILLER_89_709 vssd1 vccd1 vssd1 vccd1 SS_sky130_ef_sc_hd__decap_40_12
XFILLER_130_327 vccd1 vssd1 vccd1 vssd1 SS_sky130_fd_sc_hd__fill_1
XFILLER_115_368 vssd1 vccd1 vccd1 vssd1 SS_sky130_fd_sc_hd__fill_4
XTAP_TAPCELL_ROW_90_1644 vccd1 vssd1 SS_sky130_fd_sc_hd__tapvpwrvgnd_1
XTAP_TAPCELL_ROW_90_1655 vccd1 vssd1 SS_sky130_fd_sc_hd__tapvpwrvgnd_1
XFILLER_97_753 vssd1 vccd1 vssd1 vccd1 SS_sky130_ef_sc_hd__decap_40_12
XFILLER_57_606 vssd1 vccd1 vccd1 vssd1 SS_sky130_fd_sc_hd__fill_8
XFILLER_57_617 vssd1 vccd1 vssd1 vccd1 SS_sky130_ef_sc_hd__decap_40_12
X_1306_ vccd1 vssd1 vccd1 vssd1 _1306_/X _1306_/A _1318_/B SS_sky130_fd_sc_hd__or2_2
XFILLER_111_541 vssd1 vccd1 vssd1 vccd1 SS_sky130_ef_sc_hd__decap_40_12
XFILLER_111_596 vssd1 vccd1 vssd1 vccd1 SS_sky130_ef_sc_hd__decap_40_12
XFILLER_97_797 vssd1 vccd1 vccd1 vssd1 SS_sky130_fd_sc_hd__fill_2
X_1237_ vssd1 vccd1 vccd1 vssd1 _1267_/A2 wire499/X _1647_/D _1451_/C1 _1236_/X SS_sky130_fd_sc_hd__o211a_2
XFILLER_25_503 vccd1 vssd1 vccd1 vssd1 SS_sky130_fd_sc_hd__fill_1
XFILLER_37_385 vssd1 vccd1 vccd1 vssd1 SS_sky130_fd_sc_hd__fill_4
X_1168_ vccd1 vssd1 vccd1 vssd1 _1168_/X _1168_/A _1186_/B SS_sky130_fd_sc_hd__or2_2
XTAP_TAPCELL_ROW_121_2110 vccd1 vssd1 SS_sky130_fd_sc_hd__tapvpwrvgnd_1
XFILLER_44_29 vssd1 vccd1 vssd1 vccd1 SS_sky130_ef_sc_hd__decap_40_12
XFILLER_52_333 vssd1 vccd1 vssd1 vccd1 SS_sky130_ef_sc_hd__decap_40_12
XFILLER_64_193 vssd1 vccd1 vccd1 vssd1 SS_sky130_fd_sc_hd__fill_2
XTAP_TAPCELL_ROW_121_2121 vccd1 vssd1 SS_sky130_fd_sc_hd__tapvpwrvgnd_1
XFILLER_13_709 vssd1 vccd1 vssd1 vccd1 SS_sky130_ef_sc_hd__decap_40_12
X_1099_ vssd1 vccd1 vccd1 vssd1 wire239/X wire494/X _1580_/D _1099_/C1 _1098_/X SS_sky130_fd_sc_hd__o211a_2
XFILLER_52_377 vssd1 vccd1 vssd1 vccd1 SS_sky130_ef_sc_hd__decap_40_12
XFILLER_80_697 vssd1 vccd1 vccd1 vssd1 SS_sky130_fd_sc_hd__fill_2
XFILLER_21_753 vssd1 vccd1 vssd1 vccd1 SS_sky130_ef_sc_hd__decap_40_12
XFILLER_21_797 vssd1 vccd1 vssd1 vccd1 SS_sky130_ef_sc_hd__decap_40_12
XTAP_TAPCELL_ROW_31_770 vccd1 vssd1 SS_sky130_fd_sc_hd__tapvpwrvgnd_1
XFILLER_138_449 vssd1 vccd1 vccd1 vssd1 SS_sky130_fd_sc_hd__fill_2
XFILLER_119_641 vssd1 vccd1 vssd1 vccd1 SS_sky130_ef_sc_hd__decap_40_12
XTAP_TAPCELL_ROW_119_2083 vccd1 vssd1 SS_sky130_fd_sc_hd__tapvpwrvgnd_1
XFILLER_119_685 vssd1 vccd1 vssd1 vccd1 SS_sky130_ef_sc_hd__decap_40_12
XFILLER_109_55 vccd1 vssd1 vccd1 vssd1 SS_sky130_fd_sc_hd__fill_1
XFILLER_69_15 vssd1 vccd1 vssd1 vccd1 SS_sky130_ef_sc_hd__decap_40_12
XTAP_TAPCELL_ROW_132_2283 vccd1 vssd1 SS_sky130_fd_sc_hd__tapvpwrvgnd_1
XFILLER_118_195 vccd1 vssd1 vccd1 vssd1 SS_sky130_fd_sc_hd__fill_1
XFILLER_0_613 vssd1 vccd1 vccd1 vssd1 SS_sky130_fd_sc_hd__fill_2
XFILLER_133_165 vssd1 vccd1 vccd1 vssd1 SS_sky130_fd_sc_hd__fill_2
XFILLER_88_753 vssd1 vccd1 vccd1 vssd1 SS_sky130_fd_sc_hd__fill_2
XFILLER_102_530 vssd1 vccd1 vccd1 vssd1 SS_sky130_fd_sc_hd__fill_2
XFILLER_0_657 vssd1 vccd1 vssd1 vccd1 SS_sky130_ef_sc_hd__decap_40_12
XFILLER_47_105 vssd1 vccd1 vccd1 vssd1 SS_sky130_fd_sc_hd__fill_4
XFILLER_75_425 vssd1 vccd1 vssd1 vccd1 SS_sky130_ef_sc_hd__decap_40_12
XFILLER_18_41 vssd1 vccd1 vssd1 vccd1 SS_sky130_ef_sc_hd__decap_40_12
XFILLER_47_149 vssd1 vccd1 vssd1 vccd1 SS_sky130_ef_sc_hd__decap_40_12
XFILLER_75_447 vccd1 vssd1 vccd1 vssd1 SS_sky130_fd_sc_hd__fill_1
XFILLER_85_69 vssd1 vccd1 vssd1 vccd1 SS_sky130_ef_sc_hd__decap_40_12
XFILLER_16_525 vssd1 vccd1 vccd1 vssd1 SS_sky130_fd_sc_hd__fill_4
XFILLER_18_85 vssd1 vccd1 vssd1 vccd1 SS_sky130_ef_sc_hd__decap_40_12
XFILLER_28_363 vccd1 vssd1 vccd1 vssd1 SS_sky130_fd_sc_hd__fill_1
XTAP_TAPCELL_ROW_39_881 vccd1 vssd1 SS_sky130_fd_sc_hd__tapvpwrvgnd_1
XTAP_TAPCELL_ROW_39_892 vccd1 vssd1 SS_sky130_fd_sc_hd__tapvpwrvgnd_1
XFILLER_43_333 vssd1 vccd1 vccd1 vssd1 SS_sky130_fd_sc_hd__fill_2
XTAP_TAPCELL_ROW_48_1023 vccd1 vssd1 SS_sky130_fd_sc_hd__tapvpwrvgnd_1
XFILLER_55_193 vssd1 vccd1 vssd1 vccd1 SS_sky130_ef_sc_hd__decap_40_12
XFILLER_71_631 vccd1 vssd1 vccd1 vssd1 SS_sky130_fd_sc_hd__fill_1
XFILLER_16_569 vssd1 vccd1 vssd1 vccd1 SS_sky130_ef_sc_hd__decap_40_12
XFILLER_31_517 vssd1 vccd1 vssd1 vccd1 SS_sky130_ef_sc_hd__decap_40_12
XFILLER_70_141 vssd1 vccd1 vssd1 vccd1 SS_sky130_ef_sc_hd__decap_40_12
XTAP_TAPCELL_ROW_61_1212 vccd1 vssd1 SS_sky130_fd_sc_hd__tapvpwrvgnd_1
XFILLER_8_713 vssd1 vccd1 vssd1 vccd1 SS_sky130_ef_sc_hd__decap_40_12
XFILLER_12_753 vssd1 vccd1 vccd1 vssd1 SS_sky130_fd_sc_hd__fill_2
XFILLER_7_223 vccd1 vssd1 vccd1 vssd1 SS_sky130_fd_sc_hd__fill_1
XFILLER_129_449 vssd1 vccd1 vssd1 vccd1 SS_sky130_ef_sc_hd__decap_40_12
XFILLER_8_757 vssd1 vccd1 vssd1 vccd1 SS_sky130_ef_sc_hd__decap_40_12
XFILLER_50_83 vccd1 vssd1 vccd1 vssd1 SS_sky130_fd_sc_hd__fill_1
XFILLER_137_493 vssd1 vccd1 vccd1 vssd1 SS_sky130_fd_sc_hd__fill_2
XFILLER_124_121 vssd1 vccd1 vssd1 vccd1 SS_sky130_ef_sc_hd__decap_40_12
XTAP_TAPCELL_ROW_59_1185 vccd1 vssd1 SS_sky130_fd_sc_hd__tapvpwrvgnd_1
XFILLER_124_165 vssd1 vccd1 vssd1 vccd1 SS_sky130_ef_sc_hd__decap_40_12
XFILLER_3_473 vssd1 vccd1 vssd1 vccd1 SS_sky130_ef_sc_hd__decap_40_12
XFILLER_79_753 vssd1 vccd1 vssd1 vccd1 SS_sky130_ef_sc_hd__decap_40_12
XFILLER_59_81 vssd1 vccd1 vssd1 vccd1 SS_sky130_ef_sc_hd__decap_40_12
XTAP_TAPCELL_ROW_72_1374 vccd1 vssd1 SS_sky130_fd_sc_hd__tapvpwrvgnd_1
XTAP_TAPCELL_ROW_72_1385 vccd1 vssd1 SS_sky130_fd_sc_hd__tapvpwrvgnd_1
XFILLER_94_701 vssd1 vccd1 vssd1 vccd1 SS_sky130_ef_sc_hd__decap_40_12
XFILLER_94_745 vssd1 vccd1 vccd1 vssd1 SS_sky130_fd_sc_hd__fill_2
X_1022_ vccd1 vssd1 vccd1 vssd1 _1022_/X _1830_/A _1050_/B SS_sky130_fd_sc_hd__or2_2
XFILLER_81_417 vssd1 vccd1 vssd1 vccd1 SS_sky130_ef_sc_hd__decap_40_12
XFILLER_93_277 vssd1 vccd1 vccd1 vssd1 SS_sky130_fd_sc_hd__fill_2
XFILLER_19_385 vssd1 vccd1 vccd1 vssd1 SS_sky130_fd_sc_hd__fill_4
XFILLER_34_333 vssd1 vccd1 vssd1 vccd1 SS_sky130_ef_sc_hd__decap_40_12
XFILLER_46_193 vssd1 vccd1 vccd1 vssd1 SS_sky130_fd_sc_hd__fill_2
XFILLER_62_631 vssd1 vccd1 vccd1 vssd1 SS_sky130_fd_sc_hd__fill_2
XTAP_TAPCELL_ROW_17_553 vccd1 vssd1 SS_sky130_fd_sc_hd__tapvpwrvgnd_1
XFILLER_34_377 vssd1 vccd1 vssd1 vccd1 SS_sky130_ef_sc_hd__decap_40_12
XFILLER_62_653 vssd1 vccd1 vssd1 vccd1 SS_sky130_ef_sc_hd__decap_40_12
XFILLER_62_697 vssd1 vccd1 vccd1 vssd1 SS_sky130_fd_sc_hd__fill_2
X_1855_ vccd1 vssd1 _1855_/X _1855_/A vccd1 vssd1 SS_sky130_fd_sc_hd__buf_2
X_0806_ vccd1 vssd1 vssd1 vccd1 _0803_/X _0805_/X _0860_/A2 _1483_/Q _1483_/D _1447_/C1
+ SS_sky130_fd_sc_hd__o221a_2
Xhold702 _1328_/A _1692_/Q vccd1 vssd1 vssd1 vccd1 SS_sky130_fd_sc_hd__dlygate4sd3_1
X_0737_ vccd1 vssd1 vccd1 vssd1 _0738_/D _0737_/A SS_sky130_fd_sc_hd__inv_2
Xhold735 input34/A wbs_dat_i[22] vccd1 vssd1 vssd1 vccd1 SS_sky130_fd_sc_hd__dlygate4sd3_1
Xhold724 _1194_/A _1627_/Q vccd1 vssd1 vssd1 vccd1 SS_sky130_fd_sc_hd__dlygate4sd3_1
Xhold746 _1190_/A _1625_/Q vccd1 vssd1 vssd1 vccd1 SS_sky130_fd_sc_hd__dlygate4sd3_1
Xhold713 _1006_/A _1536_/Q vccd1 vssd1 vssd1 vccd1 SS_sky130_fd_sc_hd__dlygate4sd3_1
Xhold757 _1446_/A _1749_/Q vccd1 vssd1 vssd1 vccd1 SS_sky130_fd_sc_hd__dlygate4sd3_1
XFILLER_89_517 vssd1 vccd1 vccd1 vssd1 SS_sky130_fd_sc_hd__fill_2
XFILLER_131_614 vssd1 vccd1 vccd1 vssd1 SS_sky130_fd_sc_hd__fill_2
Xhold768 _1562_/D _1061_/X vccd1 vssd1 vssd1 vccd1 SS_sky130_fd_sc_hd__dlygate4sd3_1
Xhold779 _1126_/A _1594_/Q vccd1 vssd1 vssd1 vccd1 SS_sky130_fd_sc_hd__dlygate4sd3_1
XPHY_EDGE_ROW_123_Right_123 vccd1 vssd1 vccd1 vssd1 SS_sky130_fd_sc_hd__decap_3
XFILLER_115_165 vssd1 vccd1 vccd1 vssd1 SS_sky130_fd_sc_hd__fill_2
XFILLER_103_305 vssd1 vccd1 vccd1 vssd1 SS_sky130_fd_sc_hd__fill_4
XFILLER_103_327 vccd1 vssd1 vccd1 vssd1 SS_sky130_fd_sc_hd__fill_1
XFILLER_97_561 vssd1 vccd1 vccd1 vssd1 SS_sky130_fd_sc_hd__fill_4
XFILLER_29_105 vssd1 vccd1 vccd1 vssd1 SS_sky130_fd_sc_hd__fill_4
XFILLER_29_149 vssd1 vccd1 vssd1 vccd1 SS_sky130_ef_sc_hd__decap_40_12
XFILLER_57_447 vccd1 vssd1 vccd1 vssd1 SS_sky130_fd_sc_hd__fill_1
XFILLER_57_458 vssd1 vccd1 vssd1 vccd1 SS_sky130_ef_sc_hd__decap_40_12
XFILLER_84_233 vssd1 vccd1 vssd1 vccd1 SS_sky130_ef_sc_hd__decap_40_12
XFILLER_55_39 vssd1 vccd1 vssd1 vccd1 SS_sky130_ef_sc_hd__decap_40_12
XFILLER_84_277 vssd1 vccd1 vssd1 vccd1 SS_sky130_ef_sc_hd__decap_40_12
XFILLER_85_789 vssd1 vccd1 vccd1 vssd1 SS_sky130_fd_sc_hd__fill_2
XFILLER_25_333 vssd1 vccd1 vccd1 vssd1 SS_sky130_fd_sc_hd__fill_2
XFILLER_37_193 vssd1 vccd1 vssd1 vccd1 SS_sky130_ef_sc_hd__decap_40_12
XFILLER_53_642 vssd1 vccd1 vssd1 vccd1 SS_sky130_ef_sc_hd__decap_40_12
XFILLER_13_517 vssd1 vccd1 vssd1 vccd1 SS_sky130_ef_sc_hd__decap_40_12
XTAP_TAPCELL_ROW_36_840 vccd1 vssd1 SS_sky130_fd_sc_hd__tapvpwrvgnd_1
XFILLER_41_815 vssd1 vccd1 vccd1 vssd1 SS_sky130_fd_sc_hd__fill_2
XFILLER_52_141 vssd1 vccd1 vssd1 vccd1 SS_sky130_ef_sc_hd__decap_40_12
XTAP_TAPCELL_ROW_101_1813 vccd1 vssd1 SS_sky130_fd_sc_hd__tapvpwrvgnd_1
XFILLER_21_561 vssd1 vccd1 vssd1 vccd1 SS_sky130_ef_sc_hd__decap_40_12
XTAP_TAPCELL_ROW_134_2312 vccd1 vssd1 SS_sky130_fd_sc_hd__tapvpwrvgnd_1
XFILLER_5_727 vccd1 vssd1 vccd1 vssd1 SS_sky130_fd_sc_hd__fill_1
XFILLER_106_121 vssd1 vccd1 vssd1 vccd1 SS_sky130_ef_sc_hd__decap_40_12
XFILLER_105_3 vssd1 vccd1 vssd1 vccd1 SS_sky130_ef_sc_hd__decap_40_12
XFILLER_20_53 vssd1 vccd1 vssd1 vccd1 SS_sky130_ef_sc_hd__decap_40_12
XFILLER_106_165 vssd1 vccd1 vssd1 vccd1 SS_sky130_ef_sc_hd__decap_40_12
XFILLER_0_421 vssd1 vccd1 vccd1 vssd1 SS_sky130_fd_sc_hd__fill_2
XFILLER_20_97 vssd1 vccd1 vssd1 vccd1 SS_sky130_ef_sc_hd__decap_40_12
XFILLER_121_113 vssd1 vccd1 vssd1 vccd1 SS_sky130_ef_sc_hd__decap_40_12
XFILLER_0_443 vssd1 vccd1 vccd1 vssd1 SS_sky130_fd_sc_hd__fill_4
XFILLER_76_701 vssd1 vccd1 vssd1 vccd1 SS_sky130_ef_sc_hd__decap_40_12
XFILLER_136_97 vssd1 vccd1 vssd1 vccd1 SS_sky130_ef_sc_hd__decap_40_12
XFILLER_122_669 vssd1 vccd1 vssd1 vccd1 SS_sky130_ef_sc_hd__decap_40_12
XTAP_TAPCELL_ROW_112_1986 vccd1 vssd1 SS_sky130_fd_sc_hd__tapvpwrvgnd_1
XTAP_TAPCELL_ROW_112_1975 vccd1 vssd1 SS_sky130_fd_sc_hd__tapvpwrvgnd_1
XFILLER_29_51 vssd1 vccd1 vccd1 vssd1 SS_sky130_fd_sc_hd__fill_4
XFILLER_36_609 vssd1 vccd1 vssd1 vccd1 SS_sky130_ef_sc_hd__decap_40_12
XFILLER_76_778 vssd1 vccd1 vssd1 vccd1 SS_sky130_ef_sc_hd__decap_40_12
XFILLER_29_650 vssd1 vccd1 vssd1 vccd1 SS_sky130_ef_sc_hd__decap_40_12
XFILLER_75_277 vssd1 vccd1 vccd1 vssd1 SS_sky130_fd_sc_hd__fill_2
XFILLER_16_333 vssd1 vccd1 vssd1 vccd1 SS_sky130_ef_sc_hd__decap_40_12
XFILLER_28_193 vssd1 vccd1 vccd1 vssd1 SS_sky130_fd_sc_hd__fill_2
XFILLER_44_653 vssd1 vccd1 vccd1 vssd1 SS_sky130_fd_sc_hd__fill_2
XTAP_TAPCELL_ROW_14_512 vccd1 vssd1 SS_sky130_fd_sc_hd__tapvpwrvgnd_1
XFILLER_16_377 vssd1 vccd1 vssd1 vccd1 SS_sky130_ef_sc_hd__decap_40_12
XFILLER_44_697 vssd1 vccd1 vccd1 vssd1 SS_sky130_fd_sc_hd__fill_2
XFILLER_61_93 vssd1 vccd1 vssd1 vccd1 SS_sky130_ef_sc_hd__decap_40_12
XFILLER_8_587 vccd1 vssd1 vccd1 vssd1 SS_sky130_fd_sc_hd__fill_1
X_1640_ _1640_/Q clkload8/A _1640_/D vccd1 vssd1 vccd1 vssd1 SS_sky130_fd_sc_hd__dfxtp_2
XFILLER_129_279 vccd1 vssd1 vccd1 vssd1 SS_sky130_fd_sc_hd__fill_1
X_1571_ _1841_/A _1608_/CLK _1571_/D vccd1 vssd1 vccd1 vssd1 SS_sky130_fd_sc_hd__dfxtp_2
XTAP_TAPCELL_ROW_74_1403 vccd1 vssd1 SS_sky130_fd_sc_hd__tapvpwrvgnd_1
XFILLER_137_290 vccd1 vssd1 vccd1 vssd1 SS_sky130_fd_sc_hd__fill_1
XANTENNA_4 input42/X vssd1 vccd1 vccd1 vssd1 SS_sky130_fd_sc_hd__diode_2
XFILLER_6_77 vssd1 vccd1 vccd1 vssd1 SS_sky130_fd_sc_hd__fill_4
XTAP_TAPCELL_ROW_74_1414 vccd1 vssd1 SS_sky130_fd_sc_hd__tapvpwrvgnd_1
XFILLER_113_603 vssd1 vccd1 vssd1 vccd1 SS_sky130_ef_sc_hd__decap_40_12
XFILLER_3_281 vssd1 vccd1 vssd1 vccd1 SS_sky130_ef_sc_hd__decap_40_12
XFILLER_4_793 vssd1 vccd1 vssd1 vccd1 SS_sky130_ef_sc_hd__decap_40_12
XFILLER_113_647 vssd1 vccd1 vssd1 vccd1 SS_sky130_ef_sc_hd__decap_40_12
XFILLER_79_561 vssd1 vccd1 vccd1 vssd1 SS_sky130_fd_sc_hd__fill_4
XFILLER_20_3 vssd1 vccd1 vssd1 vccd1 SS_sky130_ef_sc_hd__decap_40_12
XPHY_EDGE_ROW_60_Left_199 vccd1 vssd1 vccd1 vssd1 SS_sky130_fd_sc_hd__decap_3
XFILLER_67_723 vssd1 vccd1 vccd1 vssd1 SS_sky130_fd_sc_hd__fill_4
XFILLER_79_594 vssd1 vccd1 vssd1 vccd1 SS_sky130_ef_sc_hd__decap_40_12
XFILLER_27_609 vssd1 vccd1 vccd1 vssd1 SS_sky130_fd_sc_hd__fill_4
XFILLER_39_447 vccd1 vssd1 vccd1 vssd1 SS_sky130_fd_sc_hd__fill_1
XFILLER_66_233 vssd1 vccd1 vssd1 vccd1 SS_sky130_ef_sc_hd__decap_40_12
XFILLER_94_531 vccd1 vssd1 vccd1 vssd1 SS_sky130_fd_sc_hd__fill_1
XFILLER_66_277 vssd1 vccd1 vssd1 vccd1 SS_sky130_ef_sc_hd__decap_40_12
XFILLER_94_586 vssd1 vccd1 vccd1 vssd1 SS_sky130_fd_sc_hd__fill_2
XFILLER_81_225 vssd1 vccd1 vssd1 vccd1 SS_sky130_ef_sc_hd__decap_40_12
XFILLER_19_193 vssd1 vccd1 vssd1 vccd1 SS_sky130_ef_sc_hd__decap_40_12
XFILLER_34_141 vssd1 vccd1 vssd1 vccd1 SS_sky130_ef_sc_hd__decap_40_12
XFILLER_35_653 vssd1 vccd1 vssd1 vccd1 SS_sky130_ef_sc_hd__decap_40_12
XTAP_TAPCELL_ROW_85_1576 vccd1 vssd1 SS_sky130_fd_sc_hd__tapvpwrvgnd_1
X_1005_ vssd1 vccd1 vccd1 vssd1 wire253/X input40/X _1535_/D _1401_/C1 _1004_/X SS_sky130_fd_sc_hd__o211a_2
XFILLER_35_697 vssd1 vccd1 vccd1 vssd1 SS_sky130_fd_sc_hd__fill_2
XFILLER_50_623 vssd1 vccd1 vssd1 vccd1 SS_sky130_ef_sc_hd__decap_40_12
XFILLER_62_494 vssd1 vccd1 vccd1 vssd1 SS_sky130_fd_sc_hd__fill_4
XFILLER_90_781 vssd1 vccd1 vssd1 vccd1 SS_sky130_ef_sc_hd__decap_40_12
XFILLER_50_645 vssd1 vccd1 vccd1 vssd1 SS_sky130_fd_sc_hd__fill_8
X_1907_ vccd1 vssd1 _1907_/X _1907_/A vccd1 vssd1 SS_sky130_fd_sc_hd__buf_2
X_1838_ vccd1 vssd1 _1838_/X _1838_/A vccd1 vssd1 SS_sky130_fd_sc_hd__buf_2
XFILLER_135_205 vssd1 vccd1 vssd1 vccd1 SS_sky130_ef_sc_hd__decap_40_12
XFILLER_136_728 vssd1 vccd1 vssd1 vccd1 SS_sky130_ef_sc_hd__decap_40_12
XTAP_TAPCELL_ROW_116_2042 vccd1 vssd1 SS_sky130_fd_sc_hd__tapvpwrvgnd_1
XFILLER_135_249 vssd1 vccd1 vssd1 vccd1 SS_sky130_ef_sc_hd__decap_40_12
XFILLER_116_474 vssd1 vccd1 vccd1 vssd1 SS_sky130_fd_sc_hd__fill_2
Xhold576 _1030_/A _1547_/Q vccd1 vssd1 vssd1 vccd1 SS_sky130_fd_sc_hd__dlygate4sd3_1
Xhold587 _1350_/A _1881_/A vccd1 vssd1 vssd1 vccd1 SS_sky130_fd_sc_hd__dlygate4sd3_1
Xhold565 input23/A wbs_dat_i[12] vccd1 vssd1 vssd1 vccd1 SS_sky130_fd_sc_hd__dlygate4sd3_1
XFILLER_103_113 vssd1 vccd1 vssd1 vccd1 SS_sky130_ef_sc_hd__decap_40_12
Xhold598 _1300_/A _1678_/Q vccd1 vssd1 vssd1 vccd1 SS_sky130_fd_sc_hd__dlygate4sd3_1
XFILLER_89_369 vssd1 vccd1 vccd1 vssd1 SS_sky130_fd_sc_hd__fill_4
XFILLER_131_444 vssd1 vccd1 vccd1 vssd1 SS_sky130_fd_sc_hd__fill_4
XFILLER_104_669 vssd1 vccd1 vssd1 vccd1 SS_sky130_ef_sc_hd__decap_40_12
XFILLER_131_499 vssd1 vccd1 vccd1 vssd1 SS_sky130_fd_sc_hd__fill_4
XFILLER_58_745 vssd1 vccd1 vccd1 vssd1 SS_sky130_fd_sc_hd__fill_8
Xload_slew490 vccd1 vssd1 _1473_/C1 _1143_/C1 vccd1 vssd1 SS_sky130_fd_sc_hd__buf_4
XFILLER_100_831 vssd1 vccd1 vccd1 vssd1 SS_sky130_fd_sc_hd__fill_4
XFILLER_97_391 vccd1 vssd1 vccd1 vssd1 SS_sky130_fd_sc_hd__fill_1
XFILLER_57_277 vssd1 vccd1 vccd1 vssd1 SS_sky130_fd_sc_hd__fill_2
XFILLER_82_15 vssd1 vccd1 vssd1 vccd1 SS_sky130_ef_sc_hd__decap_40_12
XFILLER_122_77 vssd1 vccd1 vccd1 vssd1 SS_sky130_fd_sc_hd__fill_4
XTAP_TAPCELL_ROW_0_284 vccd1 vssd1 SS_sky130_fd_sc_hd__tapvpwrvgnd_1
XTAP_TAPCELL_ROW_0_295 vccd1 vssd1 SS_sky130_fd_sc_hd__tapvpwrvgnd_1
XFILLER_53_494 vccd1 vssd1 vccd1 vssd1 SS_sky130_fd_sc_hd__fill_1
XFILLER_81_781 vssd1 vccd1 vccd1 vssd1 SS_sky130_fd_sc_hd__fill_2
XFILLER_40_133 vssd1 vccd1 vccd1 vssd1 SS_sky130_fd_sc_hd__fill_4
XFILLER_9_329 vssd1 vccd1 vccd1 vssd1 SS_sky130_fd_sc_hd__fill_4
XFILLER_40_177 vssd1 vccd1 vssd1 vccd1 SS_sky130_ef_sc_hd__decap_40_12
XFILLER_21_391 vccd1 vssd1 vccd1 vssd1 SS_sky130_fd_sc_hd__fill_1
XFILLER_31_30 vssd1 vccd1 vssd1 vccd1 SS_sky130_ef_sc_hd__decap_40_12
XFILLER_126_249 vssd1 vccd1 vccd1 vssd1 SS_sky130_fd_sc_hd__fill_2
XFILLER_5_557 vssd1 vccd1 vccd1 vssd1 SS_sky130_fd_sc_hd__fill_2
XFILLER_107_441 vssd1 vccd1 vccd1 vssd1 SS_sky130_fd_sc_hd__fill_4
XTAP_TAPCELL_ROW_56_1133 vccd1 vssd1 SS_sky130_fd_sc_hd__tapvpwrvgnd_1
XTAP_TAPCELL_ROW_56_1144 vccd1 vssd1 SS_sky130_fd_sc_hd__tapvpwrvgnd_1
XFILLER_122_433 vssd1 vccd1 vssd1 vccd1 SS_sky130_ef_sc_hd__decap_40_12
XFILLER_107_496 vssd1 vccd1 vccd1 vssd1 SS_sky130_fd_sc_hd__fill_8
XFILLER_1_741 vssd1 vccd1 vssd1 vccd1 SS_sky130_ef_sc_hd__decap_40_12
Xoutput85 vccd1 vssd1 wire275/A _1845_/X vccd1 vssd1 SS_sky130_fd_sc_hd__buf_4
Xoutput74 vccd1 vssd1 wire286/A _1908_/X vccd1 vssd1 SS_sky130_fd_sc_hd__buf_4
XFILLER_122_466 vssd1 vccd1 vccd1 vssd1 SS_sky130_fd_sc_hd__fill_8
Xoutput63 vccd1 vssd1 wire297/A _1898_/X vccd1 vssd1 SS_sky130_fd_sc_hd__buf_4
XFILLER_96_807 vccd1 vssd1 vccd1 vssd1 SS_sky130_fd_sc_hd__fill_1
XFILLER_0_251 vccd1 vssd1 vccd1 vssd1 SS_sky130_fd_sc_hd__fill_1
XFILLER_1_785 vssd1 vccd1 vssd1 vccd1 SS_sky130_ef_sc_hd__decap_40_12
Xoutput96 vccd1 vssd1 wire264/A _1855_/X vccd1 vssd1 SS_sky130_fd_sc_hd__buf_4
XFILLER_122_477 vssd1 vccd1 vssd1 vccd1 SS_sky130_ef_sc_hd__decap_40_12
XFILLER_48_233 vssd1 vccd1 vssd1 vccd1 SS_sky130_ef_sc_hd__decap_40_12
XFILLER_76_531 vccd1 vssd1 vccd1 vssd1 SS_sky130_fd_sc_hd__fill_1
XFILLER_36_417 vssd1 vccd1 vccd1 vssd1 SS_sky130_fd_sc_hd__fill_2
XFILLER_48_277 vssd1 vccd1 vssd1 vccd1 SS_sky130_ef_sc_hd__decap_40_12
XFILLER_49_789 vssd1 vccd1 vccd1 vssd1 SS_sky130_fd_sc_hd__fill_2
XFILLER_63_225 vssd1 vccd1 vssd1 vccd1 SS_sky130_ef_sc_hd__decap_40_12
XFILLER_64_737 vssd1 vccd1 vccd1 vssd1 SS_sky130_fd_sc_hd__fill_8
XFILLER_16_141 vssd1 vccd1 vssd1 vccd1 SS_sky130_ef_sc_hd__decap_40_12
XFILLER_17_653 vssd1 vccd1 vssd1 vccd1 SS_sky130_ef_sc_hd__decap_40_12
XFILLER_17_697 vssd1 vccd1 vssd1 vccd1 SS_sky130_ef_sc_hd__decap_40_12
XFILLER_31_111 vccd1 vssd1 vccd1 vssd1 SS_sky130_fd_sc_hd__fill_1
XFILLER_72_81 vssd1 vccd1 vccd1 vssd1 SS_sky130_fd_sc_hd__fill_2
XFILLER_9_841 vccd1 vssd1 vccd1 vssd1 SS_sky130_fd_sc_hd__fill_1
XTAP_TAPCELL_ROW_80_1495 vccd1 vssd1 SS_sky130_fd_sc_hd__tapvpwrvgnd_1
XFILLER_117_205 vssd1 vccd1 vssd1 vccd1 SS_sky130_ef_sc_hd__decap_40_12
XFILLER_117_249 vssd1 vccd1 vssd1 vccd1 SS_sky130_ef_sc_hd__decap_40_12
X_1623_ _1623_/Q clkload4/A _1623_/D vccd1 vssd1 vccd1 vssd1 SS_sky130_fd_sc_hd__dfxtp_2
X_1554_ _1554_/Q _1746_/CLK _1554_/D vccd1 vssd1 vccd1 vssd1 SS_sky130_fd_sc_hd__dfxtp_2
X_1485_ _1485_/Q clkload7/A _1485_/D vccd1 vssd1 vccd1 vssd1 SS_sky130_fd_sc_hd__dfxtp_2
XFILLER_98_133 vssd1 vccd1 vccd1 vssd1 SS_sky130_fd_sc_hd__fill_4
XFILLER_101_617 vssd1 vccd1 vccd1 vssd1 SS_sky130_fd_sc_hd__fill_4
XFILLER_98_177 vssd1 vccd1 vssd1 vccd1 SS_sky130_ef_sc_hd__decap_40_12
.ends

* Black-box entry subcircuit for KX_CF_ADC_SAR12_core abstract view
.subckt KX_CF_ADC_SAR12_core sample_width[1] sample_width[3] sample_width[4] sample_width[5]
+ sample_width[6] sample_width[7] sample_width[8] sample_width[9] resolution[0] resolution[1]
+ scan_test_mode test_scanin test_scanen test_scanout en_csel_dft sel_csel_dft[0]
+ sel_csel_dft[2] sel_csel_dft[3] hiz sof test_sea reset_n eof data_out[0] data_out[3]
+ data_out[4] data_out[5] data_out[6] data_out[10] data_out[11] iso_en next sample_width[0]
+ vssa_q dft_inp dft_inm dft_op dft_om vpwr_lv_int sel_csel_dft[1] data_out[9] data_out[7]
+ data_out[8] vdda_q vboost vssa pumpclk vccd_q sample_width[2] vsub_vic vsub_agr
+ icont_lv[0] dly_inc dcen data_out[2] data_out[1] en_pump_lv trimunit vdda vssd VPUMP
+ cap_trim[2] cap_trim[1] dft_enc cap_trim[0] pd pd_ana refclk dft_inc[3] dft_inc[2]
+ dft_inc[1] dft_inc[0] dft_outc[2] dft_outc[1] vpwr_int vccd vpwrd_int icont_lv[1]
+ ibiasin dft_outc[0] enable_hv ibias2p5u_out vreflo vinp vinm vrefhi refby2 ibias2p5u
+ ibias2p5u_1
.ends

.subckt CF_ADC_SAR12 sample_width[1] sample_width[3] sample_width[4] sample_width[5]
+ sample_width[7] scan_test_mode test_scanout en_csel_dft sel_csel_dft[2] sof reset_n
+ eof data_out[0] data_out[4] data_out[5] data_out[6] data_out[10] data_out[11] sample_width[0]
+ vpwr_lv_int vdda data_out[9] data_out[7] data_out[8] vccd_q sample_width[2] vpwr_int
+ vpwrd_int data_out[2] data_out[1] dft_om vdda_q VPUMP vboost vssa cap_trim[2] cap_trim[1]
+ pumpclk dft_enc cap_trim[0] refclk dft_inc[2] dft_inc[0] dft_outc[2] dft_outc[1]
+ trimunit vssa_q dft_inp vsub_vic vsub_agr icont_lv[0] dly_inc dcen dft_outc[0] enable_hv
+ dft_inm dft_op ibiasin vreflo vinp vinm vrefhi vgnd vpwr ibias2p5u ibias2p5u_out
+ ibias2p5u_1 refby2 test_scanen en_pump_lv test_scanin sample_width[6] data_out[3]
+ sample_width[8] sample_width[9] resolution[0] dft_inc[1] pd_ana test_sea pd resolution[1]
+ sel_csel_dft[0] dft_inc[3] sel_csel_dft[1] sel_csel_dft[3] hiz next iso_en icont_lv[1]
XKX_CF_ADC_SAR12_core_0 sample_width[1] sample_width[3] sample_width[4] sample_width[5]
+ sample_width[6] sample_width[7] sample_width[8] sample_width[9] resolution[0] resolution[1]
+ scan_test_mode test_scanin test_scanen test_scanout en_csel_dft sel_csel_dft[0]
+ sel_csel_dft[2] sel_csel_dft[3] hiz sof test_sea reset_n eof data_out[0] data_out[3]
+ data_out[4] data_out[5] data_out[6] data_out[10] data_out[11] iso_en next sample_width[0]
+ vssa_q dft_inp dft_inm dft_op dft_om vpwr_lv_int sel_csel_dft[1] data_out[9] data_out[7]
+ data_out[8] vdda_q vboost vssa pumpclk vccd_q sample_width[2] vsub_vic vsub_agr
+ icont_lv[0] dly_inc dcen data_out[2] data_out[1] en_pump_lv trimunit vdda vgnd VPUMP
+ cap_trim[2] cap_trim[1] dft_enc cap_trim[0] pd pd_ana refclk dft_inc[3] dft_inc[2]
+ dft_inc[1] dft_inc[0] dft_outc[2] dft_outc[1] vpwr_int vpwr vpwrd_int icont_lv[1]
+ ibiasin dft_outc[0] enable_hv ibias2p5u_out vreflo vinp vinm vrefhi refby2 ibias2p5u
+ ibias2p5u_1 KX_CF_ADC_SAR12_core
.ends

* Black-box entry subcircuit for C0_CF_REFBUF_core abstract view
.subckt C0_CF_REFBUF_core nbias vpbe pd ch_cont vpwr ch1 switchon out switchoff ref_1v2
+ vnb vpb vgnd ng boost vpwre ch2
.ends

.subckt CF_REFBUF nbias pd ch_cont vpwre ch1 out switchoff ref_1v2 ng switchon boost
+ ch2 vgnd vpwr
XC0_CF_REFBUF_core_0 nbias vpwre pd ch_cont vpwr ch1 switchon out switchoff ref_1v2
+ vgnd vpwr vgnd ng boost vpwre ch2 C0_CF_REFBUF_core
.ends

* Black-box entry subcircuit for T2_CF_BUF_HIZ_core abstract view
.subckt T2_CF_BUF_HIZ_core tp vpb_a vnb vgnd_a clk2_boost clk1_boostr vpwr_a ion iop
+ e_pd en_pd vinp_n vinn_n vinp_na vinn_na vinn_p vinp_p e_na_boost e_n_boost vbpt
+ vbpcis vbncis vout vbpci vbnt ibias vbnci vbpcid vbptd vbnc vbpc vbpb
.ends

.subckt CF_BUF_HIZ tp clk2_boost clk1_boostr ion iop e_pd en_pd vinp_n vinn_n vinn_na
+ vinp_p e_na_boost e_n_boost vbpt vbpci ibias vbnci vbpcid vbptd vbpc vbpb vgnd vpwr
+ vbnt vbpcis vout vbnc vinn_p vbncis vinp_na
XT2_CF_BUF_HIZ_core_0 tp vpwr vgnd vgnd clk2_boost clk1_boostr vpwr ion iop e_pd en_pd
+ vinp_n vinn_n vinp_na vinn_na vinn_p vinp_p e_na_boost e_n_boost vbpt vbpcis vbncis
+ vout vbpci vbnt ibias vbnci vbpcid vbptd vbnc vbpc vbpb T2_CF_BUF_HIZ_core
.ends

* Black-box entry subcircuit for BI_CF_BGR_core abstract view
.subckt BI_CF_BGR_core CurrAbsTrim[5] finetune boost4 boost7 boost6 boost5 trimCurr[5]
+ trimCurr[4] trimCurr[3] trimCurr[2] trimCurr[0] trimCurr[1] CurrAbsTrim[0] CurrAbsTrim[1]
+ CurrAbsTrim[2] CurrAbsTrim[3] CurrAbsTrim[4] mux2sel mux1sel[0] mux1sel[1] dft_sel
+ pd_ibg pd trimTC[6] trimTC[5] trimTC[4] trimTC[3] trimTC[2] trimTC[0] trimTC[1]
+ inl_ctrl[0] inl_ctrl[1] vbias_cascode vbias boost3 dft_curr_in Vout ibg_3uA ibg_2p375uA
+ mux1out mux2out ictat iptat inl_ctrl[6] inl_ctrl[5] inl_ctrl[3] inl_ctrl[2] pbias_ctat
+ vout_ictat inl_ctrl[4] en_startb vb2_fast vpb vgnd vnb vpwr
.ends

.subckt CF_BGR CurrAbsTrim[5] finetune boost4 boost7 boost6 boost5 trimCurr[5] trimCurr[4]
+ trimCurr[3] trimCurr[2] trimCurr[0] trimCurr[1] CurrAbsTrim[0] CurrAbsTrim[1] CurrAbsTrim[2]
+ CurrAbsTrim[3] CurrAbsTrim[4] mux2sel mux1sel[0] mux1sel[1] dft_sel pd_ibg pd trimTC[6]
+ trimTC[5] trimTC[4] trimTC[3] trimTC[2] trimTC[0] trimTC[1] inl_ctrl[0] inl_ctrl[1]
+ vbias_cascode vbias boost3 dft_curr_in ibg_3uA ibg_2p375uA mux1out mux2out ictat
+ iptat inl_ctrl[6] inl_ctrl[5] inl_ctrl[3] inl_ctrl[2] pbias_ctat vout_ictat inl_ctrl[4]
+ vb2_fast vgnd vpwr en_startb Vout
XBI_CF_BGR_core_0 CurrAbsTrim[5] finetune boost4 boost7 boost6 boost5 trimCurr[5]
+ trimCurr[4] trimCurr[3] trimCurr[2] trimCurr[0] trimCurr[1] CurrAbsTrim[0] CurrAbsTrim[1]
+ CurrAbsTrim[2] CurrAbsTrim[3] CurrAbsTrim[4] mux2sel mux1sel[0] mux1sel[1] dft_sel
+ pd_ibg pd trimTC[6] trimTC[5] trimTC[4] trimTC[3] trimTC[2] trimTC[0] trimTC[1]
+ inl_ctrl[0] inl_ctrl[1] vbias_cascode vbias boost3 dft_curr_in Vout ibg_3uA ibg_2p375uA
+ mux1out mux2out ictat iptat inl_ctrl[6] inl_ctrl[5] inl_ctrl[3] inl_ctrl[2] pbias_ctat
+ vout_ictat inl_ctrl[4] en_startb vb2_fast vpwr vgnd vgnd vpwr BI_CF_BGR_core
.ends

* Black-box entry subcircuit for TJ_CF_ADC_SAR12_sar_refs_core abstract view
.subckt TJ_CF_ADC_SAR12_sar_refs_core vssa pd hiz PWR_CTRL_VREF[1] pd_ana EN_RESVDA
+ sw_start PWR_CTRL_VREF[0] pd_vcmbuf refout_en sw_holdb enpdb_hv enable_hv PD_BUF_VREF
+ vdda vda_int vccd vpwrd_int VPUMP muxsarref[2] muxsarref[1] muxsarref[0] S_LV[7]
+ px_in px en_pxin_cap S_LV[6] S_LV[5] S_LV[4] S_LV[3] S_LV[2] S_LV[1] S_LV[0] vssa_shield
+ dft_comp_en vssd vref[4] vref[3] vref[2] vref[1] vref[0] REFBY2 IREF_VCMBUF IREF_VREFBUF
+ refout REFHI
.ends

.subckt CF_ADC_SAR12_sar_refs vdda vda_int vpwrd_int VPUMP vssa pd hiz PWR_CTRL_VREF[1]
+ muxsarref[2] muxsarref[1] muxsarref[0] pd_ana EN_RESVDA sw_start PWR_CTRL_VREF[0]
+ pd_vcmbuf S_LV[7] px_in px refout_en sw_holdb enpdb_hv en_pxin_cap S_LV[6] S_LV[5]
+ S_LV[4] S_LV[3] S_LV[2] S_LV[1] S_LV[0] enable_hv PD_BUF_VREF vssa_shield dft_comp_en
+ vpwr vgnd REFBY2 IREF_VREFBUF refout REFHI vref[0] vref[1] vref[2] vref[3] vref[4]
+ IREF_VCMBUF
XTJ_CF_ADC_SAR12_sar_refs_core_0 vssa pd hiz PWR_CTRL_VREF[1] pd_ana EN_RESVDA sw_start
+ PWR_CTRL_VREF[0] pd_vcmbuf refout_en sw_holdb enpdb_hv enable_hv PD_BUF_VREF vdda
+ vda_int vpwr vpwrd_int VPUMP muxsarref[2] muxsarref[1] muxsarref[0] S_LV[7] px_in
+ px en_pxin_cap S_LV[6] S_LV[5] S_LV[4] S_LV[3] S_LV[2] S_LV[1] S_LV[0] vssa_shield
+ dft_comp_en vgnd vref[4] vref[3] vref[2] vref[1] vref[0] REFBY2 IREF_VCMBUF IREF_VREFBUF
+ refout REFHI TJ_CF_ADC_SAR12_sar_refs_core
.ends

.subckt user_project_wrapper analog_io[0] analog_io[10] analog_io[11] analog_io[12]
+ analog_io[13] analog_io[14] analog_io[15] analog_io[16] analog_io[17] analog_io[18]
+ analog_io[19] analog_io[1] analog_io[20] analog_io[21] analog_io[22] analog_io[23]
+ analog_io[24] analog_io[25] analog_io[26] analog_io[27] analog_io[28] analog_io[2]
+ analog_io[3] analog_io[4] analog_io[5] analog_io[6] analog_io[7] analog_io[8] analog_io[9]
+ io_in[0] io_in[10] io_in[11] io_in[12] io_in[13] io_in[14] io_in[15] io_in[16] io_in[17]
+ io_in[18] io_in[19] io_in[1] io_in[20] io_in[21] io_in[22] io_in[23] io_in[24] io_in[25]
+ io_in[26] io_in[27] io_in[28] io_in[29] io_in[2] io_in[30] io_in[31] io_in[32] io_in[33]
+ io_in[34] io_in[35] io_in[36] io_in[37] io_in[3] io_in[4] io_in[5] io_in[6] io_in[7]
+ io_in[8] io_in[9] io_oeb[0] io_oeb[10] io_oeb[11] io_oeb[12] io_oeb[13] io_oeb[14]
+ io_oeb[15] io_oeb[16] io_oeb[17] io_oeb[18] io_oeb[19] io_oeb[1] io_oeb[20] io_oeb[21]
+ io_oeb[22] io_oeb[23] io_oeb[24] io_oeb[25] io_oeb[26] io_oeb[27] io_oeb[28] io_oeb[29]
+ io_oeb[2] io_oeb[30] io_oeb[31] io_oeb[32] io_oeb[33] io_oeb[34] io_oeb[35] io_oeb[36]
+ io_oeb[37] io_oeb[3] io_oeb[4] io_oeb[5] io_oeb[6] io_oeb[7] io_oeb[8] io_oeb[9]
+ io_out[0] io_out[10] io_out[11] io_out[12] io_out[13] io_out[14] io_out[15] io_out[16]
+ io_out[17] io_out[18] io_out[19] io_out[1] io_out[20] io_out[21] io_out[22] io_out[23]
+ io_out[24] io_out[25] io_out[26] io_out[27] io_out[28] io_out[29] io_out[2] io_out[30]
+ io_out[31] io_out[32] io_out[33] io_out[34] io_out[35] io_out[36] io_out[37] io_out[3]
+ io_out[4] io_out[5] io_out[6] io_out[7] io_out[8] io_out[9] la_data_in[0] la_data_in[100]
+ la_data_in[101] la_data_in[102] la_data_in[103] la_data_in[104] la_data_in[105]
+ la_data_in[106] la_data_in[107] la_data_in[108] la_data_in[109] la_data_in[10] la_data_in[110]
+ la_data_in[111] la_data_in[112] la_data_in[113] la_data_in[114] la_data_in[115]
+ la_data_in[116] la_data_in[117] la_data_in[118] la_data_in[119] la_data_in[11] la_data_in[120]
+ la_data_in[121] la_data_in[122] la_data_in[123] la_data_in[124] la_data_in[125]
+ la_data_in[126] la_data_in[127] la_data_in[12] la_data_in[13] la_data_in[14] la_data_in[15]
+ la_data_in[16] la_data_in[17] la_data_in[18] la_data_in[19] la_data_in[1] la_data_in[20]
+ la_data_in[21] la_data_in[22] la_data_in[23] la_data_in[24] la_data_in[25] la_data_in[26]
+ la_data_in[27] la_data_in[28] la_data_in[29] la_data_in[2] la_data_in[30] la_data_in[31]
+ la_data_in[32] la_data_in[33] la_data_in[34] la_data_in[35] la_data_in[36] la_data_in[37]
+ la_data_in[38] la_data_in[39] la_data_in[3] la_data_in[40] la_data_in[41] la_data_in[42]
+ la_data_in[43] la_data_in[44] la_data_in[45] la_data_in[46] la_data_in[47] la_data_in[48]
+ la_data_in[49] la_data_in[4] la_data_in[50] la_data_in[51] la_data_in[52] la_data_in[53]
+ la_data_in[54] la_data_in[55] la_data_in[56] la_data_in[57] la_data_in[58] la_data_in[59]
+ la_data_in[5] la_data_in[60] la_data_in[61] la_data_in[62] la_data_in[63] la_data_in[64]
+ la_data_in[65] la_data_in[66] la_data_in[67] la_data_in[68] la_data_in[69] la_data_in[6]
+ la_data_in[70] la_data_in[71] la_data_in[72] la_data_in[73] la_data_in[74] la_data_in[75]
+ la_data_in[76] la_data_in[77] la_data_in[78] la_data_in[79] la_data_in[7] la_data_in[80]
+ la_data_in[81] la_data_in[82] la_data_in[83] la_data_in[84] la_data_in[85] la_data_in[86]
+ la_data_in[87] la_data_in[88] la_data_in[89] la_data_in[8] la_data_in[90] la_data_in[91]
+ la_data_in[92] la_data_in[93] la_data_in[94] la_data_in[95] la_data_in[96] la_data_in[97]
+ la_data_in[98] la_data_in[99] la_data_in[9] la_data_out[0] la_data_out[100] la_data_out[101]
+ la_data_out[102] la_data_out[103] la_data_out[104] la_data_out[105] la_data_out[106]
+ la_data_out[107] la_data_out[108] la_data_out[109] la_data_out[10] la_data_out[110]
+ la_data_out[111] la_data_out[112] la_data_out[113] la_data_out[114] la_data_out[115]
+ la_data_out[116] la_data_out[117] la_data_out[118] la_data_out[119] la_data_out[11]
+ la_data_out[120] la_data_out[121] la_data_out[122] la_data_out[123] la_data_out[124]
+ la_data_out[125] la_data_out[126] la_data_out[127] la_data_out[12] la_data_out[13]
+ la_data_out[14] la_data_out[15] la_data_out[16] la_data_out[17] la_data_out[18]
+ la_data_out[19] la_data_out[1] la_data_out[20] la_data_out[21] la_data_out[22] la_data_out[23]
+ la_data_out[24] la_data_out[25] la_data_out[26] la_data_out[27] la_data_out[28]
+ la_data_out[29] la_data_out[2] la_data_out[30] la_data_out[31] la_data_out[32] la_data_out[33]
+ la_data_out[34] la_data_out[35] la_data_out[36] la_data_out[37] la_data_out[38]
+ la_data_out[39] la_data_out[3] la_data_out[40] la_data_out[41] la_data_out[42] la_data_out[43]
+ la_data_out[44] la_data_out[45] la_data_out[46] la_data_out[47] la_data_out[48]
+ la_data_out[49] la_data_out[4] la_data_out[50] la_data_out[51] la_data_out[52] la_data_out[53]
+ la_data_out[54] la_data_out[55] la_data_out[56] la_data_out[57] la_data_out[58]
+ la_data_out[59] la_data_out[5] la_data_out[60] la_data_out[61] la_data_out[62] la_data_out[63]
+ la_data_out[64] la_data_out[65] la_data_out[66] la_data_out[67] la_data_out[68]
+ la_data_out[69] la_data_out[6] la_data_out[70] la_data_out[71] la_data_out[72] la_data_out[73]
+ la_data_out[74] la_data_out[75] la_data_out[76] la_data_out[77] la_data_out[78]
+ la_data_out[79] la_data_out[7] la_data_out[80] la_data_out[81] la_data_out[82] la_data_out[83]
+ la_data_out[84] la_data_out[85] la_data_out[86] la_data_out[87] la_data_out[88]
+ la_data_out[89] la_data_out[8] la_data_out[90] la_data_out[91] la_data_out[92] la_data_out[93]
+ la_data_out[94] la_data_out[95] la_data_out[96] la_data_out[97] la_data_out[98]
+ la_data_out[99] la_data_out[9] la_oenb[0] la_oenb[100] la_oenb[101] la_oenb[102]
+ la_oenb[103] la_oenb[104] la_oenb[105] la_oenb[106] la_oenb[107] la_oenb[108] la_oenb[109]
+ la_oenb[10] la_oenb[110] la_oenb[111] la_oenb[112] la_oenb[113] la_oenb[114] la_oenb[115]
+ la_oenb[116] la_oenb[117] la_oenb[118] la_oenb[119] la_oenb[11] la_oenb[120] la_oenb[121]
+ la_oenb[122] la_oenb[123] la_oenb[124] la_oenb[125] la_oenb[126] la_oenb[127] la_oenb[12]
+ la_oenb[13] la_oenb[14] la_oenb[15] la_oenb[16] la_oenb[17] la_oenb[18] la_oenb[19]
+ la_oenb[1] la_oenb[20] la_oenb[21] la_oenb[22] la_oenb[23] la_oenb[24] la_oenb[25]
+ la_oenb[26] la_oenb[27] la_oenb[28] la_oenb[29] la_oenb[2] la_oenb[30] la_oenb[31]
+ la_oenb[32] la_oenb[33] la_oenb[34] la_oenb[35] la_oenb[36] la_oenb[37] la_oenb[38]
+ la_oenb[39] la_oenb[3] la_oenb[40] la_oenb[41] la_oenb[42] la_oenb[43] la_oenb[44]
+ la_oenb[45] la_oenb[46] la_oenb[47] la_oenb[48] la_oenb[49] la_oenb[4] la_oenb[50]
+ la_oenb[51] la_oenb[52] la_oenb[53] la_oenb[54] la_oenb[55] la_oenb[56] la_oenb[57]
+ la_oenb[58] la_oenb[59] la_oenb[5] la_oenb[60] la_oenb[61] la_oenb[62] la_oenb[63]
+ la_oenb[64] la_oenb[65] la_oenb[66] la_oenb[67] la_oenb[68] la_oenb[69] la_oenb[6]
+ la_oenb[70] la_oenb[71] la_oenb[72] la_oenb[73] la_oenb[74] la_oenb[75] la_oenb[76]
+ la_oenb[77] la_oenb[78] la_oenb[79] la_oenb[7] la_oenb[80] la_oenb[81] la_oenb[82]
+ la_oenb[83] la_oenb[84] la_oenb[85] la_oenb[86] la_oenb[87] la_oenb[88] la_oenb[89]
+ la_oenb[8] la_oenb[90] la_oenb[91] la_oenb[92] la_oenb[93] la_oenb[94] la_oenb[95]
+ la_oenb[96] la_oenb[97] la_oenb[98] la_oenb[99] la_oenb[9] user_clock2 user_irq[0]
+ user_irq[1] user_irq[2] vccd1 vccd2 vdda1 vdda2 vssa1 vssa2 vssd1 vssd2 wb_clk_i
+ wb_rst_i wbs_ack_o wbs_adr_i[0] wbs_adr_i[10] wbs_adr_i[11] wbs_adr_i[12] wbs_adr_i[13]
+ wbs_adr_i[14] wbs_adr_i[15] wbs_adr_i[16] wbs_adr_i[17] wbs_adr_i[18] wbs_adr_i[19]
+ wbs_adr_i[1] wbs_adr_i[20] wbs_adr_i[21] wbs_adr_i[22] wbs_adr_i[23] wbs_adr_i[24]
+ wbs_adr_i[25] wbs_adr_i[26] wbs_adr_i[27] wbs_adr_i[28] wbs_adr_i[29] wbs_adr_i[2]
+ wbs_adr_i[30] wbs_adr_i[31] wbs_adr_i[3] wbs_adr_i[4] wbs_adr_i[5] wbs_adr_i[6]
+ wbs_adr_i[7] wbs_adr_i[8] wbs_adr_i[9] wbs_cyc_i wbs_dat_i[0] wbs_dat_i[10] wbs_dat_i[11]
+ wbs_dat_i[12] wbs_dat_i[13] wbs_dat_i[14] wbs_dat_i[15] wbs_dat_i[16] wbs_dat_i[17]
+ wbs_dat_i[18] wbs_dat_i[19] wbs_dat_i[1] wbs_dat_i[20] wbs_dat_i[21] wbs_dat_i[22]
+ wbs_dat_i[23] wbs_dat_i[24] wbs_dat_i[25] wbs_dat_i[26] wbs_dat_i[27] wbs_dat_i[28]
+ wbs_dat_i[29] wbs_dat_i[2] wbs_dat_i[30] wbs_dat_i[31] wbs_dat_i[3] wbs_dat_i[4]
+ wbs_dat_i[5] wbs_dat_i[6] wbs_dat_i[7] wbs_dat_i[8] wbs_dat_i[9] wbs_dat_o[0] wbs_dat_o[10]
+ wbs_dat_o[11] wbs_dat_o[12] wbs_dat_o[13] wbs_dat_o[14] wbs_dat_o[15] wbs_dat_o[16]
+ wbs_dat_o[17] wbs_dat_o[18] wbs_dat_o[19] wbs_dat_o[1] wbs_dat_o[20] wbs_dat_o[21]
+ wbs_dat_o[22] wbs_dat_o[23] wbs_dat_o[24] wbs_dat_o[25] wbs_dat_o[26] wbs_dat_o[27]
+ wbs_dat_o[28] wbs_dat_o[29] wbs_dat_o[2] wbs_dat_o[30] wbs_dat_o[31] wbs_dat_o[3]
+ wbs_dat_o[4] wbs_dat_o[5] wbs_dat_o[6] wbs_dat_o[7] wbs_dat_o[8] wbs_dat_o[9] wbs_sel_i[0]
+ wbs_sel_i[1] wbs_sel_i[2] wbs_sel_i[3] wbs_stb_i wbs_we_i
Xu_afe_wb u_afe_wb/adc_data[0] u_afe_wb/adc_data[10] u_afe_wb/adc_data[11] u_afe_wb/adc_data[1]
+ u_afe_wb/adc_data[2] u_afe_wb/adc_data[3] u_afe_wb/adc_data[4] u_afe_wb/adc_data[5]
+ u_afe_wb/adc_data[6] u_afe_wb/adc_data[7] u_afe_wb/adc_data[8] u_afe_wb/adc_data[9]
+ u_afe_wb/adc_eof u_cf_buf_hiz/e_pd u_afe_wb/analog_ctrl[100] u_afe_wb/analog_ctrl[101]
+ u_afe_wb/analog_ctrl[102] u_afe_wb/analog_ctrl[103] u_cf_refbuf/pd u_cf_refbuf/switchon
+ u_cf_refbuf/boost u_cf_refbuf/ch_cont u_afe_wb/analog_ctrl[108] u_afe_wb/analog_ctrl[109]
+ u_cf_adc_sar12/reset_n u_afe_wb/analog_ctrl[110] u_afe_wb/analog_ctrl[111] u_afe_wb/analog_ctrl[112]
+ u_afe_wb/analog_ctrl[113] u_afe_wb/analog_ctrl[114] u_afe_wb/analog_ctrl[115] u_afe_wb/analog_ctrl[116]
+ u_afe_wb/analog_ctrl[117] u_afe_wb/analog_ctrl[118] u_afe_wb/analog_ctrl[119] u_cf_adc_sar12/sof
+ u_afe_wb/analog_ctrl[120] u_afe_wb/analog_ctrl[121] u_afe_wb/analog_ctrl[122] u_cf_adc_sar12/next
+ u_cf_adc_sar12/hiz u_cf_adc_sar12/iso_en u_cf_adc_sar12/enable_hv u_cf_adc_sar12/trimunit
+ u_cf_adc_sar12/dly_inc u_cf_adc_sar12/dcen u_cf_adc_sar12/pumpclk u_cf_buf_hiz/en_pd
+ u_afe_wb/analog_ctrl[20] u_afe_wb/analog_ctrl[21] u_afe_wb/analog_ctrl[22] u_afe_wb/analog_ctrl[23]
+ u_cf_adc_sar12/test_sea u_afe_wb/analog_ctrl[25] u_afe_wb/analog_ctrl[26] u_afe_wb/analog_ctrl[27]
+ u_afe_wb/analog_ctrl[28] u_afe_wb/analog_ctrl[29] u_cf_buf_hiz/tp u_afe_wb/analog_ctrl[30]
+ u_afe_wb/analog_ctrl[31] u_afe_wb/analog_ctrl[32] u_afe_wb/analog_ctrl[33] u_afe_wb/analog_ctrl[34]
+ u_afe_wb/analog_ctrl[35] u_afe_wb/analog_ctrl[36] u_afe_wb/analog_ctrl[37] u_afe_wb/analog_ctrl[38]
+ u_afe_wb/analog_ctrl[39] u_cf_buf_hiz/clk2_boost u_afe_wb/analog_ctrl[40] u_afe_wb/analog_ctrl[41]
+ u_afe_wb/analog_ctrl[42] u_afe_wb/analog_ctrl[43] u_afe_wb/analog_ctrl[44] u_afe_wb/analog_ctrl[45]
+ u_afe_wb/analog_ctrl[46] u_afe_wb/analog_ctrl[47] u_afe_wb/analog_ctrl[48] u_afe_wb/analog_ctrl[49]
+ u_cf_buf_hiz/e_n_boost u_afe_wb/analog_ctrl[50] u_afe_wb/analog_ctrl[51] u_afe_wb/analog_ctrl[52]
+ u_afe_wb/analog_ctrl[53] u_afe_wb/analog_ctrl[54] u_afe_wb/analog_ctrl[55] u_afe_wb/analog_ctrl[56]
+ u_afe_wb/analog_ctrl[57] u_afe_wb/analog_ctrl[58] u_afe_wb/analog_ctrl[59] u_cf_buf_hiz/e_na_boost
+ u_afe_wb/analog_ctrl[60] u_afe_wb/analog_ctrl[61] u_afe_wb/analog_ctrl[62] u_afe_wb/analog_ctrl[63]
+ u_cf_bgr/trimTC[0] u_cf_bgr/trimTC[1] u_cf_bgr/trimTC[2] u_cf_bgr/trimTC[3] u_cf_bgr/trimTC[4]
+ u_cf_bgr/trimTC[5] u_afe_wb/analog_ctrl[6] u_cf_bgr/trimTC[6] u_cf_bgr/trimCurr[0]
+ u_cf_bgr/trimCurr[1] u_cf_bgr/trimCurr[2] u_cf_bgr/trimCurr[3] u_cf_bgr/trimCurr[4]
+ u_cf_bgr/trimCurr[5] u_cf_bgr/CurrAbsTrim[0] u_cf_bgr/CurrAbsTrim[1] u_cf_bgr/CurrAbsTrim[2]
+ u_afe_wb/analog_ctrl[7] u_cf_bgr/CurrAbsTrim[3] u_cf_bgr/CurrAbsTrim[4] u_cf_bgr/CurrAbsTrim[5]
+ u_cf_bgr/inl_ctrl[0] u_cf_bgr/inl_ctrl[1] u_cf_bgr/inl_ctrl[2] u_cf_bgr/inl_ctrl[3]
+ u_cf_bgr/inl_ctrl[4] u_cf_bgr/inl_ctrl[5] u_cf_bgr/inl_ctrl[6] u_cf_adc_sar12/pd
+ u_cf_bgr/mux1sel[0] u_cf_bgr/mux1sel[1] u_cf_bgr/mux2sel u_cf_bgr/dft_sel u_cf_bgr/pd
+ u_cf_bgr/pd_ibg u_cf_bgr/finetune u_cf_bgr/en_startb u_afe_wb/analog_ctrl[98] u_afe_wb/analog_ctrl[99]
+ u_cf_adc_sar12/pd_ana io_oeb[7] io_oeb[17] io_oeb[18] io_oeb[19] io_oeb[20] io_oeb[21]
+ io_oeb[22] io_oeb[23] io_oeb[24] io_oeb[25] io_oeb[26] io_oeb[8] io_oeb[27] io_oeb[28]
+ io_oeb[29] io_oeb[30] io_oeb[31] io_oeb[32] io_oeb[33] io_oeb[34] io_oeb[9] io_oeb[10]
+ io_oeb[11] io_oeb[12] io_oeb[13] io_oeb[14] io_oeb[15] io_oeb[16] io_out[7] io_out[17]
+ io_out[18] io_out[19] io_out[20] io_out[21] io_out[22] io_out[23] io_out[24] io_out[25]
+ io_out[26] io_out[8] io_out[27] io_out[28] io_out[29] io_out[30] io_out[31] io_out[32]
+ io_out[33] io_out[34] io_out[9] io_out[10] io_out[11] io_out[12] io_out[13] io_out[14]
+ io_out[15] io_out[16] wb_clk_i wb_rst_i wbs_ack_o wbs_adr_i[0] wbs_adr_i[10] wbs_adr_i[11]
+ wbs_adr_i[12] wbs_adr_i[13] wbs_adr_i[14] wbs_adr_i[15] wbs_adr_i[16] wbs_adr_i[17]
+ wbs_adr_i[18] wbs_adr_i[19] wbs_adr_i[1] wbs_adr_i[20] wbs_adr_i[21] wbs_adr_i[22]
+ wbs_adr_i[23] wbs_adr_i[24] wbs_adr_i[25] wbs_adr_i[26] wbs_adr_i[27] wbs_adr_i[28]
+ wbs_adr_i[29] wbs_adr_i[2] wbs_adr_i[30] wbs_adr_i[31] wbs_adr_i[3] wbs_adr_i[4]
+ wbs_adr_i[5] wbs_adr_i[6] wbs_adr_i[7] wbs_adr_i[8] wbs_adr_i[9] wbs_cyc_i wbs_dat_i[0]
+ wbs_dat_i[10] wbs_dat_i[11] wbs_dat_i[12] wbs_dat_i[13] wbs_dat_i[14] wbs_dat_i[15]
+ wbs_dat_i[16] wbs_dat_i[17] wbs_dat_i[18] wbs_dat_i[19] wbs_dat_i[1] wbs_dat_i[20]
+ wbs_dat_i[21] wbs_dat_i[22] wbs_dat_i[23] wbs_dat_i[24] wbs_dat_i[25] wbs_dat_i[26]
+ wbs_dat_i[27] wbs_dat_i[28] wbs_dat_i[29] wbs_dat_i[2] wbs_dat_i[30] wbs_dat_i[31]
+ wbs_dat_i[3] wbs_dat_i[4] wbs_dat_i[5] wbs_dat_i[6] wbs_dat_i[7] wbs_dat_i[8] wbs_dat_i[9]
+ wbs_dat_o[0] wbs_dat_o[10] wbs_dat_o[11] wbs_dat_o[12] wbs_dat_o[13] wbs_dat_o[14]
+ wbs_dat_o[15] wbs_dat_o[16] wbs_dat_o[17] wbs_dat_o[18] wbs_dat_o[19] wbs_dat_o[1]
+ wbs_dat_o[20] wbs_dat_o[21] wbs_dat_o[22] wbs_dat_o[23] wbs_dat_o[24] wbs_dat_o[25]
+ wbs_dat_o[26] wbs_dat_o[27] wbs_dat_o[28] wbs_dat_o[29] wbs_dat_o[2] wbs_dat_o[30]
+ wbs_dat_o[31] wbs_dat_o[3] wbs_dat_o[4] wbs_dat_o[5] wbs_dat_o[6] wbs_dat_o[7] wbs_dat_o[8]
+ wbs_dat_o[9] wbs_sel_i[0] wbs_sel_i[1] wbs_sel_i[2] wbs_sel_i[3] wbs_stb_i wbs_we_i
+ vccd1 vssd1 afe_wb
Xu_cf_adc_sar12 u_afe_wb/analog_ctrl[28] u_afe_wb/analog_ctrl[30] u_afe_wb/analog_ctrl[31]
+ u_afe_wb/analog_ctrl[32] u_afe_wb/analog_ctrl[34] u_afe_wb/analog_ctrl[21] u_cf_adc_sar12/test_scanout
+ u_cf_adc_sar12/en_csel_dft u_afe_wb/analog_ctrl[51] u_cf_adc_sar12/sof u_cf_adc_sar12/reset_n
+ u_afe_wb/adc_eof u_afe_wb/adc_data[0] u_afe_wb/adc_data[4] u_afe_wb/adc_data[5]
+ u_afe_wb/adc_data[6] u_afe_wb/adc_data[10] u_afe_wb/adc_data[11] u_afe_wb/analog_ctrl[27]
+ u_cf_adc_sar12/vpwr_lv_int analog_io[25] u_afe_wb/adc_data[9] u_afe_wb/adc_data[7]
+ u_afe_wb/adc_data[8] u_cf_adc_sar12/vccd_q u_afe_wb/analog_ctrl[29] u_cf_adc_sar12/vpwr_int
+ u_cf_adc_sar12/vpwrd_int u_afe_wb/adc_data[2] u_afe_wb/adc_data[1] u_cf_adc_sar12/dft_om
+ u_cf_adc_sar12/vdda_q analog_io[27] u_cf_adc_sar12/vboost analog_io[26] u_afe_wb/analog_ctrl[39]
+ u_afe_wb/analog_ctrl[38] u_cf_adc_sar12/pumpclk u_cf_adc_sar12/dft_enc u_afe_wb/analog_ctrl[37]
+ user_clock2 u_afe_wb/analog_ctrl[44] u_afe_wb/analog_ctrl[42] u_afe_wb/analog_ctrl[48]
+ u_afe_wb/analog_ctrl[47] u_cf_adc_sar12/trimunit u_cf_adc_sar12/vssa_q u_cf_adc_sar12/dft_inp
+ u_cf_adc_sar12/vsub_vic u_cf_adc_sar12/vsub_agr u_afe_wb/analog_ctrl[40] u_cf_adc_sar12/dly_inc
+ u_cf_adc_sar12/dcen u_afe_wb/analog_ctrl[46] u_cf_adc_sar12/enable_hv u_cf_adc_sar12/dft_inm
+ u_cf_adc_sar12/dft_op u_cf_adc_sar12/ibiasin analog_io[22] u_cf_buf_hiz/vout analog_io[20]
+ u_cf_adc_sar12/vrefhi vssd1 vccd1 u_cf_buf_hiz/ibias u_cf_adc_sar12/ibias2p5u_out
+ u_cf_buf_hiz/ibias u_cf_adc_sar12/refby2 u_afe_wb/analog_ctrl[23] u_afe_wb/analog_ctrl[20]
+ u_afe_wb/analog_ctrl[22] u_afe_wb/analog_ctrl[33] u_afe_wb/adc_data[3] u_afe_wb/analog_ctrl[35]
+ u_afe_wb/analog_ctrl[36] u_afe_wb/analog_ctrl[25] u_afe_wb/analog_ctrl[43] u_cf_adc_sar12/pd_ana
+ u_cf_adc_sar12/test_sea u_cf_adc_sar12/pd u_afe_wb/analog_ctrl[26] u_afe_wb/analog_ctrl[49]
+ u_afe_wb/analog_ctrl[45] u_afe_wb/analog_ctrl[50] u_afe_wb/analog_ctrl[52] u_cf_adc_sar12/hiz
+ u_cf_adc_sar12/next u_cf_adc_sar12/iso_en u_afe_wb/analog_ctrl[41] CF_ADC_SAR12
Xu_cf_refbuf u_cf_bgr/ibg_3uA u_cf_refbuf/pd u_cf_refbuf/ch_cont analog_io[8] analog_io[7]
+ analog_io[7] u_cf_refbuf/switchoff u_cf_bgr/Vout analog_io[8] u_cf_refbuf/switchon
+ u_cf_refbuf/boost analog_io[7] vssd1 vccd1 CF_REFBUF
Xu_cf_buf_hiz u_cf_buf_hiz/tp u_cf_buf_hiz/clk2_boost u_afe_wb/analog_ctrl[6] u_cf_buf_hiz/ion
+ u_cf_buf_hiz/iop u_cf_buf_hiz/e_pd u_cf_buf_hiz/en_pd analog_io[3] analog_io[4]
+ analog_io[6] analog_io[1] u_cf_buf_hiz/e_na_boost u_cf_buf_hiz/e_n_boost analog_io[9]
+ analog_io[14] u_cf_buf_hiz/ibias analog_io[15] analog_io[18] analog_io[19] analog_io[12]
+ analog_io[11] vssd1 vccd1 analog_io[10] analog_io[16] u_cf_buf_hiz/vout analog_io[13]
+ analog_io[2] analog_io[17] analog_io[5] CF_BUF_HIZ
Xu_cf_bgr u_cf_bgr/CurrAbsTrim[5] u_cf_bgr/finetune u_cf_bgr/boost4 u_cf_bgr/boost7
+ u_cf_bgr/boost6 u_cf_bgr/boost5 u_cf_bgr/trimCurr[5] u_cf_bgr/trimCurr[4] u_cf_bgr/trimCurr[3]
+ u_cf_bgr/trimCurr[2] u_cf_bgr/trimCurr[0] u_cf_bgr/trimCurr[1] u_cf_bgr/CurrAbsTrim[0]
+ u_cf_bgr/CurrAbsTrim[1] u_cf_bgr/CurrAbsTrim[2] u_cf_bgr/CurrAbsTrim[3] u_cf_bgr/CurrAbsTrim[4]
+ u_cf_bgr/mux2sel u_cf_bgr/mux1sel[0] u_cf_bgr/mux1sel[1] u_cf_bgr/dft_sel u_cf_bgr/pd_ibg
+ u_cf_bgr/pd u_cf_bgr/trimTC[6] u_cf_bgr/trimTC[5] u_cf_bgr/trimTC[4] u_cf_bgr/trimTC[3]
+ u_cf_bgr/trimTC[2] u_cf_bgr/trimTC[0] u_cf_bgr/trimTC[1] u_cf_bgr/inl_ctrl[0] u_cf_bgr/inl_ctrl[1]
+ u_cf_bgr/vbias_cascode u_cf_bgr/vbias u_cf_bgr/boost3 analog_io[24] u_cf_bgr/ibg_3uA
+ u_cf_buf_hiz/ibias u_cf_bgr/mux1out u_cf_bgr/mux2out u_cf_bgr/ictat u_cf_bgr/iptat
+ u_cf_bgr/inl_ctrl[6] u_cf_bgr/inl_ctrl[5] u_cf_bgr/inl_ctrl[3] u_cf_bgr/inl_ctrl[2]
+ u_cf_bgr/pbias_ctat u_cf_bgr/vout_ictat u_cf_bgr/inl_ctrl[4] analog_io[0] vssd1
+ vccd1 u_cf_bgr/en_startb u_cf_bgr/Vout CF_BGR
Xu_cf_adc_sar12_sar_refs analog_io[25] u_cf_adc_sar12_sar_refs/vda_int u_cf_adc_sar12_sar_refs/vpwrd_int
+ analog_io[27] analog_io[26] u_cf_adc_sar12/pd u_cf_adc_sar12/hiz u_afe_wb/analog_ctrl[59]
+ u_afe_wb/analog_ctrl[62] u_afe_wb/analog_ctrl[61] u_afe_wb/analog_ctrl[60] u_cf_adc_sar12/pd_ana
+ u_afe_wb/analog_ctrl[63] u_afe_wb/analog_ctrl[108] u_afe_wb/analog_ctrl[58] u_afe_wb/analog_ctrl[109]
+ u_afe_wb/analog_ctrl[117] u_cf_adc_sar12_sar_refs/px_in u_cf_adc_sar12_sar_refs/px
+ u_afe_wb/analog_ctrl[118] u_afe_wb/analog_ctrl[119] u_afe_wb/analog_ctrl[120] u_cf_adc_sar12_sar_refs/en_pxin_cap
+ u_afe_wb/analog_ctrl[116] u_afe_wb/analog_ctrl[115] u_afe_wb/analog_ctrl[114] u_afe_wb/analog_ctrl[113]
+ u_afe_wb/analog_ctrl[112] u_afe_wb/analog_ctrl[111] u_afe_wb/analog_ctrl[110] u_cf_adc_sar12/enable_hv
+ u_afe_wb/analog_ctrl[121] analog_io[26] u_afe_wb/analog_ctrl[122] vccd1 vssd1 u_cf_adc_sar12/refby2
+ u_cf_buf_hiz/ibias analog_io[21] u_cf_adc_sar12/vrefhi u_afe_wb/analog_ctrl[53]
+ u_afe_wb/analog_ctrl[54] u_afe_wb/analog_ctrl[55] u_afe_wb/analog_ctrl[56] u_afe_wb/analog_ctrl[57]
+ u_cf_buf_hiz/ibias CF_ADC_SAR12_sar_refs
.ends
