* NGSPICE file created from user_project_wrapper.ext - technology: sky130A

* Black-box entry subcircuit for sky130_fd_sc_hd__fill_2$1 abstract view
.subckt sky130_fd_sc_hd__fill_2$1 VGND VPWR VPB VNB
.ends

* Black-box entry subcircuit for sky130_fd_sc_hd__tapvpwrvgnd_1$1 abstract view
.subckt sky130_fd_sc_hd__tapvpwrvgnd_1$1 VPWR VGND
.ends

* Black-box entry subcircuit for sky130_fd_sc_hd__fill_4$1 abstract view
.subckt sky130_fd_sc_hd__fill_4$1 VGND VPWR VPB VNB
.ends

.subckt sky130_ef_sc_hd__decap_40_12$1 VGND VPWR VPB VNB
X0 VPWR VGND VPWR VPB sky130_fd_pr__pfet_01v8_hvt ad=0.7482 pd=3.46 as=0 ps=0 w=0.87 l=1.65
X1 VGND VPWR VGND VNB sky130_fd_pr__nfet_01v8 ad=1.496 pd=6.54 as=0 ps=0 w=0.55 l=1.6
.ends

.subckt sky130_fd_sc_hd__decap_3$1 VPWR VGND VPB VNB
X0 VPWR VGND VPWR VPB sky130_fd_pr__pfet_01v8_hvt ad=0.2262 pd=2.26 as=0 ps=0 w=0.87 l=0.59
X1 VGND VPWR VGND VNB sky130_fd_pr__nfet_01v8 ad=0.143 pd=1.62 as=0 ps=0 w=0.55 l=0.59
.ends

* Black-box entry subcircuit for sky130_fd_sc_hd__fill_1$1 abstract view
.subckt sky130_fd_sc_hd__fill_1$1 VPWR VGND VPB VNB
.ends

* Black-box entry subcircuit for sky130_fd_sc_hd__fill_8$1 abstract view
.subckt sky130_fd_sc_hd__fill_8$1 VGND VPWR VPB VNB
.ends

.subckt sky130_fd_sc_hd__or2_1$1 A X B VGND VPWR VPB VNB
X0 VGND A a_68_297# VNB sky130_fd_pr__nfet_01v8 ad=0.10025 pd=0.985 as=0.0567 ps=0.69 w=0.42 l=0.15
X1 a_68_297# B VGND VNB sky130_fd_pr__nfet_01v8 ad=0.0567 pd=0.69 as=0.1092 ps=1.36 w=0.42 l=0.15
X2 X a_68_297# VGND VNB sky130_fd_pr__nfet_01v8 ad=0.169 pd=1.82 as=0.10025 ps=0.985 w=0.65 l=0.15
X3 VPWR A a_150_297# VPB sky130_fd_pr__pfet_01v8_hvt ad=0.14575 pd=1.335 as=0.0441 ps=0.63 w=0.42 l=0.15
X4 X a_68_297# VPWR VPB sky130_fd_pr__pfet_01v8_hvt ad=0.34 pd=2.68 as=0.14575 ps=1.335 w=1 l=0.15
X5 a_150_297# B a_68_297# VPB sky130_fd_pr__pfet_01v8_hvt ad=0.0441 pd=0.63 as=0.1092 ps=1.36 w=0.42 l=0.15
.ends

.subckt sky130_fd_sc_hd__o211a_1$1 C1 B1 A2 A1 X VGND VPWR VPB VNB
X0 VGND A1 a_215_47# VNB sky130_fd_pr__nfet_01v8 ad=0.105625 pd=0.975 as=0.169 ps=1.82 w=0.65 l=0.15
X1 a_510_47# B1 a_215_47# VNB sky130_fd_pr__nfet_01v8 ad=0.11375 pd=1 as=0.143 ps=1.09 w=0.65 l=0.15
X2 a_79_21# C1 VPWR VPB sky130_fd_pr__pfet_01v8_hvt ad=0.3 pd=2.6 as=0.175 ps=1.35 w=1 l=0.15
X3 VPWR B1 a_79_21# VPB sky130_fd_pr__pfet_01v8_hvt ad=0.175 pd=1.35 as=0.22 ps=1.44 w=1 l=0.15
X4 a_79_21# A2 a_297_297# VPB sky130_fd_pr__pfet_01v8_hvt ad=0.22 pd=1.44 as=0.1625 ps=1.325 w=1 l=0.15
X5 a_297_297# A1 VPWR VPB sky130_fd_pr__pfet_01v8_hvt ad=0.1625 pd=1.325 as=0.26 ps=2.52 w=1 l=0.15
X6 a_79_21# C1 a_510_47# VNB sky130_fd_pr__nfet_01v8 ad=0.195 pd=1.9 as=0.11375 ps=1 w=0.65 l=0.15
X7 VPWR a_79_21# X VPB sky130_fd_pr__pfet_01v8_hvt ad=0.26 pd=2.52 as=0.26 ps=2.52 w=1 l=0.15
X8 VGND a_79_21# X VNB sky130_fd_pr__nfet_01v8 ad=0.169 pd=1.82 as=0.169 ps=1.82 w=0.65 l=0.15
X9 a_215_47# A2 VGND VNB sky130_fd_pr__nfet_01v8 ad=0.143 pd=1.09 as=0.105625 ps=0.975 w=0.65 l=0.15
.ends

.subckt sky130_fd_sc_hd__dfxtp_1$1 Q CLK D VPWR VGND VPB VNB
X0 Q a_1059_315# VGND VNB sky130_fd_pr__nfet_01v8 ad=0.169 pd=1.82 as=0.08775 ps=0.92 w=0.65 l=0.15
X1 a_891_413# a_193_47# a_634_159# VNB sky130_fd_pr__special_nfet_01v8 ad=0.0684 pd=0.74 as=0.0989 ps=0.995 w=0.36 l=0.15
X2 a_561_413# a_27_47# a_466_413# VPB sky130_fd_pr__pfet_01v8_hvt ad=0.07665 pd=0.785 as=0.06825 ps=0.745 w=0.42 l=0.15
X3 VPWR CLK a_27_47# VPB sky130_fd_pr__pfet_01v8_hvt ad=0.0864 pd=0.91 as=0.1664 ps=1.8 w=0.64 l=0.15
X4 Q a_1059_315# VPWR VPB sky130_fd_pr__pfet_01v8_hvt ad=0.26 pd=2.52 as=0.135 ps=1.27 w=1 l=0.15
X5 a_381_47# D VPWR VPB sky130_fd_pr__pfet_01v8_hvt ad=0.05775 pd=0.695 as=0.1092 ps=1.36 w=0.42 l=0.15
X6 VGND a_634_159# a_592_47# VNB sky130_fd_pr__nfet_01v8 ad=0.12095 pd=1.085 as=0.0696 ps=0.765 w=0.42 l=0.15
X7 VPWR a_891_413# a_1059_315# VPB sky130_fd_pr__pfet_01v8_hvt ad=0.135 pd=1.27 as=0.27 ps=2.54 w=1 l=0.15
X8 a_466_413# a_193_47# a_381_47# VPB sky130_fd_pr__pfet_01v8_hvt ad=0.06825 pd=0.745 as=0.05775 ps=0.695 w=0.42 l=0.15
X9 VPWR a_634_159# a_561_413# VPB sky130_fd_pr__pfet_01v8_hvt ad=0.178875 pd=1.26 as=0.07665 ps=0.785 w=0.42 l=0.15
X10 a_634_159# a_466_413# VGND VNB sky130_fd_pr__nfet_01v8 ad=0.0989 pd=0.995 as=0.12095 ps=1.085 w=0.64 l=0.15
X11 a_634_159# a_466_413# VPWR VPB sky130_fd_pr__pfet_01v8_hvt ad=0.1095 pd=1.075 as=0.178875 ps=1.26 w=0.75 l=0.15
X12 a_975_413# a_193_47# a_891_413# VPB sky130_fd_pr__pfet_01v8_hvt ad=0.0882 pd=0.84 as=0.0567 ps=0.69 w=0.42 l=0.15
X13 VGND a_1059_315# a_1017_47# VNB sky130_fd_pr__nfet_01v8 ad=0.1092 pd=1.36 as=0.066 ps=0.745 w=0.42 l=0.15
X14 a_193_47# a_27_47# VGND VNB sky130_fd_pr__nfet_01v8 ad=0.1092 pd=1.36 as=0.0567 ps=0.69 w=0.42 l=0.15
X15 a_891_413# a_27_47# a_634_159# VPB sky130_fd_pr__pfet_01v8_hvt ad=0.0567 pd=0.69 as=0.1095 ps=1.075 w=0.42 l=0.15
X16 a_592_47# a_193_47# a_466_413# VNB sky130_fd_pr__special_nfet_01v8 ad=0.0696 pd=0.765 as=0.0621 ps=0.705 w=0.36 l=0.15
X17 VPWR a_1059_315# a_975_413# VPB sky130_fd_pr__pfet_01v8_hvt ad=0.1113 pd=1.37 as=0.0882 ps=0.84 w=0.42 l=0.15
X18 a_1017_47# a_27_47# a_891_413# VNB sky130_fd_pr__special_nfet_01v8 ad=0.066 pd=0.745 as=0.0684 ps=0.74 w=0.36 l=0.15
X19 a_193_47# a_27_47# VPWR VPB sky130_fd_pr__pfet_01v8_hvt ad=0.1664 pd=1.8 as=0.0864 ps=0.91 w=0.64 l=0.15
X20 a_466_413# a_27_47# a_381_47# VNB sky130_fd_pr__special_nfet_01v8 ad=0.0621 pd=0.705 as=0.0813 ps=0.83 w=0.36 l=0.15
X21 VGND a_891_413# a_1059_315# VNB sky130_fd_pr__nfet_01v8 ad=0.08775 pd=0.92 as=0.169 ps=1.82 w=0.65 l=0.15
X22 a_381_47# D VGND VNB sky130_fd_pr__nfet_01v8 ad=0.0813 pd=0.83 as=0.1092 ps=1.36 w=0.42 l=0.15
X23 VGND CLK a_27_47# VNB sky130_fd_pr__nfet_01v8 ad=0.0567 pd=0.69 as=0.1092 ps=1.36 w=0.42 l=0.15
.ends

.subckt sky130_fd_sc_hd__dlygate4sd3_1$1 A X VGND VPWR VPB VNB
X0 VPWR A a_49_47# VPB sky130_fd_pr__pfet_01v8_hvt ad=0.0567 pd=0.69 as=0.1092 ps=1.36 w=0.42 l=0.15
X1 VGND a_285_47# a_391_47# VNB sky130_fd_pr__nfet_01v8 ad=0.097 pd=0.975 as=0.1092 ps=1.36 w=0.42 l=0.5
X2 X a_391_47# VPWR VPB sky130_fd_pr__pfet_01v8_hvt ad=0.26 pd=2.52 as=0.14075 ps=1.325 w=1 l=0.15
X3 VGND A a_49_47# VNB sky130_fd_pr__nfet_01v8 ad=0.0567 pd=0.69 as=0.1092 ps=1.36 w=0.42 l=0.15
X4 VPWR a_285_47# a_391_47# VPB sky130_fd_pr__pfet_01v8_hvt ad=0.14075 pd=1.325 as=0.1092 ps=1.36 w=0.42 l=0.5
X5 a_285_47# a_49_47# VGND VNB sky130_fd_pr__nfet_01v8 ad=0.1092 pd=1.36 as=0.0567 ps=0.69 w=0.42 l=0.5
X6 a_285_47# a_49_47# VPWR VPB sky130_fd_pr__pfet_01v8_hvt ad=0.1092 pd=1.36 as=0.0567 ps=0.69 w=0.42 l=0.5
X7 X a_391_47# VGND VNB sky130_fd_pr__nfet_01v8 ad=0.169 pd=1.82 as=0.097 ps=0.975 w=0.65 l=0.15
.ends

.subckt sky130_fd_sc_hd__a2111o_1$1 B1 X D1 A1 A2 C1 VGND VPWR VPB VNB
X0 VGND A2 a_660_47# VNB sky130_fd_pr__nfet_01v8 ad=0.1885 pd=1.88 as=0.082875 ps=0.905 w=0.65 l=0.15
X1 VGND C1 a_85_193# VNB sky130_fd_pr__nfet_01v8 ad=0.117 pd=1.01 as=0.10075 ps=0.96 w=0.65 l=0.15
X2 a_414_297# C1 a_334_297# VPB sky130_fd_pr__pfet_01v8_hvt ad=0.18 pd=1.36 as=0.125 ps=1.25 w=1 l=0.15
X3 VGND a_85_193# X VNB sky130_fd_pr__nfet_01v8 ad=0.274625 pd=1.495 as=0.2145 ps=1.96 w=0.65 l=0.15
X4 a_334_297# D1 a_85_193# VPB sky130_fd_pr__pfet_01v8_hvt ad=0.125 pd=1.25 as=0.385 ps=2.77 w=1 l=0.15
X5 a_516_297# B1 a_414_297# VPB sky130_fd_pr__pfet_01v8_hvt ad=0.28 pd=1.56 as=0.18 ps=1.36 w=1 l=0.15
X6 a_516_297# A2 VPWR VPB sky130_fd_pr__pfet_01v8_hvt ad=0.29 pd=2.58 as=0.135 ps=1.27 w=1 l=0.15
X7 a_660_47# A1 a_85_193# VNB sky130_fd_pr__nfet_01v8 ad=0.082875 pd=0.905 as=0.18525 ps=1.22 w=0.65 l=0.15
X8 a_85_193# D1 VGND VNB sky130_fd_pr__nfet_01v8 ad=0.10075 pd=0.96 as=0.274625 ps=1.495 w=0.65 l=0.15
X9 VPWR A1 a_516_297# VPB sky130_fd_pr__pfet_01v8_hvt ad=0.135 pd=1.27 as=0.28 ps=1.56 w=1 l=0.15
X10 a_85_193# B1 VGND VNB sky130_fd_pr__nfet_01v8 ad=0.18525 pd=1.22 as=0.117 ps=1.01 w=0.65 l=0.15
X11 VPWR a_85_193# X VPB sky130_fd_pr__pfet_01v8_hvt ad=0.265 pd=2.53 as=0.29 ps=2.58 w=1 l=0.15
.ends

.subckt sky130_fd_sc_hd__a22o_1$1 A1 A2 X B2 B1 VPWR VGND VPB VNB
X0 VPWR A2 a_109_297# VPB sky130_fd_pr__pfet_01v8_hvt ad=0.155 pd=1.31 as=0.16 ps=1.32 w=1 l=0.15
X1 a_27_297# B1 a_109_47# VNB sky130_fd_pr__nfet_01v8 ad=0.169 pd=1.82 as=0.07475 ps=0.88 w=0.65 l=0.15
X2 VGND A2 a_373_47# VNB sky130_fd_pr__nfet_01v8 ad=0.10075 pd=0.96 as=0.11375 ps=1 w=0.65 l=0.15
X3 X a_27_297# VPWR VPB sky130_fd_pr__pfet_01v8_hvt ad=0.26 pd=2.52 as=0.155 ps=1.31 w=1 l=0.15
X4 a_27_297# B1 a_109_297# VPB sky130_fd_pr__pfet_01v8_hvt ad=0.25285 pd=2.52 as=0.135 ps=1.27 w=1 l=0.15
X5 a_109_297# A1 VPWR VPB sky130_fd_pr__pfet_01v8_hvt ad=0.16 pd=1.32 as=0.2529 ps=2.52 w=1 l=0.15
X6 a_373_47# A1 a_27_297# VNB sky130_fd_pr__nfet_01v8 ad=0.11375 pd=1 as=0.169 ps=1.82 w=0.65 l=0.15
X7 X a_27_297# VGND VNB sky130_fd_pr__nfet_01v8 ad=0.169 pd=1.82 as=0.10075 ps=0.96 w=0.65 l=0.15
X8 a_109_297# B2 a_27_297# VPB sky130_fd_pr__pfet_01v8_hvt ad=0.135 pd=1.27 as=0.26 ps=2.52 w=1 l=0.15
X9 a_109_47# B2 VGND VNB sky130_fd_pr__nfet_01v8 ad=0.07475 pd=0.88 as=0.169 ps=1.82 w=0.65 l=0.15
.ends

.subckt sky130_fd_sc_hd__and4bb_4$1 C A_N D X B_N VGND VPWR VPB VNB
X0 VPWR a_174_21# X VPB sky130_fd_pr__pfet_01v8_hvt ad=0.175 pd=1.35 as=0.135 ps=1.27 w=1 l=0.15 M=4
X1 a_174_21# a_832_21# a_766_47# VNB sky130_fd_pr__nfet_01v8 ad=0.169 pd=1.82 as=0.10725 ps=0.98 w=0.65 l=0.15
X2 a_832_21# A_N VGND VNB sky130_fd_pr__nfet_01v8 ad=0.1092 pd=1.36 as=0.1764 ps=1.68 w=0.42 l=0.15
X3 a_766_47# a_27_47# a_652_47# VNB sky130_fd_pr__nfet_01v8 ad=0.10725 pd=0.98 as=0.1365 ps=1.07 w=0.65 l=0.15
X4 VPWR B_N a_27_47# VPB sky130_fd_pr__pfet_01v8_hvt ad=0.14075 pd=1.325 as=0.1092 ps=1.36 w=0.42 l=0.15
X5 a_652_47# C a_556_47# VNB sky130_fd_pr__nfet_01v8 ad=0.1365 pd=1.07 as=0.10725 ps=0.98 w=0.65 l=0.15
X6 a_832_21# A_N VPWR VPB sky130_fd_pr__pfet_01v8_hvt ad=0.1092 pd=1.36 as=0.31165 ps=2.125 w=0.42 l=0.15
X7 X a_174_21# VGND VNB sky130_fd_pr__nfet_01v8 ad=0.08775 pd=0.92 as=0.097 ps=0.975 w=0.65 l=0.15 M=4
X8 a_556_47# D VGND VNB sky130_fd_pr__nfet_01v8 ad=0.10725 pd=0.98 as=0.11375 ps=1 w=0.65 l=0.15
X9 a_174_21# D VPWR VPB sky130_fd_pr__pfet_01v8_hvt ad=0.165 pd=1.33 as=0.175 ps=1.35 w=1 l=0.15
X10 VPWR C a_174_21# VPB sky130_fd_pr__pfet_01v8_hvt ad=0.21 pd=1.42 as=0.165 ps=1.33 w=1 l=0.15
X11 VPWR a_832_21# a_174_21# VPB sky130_fd_pr__pfet_01v8_hvt ad=0.31165 pd=2.125 as=0.165 ps=1.33 w=1 l=0.15
X12 a_174_21# a_27_47# VPWR VPB sky130_fd_pr__pfet_01v8_hvt ad=0.165 pd=1.33 as=0.21 ps=1.42 w=1 l=0.15
X13 VGND B_N a_27_47# VNB sky130_fd_pr__nfet_01v8 ad=0.097 pd=0.975 as=0.1092 ps=1.36 w=0.42 l=0.15
.ends

.subckt sky130_fd_sc_hd__buf_2$1 VPWR VGND X A VPB VNB
X0 VPWR a_27_47# X VPB sky130_fd_pr__pfet_01v8_hvt ad=0.265 pd=2.53 as=0.135 ps=1.27 w=1 l=0.15 M=2
X1 VPWR A a_27_47# VPB sky130_fd_pr__pfet_01v8_hvt ad=0.149 pd=1.325 as=0.1664 ps=1.8 w=0.64 l=0.15
X2 X a_27_47# VGND VNB sky130_fd_pr__nfet_01v8 ad=0.08775 pd=0.92 as=0.097 ps=0.975 w=0.65 l=0.15 M=2
X3 VGND A a_27_47# VNB sky130_fd_pr__nfet_01v8 ad=0.097 pd=0.975 as=0.1092 ps=1.36 w=0.42 l=0.15
.ends

.subckt sky130_fd_sc_hd__clkbuf_2$1 A X VGND VPWR VPB VNB
X0 VPWR A a_27_47# VPB sky130_fd_pr__pfet_01v8_hvt ad=0.1625 pd=1.325 as=0.265 ps=2.53 w=1 l=0.15
X1 VPWR a_27_47# X VPB sky130_fd_pr__pfet_01v8_hvt ad=0.26 pd=2.52 as=0.135 ps=1.27 w=1 l=0.15 M=2
X2 VGND A a_27_47# VNB sky130_fd_pr__nfet_01v8 ad=0.06825 pd=0.745 as=0.1113 ps=1.37 w=0.42 l=0.15
X3 X a_27_47# VGND VNB sky130_fd_pr__nfet_01v8 ad=0.0567 pd=0.69 as=0.06825 ps=0.745 w=0.42 l=0.15 M=2
.ends

.subckt sky130_fd_sc_hd__buf_4$1 X VPWR VGND A VPB VNB
X0 VPWR a_27_47# X VPB sky130_fd_pr__pfet_01v8_hvt ad=0.26 pd=2.52 as=0.135 ps=1.27 w=1 l=0.15 M=4
X1 X a_27_47# VGND VNB sky130_fd_pr__nfet_01v8 ad=0.08775 pd=0.92 as=0.08775 ps=0.92 w=0.65 l=0.15 M=4
X2 VPWR A a_27_47# VPB sky130_fd_pr__pfet_01v8_hvt ad=0.135 pd=1.27 as=0.26 ps=2.52 w=1 l=0.15
X3 VGND A a_27_47# VNB sky130_fd_pr__nfet_01v8 ad=0.08775 pd=0.92 as=0.169 ps=1.82 w=0.65 l=0.15
.ends

.subckt sky130_fd_sc_hd__clkbuf_8$1 X A VGND VPWR VPB VNB
X0 VPWR A a_110_47# VPB sky130_fd_pr__pfet_01v8_hvt ad=0.14 pd=1.28 as=0.14 ps=1.28 w=1 l=0.15 M=2
X1 VPWR a_110_47# X VPB sky130_fd_pr__pfet_01v8_hvt ad=0.14 pd=1.28 as=0.14 ps=1.28 w=1 l=0.15 M=8
X2 X a_110_47# VGND VNB sky130_fd_pr__nfet_01v8 ad=0.0588 pd=0.7 as=0.0588 ps=0.7 w=0.42 l=0.15 M=8
X3 VGND A a_110_47# VNB sky130_fd_pr__nfet_01v8 ad=0.0588 pd=0.7 as=0.0588 ps=0.7 w=0.42 l=0.15 M=2
.ends

.subckt sky130_fd_sc_hd__diode_2$1 DIODE VGND VPWR VPB VNB
X0 VNB DIODE sky130_fd_pr__diode_pw2nd_05v5 perim=2.64e+06 area=4.347e+11
.ends

.subckt sky130_fd_sc_hd__buf_12$1 A X VGND VPWR VPB VNB
X0 VGND a_109_47# X VNB sky130_fd_pr__nfet_01v8 ad=0.08775 pd=0.92 as=0.08775 ps=0.92 w=0.65 l=0.15 M=12
X1 X a_109_47# VPWR VPB sky130_fd_pr__pfet_01v8_hvt ad=0.135 pd=1.27 as=0.135 ps=1.27 w=1 l=0.15 M=12
X2 VPWR A a_109_47# VPB sky130_fd_pr__pfet_01v8_hvt ad=0.135 pd=1.27 as=0.135 ps=1.27 w=1 l=0.15 M=4
X3 VGND A a_109_47# VNB sky130_fd_pr__nfet_01v8 ad=0.08775 pd=0.92 as=0.08775 ps=0.92 w=0.65 l=0.15 M=4
.ends

.subckt sky130_fd_sc_hd__dfxtp_4$1 D CLK Q VGND VPWR VPB VNB
X0 Q a_1062_300# VPWR VPB sky130_fd_pr__pfet_01v8_hvt ad=0.135 pd=1.27 as=0.1425 ps=1.285 w=1 l=0.15 M=4
X1 a_1020_47# a_27_47# a_891_413# VNB sky130_fd_pr__special_nfet_01v8 ad=0.066 pd=0.745 as=0.0657 ps=0.725 w=0.36 l=0.15
X2 a_572_47# a_193_47# a_475_413# VNB sky130_fd_pr__special_nfet_01v8 ad=0.0687 pd=0.76 as=0.0594 ps=0.69 w=0.36 l=0.15
X3 VPWR a_1062_300# a_975_413# VPB sky130_fd_pr__pfet_01v8_hvt ad=0.1218 pd=1.42 as=0.09135 ps=0.855 w=0.42 l=0.15
X4 a_634_183# a_475_413# VGND VNB sky130_fd_pr__nfet_01v8 ad=0.0989 pd=0.995 as=0.1493 ps=1.22 w=0.64 l=0.15
X5 VPWR CLK a_27_47# VPB sky130_fd_pr__pfet_01v8_hvt ad=0.0864 pd=0.91 as=0.1664 ps=1.8 w=0.64 l=0.15
X6 a_381_47# D VPWR VPB sky130_fd_pr__pfet_01v8_hvt ad=0.0672 pd=0.74 as=0.1092 ps=1.36 w=0.42 l=0.15
X7 a_475_413# a_27_47# a_381_47# VNB sky130_fd_pr__special_nfet_01v8 ad=0.0594 pd=0.69 as=0.066 ps=0.745 w=0.36 l=0.15
X8 VGND a_1062_300# a_1020_47# VNB sky130_fd_pr__nfet_01v8 ad=0.1197 pd=1.41 as=0.066 ps=0.745 w=0.42 l=0.15
X9 VPWR a_634_183# a_568_413# VPB sky130_fd_pr__pfet_01v8_hvt ad=0.178875 pd=1.26 as=0.0693 ps=0.75 w=0.42 l=0.15
X10 Q a_1062_300# VGND VNB sky130_fd_pr__nfet_01v8 ad=0.08775 pd=0.92 as=0.092625 ps=0.935 w=0.65 l=0.15 M=4
X11 a_568_413# a_27_47# a_475_413# VPB sky130_fd_pr__pfet_01v8_hvt ad=0.0693 pd=0.75 as=0.06615 ps=0.735 w=0.42 l=0.15
X12 a_634_183# a_475_413# VPWR VPB sky130_fd_pr__pfet_01v8_hvt ad=0.1095 pd=1.075 as=0.178875 ps=1.26 w=0.75 l=0.15
X13 a_975_413# a_193_47# a_891_413# VPB sky130_fd_pr__pfet_01v8_hvt ad=0.09135 pd=0.855 as=0.0567 ps=0.69 w=0.42 l=0.15
X14 a_193_47# a_27_47# VGND VNB sky130_fd_pr__nfet_01v8 ad=0.1092 pd=1.36 as=0.0567 ps=0.69 w=0.42 l=0.15
X15 a_891_413# a_27_47# a_634_183# VPB sky130_fd_pr__pfet_01v8_hvt ad=0.0567 pd=0.69 as=0.1095 ps=1.075 w=0.42 l=0.15
X16 VGND a_891_413# a_1062_300# VNB sky130_fd_pr__nfet_01v8 ad=0.105625 pd=0.975 as=0.169 ps=1.82 w=0.65 l=0.15
X17 a_193_47# a_27_47# VPWR VPB sky130_fd_pr__pfet_01v8_hvt ad=0.1664 pd=1.8 as=0.0864 ps=0.91 w=0.64 l=0.15
X18 a_381_47# D VGND VNB sky130_fd_pr__nfet_01v8 ad=0.066 pd=0.745 as=0.1092 ps=1.36 w=0.42 l=0.15
X19 VPWR a_891_413# a_1062_300# VPB sky130_fd_pr__pfet_01v8_hvt ad=0.1625 pd=1.325 as=0.28 ps=2.56 w=1 l=0.15
X20 a_475_413# a_193_47# a_381_47# VPB sky130_fd_pr__pfet_01v8_hvt ad=0.06615 pd=0.735 as=0.0672 ps=0.74 w=0.42 l=0.15
X21 a_891_413# a_193_47# a_634_183# VNB sky130_fd_pr__special_nfet_01v8 ad=0.0657 pd=0.725 as=0.0989 ps=0.995 w=0.36 l=0.15
X22 VGND a_634_183# a_572_47# VNB sky130_fd_pr__nfet_01v8 ad=0.1493 pd=1.22 as=0.0687 ps=0.76 w=0.42 l=0.15
X23 VGND CLK a_27_47# VNB sky130_fd_pr__nfet_01v8 ad=0.0567 pd=0.69 as=0.1092 ps=1.36 w=0.42 l=0.15
.ends

.subckt sky130_fd_sc_hd__o221a_1$1 A2 X B1 C1 A1 B2 VGND VPWR VPB VNB
X0 a_240_47# A2 VGND VNB sky130_fd_pr__nfet_01v8 ad=0.08775 pd=0.92 as=0.169 ps=1.82 w=0.65 l=0.15
X1 X a_51_297# VGND VNB sky130_fd_pr__nfet_01v8 ad=0.182 pd=1.86 as=0.08775 ps=0.92 w=0.65 l=0.15
X2 VGND A1 a_240_47# VNB sky130_fd_pr__nfet_01v8 ad=0.08775 pd=0.92 as=0.08775 ps=0.92 w=0.65 l=0.15
X3 a_51_297# B2 a_245_297# VPB sky130_fd_pr__pfet_01v8_hvt ad=0.4125 pd=1.825 as=0.105 ps=1.21 w=1 l=0.15
X4 a_149_47# C1 a_51_297# VNB sky130_fd_pr__nfet_01v8 ad=0.099125 pd=0.955 as=0.2015 ps=1.92 w=0.65 l=0.15
X5 a_240_47# B1 a_149_47# VNB sky130_fd_pr__nfet_01v8 ad=0.08775 pd=0.92 as=0.099125 ps=0.955 w=0.65 l=0.15
X6 VPWR A1 a_512_297# VPB sky130_fd_pr__pfet_01v8_hvt ad=0.165 pd=1.33 as=0.105 ps=1.21 w=1 l=0.15
X7 X a_51_297# VPWR VPB sky130_fd_pr__pfet_01v8_hvt ad=0.28 pd=2.56 as=0.165 ps=1.33 w=1 l=0.15
X8 a_149_47# B2 a_240_47# VNB sky130_fd_pr__nfet_01v8 ad=0.169 pd=1.82 as=0.08775 ps=0.92 w=0.65 l=0.15
X9 a_245_297# B1 VPWR VPB sky130_fd_pr__pfet_01v8_hvt ad=0.105 pd=1.21 as=0.165 ps=1.33 w=1 l=0.15
X10 VPWR C1 a_51_297# VPB sky130_fd_pr__pfet_01v8_hvt ad=0.165 pd=1.33 as=0.34 ps=2.68 w=1 l=0.15
X11 a_512_297# A2 a_51_297# VPB sky130_fd_pr__pfet_01v8_hvt ad=0.105 pd=1.21 as=0.4125 ps=1.825 w=1 l=0.15
.ends

.subckt sky130_fd_sc_hd__a221o_1$1 X B1 A1 B2 A2 VGND VPWR C1 VPB VNB
X0 a_465_47# A1 a_27_47# VNB sky130_fd_pr__nfet_01v8 ad=0.10725 pd=0.98 as=0.169 ps=1.82 w=0.65 l=0.15
X1 X a_27_47# VPWR VPB sky130_fd_pr__pfet_01v8_hvt ad=0.26 pd=2.52 as=0.1575 ps=1.315 w=1 l=0.15
X2 a_109_297# B1 a_193_297# VPB sky130_fd_pr__pfet_01v8_hvt ad=0.26 pd=2.52 as=0.135 ps=1.27 w=1 l=0.15
X3 a_193_297# B2 a_109_297# VPB sky130_fd_pr__pfet_01v8_hvt ad=0.135 pd=1.27 as=0.135 ps=1.27 w=1 l=0.15
X4 X a_27_47# VGND VNB sky130_fd_pr__nfet_01v8 ad=0.169 pd=1.82 as=0.102375 ps=0.965 w=0.65 l=0.15
X5 a_205_47# B2 VGND VNB sky130_fd_pr__nfet_01v8 ad=0.06825 pd=0.86 as=0.10725 ps=0.98 w=0.65 l=0.15
X6 VPWR A2 a_193_297# VPB sky130_fd_pr__pfet_01v8_hvt ad=0.1575 pd=1.315 as=0.165 ps=1.33 w=1 l=0.15
X7 a_193_297# A1 VPWR VPB sky130_fd_pr__pfet_01v8_hvt ad=0.165 pd=1.33 as=0.26 ps=2.52 w=1 l=0.15
X8 a_27_47# B1 a_205_47# VNB sky130_fd_pr__nfet_01v8 ad=0.169 pd=1.82 as=0.06825 ps=0.86 w=0.65 l=0.15
X9 a_109_297# C1 a_27_47# VPB sky130_fd_pr__pfet_01v8_hvt ad=0.135 pd=1.27 as=0.26 ps=2.52 w=1 l=0.15
X10 VGND C1 a_27_47# VNB sky130_fd_pr__nfet_01v8 ad=0.10725 pd=0.98 as=0.169 ps=1.82 w=0.65 l=0.15
X11 VGND A2 a_465_47# VNB sky130_fd_pr__nfet_01v8 ad=0.102375 pd=0.965 as=0.10725 ps=0.98 w=0.65 l=0.15
.ends

.subckt sky130_fd_sc_hd__nand2_8$1 A B Y VGND VPWR VPB VNB
X0 a_27_47# B VGND VNB sky130_fd_pr__nfet_01v8 ad=0.08775 pd=0.92 as=0.08775 ps=0.92 w=0.65 l=0.15 M=8
X1 Y A VPWR VPB sky130_fd_pr__pfet_01v8_hvt ad=0.135 pd=1.27 as=0.135 ps=1.27 w=1 l=0.15 M=8
X2 a_27_47# A Y VNB sky130_fd_pr__nfet_01v8 ad=0.08775 pd=0.92 as=0.08775 ps=0.92 w=0.65 l=0.15 M=8
X3 Y B VPWR VPB sky130_fd_pr__pfet_01v8_hvt ad=0.135 pd=1.27 as=0.135 ps=1.27 w=1 l=0.15 M=8
.ends

.subckt sky130_fd_sc_hd__buf_1$1 VPWR VGND X A VPB VNB
X0 VPWR A a_27_47# VPB sky130_fd_pr__pfet_01v8_hvt ad=0.11455 pd=1.08 as=0.2054 ps=2.1 w=0.79 l=0.15
X1 X a_27_47# VGND VNB sky130_fd_pr__nfet_01v8 ad=0.1352 pd=1.56 as=0.0754 ps=0.81 w=0.52 l=0.15
X2 X a_27_47# VPWR VPB sky130_fd_pr__pfet_01v8_hvt ad=0.2054 pd=2.1 as=0.11455 ps=1.08 w=0.79 l=0.15
X3 VGND A a_27_47# VNB sky130_fd_pr__nfet_01v8 ad=0.0754 pd=0.81 as=0.1352 ps=1.56 w=0.52 l=0.15
.ends

.subckt sky130_fd_sc_hd__or3_1$1 A X B C VPWR VGND VPB VNB
X0 X a_29_53# VPWR VPB sky130_fd_pr__pfet_01v8_hvt ad=0.28 pd=2.56 as=0.14825 ps=1.34 w=1 l=0.15
X1 a_111_297# C a_29_53# VPB sky130_fd_pr__pfet_01v8_hvt ad=0.0441 pd=0.63 as=0.1092 ps=1.36 w=0.42 l=0.15
X2 X a_29_53# VGND VNB sky130_fd_pr__nfet_01v8 ad=0.182 pd=1.86 as=0.101875 ps=0.99 w=0.65 l=0.15
X3 a_183_297# B a_111_297# VPB sky130_fd_pr__pfet_01v8_hvt ad=0.0693 pd=0.75 as=0.0441 ps=0.63 w=0.42 l=0.15
X4 VPWR A a_183_297# VPB sky130_fd_pr__pfet_01v8_hvt ad=0.14825 pd=1.34 as=0.0693 ps=0.75 w=0.42 l=0.15
X5 a_29_53# B VGND VNB sky130_fd_pr__nfet_01v8 ad=0.0567 pd=0.69 as=0.0567 ps=0.69 w=0.42 l=0.15
X6 VGND C a_29_53# VNB sky130_fd_pr__nfet_01v8 ad=0.0567 pd=0.69 as=0.1092 ps=1.36 w=0.42 l=0.15
X7 VGND A a_29_53# VNB sky130_fd_pr__nfet_01v8 ad=0.101875 pd=0.99 as=0.0567 ps=0.69 w=0.42 l=0.15
.ends

.subckt sky130_fd_sc_hd__or4_2$1 C A X B D VPWR VGND VPB VNB
X0 a_27_297# B VGND VNB sky130_fd_pr__nfet_01v8 ad=0.0567 pd=0.69 as=0.0567 ps=0.69 w=0.42 l=0.15
X1 a_27_297# D VGND VNB sky130_fd_pr__nfet_01v8 ad=0.0693 pd=0.75 as=0.1092 ps=1.36 w=0.42 l=0.15
X2 a_277_297# B a_205_297# VPB sky130_fd_pr__pfet_01v8_hvt ad=0.0693 pd=0.75 as=0.0441 ps=0.63 w=0.42 l=0.15
X3 VPWR A a_277_297# VPB sky130_fd_pr__pfet_01v8_hvt ad=0.14825 pd=1.34 as=0.0693 ps=0.75 w=0.42 l=0.15
X4 X a_27_297# VGND VNB sky130_fd_pr__nfet_01v8 ad=0.08775 pd=0.92 as=0.101875 ps=0.99 w=0.65 l=0.15 M=2
X5 a_205_297# C a_109_297# VPB sky130_fd_pr__pfet_01v8_hvt ad=0.0441 pd=0.63 as=0.0693 ps=0.75 w=0.42 l=0.15
X6 VPWR a_27_297# X VPB sky130_fd_pr__pfet_01v8_hvt ad=0.305 pd=2.61 as=0.135 ps=1.27 w=1 l=0.15 M=2
X7 VGND C a_27_297# VNB sky130_fd_pr__nfet_01v8 ad=0.0567 pd=0.69 as=0.0693 ps=0.75 w=0.42 l=0.15
X8 a_109_297# D a_27_297# VPB sky130_fd_pr__pfet_01v8_hvt ad=0.0693 pd=0.75 as=0.1092 ps=1.36 w=0.42 l=0.15
X9 VGND A a_27_297# VNB sky130_fd_pr__nfet_01v8 ad=0.101875 pd=0.99 as=0.0567 ps=0.69 w=0.42 l=0.15
.ends

.subckt sky130_fd_sc_hd__nand2_2$1 Y A B VGND VPWR VPB VNB
X0 VPWR A Y VPB sky130_fd_pr__pfet_01v8_hvt ad=0.26 pd=2.52 as=0.135 ps=1.27 w=1 l=0.15 M=2
X1 VPWR B Y VPB sky130_fd_pr__pfet_01v8_hvt ad=0.135 pd=1.27 as=0.135 ps=1.27 w=1 l=0.15 M=2
X2 a_27_47# B VGND VNB sky130_fd_pr__nfet_01v8 ad=0.08775 pd=0.92 as=0.08775 ps=0.92 w=0.65 l=0.15 M=2
X3 a_27_47# A Y VNB sky130_fd_pr__nfet_01v8 ad=0.169 pd=1.82 as=0.08775 ps=0.92 w=0.65 l=0.15 M=2
.ends

.subckt sky130_fd_sc_hd__or4bb_4$1 D_N B A C_N X VGND VPWR VPB VNB
X0 VPWR a_315_380# X VPB sky130_fd_pr__pfet_01v8_hvt ad=0.135 pd=1.27 as=0.135 ps=1.27 w=1 l=0.15 M=4
X1 a_315_380# B VGND VNB sky130_fd_pr__nfet_01v8 ad=0.08775 pd=0.92 as=0.08775 ps=0.92 w=0.65 l=0.15
X2 VGND C_N a_27_410# VNB sky130_fd_pr__nfet_01v8 ad=0.06195 pd=0.715 as=0.1092 ps=1.36 w=0.42 l=0.15
X3 VPWR C_N a_27_410# VPB sky130_fd_pr__pfet_01v8_hvt ad=0.1226 pd=1.32 as=0.1092 ps=1.36 w=0.42 l=0.15
X4 VPWR A a_583_297# VPB sky130_fd_pr__pfet_01v8_hvt ad=0.19 pd=1.38 as=0.135 ps=1.27 w=1 l=0.15
X5 VGND a_27_410# a_315_380# VNB sky130_fd_pr__nfet_01v8 ad=0.08775 pd=0.92 as=0.1235 ps=1.03 w=0.65 l=0.15
X6 a_583_297# B a_499_297# VPB sky130_fd_pr__pfet_01v8_hvt ad=0.135 pd=1.27 as=0.135 ps=1.27 w=1 l=0.15
X7 VGND A a_315_380# VNB sky130_fd_pr__nfet_01v8 ad=0.1235 pd=1.03 as=0.08775 ps=0.92 w=0.65 l=0.15
X8 a_397_297# a_205_93# a_315_380# VPB sky130_fd_pr__pfet_01v8_hvt ad=0.18 pd=1.36 as=0.257925 ps=2.52 w=1 l=0.15
X9 X a_315_380# VGND VNB sky130_fd_pr__nfet_01v8 ad=0.08775 pd=0.92 as=0.1235 ps=1.03 w=0.65 l=0.15 M=4
X10 a_499_297# a_27_410# a_397_297# VPB sky130_fd_pr__pfet_01v8_hvt ad=0.135 pd=1.27 as=0.18 ps=1.36 w=1 l=0.15
X11 a_205_93# D_N VGND VNB sky130_fd_pr__nfet_01v8 ad=0.1092 pd=1.36 as=0.06195 ps=0.715 w=0.42 l=0.15
X12 a_205_93# D_N VPWR VPB sky130_fd_pr__pfet_01v8_hvt ad=0.11295 pd=1.4 as=0.1226 ps=1.32 w=0.42 l=0.15
X13 a_315_380# a_205_93# VGND VNB sky130_fd_pr__nfet_01v8 ad=0.1235 pd=1.03 as=0.169 ps=1.82 w=0.65 l=0.15
.ends

.subckt sky130_fd_sc_hd__and2_1$1 X B A VPWR VGND VPB VNB
X0 VPWR B a_59_75# VPB sky130_fd_pr__pfet_01v8_hvt ad=0.16655 pd=1.39 as=0.0567 ps=0.69 w=0.42 l=0.15
X1 X a_59_75# VPWR VPB sky130_fd_pr__pfet_01v8_hvt ad=0.475 pd=2.95 as=0.16655 ps=1.39 w=1 l=0.15
X2 VGND B a_145_75# VNB sky130_fd_pr__nfet_01v8 ad=0.1118 pd=1.04 as=0.0567 ps=0.69 w=0.42 l=0.15
X3 a_59_75# A VPWR VPB sky130_fd_pr__pfet_01v8_hvt ad=0.0567 pd=0.69 as=0.1176 ps=1.4 w=0.42 l=0.15
X4 X a_59_75# VGND VNB sky130_fd_pr__nfet_01v8 ad=0.182 pd=1.86 as=0.1118 ps=1.04 w=0.65 l=0.15
X5 a_145_75# A a_59_75# VNB sky130_fd_pr__nfet_01v8 ad=0.0567 pd=0.69 as=0.1176 ps=1.4 w=0.42 l=0.15
.ends

.subckt sky130_fd_sc_hd__and4b_4$1 X D C B A_N VGND VPWR VPB VNB
X0 VPWR a_174_21# X VPB sky130_fd_pr__pfet_01v8_hvt ad=0.3275 pd=1.655 as=0.135 ps=1.27 w=1 l=0.15 M=4
X1 a_815_47# B a_701_47# VNB sky130_fd_pr__nfet_01v8 ad=0.143 pd=1.09 as=0.1365 ps=1.07 w=0.65 l=0.15
X2 VPWR C a_174_21# VPB sky130_fd_pr__pfet_01v8_hvt ad=0.21 pd=1.42 as=0.135 ps=1.27 w=1 l=0.15
X3 a_174_21# a_27_47# a_815_47# VNB sky130_fd_pr__nfet_01v8 ad=0.169 pd=1.82 as=0.143 ps=1.09 w=0.65 l=0.15
X4 VPWR A_N a_27_47# VPB sky130_fd_pr__pfet_01v8_hvt ad=0.14075 pd=1.325 as=0.1092 ps=1.36 w=0.42 l=0.15
X5 a_701_47# C a_617_47# VNB sky130_fd_pr__nfet_01v8 ad=0.1365 pd=1.07 as=0.08775 ps=0.92 w=0.65 l=0.15
X6 a_174_21# D VPWR VPB sky130_fd_pr__pfet_01v8_hvt ad=0.135 pd=1.27 as=0.3275 ps=1.655 w=1 l=0.15
X7 a_174_21# B VPWR VPB sky130_fd_pr__pfet_01v8_hvt ad=0.22 pd=1.44 as=0.21 ps=1.42 w=1 l=0.15
X8 VPWR a_27_47# a_174_21# VPB sky130_fd_pr__pfet_01v8_hvt ad=0.26 pd=2.52 as=0.22 ps=1.44 w=1 l=0.15
X9 X a_174_21# VGND VNB sky130_fd_pr__nfet_01v8 ad=0.08775 pd=0.92 as=0.097 ps=0.975 w=0.65 l=0.15 M=4
X10 a_617_47# D VGND VNB sky130_fd_pr__nfet_01v8 ad=0.08775 pd=0.92 as=0.212875 ps=1.305 w=0.65 l=0.15
X11 VGND A_N a_27_47# VNB sky130_fd_pr__nfet_01v8 ad=0.097 pd=0.975 as=0.1092 ps=1.36 w=0.42 l=0.15
.ends

.subckt sky130_fd_sc_hd__inv_8$1 A Y VGND VPWR VPB VNB
X0 VPWR A Y VPB sky130_fd_pr__pfet_01v8_hvt ad=0.135 pd=1.27 as=0.135 ps=1.27 w=1 l=0.15 M=8
X1 Y A VGND VNB sky130_fd_pr__nfet_01v8 ad=0.08775 pd=0.92 as=0.08775 ps=0.92 w=0.65 l=0.15 M=8
.ends

.subckt sky130_fd_sc_hd__clkinv_2$1 Y A VPWR VGND VPB VNB
X0 Y A VGND VNB sky130_fd_pr__nfet_01v8 ad=0.0588 pd=0.7 as=0.1113 ps=1.37 w=0.42 l=0.15 M=2
X1 Y A VPWR VPB sky130_fd_pr__pfet_01v8_hvt ad=0.14 pd=1.28 as=0.14 ps=1.28 w=1 l=0.15 M=3
.ends

.subckt sky130_fd_sc_hd__a21o_1$1 A2 A1 B1 X VPWR VGND VPB VNB
X0 a_81_21# B1 VGND VNB sky130_fd_pr__nfet_01v8 ad=0.089375 pd=0.925 as=0.25675 ps=1.44 w=0.65 l=0.15
X1 a_299_297# B1 a_81_21# VPB sky130_fd_pr__pfet_01v8_hvt ad=0.1375 pd=1.275 as=0.26 ps=2.52 w=1 l=0.15
X2 VPWR a_81_21# X VPB sky130_fd_pr__pfet_01v8_hvt ad=0.26 pd=2.52 as=0.26 ps=2.52 w=1 l=0.15
X3 VPWR A1 a_299_297# VPB sky130_fd_pr__pfet_01v8_hvt ad=0.14 pd=1.28 as=0.1375 ps=1.275 w=1 l=0.15
X4 VGND a_81_21# X VNB sky130_fd_pr__nfet_01v8 ad=0.25675 pd=1.44 as=0.169 ps=1.82 w=0.65 l=0.15
X5 VGND A2 a_384_47# VNB sky130_fd_pr__nfet_01v8 ad=0.17225 pd=1.83 as=0.091 ps=0.93 w=0.65 l=0.15
X6 a_299_297# A2 VPWR VPB sky130_fd_pr__pfet_01v8_hvt ad=0.265 pd=2.53 as=0.14 ps=1.28 w=1 l=0.15
X7 a_384_47# A1 a_81_21# VNB sky130_fd_pr__nfet_01v8 ad=0.091 pd=0.93 as=0.089375 ps=0.925 w=0.65 l=0.15
.ends

.subckt sky130_fd_sc_hd__clkinvlp_4$1 A Y VPWR VGND VPB VNB
X0 Y A VPWR VPB sky130_fd_pr__pfet_01v8_hvt ad=0.14 pd=1.28 as=0.265 ps=2.53 w=1 l=0.25 M=4
X1 VGND A a_268_47# VNB sky130_fd_pr__nfet_01v8 ad=0.14575 pd=1.63 as=0.05775 ps=0.76 w=0.55 l=0.15
X2 Y A a_110_47# VNB sky130_fd_pr__nfet_01v8 ad=0.077 pd=0.83 as=0.05775 ps=0.76 w=0.55 l=0.15
X3 a_110_47# A VGND VNB sky130_fd_pr__nfet_01v8 ad=0.05775 pd=0.76 as=0.14575 ps=1.63 w=0.55 l=0.15
X4 a_268_47# A Y VNB sky130_fd_pr__nfet_01v8 ad=0.05775 pd=0.76 as=0.077 ps=0.83 w=0.55 l=0.15
.ends

.subckt sky130_fd_sc_hd__clkbuf_4$1 X A VGND VPWR VPB VNB
X0 VPWR A a_27_47# VPB sky130_fd_pr__pfet_01v8_hvt ad=0.165 pd=1.33 as=0.265 ps=2.53 w=1 l=0.15
X1 VGND a_27_47# X VNB sky130_fd_pr__nfet_01v8 ad=0.1218 pd=1.42 as=0.0588 ps=0.7 w=0.42 l=0.15 M=4
X2 X a_27_47# VPWR VPB sky130_fd_pr__pfet_01v8_hvt ad=0.14 pd=1.28 as=0.14 ps=1.28 w=1 l=0.15 M=4
X3 VGND A a_27_47# VNB sky130_fd_pr__nfet_01v8 ad=0.07035 pd=0.755 as=0.1113 ps=1.37 w=0.42 l=0.15
.ends

.subckt sky130_fd_sc_hd__buf_6$1 X VPWR VGND A VPB VNB
X0 VPWR a_161_47# X VPB sky130_fd_pr__pfet_01v8_hvt ad=0.26 pd=2.52 as=0.135 ps=1.27 w=1 l=0.15 M=6
X1 a_161_47# A VGND VNB sky130_fd_pr__nfet_01v8 ad=0.08775 pd=0.92 as=0.169 ps=1.82 w=0.65 l=0.15 M=2
X2 VGND a_161_47# X VNB sky130_fd_pr__nfet_01v8 ad=0.08775 pd=0.92 as=0.08775 ps=0.92 w=0.65 l=0.15 M=6
X3 VPWR A a_161_47# VPB sky130_fd_pr__pfet_01v8_hvt ad=0.135 pd=1.27 as=0.135 ps=1.27 w=1 l=0.15 M=2
.ends

.subckt sky130_fd_sc_hd__dfxtp_2$1 Q CLK D VPWR VGND VPB VNB
X0 Q a_1059_315# VGND VNB sky130_fd_pr__nfet_01v8 ad=0.08775 pd=0.92 as=0.08775 ps=0.92 w=0.65 l=0.15 M=2
X1 VPWR a_1059_315# Q VPB sky130_fd_pr__pfet_01v8_hvt ad=0.26 pd=2.52 as=0.135 ps=1.27 w=1 l=0.15 M=2
X2 a_891_413# a_193_47# a_634_159# VNB sky130_fd_pr__special_nfet_01v8 ad=0.0684 pd=0.74 as=0.0989 ps=0.995 w=0.36 l=0.15
X3 a_561_413# a_27_47# a_466_413# VPB sky130_fd_pr__pfet_01v8_hvt ad=0.07665 pd=0.785 as=0.06825 ps=0.745 w=0.42 l=0.15
X4 VPWR CLK a_27_47# VPB sky130_fd_pr__pfet_01v8_hvt ad=0.0864 pd=0.91 as=0.1664 ps=1.8 w=0.64 l=0.15
X5 a_381_47# D VPWR VPB sky130_fd_pr__pfet_01v8_hvt ad=0.05775 pd=0.695 as=0.1092 ps=1.36 w=0.42 l=0.15
X6 VGND a_634_159# a_592_47# VNB sky130_fd_pr__nfet_01v8 ad=0.12095 pd=1.085 as=0.0696 ps=0.765 w=0.42 l=0.15
X7 VPWR a_891_413# a_1059_315# VPB sky130_fd_pr__pfet_01v8_hvt ad=0.135 pd=1.27 as=0.27 ps=2.54 w=1 l=0.15
X8 a_466_413# a_193_47# a_381_47# VPB sky130_fd_pr__pfet_01v8_hvt ad=0.06825 pd=0.745 as=0.05775 ps=0.695 w=0.42 l=0.15
X9 VPWR a_634_159# a_561_413# VPB sky130_fd_pr__pfet_01v8_hvt ad=0.178875 pd=1.26 as=0.07665 ps=0.785 w=0.42 l=0.15
X10 a_634_159# a_466_413# VGND VNB sky130_fd_pr__nfet_01v8 ad=0.0989 pd=0.995 as=0.12095 ps=1.085 w=0.64 l=0.15
X11 a_634_159# a_466_413# VPWR VPB sky130_fd_pr__pfet_01v8_hvt ad=0.1095 pd=1.075 as=0.178875 ps=1.26 w=0.75 l=0.15
X12 a_975_413# a_193_47# a_891_413# VPB sky130_fd_pr__pfet_01v8_hvt ad=0.0882 pd=0.84 as=0.0567 ps=0.69 w=0.42 l=0.15
X13 VGND a_1059_315# a_1017_47# VNB sky130_fd_pr__nfet_01v8 ad=0.1092 pd=1.36 as=0.066 ps=0.745 w=0.42 l=0.15
X14 a_193_47# a_27_47# VGND VNB sky130_fd_pr__nfet_01v8 ad=0.1092 pd=1.36 as=0.0567 ps=0.69 w=0.42 l=0.15
X15 a_891_413# a_27_47# a_634_159# VPB sky130_fd_pr__pfet_01v8_hvt ad=0.0567 pd=0.69 as=0.1095 ps=1.075 w=0.42 l=0.15
X16 a_592_47# a_193_47# a_466_413# VNB sky130_fd_pr__special_nfet_01v8 ad=0.0696 pd=0.765 as=0.0621 ps=0.705 w=0.36 l=0.15
X17 VPWR a_1059_315# a_975_413# VPB sky130_fd_pr__pfet_01v8_hvt ad=0.1113 pd=1.37 as=0.0882 ps=0.84 w=0.42 l=0.15
X18 a_1017_47# a_27_47# a_891_413# VNB sky130_fd_pr__special_nfet_01v8 ad=0.066 pd=0.745 as=0.0684 ps=0.74 w=0.36 l=0.15
X19 a_193_47# a_27_47# VPWR VPB sky130_fd_pr__pfet_01v8_hvt ad=0.1664 pd=1.8 as=0.0864 ps=0.91 w=0.64 l=0.15
X20 a_466_413# a_27_47# a_381_47# VNB sky130_fd_pr__special_nfet_01v8 ad=0.0621 pd=0.705 as=0.0813 ps=0.83 w=0.36 l=0.15
X21 VGND a_891_413# a_1059_315# VNB sky130_fd_pr__nfet_01v8 ad=0.08775 pd=0.92 as=0.169 ps=1.82 w=0.65 l=0.15
X22 a_381_47# D VGND VNB sky130_fd_pr__nfet_01v8 ad=0.0813 pd=0.83 as=0.1092 ps=1.36 w=0.42 l=0.15
X23 VGND CLK a_27_47# VNB sky130_fd_pr__nfet_01v8 ad=0.0567 pd=0.69 as=0.1092 ps=1.36 w=0.42 l=0.15
.ends

.subckt sky130_fd_sc_hd__and2_2$1 A X B VPWR VGND VPB VNB
X0 X a_61_75# VPWR VPB sky130_fd_pr__pfet_01v8_hvt ad=0.195 pd=1.39 as=0.16655 ps=1.39 w=1 l=0.15 M=2
X1 VPWR B a_61_75# VPB sky130_fd_pr__pfet_01v8_hvt ad=0.16655 pd=1.39 as=0.0567 ps=0.69 w=0.42 l=0.15
X2 VGND B a_147_75# VNB sky130_fd_pr__nfet_01v8 ad=0.1118 pd=1.04 as=0.0567 ps=0.69 w=0.42 l=0.15
X3 X a_61_75# VGND VNB sky130_fd_pr__nfet_01v8 ad=0.12675 pd=1.04 as=0.1118 ps=1.04 w=0.65 l=0.15 M=2
X4 a_61_75# A VPWR VPB sky130_fd_pr__pfet_01v8_hvt ad=0.0567 pd=0.69 as=0.1176 ps=1.4 w=0.42 l=0.15
X5 a_147_75# A a_61_75# VNB sky130_fd_pr__nfet_01v8 ad=0.0567 pd=0.69 as=0.1176 ps=1.4 w=0.42 l=0.15
.ends

.subckt sky130_fd_sc_hd__bufinv_16$1 A Y VGND VPWR VPB VNB
X0 a_361_47# a_27_47# VGND VNB sky130_fd_pr__nfet_01v8 ad=0.08775 pd=0.92 as=0.08775 ps=0.92 w=0.65 l=0.15 M=6
X1 VPWR a_361_47# Y VPB sky130_fd_pr__pfet_01v8_hvt ad=0.135 pd=1.27 as=0.135 ps=1.27 w=1 l=0.15 M=16
X2 Y a_361_47# VGND VNB sky130_fd_pr__nfet_01v8 ad=0.08775 pd=0.92 as=0.08775 ps=0.92 w=0.65 l=0.15 M=16
X3 VPWR a_27_47# a_361_47# VPB sky130_fd_pr__pfet_01v8_hvt ad=0.135 pd=1.27 as=0.135 ps=1.27 w=1 l=0.15 M=6
X4 VPWR A a_27_47# VPB sky130_fd_pr__pfet_01v8_hvt ad=0.135 pd=1.27 as=0.135 ps=1.27 w=1 l=0.15 M=3
X5 a_27_47# A VGND VNB sky130_fd_pr__nfet_01v8 ad=0.08775 pd=0.92 as=0.08775 ps=0.92 w=0.65 l=0.15 M=3
.ends

.subckt sky130_fd_sc_hd__clkinv_4$1 A Y VPWR VGND VPB VNB
X0 Y A VPWR VPB sky130_fd_pr__pfet_01v8_hvt ad=0.14 pd=1.28 as=0.14 ps=1.28 w=1 l=0.15 M=6
X1 VGND A Y VNB sky130_fd_pr__nfet_01v8 ad=0.1659 pd=1.63 as=0.0588 ps=0.7 w=0.42 l=0.15 M=4
.ends

.subckt sky130_fd_sc_hd__buf_8$1 A X VGND VPWR VPB VNB
X0 X a_27_47# VGND VNB sky130_fd_pr__nfet_01v8 ad=0.08775 pd=0.92 as=0.08775 ps=0.92 w=0.65 l=0.15 M=8
X1 VPWR a_27_47# X VPB sky130_fd_pr__pfet_01v8_hvt ad=0.135 pd=1.27 as=0.135 ps=1.27 w=1 l=0.15 M=8
X2 VPWR A a_27_47# VPB sky130_fd_pr__pfet_01v8_hvt ad=0.135 pd=1.27 as=0.135 ps=1.27 w=1 l=0.15 M=3
X3 a_27_47# A VGND VNB sky130_fd_pr__nfet_01v8 ad=0.08775 pd=0.92 as=0.08775 ps=0.92 w=0.65 l=0.15 M=3
.ends

.subckt sky130_fd_sc_hd__o31a_1$1 X A2 B1 A1 A3 VGND VPWR VPB VNB
X0 a_103_199# B1 a_253_47# VNB sky130_fd_pr__nfet_01v8 ad=0.2015 pd=1.92 as=0.10725 ps=0.98 w=0.65 l=0.15
X1 VPWR a_103_199# X VPB sky130_fd_pr__pfet_01v8_hvt ad=0.195 pd=1.39 as=0.36 ps=2.72 w=1 l=0.15
X2 a_337_297# A2 a_253_297# VPB sky130_fd_pr__pfet_01v8_hvt ad=0.165 pd=1.33 as=0.135 ps=1.27 w=1 l=0.15
X3 a_103_199# A3 a_337_297# VPB sky130_fd_pr__pfet_01v8_hvt ad=0.2125 pd=1.425 as=0.165 ps=1.33 w=1 l=0.15
X4 a_253_297# A1 VPWR VPB sky130_fd_pr__pfet_01v8_hvt ad=0.135 pd=1.27 as=0.195 ps=1.39 w=1 l=0.15
X5 VPWR B1 a_103_199# VPB sky130_fd_pr__pfet_01v8_hvt ad=0.345 pd=2.69 as=0.2125 ps=1.425 w=1 l=0.15
X6 VGND a_103_199# X VNB sky130_fd_pr__nfet_01v8 ad=0.12675 pd=1.04 as=0.234 ps=2.02 w=0.65 l=0.15
X7 a_253_47# A1 VGND VNB sky130_fd_pr__nfet_01v8 ad=0.08775 pd=0.92 as=0.12675 ps=1.04 w=0.65 l=0.15
X8 a_253_47# A3 VGND VNB sky130_fd_pr__nfet_01v8 ad=0.10725 pd=0.98 as=0.10725 ps=0.98 w=0.65 l=0.15
X9 VGND A2 a_253_47# VNB sky130_fd_pr__nfet_01v8 ad=0.10725 pd=0.98 as=0.08775 ps=0.92 w=0.65 l=0.15
.ends

.subckt sky130_fd_sc_hd__o21a_1$1 X A1 B1 A2 VGND VPWR VPB VNB
X0 VPWR A1 a_382_297# VPB sky130_fd_pr__pfet_01v8_hvt ad=0.26 pd=2.52 as=0.1525 ps=1.305 w=1 l=0.15
X1 a_297_47# B1 a_79_21# VNB sky130_fd_pr__nfet_01v8 ad=0.10075 pd=0.96 as=0.169 ps=1.82 w=0.65 l=0.15
X2 a_297_47# A1 VGND VNB sky130_fd_pr__nfet_01v8 ad=0.169 pd=1.82 as=0.08775 ps=0.92 w=0.65 l=0.15
X3 VGND A2 a_297_47# VNB sky130_fd_pr__nfet_01v8 ad=0.08775 pd=0.92 as=0.10075 ps=0.96 w=0.65 l=0.15
X4 VPWR a_79_21# X VPB sky130_fd_pr__pfet_01v8_hvt ad=0.3275 pd=1.655 as=0.28 ps=2.56 w=1 l=0.15
X5 a_79_21# B1 VPWR VPB sky130_fd_pr__pfet_01v8_hvt ad=0.195 pd=1.39 as=0.3275 ps=1.655 w=1 l=0.15
X6 a_382_297# A2 a_79_21# VPB sky130_fd_pr__pfet_01v8_hvt ad=0.1525 pd=1.305 as=0.195 ps=1.39 w=1 l=0.15
X7 VGND a_79_21# X VNB sky130_fd_pr__nfet_01v8 ad=0.169 pd=1.82 as=0.169 ps=1.82 w=0.65 l=0.15
.ends

.subckt sky130_fd_sc_hd__inv_4$1 Y A VPWR VGND VPB VNB
X0 VPWR A Y VPB sky130_fd_pr__pfet_01v8_hvt ad=0.26 pd=2.52 as=0.135 ps=1.27 w=1 l=0.15 M=4
X1 Y A VGND VNB sky130_fd_pr__nfet_01v8 ad=0.08775 pd=0.92 as=0.169 ps=1.82 w=0.65 l=0.15 M=4
.ends

.subckt sky130_fd_sc_hd__inv_6$1 Y A VPWR VGND VPB VNB
X0 VPWR A Y VPB sky130_fd_pr__pfet_01v8_hvt ad=0.27 pd=2.54 as=0.135 ps=1.27 w=1 l=0.15 M=6
X1 Y A VGND VNB sky130_fd_pr__nfet_01v8 ad=0.08775 pd=0.92 as=0.08775 ps=0.92 w=0.65 l=0.15 M=6
.ends

.subckt sky130_fd_sc_hd__dlymetal6s2s_1$1 A X VPWR VGND VPB VNB
X0 a_558_47# a_381_47# VPWR VPB sky130_fd_pr__pfet_01v8_hvt ad=0.26 pd=2.52 as=0.14075 ps=1.325 w=1 l=0.15
X1 VGND X a_381_47# VNB sky130_fd_pr__nfet_01v8 ad=0.097 pd=0.975 as=0.1092 ps=1.36 w=0.42 l=0.15
X2 a_841_47# a_664_47# VPWR VPB sky130_fd_pr__pfet_01v8_hvt ad=0.26 pd=2.52 as=0.14075 ps=1.325 w=1 l=0.15
X3 VPWR A a_62_47# VPB sky130_fd_pr__pfet_01v8_hvt ad=0.14075 pd=1.325 as=0.1092 ps=1.36 w=0.42 l=0.15
X4 VGND A a_62_47# VNB sky130_fd_pr__nfet_01v8 ad=0.097 pd=0.975 as=0.1092 ps=1.36 w=0.42 l=0.15
X5 a_558_47# a_381_47# VGND VNB sky130_fd_pr__nfet_01v8 ad=0.169 pd=1.82 as=0.097 ps=0.975 w=0.65 l=0.15
X6 X a_62_47# VPWR VPB sky130_fd_pr__pfet_01v8_hvt ad=0.26 pd=2.52 as=0.14075 ps=1.325 w=1 l=0.15
X7 VPWR X a_381_47# VPB sky130_fd_pr__pfet_01v8_hvt ad=0.14075 pd=1.325 as=0.1092 ps=1.36 w=0.42 l=0.15
X8 a_841_47# a_664_47# VGND VNB sky130_fd_pr__nfet_01v8 ad=0.169 pd=1.82 as=0.097 ps=0.975 w=0.65 l=0.15
X9 X a_62_47# VGND VNB sky130_fd_pr__nfet_01v8 ad=0.169 pd=1.82 as=0.097 ps=0.975 w=0.65 l=0.15
X10 VPWR a_558_47# a_664_47# VPB sky130_fd_pr__pfet_01v8_hvt ad=0.14075 pd=1.325 as=0.1092 ps=1.36 w=0.42 l=0.15
X11 VGND a_558_47# a_664_47# VNB sky130_fd_pr__nfet_01v8 ad=0.097 pd=0.975 as=0.1092 ps=1.36 w=0.42 l=0.15
.ends

.subckt sky130_fd_sc_hd__clkbuf_16$1 X A VGND VPWR VPB VNB
X0 VPWR A a_110_47# VPB sky130_fd_pr__pfet_01v8_hvt ad=0.14 pd=1.28 as=0.14 ps=1.28 w=1 l=0.15 M=4
X1 VPWR a_110_47# X VPB sky130_fd_pr__pfet_01v8_hvt ad=0.14 pd=1.28 as=0.14 ps=1.28 w=1 l=0.15 M=16
X2 a_110_47# A VGND VNB sky130_fd_pr__nfet_01v8 ad=0.0588 pd=0.7 as=0.0588 ps=0.7 w=0.42 l=0.15 M=4
X3 VGND a_110_47# X VNB sky130_fd_pr__nfet_01v8 ad=0.0588 pd=0.7 as=0.0588 ps=0.7 w=0.42 l=0.15 M=16
.ends

.subckt sky130_fd_sc_hd__nor4b_4$1 B A D_N C Y VGND VPWR VPB VNB
X0 VGND B Y VNB sky130_fd_pr__nfet_01v8 ad=0.08775 pd=0.92 as=0.08775 ps=0.92 w=0.65 l=0.15 M=4
X1 VGND D_N a_1191_21# VNB sky130_fd_pr__nfet_01v8 ad=0.182 pd=1.86 as=0.169 ps=1.82 w=0.65 l=0.15
X2 a_803_297# a_1191_21# Y VPB sky130_fd_pr__pfet_01v8_hvt ad=0.26 pd=2.52 as=0.135 ps=1.27 w=1 l=0.15 M=4
X3 a_445_297# B a_27_297# VPB sky130_fd_pr__pfet_01v8_hvt ad=0.135 pd=1.27 as=0.135 ps=1.27 w=1 l=0.15 M=4
X4 a_27_297# A VPWR VPB sky130_fd_pr__pfet_01v8_hvt ad=0.135 pd=1.27 as=0.135 ps=1.27 w=1 l=0.15 M=4
X5 Y C VGND VNB sky130_fd_pr__nfet_01v8 ad=0.08775 pd=0.92 as=0.08775 ps=0.92 w=0.65 l=0.15 M=4
X6 Y a_1191_21# VGND VNB sky130_fd_pr__nfet_01v8 ad=0.08775 pd=0.92 as=0.08775 ps=0.92 w=0.65 l=0.15 M=4
X7 VPWR D_N a_1191_21# VPB sky130_fd_pr__pfet_01v8_hvt ad=0.28 pd=2.56 as=0.26 ps=2.52 w=1 l=0.15
X8 VGND A Y VNB sky130_fd_pr__nfet_01v8 ad=0.08775 pd=0.92 as=0.08775 ps=0.92 w=0.65 l=0.15 M=4
X9 a_803_297# C a_445_297# VPB sky130_fd_pr__pfet_01v8_hvt ad=0.135 pd=1.27 as=0.135 ps=1.27 w=1 l=0.15 M=4
.ends

.subckt sky130_fd_sc_hd__conb_1$1 LO HI VGND VPWR VPB VNB
X0 VPWR HI sky130_fd_pr__res_generic_po w=0.48 l=0.045
X1 LO VGND sky130_fd_pr__res_generic_po w=0.48 l=0.045
.ends

.subckt sky130_fd_sc_hd__nor4b_2$1 D_N Y C A B VGND VPWR VPB VNB
X0 VPWR D_N a_694_21# VPB sky130_fd_pr__pfet_01v8_hvt ad=0.1092 pd=1.36 as=0.1092 ps=1.36 w=0.42 l=0.15
X1 a_27_297# B a_277_297# VPB sky130_fd_pr__pfet_01v8_hvt ad=0.26 pd=2.52 as=0.135 ps=1.27 w=1 l=0.15 M=2
X2 a_474_297# a_694_21# Y VPB sky130_fd_pr__pfet_01v8_hvt ad=0.26 pd=2.52 as=0.135 ps=1.27 w=1 l=0.15 M=2
X3 VGND C Y VNB sky130_fd_pr__nfet_01v8 ad=0.08775 pd=0.92 as=0.08775 ps=0.92 w=0.65 l=0.15 M=2
X4 VGND D_N a_694_21# VNB sky130_fd_pr__nfet_01v8 ad=0.1092 pd=1.36 as=0.1092 ps=1.36 w=0.42 l=0.15
X5 a_27_297# A VPWR VPB sky130_fd_pr__pfet_01v8_hvt ad=0.135 pd=1.27 as=0.135 ps=1.27 w=1 l=0.15 M=2
X6 VGND A Y VNB sky130_fd_pr__nfet_01v8 ad=0.08775 pd=0.92 as=0.08775 ps=0.92 w=0.65 l=0.15 M=2
X7 VGND B Y VNB sky130_fd_pr__nfet_01v8 ad=0.169 pd=1.82 as=0.08775 ps=0.92 w=0.65 l=0.15 M=2
X8 a_474_297# C a_277_297# VPB sky130_fd_pr__pfet_01v8_hvt ad=0.135 pd=1.27 as=0.135 ps=1.27 w=1 l=0.15 M=2
X9 Y a_694_21# VGND VNB sky130_fd_pr__nfet_01v8 ad=0.08775 pd=0.92 as=0.08775 ps=0.92 w=0.65 l=0.15 M=2
.ends

.subckt sky130_fd_sc_hd__nor4b_1$1 C B A D_N Y VGND VPWR VPB VNB
X0 Y a_91_199# VGND VNB sky130_fd_pr__nfet_01v8 ad=0.08775 pd=0.92 as=0.182 ps=1.86 w=0.65 l=0.15
X1 Y B VGND VNB sky130_fd_pr__nfet_01v8 ad=0.08775 pd=0.92 as=0.10725 ps=0.98 w=0.65 l=0.15
X2 VGND C Y VNB sky130_fd_pr__nfet_01v8 ad=0.10725 pd=0.98 as=0.08775 ps=0.92 w=0.65 l=0.15
X3 a_91_199# D_N VGND VNB sky130_fd_pr__nfet_01v8 ad=0.1092 pd=1.36 as=0.10025 ps=0.985 w=0.42 l=0.15
X4 VGND A Y VNB sky130_fd_pr__nfet_01v8 ad=0.10025 pd=0.985 as=0.08775 ps=0.92 w=0.65 l=0.15
X5 VPWR A a_341_297# VPB sky130_fd_pr__pfet_01v8_hvt ad=0.14575 pd=1.335 as=0.135 ps=1.27 w=1 l=0.15
X6 a_245_297# C a_161_297# VPB sky130_fd_pr__pfet_01v8_hvt ad=0.165 pd=1.33 as=0.135 ps=1.27 w=1 l=0.15
X7 a_341_297# B a_245_297# VPB sky130_fd_pr__pfet_01v8_hvt ad=0.135 pd=1.27 as=0.165 ps=1.33 w=1 l=0.15
X8 a_91_199# D_N VPWR VPB sky130_fd_pr__pfet_01v8_hvt ad=0.1092 pd=1.36 as=0.14575 ps=1.335 w=0.42 l=0.15
X9 a_161_297# a_91_199# Y VPB sky130_fd_pr__pfet_01v8_hvt ad=0.135 pd=1.27 as=0.52 ps=3.04 w=1 l=0.15
.ends

.subckt sky130_fd_sc_hd__or4_1$1 C A X B D VPWR VGND VPB VNB
X0 a_27_297# B VGND VNB sky130_fd_pr__nfet_01v8 ad=0.0567 pd=0.69 as=0.0567 ps=0.69 w=0.42 l=0.15
X1 a_27_297# D VGND VNB sky130_fd_pr__nfet_01v8 ad=0.0693 pd=0.75 as=0.1092 ps=1.36 w=0.42 l=0.15
X2 a_277_297# B a_205_297# VPB sky130_fd_pr__pfet_01v8_hvt ad=0.0693 pd=0.75 as=0.0441 ps=0.63 w=0.42 l=0.15
X3 VPWR A a_277_297# VPB sky130_fd_pr__pfet_01v8_hvt ad=0.14825 pd=1.34 as=0.0693 ps=0.75 w=0.42 l=0.15
X4 X a_27_297# VGND VNB sky130_fd_pr__nfet_01v8 ad=0.1755 pd=1.84 as=0.101875 ps=0.99 w=0.65 l=0.15
X5 a_205_297# C a_109_297# VPB sky130_fd_pr__pfet_01v8_hvt ad=0.0441 pd=0.63 as=0.0693 ps=0.75 w=0.42 l=0.15
X6 X a_27_297# VPWR VPB sky130_fd_pr__pfet_01v8_hvt ad=0.27 pd=2.54 as=0.14825 ps=1.34 w=1 l=0.15
X7 VGND C a_27_297# VNB sky130_fd_pr__nfet_01v8 ad=0.0567 pd=0.69 as=0.0693 ps=0.75 w=0.42 l=0.15
X8 a_109_297# D a_27_297# VPB sky130_fd_pr__pfet_01v8_hvt ad=0.0693 pd=0.75 as=0.1092 ps=1.36 w=0.42 l=0.15
X9 VGND A a_27_297# VNB sky130_fd_pr__nfet_01v8 ad=0.101875 pd=0.99 as=0.0567 ps=0.69 w=0.42 l=0.15
.ends

.subckt sky130_fd_sc_hd__nand2_4$1 Y A B VGND VPWR VPB VNB
X0 a_27_47# A Y VNB sky130_fd_pr__nfet_01v8 ad=0.08775 pd=0.92 as=0.08775 ps=0.92 w=0.65 l=0.15 M=4
X1 Y A VPWR VPB sky130_fd_pr__pfet_01v8_hvt ad=0.135 pd=1.27 as=0.135 ps=1.27 w=1 l=0.15 M=4
X2 VPWR B Y VPB sky130_fd_pr__pfet_01v8_hvt ad=0.135 pd=1.27 as=0.135 ps=1.27 w=1 l=0.15 M=4
X3 a_27_47# B VGND VNB sky130_fd_pr__nfet_01v8 ad=0.08775 pd=0.92 as=0.08775 ps=0.92 w=0.65 l=0.15 M=4
.ends

.subckt sky130_fd_sc_hd__and4b_1$1 C A_N X D B VGND VPWR VPB VNB
X0 a_297_47# a_27_47# a_193_413# VNB sky130_fd_pr__nfet_01v8 ad=0.0441 pd=0.63 as=0.1092 ps=1.36 w=0.42 l=0.15
X1 a_369_47# B a_297_47# VNB sky130_fd_pr__nfet_01v8 ad=0.0735 pd=0.77 as=0.0441 ps=0.63 w=0.42 l=0.15
X2 VPWR D a_193_413# VPB sky130_fd_pr__pfet_01v8_hvt ad=0.14075 pd=1.325 as=0.06615 ps=0.735 w=0.42 l=0.15
X3 X a_193_413# VGND VNB sky130_fd_pr__nfet_01v8 ad=0.169 pd=1.82 as=0.1034 ps=1 w=0.65 l=0.15
X4 VPWR A_N a_27_47# VPB sky130_fd_pr__pfet_01v8_hvt ad=0.0567 pd=0.69 as=0.1092 ps=1.36 w=0.42 l=0.15
X5 VGND D a_469_47# VNB sky130_fd_pr__nfet_01v8 ad=0.1034 pd=1 as=0.0609 ps=0.71 w=0.42 l=0.15
X6 X a_193_413# VPWR VPB sky130_fd_pr__pfet_01v8_hvt ad=0.26 pd=2.52 as=0.14075 ps=1.325 w=1 l=0.15
X7 VPWR B a_193_413# VPB sky130_fd_pr__pfet_01v8_hvt ad=0.1281 pd=1.03 as=0.0987 ps=0.89 w=0.42 l=0.15
X8 a_193_413# C VPWR VPB sky130_fd_pr__pfet_01v8_hvt ad=0.06615 pd=0.735 as=0.1281 ps=1.03 w=0.42 l=0.15
X9 a_193_413# a_27_47# VPWR VPB sky130_fd_pr__pfet_01v8_hvt ad=0.0987 pd=0.89 as=0.0567 ps=0.69 w=0.42 l=0.15
X10 a_469_47# C a_369_47# VNB sky130_fd_pr__nfet_01v8 ad=0.0609 pd=0.71 as=0.0735 ps=0.77 w=0.42 l=0.15
X11 VGND A_N a_27_47# VNB sky130_fd_pr__nfet_01v8 ad=0.1092 pd=1.36 as=0.1092 ps=1.36 w=0.42 l=0.15
.ends

.subckt sky130_fd_sc_hd__inv_2$1 A Y VPWR VGND VPB VNB
X0 Y A VPWR VPB sky130_fd_pr__pfet_01v8_hvt ad=0.135 pd=1.27 as=0.26 ps=2.52 w=1 l=0.15 M=2
X1 VGND A Y VNB sky130_fd_pr__nfet_01v8 ad=0.169 pd=1.82 as=0.08775 ps=0.92 w=0.65 l=0.15 M=2
.ends

.subckt afe_wb wbs_adr_i[15] wbs_adr_i[16] wbs_adr_i[17] wbs_adr_i[18] wbs_adr_i[19]
+ wbs_adr_i[20] wbs_adr_i[21] wbs_adr_i[22] wbs_adr_i[23] wbs_adr_i[24] wbs_adr_i[25]
+ wbs_adr_i[26] wbs_adr_i[27] wbs_adr_i[28] wbs_adr_i[29] wbs_adr_i[30] wbs_adr_i[31]
+ wbs_dat_i[14] wbs_dat_i[15] wbs_dat_i[16] wbs_dat_i[17] wbs_dat_i[18] wbs_dat_i[19]
+ wbs_dat_i[20] wbs_dat_i[21] wbs_dat_i[22] wbs_dat_i[23] wbs_dat_i[24] wbs_dat_i[25]
+ wbs_dat_i[26] wbs_dat_i[27] wbs_dat_i[28] wbs_dat_i[29] wbs_dat_i[30] wbs_dat_i[31]
+ wbs_dat_o[14] wbs_dat_o[15] wbs_dat_o[16] wbs_dat_o[17] wbs_dat_o[18] wbs_dat_o[19]
+ wbs_dat_o[20] wbs_dat_o[21] wbs_dat_o[22] wbs_dat_o[23] wbs_dat_o[24] wbs_dat_o[25]
+ wbs_dat_o[26] wbs_dat_o[27] wbs_dat_o[28] wbs_dat_o[29] wbs_dat_o[30] wbs_dat_o[31]
+ wbs_adr_i[3] wbs_adr_i[4] wbs_adr_i[5] wbs_adr_i[6] wbs_adr_i[7] wbs_dat_i[2] wbs_adr_i[8]
+ wbs_adr_i[9] wbs_dat_i[3] wbs_dat_i[4] wbs_dat_i[5] wbs_dat_i[6] wbs_dat_i[7] wbs_dat_i[8]
+ wbs_dat_i[9] wbs_dat_o[0] wbs_dat_o[10] wbs_dat_o[11] wbs_dat_o[12] wbs_dat_o[13]
+ wbs_cyc_i wbs_dat_i[0] wbs_dat_i[10] wbs_dat_i[11] wbs_dat_i[12] wbs_dat_i[13] wbs_dat_o[1]
+ wbs_adr_i[13] wbs_adr_i[14] wb_clk_i wb_rst_i wbs_ack_o wbs_adr_i[0] wbs_dat_i[1]
+ wbs_adr_i[10] wbs_adr_i[1] wbs_adr_i[2] wbs_dat_o[2] wbs_adr_i[11] wbs_adr_i[12]
+ wbs_dat_o[3] wbs_dat_o[4] wbs_dat_o[5] wbs_dat_o[6] wbs_dat_o[7] wbs_dat_o[8] wbs_dat_o[9]
+ wbs_sel_i[0] wbs_sel_i[1] wbs_sel_i[2] wbs_sel_i[3] wbs_stb_i wbs_we_i adc_data[1]
+ adc_data[2] adc_data[3] adc_data[4] adc_data[5] adc_data[6] adc_data[0] adc_data[9]
+ adc_eof adc_data[10] adc_data[11] adc_data[7] adc_data[8] analog_ctrl[100] analog_ctrl[101]
+ analog_ctrl[102] analog_ctrl[103] analog_ctrl[104] analog_ctrl[105] analog_ctrl[106]
+ analog_ctrl[107] analog_ctrl[108] analog_ctrl[109] analog_ctrl[110] analog_ctrl[111]
+ analog_ctrl[112] analog_ctrl[113] analog_ctrl[114] analog_ctrl[115] analog_ctrl[116]
+ analog_ctrl[117] analog_ctrl[118] analog_ctrl[119] analog_ctrl[120] analog_ctrl[121]
+ analog_ctrl[122] analog_ctrl[62] analog_ctrl[63] analog_ctrl[64] analog_ctrl[65]
+ analog_ctrl[66] analog_ctrl[67] analog_ctrl[68] analog_ctrl[69] analog_ctrl[70]
+ analog_ctrl[71] analog_ctrl[72] analog_ctrl[73] analog_ctrl[74] analog_ctrl[75]
+ analog_ctrl[76] analog_ctrl[77] analog_ctrl[78] analog_ctrl[79] analog_ctrl[80]
+ analog_ctrl[81] analog_ctrl[82] analog_ctrl[83] analog_ctrl[84] analog_ctrl[85]
+ analog_ctrl[86] analog_ctrl[87] analog_ctrl[88] analog_ctrl[89] analog_ctrl[90]
+ analog_ctrl[91] analog_ctrl[92] analog_ctrl[93] analog_ctrl[94] analog_ctrl[95]
+ analog_ctrl[96] analog_ctrl[97] analog_ctrl[98] analog_ctrl[99] analog_ctrl[44]
+ analog_ctrl[45] analog_ctrl[46] analog_ctrl[47] analog_ctrl[48] analog_ctrl[49]
+ analog_ctrl[4] analog_ctrl[50] analog_ctrl[51] analog_ctrl[52] analog_ctrl[53] analog_ctrl[54]
+ analog_ctrl[55] analog_ctrl[56] analog_ctrl[57] analog_ctrl[58] analog_ctrl[59]
+ analog_ctrl[5] analog_ctrl[60] analog_ctrl[61] analog_ctrl[0] analog_ctrl[10] analog_ctrl[11]
+ analog_ctrl[12] analog_ctrl[13] analog_ctrl[14] analog_ctrl[15] analog_ctrl[16]
+ analog_ctrl[6] analog_ctrl[17] analog_ctrl[18] analog_ctrl[19] analog_ctrl[1] analog_ctrl[20]
+ analog_ctrl[21] analog_ctrl[22] analog_ctrl[23] analog_ctrl[24] analog_ctrl[25]
+ analog_ctrl[7] analog_ctrl[26] analog_ctrl[27] analog_ctrl[28] analog_ctrl[29] analog_ctrl[2]
+ analog_ctrl[30] analog_ctrl[31] analog_ctrl[32] analog_ctrl[33] analog_ctrl[34]
+ analog_ctrl[8] analog_ctrl[35] analog_ctrl[36] analog_ctrl[37] analog_ctrl[38] analog_ctrl[39]
+ analog_ctrl[3] analog_ctrl[40] analog_ctrl[41] analog_ctrl[42] analog_ctrl[43] analog_ctrl[9]
+ vccd1 vssd1
XFILLER_94_361 vssd1 vccd1 vccd1 vssd1 sky130_fd_sc_hd__fill_2$1
XTAP_TAPCELL_ROW_87_1605 vccd1 vssd1 sky130_fd_sc_hd__tapvpwrvgnd_1$1
XFILLER_82_512 vssd1 vccd1 vccd1 vssd1 sky130_fd_sc_hd__fill_4$1
XFILLER_82_501 vssd1 vccd1 vccd1 vssd1 sky130_fd_sc_hd__fill_4$1
XFILLER_27_417 vssd1 vccd1 vccd1 vssd1 sky130_ef_sc_hd__decap_40_12$1
XFILLER_39_277 vssd1 vccd1 vccd1 vssd1 sky130_fd_sc_hd__fill_2$1
XFILLER_67_597 vssd1 vccd1 vccd1 vssd1 sky130_fd_sc_hd__fill_2$1
XFILLER_82_589 vssd1 vccd1 vccd1 vssd1 sky130_fd_sc_hd__fill_4$1
XFILLER_35_461 vssd1 vccd1 vccd1 vssd1 sky130_ef_sc_hd__decap_40_12$1
XFILLER_52_29 vssd1 vccd1 vccd1 vssd1 sky130_ef_sc_hd__decap_40_12$1
XFILLER_22_133 vssd1 vccd1 vccd1 vssd1 sky130_fd_sc_hd__fill_4$1
XTAP_TAPCELL_ROW_46_990 vccd1 vssd1 sky130_fd_sc_hd__tapvpwrvgnd_1$1
XFILLER_50_453 vssd1 vccd1 vccd1 vssd1 sky130_fd_sc_hd__fill_2$1
XFILLER_22_177 vssd1 vccd1 vccd1 vssd1 sky130_ef_sc_hd__decap_40_12$1
XFILLER_108_249 vssd1 vccd1 vccd1 vssd1 sky130_fd_sc_hd__fill_2$1
XTAP_TAPCELL_ROW_98_1767 vccd1 vssd1 sky130_fd_sc_hd__tapvpwrvgnd_1$1
XFILLER_136_569 vssd1 vccd1 vccd1 vssd1 sky130_ef_sc_hd__decap_40_12$1
XFILLER_117_772 vssd1 vccd1 vccd1 vssd1 sky130_ef_sc_hd__decap_40_12$1
XPHY_EDGE_ROW_107_Left_246 vccd1 vssd1 vccd1 vssd1 sky130_fd_sc_hd__decap_3$1
XFILLER_104_411 vssd1 vccd1 vccd1 vssd1 sky130_fd_sc_hd__fill_2$1
XFILLER_89_111 vccd1 vssd1 vccd1 vssd1 sky130_fd_sc_hd__fill_1$1
XFILLER_117_55 vccd1 vssd1 vccd1 vssd1 sky130_fd_sc_hd__fill_1$1
XFILLER_77_15 vssd1 vccd1 vccd1 vssd1 sky130_ef_sc_hd__decap_40_12$1
XTAP_TAPCELL_ROW_129_2233 vccd1 vssd1 sky130_fd_sc_hd__tapvpwrvgnd_1$1
XFILLER_104_477 vccd1 vssd1 vccd1 vssd1 sky130_fd_sc_hd__fill_1$1
XFILLER_77_317 vssd1 vccd1 vccd1 vssd1 sky130_ef_sc_hd__decap_40_12$1
XFILLER_58_531 vccd1 vssd1 vccd1 vssd1 sky130_fd_sc_hd__fill_1$1
XFILLER_92_309 vssd1 vccd1 vccd1 vssd1 sky130_ef_sc_hd__decap_40_12$1
XFILLER_85_361 vssd1 vccd1 vccd1 vssd1 sky130_ef_sc_hd__decap_40_12$1
XFILLER_73_501 vssd1 vccd1 vccd1 vssd1 sky130_fd_sc_hd__fill_2$1
XFILLER_58_553 vssd1 vccd1 vccd1 vssd1 sky130_ef_sc_hd__decap_40_12$1
XTAP_TAPCELL_ROW_51_1063 vccd1 vssd1 sky130_fd_sc_hd__tapvpwrvgnd_1$1
XTAP_TAPCELL_ROW_5_376 vccd1 vssd1 sky130_fd_sc_hd__tapvpwrvgnd_1$1
XFILLER_18_417 vssd1 vccd1 vccd1 vssd1 sky130_fd_sc_hd__fill_2$1
XPHY_EDGE_ROW_116_Left_255 vccd1 vssd1 vccd1 vssd1 sky130_fd_sc_hd__decap_3$1
XFILLER_58_597 vssd1 vccd1 vccd1 vssd1 sky130_fd_sc_hd__fill_8$1
XFILLER_45_225 vssd1 vccd1 vccd1 vssd1 sky130_ef_sc_hd__decap_40_12$1
XFILLER_93_69 vssd1 vccd1 vccd1 vssd1 sky130_ef_sc_hd__decap_40_12$1
XFILLER_61_718 vssd1 vccd1 vccd1 vssd1 sky130_fd_sc_hd__fill_8$1
XFILLER_26_41 vssd1 vccd1 vccd1 vssd1 sky130_ef_sc_hd__decap_40_12$1
XFILLER_61_729 vssd1 vccd1 vccd1 vssd1 sky130_ef_sc_hd__decap_40_12$1
XFILLER_54_781 vssd1 vccd1 vccd1 vssd1 sky130_ef_sc_hd__decap_40_12$1
XFILLER_14_601 vssd1 vccd1 vccd1 vssd1 sky130_ef_sc_hd__decap_40_12$1
XFILLER_13_111 vccd1 vssd1 vccd1 vssd1 sky130_fd_sc_hd__fill_1$1
XFILLER_14_645 vssd1 vccd1 vccd1 vssd1 sky130_ef_sc_hd__decap_40_12$1
XFILLER_26_85 vssd1 vccd1 vccd1 vssd1 sky130_ef_sc_hd__decap_40_12$1
XTAP_TAPCELL_ROW_24_662 vccd1 vssd1 sky130_fd_sc_hd__tapvpwrvgnd_1$1
XFILLER_9_137 vssd1 vccd1 vccd1 vssd1 sky130_ef_sc_hd__decap_40_12$1
XFILLER_41_497 vssd1 vccd1 vccd1 vssd1 sky130_fd_sc_hd__fill_4$1
XFILLER_6_811 vccd1 vssd1 vccd1 vssd1 sky130_fd_sc_hd__fill_1$1
XPHY_EDGE_ROW_125_Left_264 vccd1 vssd1 vccd1 vssd1 sky130_fd_sc_hd__decap_3$1
XFILLER_107_293 vssd1 vccd1 vccd1 vssd1 sky130_ef_sc_hd__decap_40_12$1
XFILLER_123_797 vssd1 vccd1 vccd1 vssd1 sky130_ef_sc_hd__decap_40_12$1
XFILLER_123_775 vssd1 vccd1 vccd1 vssd1 sky130_fd_sc_hd__fill_8$1
XFILLER_110_458 vssd1 vccd1 vccd1 vssd1 sky130_fd_sc_hd__fill_2$1
X_1270_ _1665_/Q _1270_/X _1270_/B vssd1 vccd1 vccd1 vssd1 sky130_fd_sc_hd__or2_1$1
XFILLER_95_125 vssd1 vccd1 vccd1 vssd1 sky130_ef_sc_hd__decap_40_12$1
XPHY_EDGE_ROW_134_Left_273 vccd1 vssd1 vccd1 vssd1 sky130_fd_sc_hd__decap_3$1
XFILLER_95_169 vssd1 vccd1 vccd1 vssd1 sky130_ef_sc_hd__decap_40_12$1
XFILLER_76_361 vssd1 vccd1 vccd1 vssd1 sky130_fd_sc_hd__fill_2$1
XFILLER_67_81 vssd1 vccd1 vccd1 vssd1 sky130_ef_sc_hd__decap_40_12$1
XFILLER_64_501 vssd1 vccd1 vccd1 vssd1 sky130_ef_sc_hd__decap_40_12$1
XFILLER_92_821 vccd1 vssd1 vccd1 vssd1 sky130_fd_sc_hd__fill_1$1
XTAP_TAPCELL_ROW_69_1335 vccd1 vssd1 sky130_fd_sc_hd__tapvpwrvgnd_1$1
XFILLER_49_597 vssd1 vccd1 vccd1 vssd1 sky130_ef_sc_hd__decap_40_12$1
XFILLER_37_726 vssd1 vccd1 vccd1 vssd1 sky130_fd_sc_hd__fill_2$1
XFILLER_64_545 vssd1 vccd1 vccd1 vssd1 sky130_ef_sc_hd__decap_40_12$1
XTAP_TAPCELL_ROW_82_1524 vccd1 vssd1 sky130_fd_sc_hd__tapvpwrvgnd_1$1
XFILLER_51_217 vssd1 vccd1 vccd1 vssd1 sky130_fd_sc_hd__fill_4$1
XFILLER_17_461 vssd1 vccd1 vccd1 vssd1 sky130_ef_sc_hd__decap_40_12$1
XFILLER_45_781 vssd1 vccd1 vccd1 vssd1 sky130_fd_sc_hd__fill_2$1
XTAP_TAPCELL_ROW_82_1535 vccd1 vssd1 sky130_fd_sc_hd__tapvpwrvgnd_1$1
XFILLER_60_751 vssd1 vccd1 vccd1 vssd1 sky130_fd_sc_hd__fill_4$1
XFILLER_32_475 vccd1 vssd1 vccd1 vssd1 sky130_fd_sc_hd__fill_1$1
XFILLER_20_637 vssd1 vccd1 vccd1 vssd1 sky130_fd_sc_hd__fill_4$1
X_0985_ _1447_/C1 _0984_/X _0991_/A2 hold46/X _1526_/D vssd1 vccd1 vccd1 vssd1 sky130_fd_sc_hd__o211a_1$1
XFILLER_9_671 vccd1 vssd1 vccd1 vssd1 sky130_fd_sc_hd__fill_1$1
XTAP_TAPCELL_ROW_113_2001 vccd1 vssd1 sky130_fd_sc_hd__tapvpwrvgnd_1$1
XFILLER_118_569 vssd1 vccd1 vccd1 vssd1 sky130_ef_sc_hd__decap_40_12$1
X_1606_ _1793_/A _1608_/CLK _1606_/D vccd1 vssd1 vccd1 vssd1 sky130_fd_sc_hd__dfxtp_1$1
X_1537_ _1537_/Q _1633_/CLK _1537_/D vccd1 vssd1 vccd1 vssd1 sky130_fd_sc_hd__dfxtp_1$1
XFILLER_99_497 vssd1 vccd1 vccd1 vssd1 sky130_fd_sc_hd__fill_4$1
XTAP_TAPCELL_ROW_93_1697 vccd1 vssd1 sky130_fd_sc_hd__tapvpwrvgnd_1$1
XFILLER_59_317 vssd1 vccd1 vccd1 vssd1 sky130_ef_sc_hd__decap_40_12$1
X_1468_ _1761_/Q _1468_/X _1474_/B vssd1 vccd1 vccd1 vssd1 sky130_fd_sc_hd__or2_1$1
XFILLER_68_840 vssd1 vccd1 vccd1 vssd1 sky130_fd_sc_hd__fill_2$1
X_1399_ _1465_/C1 _1398_/X _1399_/A2 hold83/X _1727_/D vssd1 vccd1 vccd1 vssd1 sky130_fd_sc_hd__o211a_1$1
XFILLER_83_810 vssd1 vccd1 vccd1 vssd1 sky130_ef_sc_hd__decap_40_12$1
XFILLER_74_309 vssd1 vccd1 vccd1 vssd1 sky130_ef_sc_hd__decap_40_12$1
XFILLER_67_361 vssd1 vccd1 vccd1 vssd1 sky130_ef_sc_hd__decap_40_12$1
XFILLER_55_501 vssd1 vccd1 vccd1 vssd1 sky130_fd_sc_hd__fill_2$1
XTAP_TAPCELL_ROW_2_324 vccd1 vssd1 sky130_fd_sc_hd__tapvpwrvgnd_1$1
XTAP_TAPCELL_ROW_2_335 vccd1 vssd1 sky130_fd_sc_hd__tapvpwrvgnd_1$1
XFILLER_27_225 vssd1 vccd1 vccd1 vssd1 sky130_ef_sc_hd__decap_40_12$1
XTAP_TAPCELL_ROW_124_2163 vccd1 vssd1 sky130_fd_sc_hd__tapvpwrvgnd_1$1
XFILLER_103_57 vssd1 vccd1 vccd1 vssd1 sky130_ef_sc_hd__decap_40_12$1
XFILLER_63_39 vssd1 vccd1 vccd1 vssd1 sky130_ef_sc_hd__decap_40_12$1
XFILLER_36_781 vssd1 vccd1 vccd1 vssd1 sky130_fd_sc_hd__fill_2$1
XFILLER_43_729 vssd1 vccd1 vccd1 vssd1 sky130_fd_sc_hd__fill_8$1
XFILLER_36_792 vssd1 vccd1 vccd1 vssd1 sky130_fd_sc_hd__fill_2$1
XFILLER_11_615 vccd1 vssd1 vccd1 vssd1 sky130_fd_sc_hd__fill_1$1
XTAP_TAPCELL_ROW_41_908 vccd1 vssd1 sky130_fd_sc_hd__tapvpwrvgnd_1$1
XTAP_TAPCELL_ROW_41_919 vccd1 vssd1 sky130_fd_sc_hd__tapvpwrvgnd_1$1
XTAP_TAPCELL_ROW_21_610 vccd1 vssd1 sky130_fd_sc_hd__tapvpwrvgnd_1$1
XTAP_TAPCELL_ROW_21_621 vccd1 vssd1 sky130_fd_sc_hd__tapvpwrvgnd_1$1
XFILLER_23_497 vssd1 vccd1 vccd1 vssd1 sky130_fd_sc_hd__fill_4$1
XFILLER_109_503 vccd1 vssd1 vccd1 vssd1 sky130_fd_sc_hd__fill_1$1
XFILLER_12_65 vssd1 vccd1 vccd1 vssd1 sky130_ef_sc_hd__decap_40_12$1
XFILLER_136_399 vssd1 vccd1 vccd1 vssd1 sky130_ef_sc_hd__decap_40_12$1
XFILLER_136_377 vssd1 vccd1 vccd1 vssd1 sky130_fd_sc_hd__fill_2$1
XFILLER_128_65 vssd1 vccd1 vccd1 vssd1 sky130_ef_sc_hd__decap_40_12$1
Xhold170 _1602_/Q _1140_/A vssd1 vccd1 vccd1 vssd1 sky130_fd_sc_hd__dlygate4sd3_1$1
XFILLER_2_357 vssd1 vccd1 vccd1 vssd1 sky130_fd_sc_hd__fill_4$1
XFILLER_120_701 vssd1 vccd1 vccd1 vssd1 sky130_ef_sc_hd__decap_40_12$1
XFILLER_105_797 vssd1 vccd1 vccd1 vssd1 sky130_ef_sc_hd__decap_40_12$1
Xhold181 _1555_/Q _1044_/A vssd1 vccd1 vccd1 vssd1 sky130_fd_sc_hd__dlygate4sd3_1$1
Xhold192 _1550_/Q _1034_/A vssd1 vccd1 vccd1 vssd1 sky130_fd_sc_hd__dlygate4sd3_1$1
XFILLER_77_125 vssd1 vccd1 vccd1 vssd1 sky130_ef_sc_hd__decap_40_12$1
XFILLER_77_169 vssd1 vccd1 vccd1 vssd1 sky130_ef_sc_hd__decap_40_12$1
XFILLER_46_501 vssd1 vccd1 vccd1 vssd1 sky130_ef_sc_hd__decap_40_12$1
XTAP_TAPCELL_ROW_109_1936 vccd1 vssd1 sky130_fd_sc_hd__tapvpwrvgnd_1$1
XFILLER_92_139 vccd1 vssd1 vccd1 vssd1 sky130_fd_sc_hd__fill_1$1
XFILLER_58_383 vccd1 vssd1 vccd1 vssd1 sky130_fd_sc_hd__fill_1$1
XFILLER_58_361 vssd1 vccd1 vccd1 vssd1 sky130_fd_sc_hd__fill_2$1
XFILLER_37_51 vssd1 vccd1 vccd1 vssd1 sky130_fd_sc_hd__fill_4$1
XFILLER_46_523 vccd1 vssd1 vccd1 vssd1 sky130_fd_sc_hd__fill_1$1
XTAP_TAPCELL_ROW_29_732 vccd1 vssd1 sky130_fd_sc_hd__tapvpwrvgnd_1$1
XFILLER_46_545 vssd1 vccd1 vccd1 vssd1 sky130_ef_sc_hd__decap_40_12$1
XFILLER_27_781 vssd1 vccd1 vccd1 vssd1 sky130_fd_sc_hd__fill_2$1
XFILLER_33_217 vssd1 vccd1 vccd1 vssd1 sky130_fd_sc_hd__fill_4$1
XFILLER_46_589 vssd1 vccd1 vccd1 vssd1 sky130_fd_sc_hd__fill_8$1
XTAP_TAPCELL_ROW_64_1265 vccd1 vssd1 sky130_fd_sc_hd__tapvpwrvgnd_1$1
XTAP_TAPCELL_ROW_64_1254 vccd1 vssd1 sky130_fd_sc_hd__tapvpwrvgnd_1$1
XFILLER_42_751 vssd1 vccd1 vccd1 vssd1 sky130_fd_sc_hd__fill_4$1
XFILLER_14_475 vccd1 vssd1 vccd1 vssd1 sky130_fd_sc_hd__fill_1$1
XFILLER_41_261 vssd1 vccd1 vccd1 vssd1 sky130_ef_sc_hd__decap_40_12$1
XFILLER_127_333 vssd1 vccd1 vccd1 vssd1 sky130_fd_sc_hd__fill_2$1
X_0770_ _0879_/B1 _0770_/X _0769_/X _1826_/A _0878_/B1 _0768_/X vssd1 vccd1 vccd1
+ vssd1 sky130_fd_sc_hd__a2111o_1$1
XFILLER_10_681 vssd1 vccd1 vccd1 vssd1 sky130_ef_sc_hd__decap_40_12$1
XFILLER_6_641 vssd1 vccd1 vccd1 vssd1 sky130_fd_sc_hd__fill_2$1
XFILLER_130_509 vssd1 vccd1 vccd1 vssd1 sky130_fd_sc_hd__fill_2$1
XFILLER_111_701 vssd1 vccd1 vccd1 vssd1 sky130_ef_sc_hd__decap_40_12$1
XFILLER_69_615 vccd1 vssd1 vccd1 vssd1 sky130_fd_sc_hd__fill_1$1
XFILLER_110_233 vssd1 vccd1 vccd1 vssd1 sky130_ef_sc_hd__decap_40_12$1
X_1322_ _1322_/A _1322_/X _1330_/B vssd1 vccd1 vccd1 vssd1 sky130_fd_sc_hd__or2_1$1
X_1253_ _1455_/C1 _1252_/X _1277_/A2 hold120/X _1656_/D vssd1 vccd1 vccd1 vssd1 sky130_fd_sc_hd__o211a_1$1
XFILLER_56_309 vssd1 vccd1 vccd1 vssd1 sky130_ef_sc_hd__decap_40_12$1
XFILLER_110_277 vssd1 vccd1 vccd1 vssd1 sky130_ef_sc_hd__decap_40_12$1
XFILLER_65_821 vssd1 vccd1 vccd1 vssd1 sky130_fd_sc_hd__fill_2$1
XFILLER_37_501 vssd1 vccd1 vccd1 vssd1 sky130_fd_sc_hd__fill_2$1
XFILLER_49_361 vssd1 vccd1 vccd1 vssd1 sky130_ef_sc_hd__decap_40_12$1
XFILLER_92_640 vssd1 vccd1 vccd1 vssd1 sky130_fd_sc_hd__fill_4$1
X_1184_ _1623_/Q _1184_/X _1210_/B vssd1 vccd1 vccd1 vssd1 sky130_fd_sc_hd__or2_1$1
XFILLER_91_161 vssd1 vccd1 vccd1 vssd1 sky130_fd_sc_hd__fill_4$1
XFILLER_80_813 vssd1 vccd1 vccd1 vssd1 sky130_fd_sc_hd__fill_8$1
XFILLER_52_526 vssd1 vccd1 vccd1 vssd1 sky130_fd_sc_hd__fill_4$1
XFILLER_18_781 vssd1 vccd1 vccd1 vssd1 sky130_ef_sc_hd__decap_40_12$1
XFILLER_25_718 vssd1 vccd1 vccd1 vssd1 sky130_fd_sc_hd__fill_8$1
XFILLER_25_729 vssd1 vccd1 vccd1 vssd1 sky130_fd_sc_hd__fill_8$1
XFILLER_60_570 vssd1 vccd1 vccd1 vssd1 sky130_ef_sc_hd__decap_40_12$1
XFILLER_20_401 vssd1 vccd1 vccd1 vssd1 sky130_ef_sc_hd__decap_40_12$1
XFILLER_119_823 vccd1 vssd1 vccd1 vssd1 sky130_fd_sc_hd__fill_1$1
XFILLER_20_445 vssd1 vccd1 vccd1 vssd1 sky130_ef_sc_hd__decap_40_12$1
XFILLER_118_333 vssd1 vccd1 vccd1 vssd1 sky130_ef_sc_hd__decap_40_12$1
X_0968_ _0968_/A _0968_/X _0990_/B vssd1 vccd1 vccd1 vssd1 sky130_fd_sc_hd__or2_1$1
XFILLER_20_489 vssd1 vccd1 vccd1 vssd1 sky130_ef_sc_hd__decap_40_12$1
XTAP_TAPCELL_ROW_95_1726 vccd1 vssd1 sky130_fd_sc_hd__tapvpwrvgnd_1$1
XFILLER_134_837 vssd1 vccd1 vccd1 vssd1 sky130_fd_sc_hd__fill_4$1
X_0899_ _1533_/Q _0949_/A _0899_/X _1757_/Q _1411_/A vccd1 vssd1 vccd1 vssd1 sky130_fd_sc_hd__a22o_1$1
XFILLER_106_528 vssd1 vccd1 vccd1 vssd1 sky130_fd_sc_hd__fill_4$1
XTAP_TAPCELL_ROW_7_405 vccd1 vssd1 sky130_fd_sc_hd__tapvpwrvgnd_1$1
XFILLER_102_701 vssd1 vccd1 vccd1 vssd1 sky130_ef_sc_hd__decap_40_12$1
XFILLER_99_261 vssd1 vccd1 vccd1 vssd1 sky130_ef_sc_hd__decap_40_12$1
XFILLER_0_817 vssd1 vccd1 vccd1 vssd1 sky130_fd_sc_hd__fill_2$1
XFILLER_102_745 vccd1 vssd1 vccd1 vssd1 sky130_fd_sc_hd__fill_1$1
XFILLER_59_125 vssd1 vccd1 vccd1 vssd1 sky130_ef_sc_hd__decap_40_12$1
XFILLER_0_839 vccd1 vssd1 vccd1 vssd1 sky130_fd_sc_hd__fill_1$1
XFILLER_75_629 vssd1 vccd1 vccd1 vssd1 sky130_ef_sc_hd__decap_40_12$1
XFILLER_59_169 vssd1 vccd1 vccd1 vssd1 sky130_ef_sc_hd__decap_40_12$1
XFILLER_101_277 vssd1 vccd1 vccd1 vssd1 sky130_fd_sc_hd__fill_2$1
XFILLER_74_139 vccd1 vssd1 vccd1 vssd1 sky130_fd_sc_hd__fill_1$1
XFILLER_28_501 vssd1 vccd1 vccd1 vssd1 sky130_ef_sc_hd__decap_40_12$1
XFILLER_74_27 vccd1 vssd1 vccd1 vssd1 sky130_fd_sc_hd__fill_1$1
XFILLER_28_545 vssd1 vccd1 vccd1 vssd1 sky130_ef_sc_hd__decap_40_12$1
XFILLER_70_301 vssd1 vccd1 vccd1 vssd1 sky130_fd_sc_hd__fill_4$1
XFILLER_15_217 vssd1 vccd1 vccd1 vssd1 sky130_fd_sc_hd__fill_4$1
XFILLER_28_589 vssd1 vccd1 vccd1 vssd1 sky130_ef_sc_hd__decap_40_12$1
XFILLER_70_345 vssd1 vccd1 vccd1 vssd1 sky130_ef_sc_hd__decap_40_12$1
XFILLER_43_559 vccd1 vssd1 vccd1 vssd1 sky130_fd_sc_hd__fill_1$1
XFILLER_130_77 vssd1 vccd1 vccd1 vssd1 sky130_fd_sc_hd__fill_4$1
XTAP_TAPCELL_ROW_104_1866 vccd1 vssd1 sky130_fd_sc_hd__tapvpwrvgnd_1$1
XTAP_TAPCELL_ROW_104_1855 vccd1 vssd1 sky130_fd_sc_hd__tapvpwrvgnd_1$1
XFILLER_90_15 vssd1 vccd1 vccd1 vssd1 sky130_ef_sc_hd__decap_40_12$1
XFILLER_30_209 vssd1 vccd1 vccd1 vssd1 sky130_ef_sc_hd__decap_40_12$1
XFILLER_70_389 vssd1 vccd1 vccd1 vssd1 sky130_ef_sc_hd__decap_40_12$1
XFILLER_51_570 vssd1 vccd1 vccd1 vssd1 sky130_ef_sc_hd__decap_40_12$1
XFILLER_23_261 vssd1 vccd1 vccd1 vssd1 sky130_ef_sc_hd__decap_40_12$1
XFILLER_135_3 vssd1 vccd1 vccd1 vssd1 sky130_ef_sc_hd__decap_40_12$1
XFILLER_11_445 vssd1 vccd1 vccd1 vssd1 sky130_fd_sc_hd__fill_2$1
XFILLER_7_405 vssd1 vccd1 vccd1 vssd1 sky130_ef_sc_hd__decap_40_12$1
XPHY_EDGE_ROW_137_Right_137 vccd1 vssd1 vccd1 vssd1 sky130_fd_sc_hd__decap_3$1
XTAP_TAPCELL_ROW_137_2354 vccd1 vssd1 sky130_fd_sc_hd__tapvpwrvgnd_1$1
XFILLER_7_449 vssd1 vccd1 vccd1 vssd1 sky130_ef_sc_hd__decap_40_12$1
XFILLER_137_664 vssd1 vccd1 vccd1 vssd1 sky130_fd_sc_hd__fill_8$1
XFILLER_136_141 vssd1 vccd1 vccd1 vssd1 sky130_ef_sc_hd__decap_40_12$1
XFILLER_125_804 vssd1 vccd1 vccd1 vssd1 sky130_fd_sc_hd__fill_4$1
XFILLER_109_333 vssd1 vccd1 vccd1 vssd1 sky130_fd_sc_hd__fill_2$1
XFILLER_136_185 vssd1 vccd1 vccd1 vssd1 sky130_fd_sc_hd__fill_8$1
XFILLER_99_57 vssd1 vccd1 vccd1 vssd1 sky130_ef_sc_hd__decap_40_12$1
XFILLER_2_121 vssd1 vccd1 vccd1 vssd1 sky130_ef_sc_hd__decap_40_12$1
XFILLER_112_509 vssd1 vccd1 vccd1 vssd1 sky130_ef_sc_hd__decap_40_12$1
XFILLER_105_561 vssd1 vccd1 vccd1 vssd1 sky130_fd_sc_hd__fill_4$1
XFILLER_2_165 vssd1 vccd1 vccd1 vssd1 sky130_ef_sc_hd__decap_40_12$1
XFILLER_66_618 vssd1 vccd1 vccd1 vssd1 sky130_ef_sc_hd__decap_40_12$1
XFILLER_38_309 vssd1 vccd1 vccd1 vssd1 sky130_ef_sc_hd__decap_40_12$1
XFILLER_19_501 vssd1 vccd1 vccd1 vssd1 sky130_fd_sc_hd__fill_2$1
XFILLER_48_83 vccd1 vssd1 vccd1 vssd1 sky130_fd_sc_hd__fill_1$1
XFILLER_74_640 vssd1 vccd1 vccd1 vssd1 sky130_fd_sc_hd__fill_4$1
XFILLER_0_35 vssd1 vccd1 vccd1 vssd1 sky130_ef_sc_hd__decap_40_12$1
XFILLER_80_109 vssd1 vccd1 vccd1 vssd1 sky130_ef_sc_hd__decap_40_12$1
XFILLER_73_161 vssd1 vccd1 vccd1 vssd1 sky130_fd_sc_hd__fill_4$1
XFILLER_62_813 vssd1 vccd1 vccd1 vssd1 sky130_fd_sc_hd__fill_8$1
XFILLER_0_57 vssd1 vccd1 vccd1 vssd1 sky130_ef_sc_hd__decap_40_12$1
XFILLER_61_389 vssd1 vccd1 vccd1 vssd1 sky130_fd_sc_hd__fill_2$1
XFILLER_42_570 vssd1 vccd1 vccd1 vssd1 sky130_ef_sc_hd__decap_40_12$1
XFILLER_9_55 vccd1 vssd1 vccd1 vssd1 sky130_fd_sc_hd__fill_1$1
XPHY_EDGE_ROW_104_Right_104 vccd1 vssd1 vccd1 vssd1 sky130_fd_sc_hd__decap_3$1
XFILLER_80_81 vssd1 vccd1 vccd1 vssd1 sky130_fd_sc_hd__fill_2$1
X_0822_ _1802_/A _0879_/A2 _0822_/X input3/X _0826_/B1 vccd1 vssd1 vccd1 vssd1 sky130_fd_sc_hd__a22o_1$1
XFILLER_116_804 vssd1 vccd1 vccd1 vssd1 sky130_fd_sc_hd__fill_2$1
XTAP_TAPCELL_ROW_12_473 vccd1 vssd1 sky130_fd_sc_hd__tapvpwrvgnd_1$1
XTAP_TAPCELL_ROW_12_484 vccd1 vssd1 sky130_fd_sc_hd__tapvpwrvgnd_1$1
X_0753_ hold8/X hold5/A hold17/X _0753_/X hold24/A vssd1 vccd1 vccd1 vssd1 sky130_fd_sc_hd__and4bb_4$1
XFILLER_128_675 vssd1 vccd1 vccd1 vssd1 sky130_ef_sc_hd__decap_40_12$1
XTAP_TAPCELL_ROW_77_1456 vccd1 vssd1 sky130_fd_sc_hd__tapvpwrvgnd_1$1
XFILLER_50_3 vssd1 vccd1 vccd1 vssd1 sky130_ef_sc_hd__decap_40_12$1
XFILLER_88_209 vssd1 vccd1 vccd1 vssd1 sky130_ef_sc_hd__decap_40_12$1
XFILLER_97_754 vssd1 vccd1 vccd1 vssd1 sky130_ef_sc_hd__decap_40_12$1
XFILLER_97_721 vssd1 vccd1 vccd1 vssd1 sky130_fd_sc_hd__fill_4$1
XTAP_TAPCELL_ROW_90_1656 vccd1 vssd1 sky130_fd_sc_hd__tapvpwrvgnd_1$1
XTAP_TAPCELL_ROW_90_1645 vccd1 vssd1 sky130_fd_sc_hd__tapvpwrvgnd_1$1
XFILLER_96_253 vssd1 vccd1 vccd1 vssd1 sky130_ef_sc_hd__decap_40_12$1
X_1305_ _1305_/C1 _1304_/X _1343_/A2 hold55/X _1681_/D vssd1 vccd1 vccd1 vssd1 sky130_fd_sc_hd__o211a_1$1
XFILLER_111_597 vssd1 vccd1 vccd1 vssd1 sky130_ef_sc_hd__decap_40_12$1
X_1236_ _1648_/Q _1236_/X _1276_/B vssd1 vccd1 vccd1 vssd1 sky130_fd_sc_hd__or2_1$1
XFILLER_56_139 vccd1 vssd1 vccd1 vssd1 sky130_fd_sc_hd__fill_1$1
XTAP_TAPCELL_ROW_121_2111 vccd1 vssd1 sky130_fd_sc_hd__tapvpwrvgnd_1$1
XFILLER_71_109 vssd1 vccd1 vccd1 vssd1 sky130_fd_sc_hd__fill_2$1
XFILLER_65_673 vssd1 vccd1 vccd1 vssd1 sky130_ef_sc_hd__decap_40_12$1
X_1167_ _1431_/C1 _1166_/X _1189_/A2 hold155/X _1614_/D vssd1 vccd1 vccd1 vssd1 sky130_fd_sc_hd__o211a_1$1
XFILLER_52_301 vssd1 vccd1 vccd1 vssd1 sky130_fd_sc_hd__fill_4$1
XTAP_TAPCELL_ROW_121_2122 vccd1 vssd1 sky130_fd_sc_hd__tapvpwrvgnd_1$1
XFILLER_80_643 vccd1 vssd1 vccd1 vssd1 sky130_fd_sc_hd__fill_1$1
XFILLER_25_559 vccd1 vssd1 vccd1 vssd1 sky130_fd_sc_hd__fill_1$1
XFILLER_52_345 vssd1 vccd1 vccd1 vssd1 sky130_ef_sc_hd__decap_40_12$1
XFILLER_12_209 vssd1 vccd1 vccd1 vssd1 sky130_ef_sc_hd__decap_40_12$1
X_1098_ _1799_/A _1098_/X _1122_/B vssd1 vccd1 vccd1 vssd1 sky130_fd_sc_hd__or2_1$1
XFILLER_52_389 vssd1 vccd1 vccd1 vssd1 sky130_ef_sc_hd__decap_40_12$1
XFILLER_21_721 vssd1 vccd1 vccd1 vssd1 sky130_fd_sc_hd__fill_4$1
XFILLER_40_529 vssd1 vccd1 vccd1 vssd1 sky130_fd_sc_hd__fill_2$1
XFILLER_138_417 vssd1 vccd1 vccd1 vssd1 sky130_fd_sc_hd__fill_2$1
XFILLER_21_765 vssd1 vccd1 vccd1 vssd1 sky130_ef_sc_hd__decap_40_12$1
XFILLER_60_29 vssd1 vccd1 vccd1 vssd1 sky130_ef_sc_hd__decap_40_12$1
XFILLER_20_253 vssd1 vccd1 vccd1 vssd1 sky130_ef_sc_hd__decap_40_12$1
XTAP_TAPCELL_ROW_31_760 vccd1 vssd1 sky130_fd_sc_hd__tapvpwrvgnd_1$1
XTAP_TAPCELL_ROW_31_771 vccd1 vssd1 sky130_fd_sc_hd__tapvpwrvgnd_1$1
XFILLER_119_653 vssd1 vccd1 vccd1 vssd1 sky130_ef_sc_hd__decap_40_12$1
XTAP_TAPCELL_ROW_119_2084 vccd1 vssd1 sky130_fd_sc_hd__tapvpwrvgnd_1$1
XFILLER_118_141 vssd1 vccd1 vccd1 vssd1 sky130_ef_sc_hd__decap_40_12$1
XFILLER_119_675 vccd1 vssd1 vccd1 vssd1 sky130_fd_sc_hd__fill_1$1
XFILLER_4_419 vccd1 vssd1 vccd1 vssd1 sky130_fd_sc_hd__fill_1$1
XFILLER_134_667 vccd1 vssd1 vccd1 vssd1 sky130_fd_sc_hd__fill_1$1
XFILLER_133_111 vccd1 vssd1 vccd1 vssd1 sky130_fd_sc_hd__fill_1$1
XTAP_TAPCELL_ROW_132_2273 vccd1 vssd1 sky130_fd_sc_hd__tapvpwrvgnd_1$1
XFILLER_69_27 vssd1 vccd1 vccd1 vssd1 sky130_ef_sc_hd__decap_40_12$1
XTAP_TAPCELL_ROW_132_2284 vccd1 vssd1 sky130_fd_sc_hd__tapvpwrvgnd_1$1
XFILLER_121_317 vssd1 vccd1 vccd1 vssd1 sky130_ef_sc_hd__decap_40_12$1
XFILLER_102_531 vccd1 vssd1 vccd1 vssd1 sky130_fd_sc_hd__fill_1$1
XFILLER_125_55 vccd1 vssd1 vccd1 vssd1 sky130_fd_sc_hd__fill_1$1
XFILLER_85_15 vssd1 vccd1 vccd1 vssd1 sky130_ef_sc_hd__decap_40_12$1
XFILLER_0_669 vssd1 vccd1 vccd1 vssd1 sky130_fd_sc_hd__fill_2$1
XFILLER_18_53 vssd1 vccd1 vccd1 vssd1 sky130_ef_sc_hd__decap_40_12$1
XFILLER_62_109 vssd1 vccd1 vccd1 vssd1 sky130_ef_sc_hd__decap_40_12$1
XFILLER_55_161 vssd1 vccd1 vccd1 vssd1 sky130_fd_sc_hd__fill_4$1
XFILLER_44_813 vssd1 vccd1 vccd1 vssd1 sky130_ef_sc_hd__decap_40_12$1
XTAP_TAPCELL_ROW_48_1013 vccd1 vssd1 sky130_fd_sc_hd__tapvpwrvgnd_1$1
XFILLER_83_481 vssd1 vccd1 vccd1 vssd1 sky130_fd_sc_hd__fill_2$1
XFILLER_71_621 vccd1 vssd1 vccd1 vssd1 sky130_fd_sc_hd__fill_1$1
XFILLER_18_97 vssd1 vccd1 vccd1 vssd1 sky130_ef_sc_hd__decap_40_12$1
XTAP_TAPCELL_ROW_39_882 vccd1 vssd1 sky130_fd_sc_hd__tapvpwrvgnd_1$1
XTAP_TAPCELL_ROW_48_1024 vccd1 vssd1 sky130_fd_sc_hd__tapvpwrvgnd_1$1
XFILLER_70_153 vssd1 vccd1 vccd1 vssd1 sky130_ef_sc_hd__decap_40_12$1
XTAP_TAPCELL_ROW_61_1213 vccd1 vssd1 sky130_fd_sc_hd__tapvpwrvgnd_1$1
XFILLER_24_581 vssd1 vccd1 vccd1 vssd1 sky130_fd_sc_hd__fill_4$1
XFILLER_31_529 vssd1 vccd1 vccd1 vssd1 sky130_ef_sc_hd__decap_40_12$1
XFILLER_34_41 vssd1 vccd1 vccd1 vssd1 sky130_ef_sc_hd__decap_40_12$1
XFILLER_43_389 vssd1 vccd1 vccd1 vssd1 sky130_fd_sc_hd__fill_2$1
XFILLER_129_417 vssd1 vccd1 vccd1 vssd1 sky130_fd_sc_hd__fill_4$1
XFILLER_70_197 vssd1 vccd1 vccd1 vssd1 sky130_ef_sc_hd__decap_40_12$1
XFILLER_34_85 vssd1 vccd1 vccd1 vssd1 sky130_ef_sc_hd__decap_40_12$1
XFILLER_8_725 vssd1 vccd1 vccd1 vssd1 sky130_ef_sc_hd__decap_40_12$1
XFILLER_8_769 vssd1 vccd1 vccd1 vssd1 sky130_ef_sc_hd__decap_40_12$1
XFILLER_7_279 vccd1 vssd1 vccd1 vssd1 sky130_fd_sc_hd__fill_1$1
XFILLER_124_133 vssd1 vccd1 vccd1 vssd1 sky130_fd_sc_hd__fill_4$1
XFILLER_98_529 vssd1 vccd1 vccd1 vssd1 sky130_fd_sc_hd__fill_2$1
XTAP_TAPCELL_ROW_59_1186 vccd1 vssd1 sky130_fd_sc_hd__tapvpwrvgnd_1$1
XFILLER_3_441 vssd1 vccd1 vccd1 vssd1 sky130_fd_sc_hd__fill_4$1
XFILLER_124_177 vssd1 vccd1 vccd1 vssd1 sky130_ef_sc_hd__decap_40_12$1
XFILLER_3_485 vssd1 vccd1 vccd1 vssd1 sky130_ef_sc_hd__decap_40_12$1
XFILLER_78_253 vssd1 vccd1 vccd1 vssd1 sky130_ef_sc_hd__decap_40_12$1
XTAP_TAPCELL_ROW_72_1386 vccd1 vssd1 sky130_fd_sc_hd__tapvpwrvgnd_1$1
XTAP_TAPCELL_ROW_72_1375 vccd1 vssd1 sky130_fd_sc_hd__tapvpwrvgnd_1$1
XFILLER_59_93 vssd1 vccd1 vccd1 vssd1 sky130_ef_sc_hd__decap_40_12$1
XFILLER_120_361 vssd1 vccd1 vccd1 vssd1 sky130_fd_sc_hd__fill_2$1
XFILLER_94_713 vssd1 vccd1 vccd1 vssd1 sky130_ef_sc_hd__decap_40_12$1
XFILLER_94_757 vssd1 vccd1 vccd1 vssd1 sky130_ef_sc_hd__decap_40_12$1
XFILLER_93_223 vccd1 vssd1 vccd1 vssd1 sky130_fd_sc_hd__fill_1$1
XFILLER_38_139 vccd1 vssd1 vccd1 vssd1 sky130_fd_sc_hd__fill_1$1
XFILLER_75_81 vssd1 vccd1 vccd1 vssd1 sky130_ef_sc_hd__decap_40_12$1
XFILLER_53_109 vssd1 vccd1 vccd1 vssd1 sky130_fd_sc_hd__fill_2$1
X_1021_ _1091_/C1 _1020_/X _1053_/A2 hold71/X _1543_/D vssd1 vccd1 vccd1 vssd1 sky130_fd_sc_hd__o211a_1$1
XFILLER_47_673 vssd1 vccd1 vccd1 vssd1 sky130_ef_sc_hd__decap_40_12$1
XFILLER_62_643 vccd1 vssd1 vccd1 vssd1 sky130_fd_sc_hd__fill_1$1
XFILLER_34_301 vssd1 vccd1 vccd1 vssd1 sky130_fd_sc_hd__fill_4$1
XTAP_TAPCELL_ROW_17_554 vccd1 vssd1 sky130_fd_sc_hd__tapvpwrvgnd_1$1
XFILLER_34_345 vssd1 vccd1 vccd1 vssd1 sky130_ef_sc_hd__decap_40_12$1
XFILLER_98_3 vssd1 vccd1 vccd1 vssd1 sky130_ef_sc_hd__decap_40_12$1
XFILLER_22_529 vssd1 vccd1 vccd1 vssd1 sky130_fd_sc_hd__fill_2$1
XFILLER_34_389 vssd1 vccd1 vccd1 vssd1 sky130_ef_sc_hd__decap_40_12$1
X_1854_ vccd1 vssd1 _1854_/X _1854_/A vccd1 vssd1 sky130_fd_sc_hd__buf_2$1
XFILLER_116_601 vssd1 vccd1 vccd1 vssd1 sky130_fd_sc_hd__fill_4$1
X_1785_ _1785_/A _1785_/X vssd1 vccd1 vccd1 vssd1 sky130_fd_sc_hd__clkbuf_2$1
X_0805_ _1817_/A _0878_/A2 _0805_/X _1517_/Q _0875_/A2 vccd1 vssd1 vccd1 vssd1 sky130_fd_sc_hd__a22o_1$1
XFILLER_115_111 vccd1 vssd1 vccd1 vssd1 sky130_fd_sc_hd__fill_1$1
XFILLER_131_615 vccd1 vssd1 vccd1 vssd1 sky130_fd_sc_hd__fill_1$1
XFILLER_116_678 vssd1 vccd1 vccd1 vssd1 sky130_ef_sc_hd__decap_40_12$1
XFILLER_89_529 vssd1 vccd1 vccd1 vssd1 sky130_ef_sc_hd__decap_40_12$1
XFILLER_103_317 vssd1 vccd1 vccd1 vssd1 sky130_ef_sc_hd__decap_40_12$1
XFILLER_111_361 vssd1 vccd1 vccd1 vssd1 sky130_fd_sc_hd__fill_8$1
XFILLER_57_426 vssd1 vccd1 vccd1 vssd1 sky130_ef_sc_hd__decap_40_12$1
XFILLER_84_245 vssd1 vccd1 vccd1 vssd1 sky130_fd_sc_hd__fill_4$1
XFILLER_84_289 vssd1 vccd1 vccd1 vssd1 sky130_ef_sc_hd__decap_40_12$1
X_1219_ _1435_/C1 _1218_/X _1273_/A2 hold71/X _1639_/D vssd1 vccd1 vccd1 vssd1 sky130_fd_sc_hd__o211a_1$1
XFILLER_26_813 vssd1 vccd1 vccd1 vssd1 sky130_fd_sc_hd__fill_8$1
XFILLER_44_109 vssd1 vccd1 vccd1 vssd1 sky130_ef_sc_hd__decap_40_12$1
XFILLER_65_481 vssd1 vccd1 vccd1 vssd1 sky130_fd_sc_hd__fill_2$1
XFILLER_37_161 vssd1 vccd1 vccd1 vssd1 sky130_fd_sc_hd__fill_4$1
XFILLER_52_153 vssd1 vccd1 vccd1 vssd1 sky130_ef_sc_hd__decap_40_12$1
XTAP_TAPCELL_ROW_36_841 vccd1 vssd1 sky130_fd_sc_hd__tapvpwrvgnd_1$1
XFILLER_111_57 vssd1 vccd1 vccd1 vssd1 sky130_ef_sc_hd__decap_40_12$1
XTAP_TAPCELL_ROW_101_1814 vccd1 vssd1 sky130_fd_sc_hd__tapvpwrvgnd_1$1
XFILLER_13_529 vssd1 vccd1 vccd1 vssd1 sky130_ef_sc_hd__decap_40_12$1
XFILLER_25_389 vssd1 vccd1 vccd1 vssd1 sky130_fd_sc_hd__fill_2$1
XFILLER_71_39 vssd1 vccd1 vccd1 vssd1 sky130_ef_sc_hd__decap_40_12$1
XFILLER_52_197 vssd1 vccd1 vccd1 vssd1 sky130_ef_sc_hd__decap_40_12$1
XFILLER_21_573 vssd1 vccd1 vccd1 vssd1 sky130_ef_sc_hd__decap_40_12$1
XTAP_TAPCELL_ROW_134_2313 vccd1 vssd1 sky130_fd_sc_hd__tapvpwrvgnd_1$1
XFILLER_119_461 vssd1 vccd1 vccd1 vssd1 sky130_fd_sc_hd__fill_2$1
XFILLER_106_133 vssd1 vccd1 vccd1 vssd1 sky130_fd_sc_hd__fill_4$1
XFILLER_4_249 vssd1 vccd1 vccd1 vssd1 sky130_fd_sc_hd__fill_2$1
XFILLER_20_65 vssd1 vccd1 vccd1 vssd1 sky130_ef_sc_hd__decap_40_12$1
XFILLER_136_65 vssd1 vccd1 vccd1 vssd1 sky130_ef_sc_hd__decap_40_12$1
XFILLER_122_637 vssd1 vccd1 vccd1 vssd1 sky130_fd_sc_hd__fill_4$1
XFILLER_121_125 vssd1 vccd1 vccd1 vssd1 sky130_ef_sc_hd__decap_40_12$1
XFILLER_106_177 vssd1 vccd1 vccd1 vssd1 sky130_ef_sc_hd__decap_40_12$1
XTAP_TAPCELL_ROW_112_1987 vccd1 vssd1 sky130_fd_sc_hd__tapvpwrvgnd_1$1
XTAP_TAPCELL_ROW_112_1976 vccd1 vssd1 sky130_fd_sc_hd__tapvpwrvgnd_1$1
XFILLER_88_562 vssd1 vccd1 vccd1 vssd1 sky130_fd_sc_hd__fill_4$1
XFILLER_130_681 vssd1 vccd1 vccd1 vssd1 sky130_fd_sc_hd__fill_8$1
XFILLER_121_169 vssd1 vccd1 vccd1 vssd1 sky130_ef_sc_hd__decap_40_12$1
Xhold30 hold30/X vccd1 vssd1 hold30/A vccd1 vssd1 sky130_fd_sc_hd__buf_4$1
Xhold41 hold41/A hold41/X vssd1 vccd1 vccd1 vssd1 sky130_fd_sc_hd__dlygate4sd3_1$1
XFILLER_102_361 vssd1 vccd1 vccd1 vssd1 sky130_fd_sc_hd__fill_2$1
XFILLER_76_713 vssd1 vccd1 vccd1 vssd1 sky130_ef_sc_hd__decap_40_12$1
XFILLER_0_477 vssd1 vccd1 vccd1 vssd1 sky130_ef_sc_hd__decap_40_12$1
Xhold63 wbs_dat_i[30] hold63/X vssd1 vccd1 vccd1 vssd1 sky130_fd_sc_hd__dlygate4sd3_1$1
Xhold52 hold52/A hold52/X vssd1 vccd1 vccd1 vssd1 sky130_fd_sc_hd__dlygate4sd3_1$1
Xhold74 hold74/A hold74/X vssd1 vccd1 vccd1 vssd1 sky130_fd_sc_hd__dlygate4sd3_1$1
XFILLER_76_757 vssd1 vccd1 vccd1 vssd1 sky130_ef_sc_hd__decap_40_12$1
XFILLER_75_223 vccd1 vssd1 vccd1 vssd1 sky130_fd_sc_hd__fill_1$1
XFILLER_48_459 vssd1 vccd1 vccd1 vssd1 sky130_fd_sc_hd__fill_8$1
Xhold85 wbs_dat_i[24] hold85/X vssd1 vccd1 vccd1 vssd1 sky130_fd_sc_hd__dlygate4sd3_1$1
Xhold96 hold96/A hold96/X vssd1 vccd1 vccd1 vssd1 sky130_fd_sc_hd__dlygate4sd3_1$1
XFILLER_29_673 vssd1 vccd1 vccd1 vssd1 sky130_ef_sc_hd__decap_40_12$1
XFILLER_35_109 vssd1 vccd1 vccd1 vssd1 sky130_fd_sc_hd__fill_2$1
XFILLER_16_301 vssd1 vccd1 vccd1 vssd1 sky130_fd_sc_hd__fill_4$1
XFILLER_16_345 vssd1 vccd1 vccd1 vssd1 sky130_ef_sc_hd__decap_40_12$1
XFILLER_44_643 vccd1 vssd1 vccd1 vssd1 sky130_fd_sc_hd__fill_1$1
XFILLER_45_51 vssd1 vccd1 vccd1 vssd1 sky130_fd_sc_hd__fill_4$1
XTAP_TAPCELL_ROW_14_513 vccd1 vssd1 sky130_fd_sc_hd__tapvpwrvgnd_1$1
XFILLER_16_389 vssd1 vccd1 vccd1 vssd1 sky130_ef_sc_hd__decap_40_12$1
XFILLER_44_698 vssd1 vccd1 vccd1 vssd1 sky130_fd_sc_hd__fill_2$1
XFILLER_31_337 vssd1 vccd1 vccd1 vssd1 sky130_ef_sc_hd__decap_40_12$1
XFILLER_129_225 vssd1 vccd1 vccd1 vssd1 sky130_ef_sc_hd__decap_40_12$1
Xclkbuf_leaf_14_wb_clk_i _1729_/CLK clkbuf_2_3__f_wb_clk_i/X vssd1 vccd1 vccd1 vssd1
+ sky130_fd_sc_hd__clkbuf_8$1
XFILLER_8_533 vssd1 vccd1 vccd1 vssd1 sky130_ef_sc_hd__decap_40_12$1
X_1570_ _1570_/Q _1762_/CLK _1570_/D vccd1 vssd1 vccd1 vssd1 sky130_fd_sc_hd__dfxtp_1$1
XTAP_TAPCELL_ROW_74_1404 vccd1 vssd1 sky130_fd_sc_hd__tapvpwrvgnd_1$1
XANTENNA_5 input6/X vssd1 vccd1 vccd1 vssd1 sky130_fd_sc_hd__diode_2$1
XFILLER_113_615 vccd1 vssd1 vccd1 vssd1 sky130_fd_sc_hd__fill_1$1
XFILLER_99_805 vssd1 vccd1 vccd1 vssd1 sky130_fd_sc_hd__fill_2$1
XTAP_TAPCELL_ROW_74_1415 vccd1 vssd1 sky130_fd_sc_hd__tapvpwrvgnd_1$1
XFILLER_113_637 vssd1 vccd1 vccd1 vssd1 sky130_ef_sc_hd__decap_40_12$1
XFILLER_3_293 vssd1 vccd1 vccd1 vssd1 sky130_ef_sc_hd__decap_40_12$1
XFILLER_100_309 vssd1 vccd1 vccd1 vssd1 sky130_ef_sc_hd__decap_40_12$1
XFILLER_79_573 vssd1 vccd1 vccd1 vssd1 sky130_ef_sc_hd__decap_40_12$1
XFILLER_67_724 vssd1 vccd1 vccd1 vssd1 sky130_fd_sc_hd__fill_4$1
XFILLER_94_521 vccd1 vssd1 vccd1 vssd1 sky130_fd_sc_hd__fill_1$1
XFILLER_66_245 vssd1 vccd1 vccd1 vssd1 sky130_fd_sc_hd__fill_4$1
XFILLER_13_3 vssd1 vccd1 vccd1 vssd1 sky130_ef_sc_hd__decap_40_12$1
XFILLER_94_587 vccd1 vssd1 vccd1 vssd1 sky130_fd_sc_hd__fill_1$1
XFILLER_82_705 vccd1 vssd1 vccd1 vssd1 sky130_fd_sc_hd__fill_1$1
XFILLER_54_407 vssd1 vccd1 vccd1 vssd1 sky130_ef_sc_hd__decap_40_12$1
XFILLER_26_109 vssd1 vccd1 vccd1 vssd1 sky130_ef_sc_hd__decap_40_12$1
XFILLER_82_738 vssd1 vccd1 vccd1 vssd1 sky130_ef_sc_hd__decap_40_12$1
XFILLER_81_237 vssd1 vccd1 vccd1 vssd1 sky130_ef_sc_hd__decap_40_12$1
XFILLER_66_289 vssd1 vccd1 vccd1 vssd1 sky130_ef_sc_hd__decap_40_12$1
XFILLER_54_429 vssd1 vccd1 vccd1 vssd1 sky130_fd_sc_hd__fill_2$1
XFILLER_19_161 vssd1 vccd1 vccd1 vssd1 sky130_fd_sc_hd__fill_4$1
X_1004_ _1004_/A _1004_/X _1012_/B vssd1 vccd1 vccd1 vssd1 sky130_fd_sc_hd__or2_1$1
XFILLER_35_643 vssd1 vccd1 vccd1 vssd1 sky130_ef_sc_hd__decap_40_12$1
XFILLER_90_793 vssd1 vccd1 vccd1 vssd1 sky130_ef_sc_hd__decap_40_12$1
XTAP_TAPCELL_ROW_85_1577 vccd1 vssd1 sky130_fd_sc_hd__tapvpwrvgnd_1$1
XFILLER_62_473 vssd1 vccd1 vccd1 vssd1 sky130_fd_sc_hd__fill_2$1
XFILLER_50_613 vssd1 vccd1 vccd1 vssd1 sky130_fd_sc_hd__fill_8$1
XFILLER_34_153 vssd1 vccd1 vccd1 vssd1 sky130_ef_sc_hd__decap_40_12$1
XTAP_TAPCELL_ROW_33_800 vccd1 vssd1 sky130_fd_sc_hd__tapvpwrvgnd_1$1
XFILLER_35_698 vssd1 vccd1 vccd1 vssd1 sky130_fd_sc_hd__fill_2$1
XFILLER_50_657 vssd1 vccd1 vccd1 vssd1 sky130_fd_sc_hd__fill_4$1
XFILLER_34_197 vssd1 vccd1 vccd1 vssd1 sky130_ef_sc_hd__decap_40_12$1
XFILLER_135_217 vssd1 vccd1 vccd1 vssd1 sky130_fd_sc_hd__fill_4$1
XFILLER_129_781 vssd1 vccd1 vccd1 vssd1 sky130_fd_sc_hd__fill_2$1
XTAP_TAPCELL_ROW_116_2043 vccd1 vssd1 sky130_fd_sc_hd__tapvpwrvgnd_1$1
X_1837_ _1837_/A _1837_/X vssd1 vccd1 vccd1 vssd1 sky130_fd_sc_hd__clkbuf_2$1
X_1699_ hold76/A _1763_/CLK _1699_/D vccd1 vssd1 vccd1 vssd1 sky130_fd_sc_hd__dfxtp_1$1
XFILLER_104_637 vssd1 vccd1 vccd1 vssd1 sky130_fd_sc_hd__fill_4$1
XFILLER_89_337 vssd1 vccd1 vccd1 vssd1 sky130_ef_sc_hd__decap_40_12$1
XFILLER_131_445 vssd1 vccd1 vccd1 vssd1 sky130_fd_sc_hd__fill_2$1
XFILLER_103_125 vssd1 vccd1 vccd1 vssd1 sky130_ef_sc_hd__decap_40_12$1
XFILLER_112_681 vccd1 vssd1 vccd1 vssd1 sky130_fd_sc_hd__fill_1$1
XFILLER_103_169 vssd1 vccd1 vccd1 vssd1 sky130_ef_sc_hd__decap_40_12$1
XFILLER_57_223 vccd1 vssd1 vccd1 vssd1 sky130_fd_sc_hd__fill_1$1
XFILLER_73_727 vccd1 vssd1 vccd1 vssd1 sky130_fd_sc_hd__fill_1$1
XFILLER_17_109 vssd1 vccd1 vccd1 vssd1 sky130_fd_sc_hd__fill_2$1
XFILLER_45_429 vssd1 vccd1 vccd1 vssd1 sky130_ef_sc_hd__decap_40_12$1
XFILLER_82_27 vccd1 vssd1 vccd1 vssd1 sky130_fd_sc_hd__fill_1$1
XFILLER_14_805 vssd1 vccd1 vccd1 vssd1 sky130_fd_sc_hd__fill_4$1
XFILLER_26_643 vccd1 vssd1 vccd1 vssd1 sky130_fd_sc_hd__fill_1$1
XFILLER_53_473 vssd1 vccd1 vccd1 vssd1 sky130_fd_sc_hd__fill_8$1
XTAP_TAPCELL_ROW_0_285 vccd1 vssd1 sky130_fd_sc_hd__tapvpwrvgnd_1$1
XTAP_TAPCELL_ROW_0_296 vccd1 vssd1 sky130_fd_sc_hd__tapvpwrvgnd_1$1
XFILLER_13_337 vssd1 vccd1 vccd1 vssd1 sky130_ef_sc_hd__decap_40_12$1
XFILLER_40_189 vssd1 vccd1 vccd1 vssd1 sky130_fd_sc_hd__fill_4$1
XFILLER_127_729 vssd1 vccd1 vccd1 vssd1 sky130_fd_sc_hd__fill_8$1
XFILLER_5_503 vccd1 vssd1 vccd1 vssd1 sky130_fd_sc_hd__fill_1$1
XFILLER_107_453 vccd1 vssd1 vccd1 vssd1 sky130_fd_sc_hd__fill_1$1
XFILLER_107_464 vssd1 vccd1 vccd1 vssd1 sky130_ef_sc_hd__decap_40_12$1
XTAP_TAPCELL_ROW_56_1145 vccd1 vssd1 sky130_fd_sc_hd__tapvpwrvgnd_1$1
XTAP_TAPCELL_ROW_56_1134 vccd1 vssd1 sky130_fd_sc_hd__tapvpwrvgnd_1$1
Xoutput75 _1855_/X analog_ctrl[122] vssd1 vccd1 vccd1 vssd1 sky130_fd_sc_hd__buf_12$1
Xoutput64 _1845_/X analog_ctrl[112] vssd1 vccd1 vccd1 vssd1 sky130_fd_sc_hd__buf_12$1
XFILLER_1_753 vssd1 vccd1 vccd1 vssd1 sky130_ef_sc_hd__decap_40_12$1
XFILLER_95_329 vssd1 vccd1 vccd1 vssd1 sky130_fd_sc_hd__fill_4$1
XFILLER_0_241 vssd1 vccd1 vccd1 vssd1 sky130_fd_sc_hd__fill_8$1
Xoutput86 _1792_/X analog_ctrl[21] vssd1 vccd1 vccd1 vssd1 sky130_fd_sc_hd__buf_12$1
Xoutput97 _1802_/X analog_ctrl[31] vssd1 vccd1 vccd1 vssd1 sky130_fd_sc_hd__buf_12$1
XFILLER_49_757 vssd1 vccd1 vccd1 vssd1 sky130_fd_sc_hd__fill_2$1
XFILLER_1_797 vssd1 vccd1 vccd1 vssd1 sky130_ef_sc_hd__decap_40_12$1
XFILLER_49_779 vssd1 vccd1 vccd1 vssd1 sky130_fd_sc_hd__fill_4$1
XFILLER_48_245 vssd1 vccd1 vccd1 vssd1 sky130_fd_sc_hd__fill_4$1
XFILLER_64_749 vssd1 vccd1 vccd1 vssd1 sky130_fd_sc_hd__fill_4$1
XFILLER_63_237 vssd1 vccd1 vccd1 vssd1 sky130_ef_sc_hd__decap_40_12$1
XFILLER_56_83 vccd1 vssd1 vccd1 vssd1 sky130_fd_sc_hd__fill_1$1
XFILLER_48_289 vssd1 vccd1 vccd1 vssd1 sky130_ef_sc_hd__decap_40_12$1
XFILLER_91_557 vssd1 vccd1 vccd1 vssd1 sky130_fd_sc_hd__fill_2$1
XFILLER_17_665 vssd1 vccd1 vccd1 vssd1 sky130_fd_sc_hd__fill_4$1
XFILLER_16_153 vssd1 vccd1 vccd1 vssd1 sky130_ef_sc_hd__decap_40_12$1
XFILLER_32_613 vssd1 vccd1 vccd1 vssd1 sky130_ef_sc_hd__decap_40_12$1
XFILLER_44_473 vssd1 vccd1 vccd1 vssd1 sky130_fd_sc_hd__fill_2$1
XFILLER_71_281 vssd1 vccd1 vccd1 vssd1 sky130_ef_sc_hd__decap_40_12$1
XFILLER_16_197 vssd1 vccd1 vccd1 vssd1 sky130_ef_sc_hd__decap_40_12$1
XFILLER_32_635 vccd1 vssd1 vccd1 vssd1 sky130_fd_sc_hd__fill_1$1
XFILLER_31_167 vccd1 vssd1 vccd1 vssd1 sky130_fd_sc_hd__fill_1$1
XTAP_TAPCELL_ROW_80_1496 vccd1 vssd1 sky130_fd_sc_hd__tapvpwrvgnd_1$1
XFILLER_117_217 vssd1 vccd1 vccd1 vssd1 sky130_fd_sc_hd__fill_4$1
XFILLER_8_363 vccd1 vssd1 vccd1 vssd1 sky130_fd_sc_hd__fill_1$1
X_1622_ _1622_/Q _1753_/CLK hold47/X vccd1 vssd1 vccd1 vssd1 sky130_fd_sc_hd__dfxtp_1$1
XFILLER_132_209 vssd1 vccd1 vccd1 vssd1 sky130_ef_sc_hd__decap_40_12$1
XFILLER_125_261 vssd1 vccd1 vccd1 vssd1 sky130_ef_sc_hd__decap_40_12$1
XFILLER_113_401 vssd1 vccd1 vccd1 vssd1 sky130_ef_sc_hd__decap_40_12$1
X_1553_ _1553_/Q _1754_/CLK hold56/X vccd1 vssd1 vccd1 vssd1 sky130_fd_sc_hd__dfxtp_1$1
XFILLER_113_445 vssd1 vccd1 vccd1 vssd1 sky130_fd_sc_hd__fill_2$1
X_1484_ _1484_/D clkload8/A _1484_/Q vssd1 vccd1 vccd1 vssd1 sky130_fd_sc_hd__dfxtp_4$1
XFILLER_101_629 vssd1 vccd1 vccd1 vssd1 sky130_fd_sc_hd__fill_2$1
XFILLER_98_189 vssd1 vccd1 vccd1 vssd1 sky130_fd_sc_hd__fill_4$1
XFILLER_86_307 vccd1 vssd1 vccd1 vssd1 sky130_fd_sc_hd__fill_1$1
XFILLER_100_139 vccd1 vssd1 vccd1 vssd1 sky130_fd_sc_hd__fill_1$1
XFILLER_95_841 vccd1 vssd1 vccd1 vssd1 sky130_fd_sc_hd__fill_1$1
XFILLER_39_223 vccd1 vssd1 vccd1 vssd1 sky130_fd_sc_hd__fill_1$1
XTAP_TAPCELL_ROW_87_1606 vccd1 vssd1 sky130_fd_sc_hd__tapvpwrvgnd_1$1
XFILLER_94_395 vccd1 vssd1 vccd1 vssd1 sky130_fd_sc_hd__fill_1$1
XFILLER_82_524 vssd1 vccd1 vccd1 vssd1 sky130_fd_sc_hd__fill_8$1
XFILLER_55_727 vccd1 vssd1 vccd1 vssd1 sky130_fd_sc_hd__fill_1$1
XFILLER_27_429 vssd1 vccd1 vccd1 vssd1 sky130_ef_sc_hd__decap_40_12$1
XFILLER_23_613 vssd1 vccd1 vccd1 vssd1 sky130_fd_sc_hd__fill_2$1
XFILLER_35_473 vssd1 vccd1 vccd1 vssd1 sky130_ef_sc_hd__decap_40_12$1
XFILLER_50_421 vssd1 vccd1 vccd1 vssd1 sky130_ef_sc_hd__decap_40_12$1
XTAP_TAPCELL_ROW_46_991 vccd1 vssd1 sky130_fd_sc_hd__tapvpwrvgnd_1$1
XFILLER_10_307 vccd1 vssd1 vccd1 vssd1 sky130_fd_sc_hd__fill_1$1
XFILLER_50_487 vccd1 vssd1 vccd1 vssd1 sky130_fd_sc_hd__fill_1$1
XFILLER_22_189 vssd1 vccd1 vccd1 vssd1 sky130_fd_sc_hd__fill_4$1
XFILLER_109_729 vssd1 vccd1 vccd1 vssd1 sky130_ef_sc_hd__decap_40_12$1
XTAP_TAPCELL_ROW_98_1768 vccd1 vssd1 sky130_fd_sc_hd__tapvpwrvgnd_1$1
XFILLER_104_445 vssd1 vccd1 vccd1 vssd1 sky130_ef_sc_hd__decap_40_12$1
XFILLER_77_27 vssd1 vccd1 vccd1 vssd1 sky130_ef_sc_hd__decap_40_12$1
XFILLER_89_167 vccd1 vssd1 vccd1 vssd1 sky130_fd_sc_hd__fill_1$1
XFILLER_77_329 vssd1 vccd1 vccd1 vssd1 sky130_fd_sc_hd__fill_4$1
XTAP_TAPCELL_ROW_129_2234 vccd1 vssd1 sky130_fd_sc_hd__tapvpwrvgnd_1$1
XFILLER_133_55 vccd1 vssd1 vccd1 vssd1 sky130_fd_sc_hd__fill_1$1
XFILLER_100_662 vssd1 vccd1 vccd1 vssd1 sky130_fd_sc_hd__fill_8$1
XFILLER_93_15 vssd1 vccd1 vccd1 vssd1 sky130_ef_sc_hd__decap_40_12$1
XFILLER_58_565 vssd1 vccd1 vccd1 vssd1 sky130_ef_sc_hd__decap_40_12$1
XTAP_TAPCELL_ROW_51_1064 vccd1 vssd1 sky130_fd_sc_hd__tapvpwrvgnd_1$1
XTAP_TAPCELL_ROW_5_377 vccd1 vssd1 sky130_fd_sc_hd__tapvpwrvgnd_1$1
XFILLER_85_373 vssd1 vccd1 vccd1 vssd1 sky130_ef_sc_hd__decap_40_12$1
XFILLER_73_513 vccd1 vssd1 vccd1 vssd1 sky130_fd_sc_hd__fill_1$1
XFILLER_58_587 vccd1 vssd1 vccd1 vssd1 sky130_fd_sc_hd__fill_1$1
XFILLER_45_237 vssd1 vccd1 vccd1 vssd1 sky130_ef_sc_hd__decap_40_12$1
XFILLER_14_613 vssd1 vccd1 vccd1 vssd1 sky130_ef_sc_hd__decap_40_12$1
XFILLER_26_53 vssd1 vccd1 vccd1 vssd1 sky130_ef_sc_hd__decap_40_12$1
XFILLER_26_473 vssd1 vccd1 vccd1 vssd1 sky130_fd_sc_hd__fill_2$1
XFILLER_54_793 vssd1 vccd1 vccd1 vssd1 sky130_fd_sc_hd__fill_4$1
XFILLER_53_281 vssd1 vccd1 vccd1 vssd1 sky130_ef_sc_hd__decap_40_12$1
XFILLER_14_657 vssd1 vccd1 vccd1 vssd1 sky130_ef_sc_hd__decap_40_12$1
XFILLER_26_97 vssd1 vccd1 vccd1 vssd1 sky130_ef_sc_hd__decap_40_12$1
XFILLER_9_105 vssd1 vccd1 vccd1 vssd1 sky130_fd_sc_hd__fill_4$1
XFILLER_13_167 vccd1 vssd1 vccd1 vssd1 sky130_fd_sc_hd__fill_1$1
XTAP_TAPCELL_ROW_24_663 vccd1 vssd1 sky130_fd_sc_hd__tapvpwrvgnd_1$1
XFILLER_9_149 vssd1 vccd1 vccd1 vssd1 sky130_ef_sc_hd__decap_40_12$1
XFILLER_42_41 vssd1 vccd1 vccd1 vssd1 sky130_ef_sc_hd__decap_40_12$1
XFILLER_42_85 vssd1 vccd1 vccd1 vssd1 sky130_ef_sc_hd__decap_40_12$1
XFILLER_127_559 vccd1 vssd1 vccd1 vssd1 sky130_fd_sc_hd__fill_1$1
XFILLER_114_209 vssd1 vccd1 vccd1 vssd1 sky130_ef_sc_hd__decap_40_12$1
XFILLER_5_333 vssd1 vccd1 vccd1 vssd1 sky130_fd_sc_hd__fill_2$1
XFILLER_123_721 vssd1 vccd1 vccd1 vssd1 sky130_fd_sc_hd__fill_4$1
XFILLER_108_773 vssd1 vccd1 vccd1 vssd1 sky130_ef_sc_hd__decap_40_12$1
XFILLER_107_261 vssd1 vccd1 vccd1 vssd1 sky130_ef_sc_hd__decap_40_12$1
XFILLER_122_253 vssd1 vccd1 vccd1 vssd1 sky130_ef_sc_hd__decap_40_12$1
XFILLER_68_307 vccd1 vssd1 vccd1 vssd1 sky130_fd_sc_hd__fill_1$1
XFILLER_1_561 vssd1 vccd1 vccd1 vssd1 sky130_ef_sc_hd__decap_40_12$1
XFILLER_110_426 vssd1 vccd1 vccd1 vssd1 sky130_ef_sc_hd__decap_40_12$1
XFILLER_95_137 vssd1 vccd1 vccd1 vssd1 sky130_ef_sc_hd__decap_40_12$1
XFILLER_77_841 vccd1 vssd1 vccd1 vssd1 sky130_fd_sc_hd__fill_1$1
XFILLER_49_521 vccd1 vssd1 vccd1 vssd1 sky130_fd_sc_hd__fill_1$1
XFILLER_3_57 vssd1 vccd1 vccd1 vssd1 sky130_ef_sc_hd__decap_40_12$1
XFILLER_92_811 vccd1 vssd1 vccd1 vssd1 sky130_fd_sc_hd__fill_1$1
XFILLER_67_93 vssd1 vccd1 vccd1 vssd1 sky130_ef_sc_hd__decap_40_12$1
XTAP_TAPCELL_ROW_69_1336 vccd1 vssd1 sky130_fd_sc_hd__tapvpwrvgnd_1$1
XFILLER_64_513 vssd1 vccd1 vccd1 vssd1 sky130_ef_sc_hd__decap_40_12$1
XFILLER_64_557 vssd1 vccd1 vccd1 vssd1 sky130_ef_sc_hd__decap_40_12$1
XFILLER_17_473 vssd1 vccd1 vccd1 vssd1 sky130_ef_sc_hd__decap_40_12$1
XFILLER_83_81 vssd1 vccd1 vccd1 vssd1 sky130_ef_sc_hd__decap_40_12$1
XTAP_TAPCELL_ROW_82_1536 vccd1 vssd1 sky130_fd_sc_hd__tapvpwrvgnd_1$1
XTAP_TAPCELL_ROW_82_1525 vccd1 vssd1 sky130_fd_sc_hd__tapvpwrvgnd_1$1
XFILLER_32_421 vssd1 vccd1 vccd1 vssd1 sky130_ef_sc_hd__decap_40_12$1
XTAP_TAPCELL_ROW_43_950 vccd1 vssd1 sky130_fd_sc_hd__tapvpwrvgnd_1$1
XFILLER_80_3 vssd1 vccd1 vccd1 vssd1 sky130_ef_sc_hd__decap_40_12$1
X_0984_ _0984_/A _0984_/X _0990_/B vssd1 vccd1 vccd1 vssd1 sky130_fd_sc_hd__or2_1$1
XTAP_TAPCELL_ROW_113_2002 vccd1 vssd1 sky130_fd_sc_hd__tapvpwrvgnd_1$1
XFILLER_8_193 vssd1 vccd1 vccd1 vssd1 sky130_fd_sc_hd__fill_2$1
XFILLER_126_581 vssd1 vccd1 vccd1 vssd1 sky130_fd_sc_hd__fill_4$1
XFILLER_99_410 vssd1 vccd1 vccd1 vssd1 sky130_ef_sc_hd__decap_40_12$1
X_1605_ _1792_/A _1671_/CLK _1605_/D vccd1 vssd1 vccd1 vssd1 sky130_fd_sc_hd__dfxtp_1$1
XFILLER_114_754 vssd1 vccd1 vccd1 vssd1 sky130_fd_sc_hd__fill_2$1
X_1536_ _1536_/Q _1729_/CLK _1536_/D vccd1 vssd1 vccd1 vssd1 sky130_fd_sc_hd__dfxtp_1$1
XFILLER_101_404 vssd1 vccd1 vccd1 vssd1 sky130_ef_sc_hd__decap_40_12$1
XTAP_TAPCELL_ROW_93_1698 vccd1 vssd1 sky130_fd_sc_hd__tapvpwrvgnd_1$1
X_1467_ _1471_/C1 _1466_/X _1475_/A2 hold146/X _1467_/X vssd1 vccd1 vccd1 vssd1 sky130_fd_sc_hd__o211a_1$1
XFILLER_86_137 vssd1 vccd1 vccd1 vssd1 sky130_fd_sc_hd__fill_2$1
XFILLER_59_329 vssd1 vccd1 vccd1 vssd1 sky130_fd_sc_hd__fill_4$1
X_1398_ _1398_/A _1398_/X _1398_/B vssd1 vccd1 vccd1 vssd1 sky130_fd_sc_hd__or2_1$1
XFILLER_95_671 vccd1 vssd1 vccd1 vssd1 sky130_fd_sc_hd__fill_1$1
XFILLER_83_822 vssd1 vccd1 vccd1 vssd1 sky130_fd_sc_hd__fill_2$1
XFILLER_67_373 vssd1 vccd1 vccd1 vssd1 sky130_ef_sc_hd__decap_40_12$1
XTAP_TAPCELL_ROW_2_336 vccd1 vssd1 sky130_fd_sc_hd__tapvpwrvgnd_1$1
XTAP_TAPCELL_ROW_2_325 vccd1 vssd1 sky130_fd_sc_hd__tapvpwrvgnd_1$1
XTAP_TAPCELL_ROW_124_2153 vccd1 vssd1 sky130_fd_sc_hd__tapvpwrvgnd_1$1
XFILLER_82_321 vssd1 vccd1 vccd1 vssd1 sky130_ef_sc_hd__decap_40_12$1
XFILLER_27_237 vssd1 vccd1 vccd1 vssd1 sky130_ef_sc_hd__decap_40_12$1
XTAP_TAPCELL_ROW_124_2164 vccd1 vssd1 sky130_fd_sc_hd__tapvpwrvgnd_1$1
XPHY_EDGE_ROW_118_Right_118 vccd1 vssd1 vccd1 vssd1 sky130_fd_sc_hd__decap_3$1
XFILLER_103_69 vssd1 vccd1 vccd1 vssd1 sky130_ef_sc_hd__decap_40_12$1
XFILLER_82_365 vssd1 vccd1 vccd1 vssd1 sky130_ef_sc_hd__decap_40_12$1
XFILLER_35_281 vssd1 vccd1 vccd1 vssd1 sky130_ef_sc_hd__decap_40_12$1
XFILLER_50_251 vccd1 vssd1 vccd1 vssd1 sky130_fd_sc_hd__fill_1$1
XTAP_TAPCELL_ROW_41_909 vccd1 vssd1 sky130_fd_sc_hd__tapvpwrvgnd_1$1
XFILLER_51_785 vssd1 vccd1 vccd1 vssd1 sky130_ef_sc_hd__decap_40_12$1
XTAP_TAPCELL_ROW_21_611 vccd1 vssd1 sky130_fd_sc_hd__tapvpwrvgnd_1$1
XFILLER_10_137 vssd1 vccd1 vccd1 vssd1 sky130_fd_sc_hd__fill_2$1
XFILLER_7_609 vssd1 vccd1 vccd1 vssd1 sky130_fd_sc_hd__fill_4$1
XTAP_TAPCELL_ROW_21_622 vccd1 vssd1 sky130_fd_sc_hd__tapvpwrvgnd_1$1
XFILLER_136_345 vssd1 vccd1 vccd1 vssd1 sky130_ef_sc_hd__decap_40_12$1
XFILLER_109_559 vccd1 vssd1 vccd1 vssd1 sky130_fd_sc_hd__fill_1$1
XFILLER_12_77 vssd1 vccd1 vccd1 vssd1 sky130_fd_sc_hd__fill_4$1
XFILLER_128_77 vssd1 vccd1 vccd1 vssd1 sky130_fd_sc_hd__fill_4$1
XFILLER_88_15 vssd1 vccd1 vccd1 vssd1 sky130_ef_sc_hd__decap_40_12$1
XFILLER_3_837 vssd1 vccd1 vccd1 vssd1 sky130_fd_sc_hd__fill_2$1
Xhold171 wbs_dat_i[14] input25/A vssd1 vccd1 vccd1 vssd1 sky130_fd_sc_hd__dlygate4sd3_1$1
Xhold160 _1519_/Q _0970_/A vssd1 vccd1 vccd1 vssd1 sky130_fd_sc_hd__dlygate4sd3_1$1
Xhold182 wbs_dat_i[8] input50/A vssd1 vccd1 vccd1 vssd1 sky130_fd_sc_hd__dlygate4sd3_1$1
XFILLER_120_713 vssd1 vccd1 vccd1 vssd1 sky130_ef_sc_hd__decap_40_12$1
XFILLER_104_253 vssd1 vccd1 vccd1 vssd1 sky130_ef_sc_hd__decap_40_12$1
Xhold193 _1551_/Q _1036_/A vssd1 vccd1 vccd1 vssd1 sky130_fd_sc_hd__dlygate4sd3_1$1
XFILLER_120_757 vssd1 vccd1 vccd1 vssd1 sky130_ef_sc_hd__decap_40_12$1
XFILLER_77_137 vssd1 vccd1 vccd1 vssd1 sky130_ef_sc_hd__decap_40_12$1
XFILLER_59_841 vccd1 vssd1 vccd1 vssd1 sky130_fd_sc_hd__fill_1$1
XTAP_TAPCELL_ROW_109_1937 vccd1 vssd1 sky130_fd_sc_hd__tapvpwrvgnd_1$1
XFILLER_74_811 vccd1 vssd1 vccd1 vssd1 sky130_fd_sc_hd__fill_1$1
XFILLER_19_727 vccd1 vssd1 vccd1 vssd1 sky130_fd_sc_hd__fill_1$1
XFILLER_46_513 vssd1 vccd1 vccd1 vssd1 sky130_fd_sc_hd__fill_8$1
XFILLER_85_181 vssd1 vccd1 vccd1 vssd1 sky130_ef_sc_hd__decap_40_12$1
XTAP_TAPCELL_ROW_29_733 vccd1 vssd1 sky130_fd_sc_hd__tapvpwrvgnd_1$1
XFILLER_46_557 vssd1 vccd1 vccd1 vssd1 sky130_ef_sc_hd__decap_40_12$1
XFILLER_61_505 vssd1 vccd1 vccd1 vssd1 sky130_ef_sc_hd__decap_40_12$1
XFILLER_14_421 vssd1 vccd1 vccd1 vssd1 sky130_ef_sc_hd__decap_40_12$1
XFILLER_42_741 vssd1 vccd1 vccd1 vssd1 sky130_fd_sc_hd__fill_2$1
XTAP_TAPCELL_ROW_64_1266 vccd1 vssd1 sky130_fd_sc_hd__tapvpwrvgnd_1$1
XTAP_TAPCELL_ROW_64_1255 vccd1 vssd1 sky130_fd_sc_hd__tapvpwrvgnd_1$1
XFILLER_53_51 vssd1 vccd1 vccd1 vssd1 sky130_fd_sc_hd__fill_4$1
XFILLER_41_273 vssd1 vccd1 vccd1 vssd1 sky130_fd_sc_hd__fill_4$1
XFILLER_42_785 vssd1 vccd1 vccd1 vssd1 sky130_ef_sc_hd__decap_40_12$1
XFILLER_128_813 vssd1 vccd1 vccd1 vssd1 sky130_ef_sc_hd__decap_40_12$1
XFILLER_128_802 vssd1 vccd1 vccd1 vssd1 sky130_fd_sc_hd__fill_8$1
XFILLER_10_693 vssd1 vccd1 vccd1 vssd1 sky130_fd_sc_hd__fill_4$1
XFILLER_6_697 vssd1 vccd1 vccd1 vssd1 sky130_fd_sc_hd__fill_2$1
XFILLER_111_713 vssd1 vccd1 vccd1 vssd1 sky130_ef_sc_hd__decap_40_12$1
XFILLER_69_627 vccd1 vssd1 vccd1 vssd1 sky130_fd_sc_hd__fill_1$1
XFILLER_111_735 vccd1 vssd1 vccd1 vssd1 sky130_fd_sc_hd__fill_1$1
XFILLER_78_81 vssd1 vccd1 vccd1 vssd1 sky130_fd_sc_hd__fill_2$1
XFILLER_68_137 vssd1 vccd1 vccd1 vssd1 sky130_fd_sc_hd__fill_2$1
X_1321_ _1387_/C1 _1320_/X _1331_/A2 hold125/X _1689_/D vssd1 vccd1 vccd1 vssd1 sky130_fd_sc_hd__o211a_1$1
XFILLER_110_245 vssd1 vccd1 vccd1 vssd1 sky130_fd_sc_hd__fill_4$1
X_1252_ _1656_/Q _1252_/X _1276_/B vssd1 vccd1 vccd1 vssd1 sky130_fd_sc_hd__or2_1$1
XFILLER_1_391 vccd1 vssd1 vccd1 vssd1 sky130_fd_sc_hd__fill_1$1
XFILLER_110_289 vssd1 vccd1 vccd1 vssd1 sky130_ef_sc_hd__decap_40_12$1
XFILLER_77_671 vccd1 vssd1 vccd1 vssd1 sky130_fd_sc_hd__fill_1$1
XFILLER_49_373 vssd1 vccd1 vccd1 vssd1 sky130_ef_sc_hd__decap_40_12$1
X_1183_ _1455_/C1 _1182_/X _1211_/A2 hold46/X hold47/A vssd1 vccd1 vccd1 vssd1 sky130_fd_sc_hd__o211a_1$1
XFILLER_64_321 vssd1 vccd1 vccd1 vssd1 sky130_ef_sc_hd__decap_40_12$1
XFILLER_64_365 vssd1 vccd1 vccd1 vssd1 sky130_ef_sc_hd__decap_40_12$1
XFILLER_17_281 vssd1 vccd1 vccd1 vssd1 sky130_ef_sc_hd__decap_40_12$1
XFILLER_18_793 vssd1 vccd1 vccd1 vssd1 sky130_ef_sc_hd__decap_40_12$1
XFILLER_60_582 vssd1 vccd1 vccd1 vssd1 sky130_fd_sc_hd__fill_4$1
XFILLER_20_413 vssd1 vccd1 vccd1 vssd1 sky130_fd_sc_hd__fill_4$1
XFILLER_32_251 vccd1 vssd1 vccd1 vssd1 sky130_fd_sc_hd__fill_1$1
XFILLER_33_785 vccd1 vssd1 vccd1 vssd1 sky130_fd_sc_hd__fill_1$1
XFILLER_20_457 vssd1 vccd1 vccd1 vssd1 sky130_ef_sc_hd__decap_40_12$1
XFILLER_118_301 vssd1 vccd1 vccd1 vssd1 sky130_fd_sc_hd__fill_4$1
X_0967_ _1387_/C1 _0966_/X _0991_/A2 hold183/X _1517_/D vssd1 vccd1 vccd1 vssd1 sky130_fd_sc_hd__o211a_1$1
XFILLER_118_345 vssd1 vccd1 vccd1 vssd1 sky130_ef_sc_hd__decap_40_12$1
XTAP_TAPCELL_ROW_95_1727 vccd1 vssd1 sky130_fd_sc_hd__tapvpwrvgnd_1$1
X_0898_ _0752_/A _1500_/D _0894_/X _1461_/C1 _1500_/Q _0897_/X vssd1 vccd1 vccd1 vssd1
+ sky130_fd_sc_hd__o221a_1$1
XFILLER_118_367 vccd1 vssd1 vccd1 vssd1 sky130_fd_sc_hd__fill_1$1
XPHY_EDGE_ROW_12_Right_12 vccd1 vssd1 vccd1 vssd1 sky130_fd_sc_hd__decap_3$1
XFILLER_133_337 vssd1 vccd1 vccd1 vssd1 sky130_ef_sc_hd__decap_40_12$1
XTAP_TAPCELL_ROW_7_406 vccd1 vssd1 sky130_fd_sc_hd__tapvpwrvgnd_1$1
XFILLER_102_713 vssd1 vccd1 vccd1 vssd1 sky130_ef_sc_hd__decap_40_12$1
XFILLER_58_29 vssd1 vccd1 vccd1 vssd1 sky130_ef_sc_hd__decap_40_12$1
XFILLER_101_223 vccd1 vssd1 vccd1 vssd1 sky130_fd_sc_hd__fill_1$1
XFILLER_99_273 vssd1 vccd1 vccd1 vssd1 sky130_fd_sc_hd__fill_4$1
XFILLER_59_137 vssd1 vccd1 vccd1 vssd1 sky130_ef_sc_hd__decap_40_12$1
X_1519_ _1519_/Q _1585_/CLK _1519_/D vccd1 vssd1 vccd1 vssd1 sky130_fd_sc_hd__dfxtp_1$1
XFILLER_102_779 vssd1 vccd1 vccd1 vssd1 sky130_ef_sc_hd__decap_40_12$1
XFILLER_102_757 vccd1 vssd1 vccd1 vssd1 sky130_fd_sc_hd__fill_1$1
XFILLER_87_457 vssd1 vccd1 vccd1 vssd1 sky130_fd_sc_hd__fill_2$1
XFILLER_87_468 vssd1 vccd1 vccd1 vssd1 sky130_ef_sc_hd__decap_40_12$1
XFILLER_75_608 vccd1 vssd1 vccd1 vssd1 sky130_fd_sc_hd__fill_1$1
XFILLER_56_822 vccd1 vssd1 vccd1 vssd1 sky130_fd_sc_hd__fill_1$1
XFILLER_28_513 vssd1 vccd1 vccd1 vssd1 sky130_ef_sc_hd__decap_40_12$1
XFILLER_67_181 vssd1 vccd1 vccd1 vssd1 sky130_ef_sc_hd__decap_40_12$1
XFILLER_28_557 vssd1 vccd1 vccd1 vssd1 sky130_ef_sc_hd__decap_40_12$1
XFILLER_83_663 vccd1 vssd1 vccd1 vssd1 sky130_fd_sc_hd__fill_1$1
XPHY_EDGE_ROW_21_Right_21 vccd1 vssd1 vccd1 vssd1 sky130_fd_sc_hd__decap_3$1
XFILLER_43_505 vssd1 vccd1 vccd1 vssd1 sky130_ef_sc_hd__decap_40_12$1
XFILLER_82_195 vccd1 vssd1 vccd1 vssd1 sky130_fd_sc_hd__fill_1$1
XTAP_TAPCELL_ROW_104_1867 vccd1 vssd1 sky130_fd_sc_hd__tapvpwrvgnd_1$1
XTAP_TAPCELL_ROW_104_1856 vccd1 vssd1 sky130_fd_sc_hd__tapvpwrvgnd_1$1
XFILLER_90_27 vccd1 vssd1 vccd1 vssd1 sky130_fd_sc_hd__fill_1$1
XFILLER_70_357 vssd1 vccd1 vccd1 vssd1 sky130_fd_sc_hd__fill_4$1
XFILLER_24_741 vccd1 vssd1 vccd1 vssd1 sky130_fd_sc_hd__fill_1$1
XFILLER_51_582 vssd1 vccd1 vccd1 vssd1 sky130_ef_sc_hd__decap_40_12$1
XFILLER_23_273 vssd1 vccd1 vccd1 vssd1 sky130_fd_sc_hd__fill_4$1
XFILLER_24_785 vccd1 vssd1 vccd1 vssd1 sky130_fd_sc_hd__fill_1$1
XFILLER_128_109 vssd1 vccd1 vccd1 vssd1 sky130_ef_sc_hd__decap_40_12$1
XTAP_TAPCELL_ROW_137_2355 vccd1 vssd1 sky130_fd_sc_hd__tapvpwrvgnd_1$1
XFILLER_128_3 vssd1 vccd1 vccd1 vssd1 sky130_ef_sc_hd__decap_40_12$1
XFILLER_7_417 vssd1 vccd1 vccd1 vssd1 sky130_ef_sc_hd__decap_40_12$1
XFILLER_137_643 vccd1 vssd1 vccd1 vssd1 sky130_fd_sc_hd__fill_1$1
XPHY_EDGE_ROW_30_Right_30 vccd1 vssd1 vccd1 vssd1 sky130_fd_sc_hd__decap_3$1
XFILLER_136_153 vssd1 vccd1 vccd1 vssd1 sky130_ef_sc_hd__decap_40_12$1
XFILLER_109_389 vssd1 vccd1 vccd1 vssd1 sky130_fd_sc_hd__fill_2$1
XFILLER_99_69 vssd1 vccd1 vccd1 vssd1 sky130_ef_sc_hd__decap_40_12$1
XFILLER_136_197 vssd1 vccd1 vccd1 vssd1 sky130_fd_sc_hd__fill_4$1
XFILLER_2_133 vssd1 vccd1 vccd1 vssd1 sky130_fd_sc_hd__fill_4$1
XFILLER_132_381 vssd1 vccd1 vccd1 vssd1 sky130_fd_sc_hd__fill_2$1
XFILLER_78_413 vssd1 vccd1 vccd1 vssd1 sky130_fd_sc_hd__fill_4$1
XFILLER_2_177 vssd1 vccd1 vccd1 vssd1 sky130_ef_sc_hd__decap_40_12$1
Xclkbuf_leaf_39_wb_clk_i clkload3/A clkload0/A vssd1 vccd1 vccd1 vssd1 sky130_fd_sc_hd__clkbuf_8$1
XFILLER_59_671 vccd1 vssd1 vccd1 vssd1 sky130_fd_sc_hd__fill_1$1
XFILLER_93_449 vssd1 vccd1 vccd1 vssd1 sky130_ef_sc_hd__decap_40_12$1
XFILLER_19_557 vssd1 vccd1 vccd1 vssd1 sky130_fd_sc_hd__fill_2$1
XFILLER_46_321 vssd1 vccd1 vccd1 vssd1 sky130_ef_sc_hd__decap_40_12$1
XFILLER_0_69 vssd1 vccd1 vccd1 vssd1 sky130_ef_sc_hd__decap_40_12$1
XFILLER_0_47 vssd1 vccd1 vccd1 vssd1 sky130_fd_sc_hd__fill_8$1
XFILLER_46_365 vssd1 vccd1 vccd1 vssd1 sky130_ef_sc_hd__decap_40_12$1
XFILLER_61_335 vccd1 vssd1 vccd1 vssd1 sky130_fd_sc_hd__fill_1$1
XFILLER_64_83 vccd1 vssd1 vccd1 vssd1 sky130_fd_sc_hd__fill_1$1
XFILLER_15_741 vssd1 vccd1 vccd1 vssd1 sky130_ef_sc_hd__decap_40_12$1
XFILLER_14_251 vccd1 vssd1 vccd1 vssd1 sky130_fd_sc_hd__fill_1$1
XFILLER_15_785 vssd1 vccd1 vccd1 vssd1 sky130_ef_sc_hd__decap_40_12$1
XFILLER_42_582 vssd1 vccd1 vccd1 vssd1 sky130_fd_sc_hd__fill_4$1
XFILLER_119_109 vssd1 vccd1 vccd1 vssd1 sky130_fd_sc_hd__fill_2$1
XFILLER_30_755 vccd1 vssd1 vccd1 vssd1 sky130_fd_sc_hd__fill_1$1
X_0821_ _0821_/X _0866_/B1 _1712_/Q _1552_/Q _0878_/B1 vssd1 vccd1 _0820_/X vccd1
+ vssd1 sky130_fd_sc_hd__a221o_1$1
X_0752_ _0752_/A _0752_/B _0945_/A vssd1 vccd1 vccd1 vssd1 sky130_fd_sc_hd__nand2_8$1
XTAP_TAPCELL_ROW_12_474 vccd1 vssd1 sky130_fd_sc_hd__tapvpwrvgnd_1$1
XTAP_TAPCELL_ROW_12_485 vccd1 vssd1 sky130_fd_sc_hd__tapvpwrvgnd_1$1
XFILLER_128_687 vssd1 vccd1 vccd1 vssd1 sky130_ef_sc_hd__decap_40_12$1
XTAP_TAPCELL_ROW_77_1457 vccd1 vssd1 sky130_fd_sc_hd__tapvpwrvgnd_1$1
XFILLER_115_337 vssd1 vccd1 vccd1 vssd1 sky130_ef_sc_hd__decap_40_12$1
XFILLER_130_307 vccd1 vssd1 vccd1 vssd1 sky130_fd_sc_hd__fill_1$1
XFILLER_97_711 vssd1 vccd1 vccd1 vssd1 sky130_fd_sc_hd__fill_4$1
XFILLER_43_3 vssd1 vccd1 vccd1 vssd1 sky130_ef_sc_hd__decap_40_12$1
XFILLER_96_221 vssd1 vccd1 vccd1 vssd1 sky130_ef_sc_hd__decap_40_12$1
XTAP_TAPCELL_ROW_90_1657 vccd1 vssd1 sky130_fd_sc_hd__tapvpwrvgnd_1$1
XTAP_TAPCELL_ROW_90_1646 vccd1 vssd1 sky130_fd_sc_hd__tapvpwrvgnd_1$1
XFILLER_97_766 vssd1 vccd1 vccd1 vssd1 sky130_ef_sc_hd__decap_40_12$1
X_1304_ _1304_/A _1304_/X _1342_/B vssd1 vccd1 vccd1 vssd1 sky130_fd_sc_hd__or2_1$1
XFILLER_96_265 vssd1 vccd1 vccd1 vssd1 sky130_ef_sc_hd__decap_40_12$1
XFILLER_38_811 vccd1 vssd1 vccd1 vssd1 sky130_fd_sc_hd__fill_1$1
X_1235_ _1435_/C1 _1234_/X _1273_/A2 hold142/X _1647_/D vssd1 vccd1 vccd1 vssd1 sky130_fd_sc_hd__o211a_1$1
XFILLER_65_641 vssd1 vccd1 vccd1 vssd1 sky130_fd_sc_hd__fill_4$1
XFILLER_49_181 vssd1 vccd1 vccd1 vssd1 sky130_ef_sc_hd__decap_40_12$1
XFILLER_65_685 vssd1 vccd1 vccd1 vssd1 sky130_ef_sc_hd__decap_40_12$1
X_1166_ _1818_/A _1166_/X _1188_/B vssd1 vccd1 vccd1 vssd1 sky130_fd_sc_hd__or2_1$1
XFILLER_25_505 vssd1 vccd1 vccd1 vssd1 sky130_ef_sc_hd__decap_40_12$1
XTAP_TAPCELL_ROW_121_2112 vccd1 vssd1 sky130_fd_sc_hd__tapvpwrvgnd_1$1
XFILLER_92_493 vssd1 vccd1 vccd1 vssd1 sky130_ef_sc_hd__decap_40_12$1
XFILLER_92_471 vssd1 vccd1 vccd1 vssd1 sky130_fd_sc_hd__fill_4$1
XFILLER_64_195 vccd1 vssd1 vccd1 vssd1 sky130_fd_sc_hd__fill_1$1
XFILLER_52_357 vssd1 vccd1 vccd1 vssd1 sky130_fd_sc_hd__fill_4$1
X_1097_ _1305_/C1 _1096_/X _1123_/A2 hold199/X _1580_/D vssd1 vccd1 vccd1 vssd1 sky130_fd_sc_hd__o211a_1$1
XFILLER_100_15 vssd1 vccd1 vccd1 vssd1 sky130_ef_sc_hd__decap_40_12$1
XFILLER_80_699 vccd1 vssd1 vccd1 vssd1 sky130_fd_sc_hd__fill_1$1
XFILLER_20_221 vssd1 vccd1 vccd1 vssd1 sky130_ef_sc_hd__decap_40_12$1
XFILLER_20_265 vssd1 vccd1 vccd1 vssd1 sky130_ef_sc_hd__decap_40_12$1
XFILLER_21_777 vssd1 vccd1 vccd1 vssd1 sky130_fd_sc_hd__fill_4$1
XTAP_TAPCELL_ROW_31_761 vccd1 vssd1 sky130_fd_sc_hd__tapvpwrvgnd_1$1
XFILLER_119_665 vssd1 vccd1 vccd1 vssd1 sky130_fd_sc_hd__fill_4$1
XTAP_TAPCELL_ROW_119_2085 vccd1 vssd1 sky130_fd_sc_hd__tapvpwrvgnd_1$1
XTAP_TAPCELL_ROW_31_772 vccd1 vssd1 sky130_fd_sc_hd__tapvpwrvgnd_1$1
XFILLER_118_153 vssd1 vccd1 vccd1 vssd1 sky130_ef_sc_hd__decap_40_12$1
XTAP_TAPCELL_ROW_132_2274 vccd1 vssd1 sky130_fd_sc_hd__tapvpwrvgnd_1$1
XFILLER_118_197 vssd1 vccd1 vccd1 vssd1 sky130_ef_sc_hd__decap_40_12$1
XFILLER_109_57 vssd1 vccd1 vccd1 vssd1 sky130_ef_sc_hd__decap_40_12$1
XFILLER_69_39 vssd1 vccd1 vccd1 vssd1 sky130_ef_sc_hd__decap_40_12$1
XTAP_TAPCELL_ROW_132_2285 vccd1 vssd1 sky130_fd_sc_hd__tapvpwrvgnd_1$1
XFILLER_133_167 vccd1 vssd1 vccd1 vssd1 sky130_fd_sc_hd__fill_1$1
XFILLER_121_329 vssd1 vccd1 vccd1 vssd1 sky130_fd_sc_hd__fill_4$1
XFILLER_87_221 vssd1 vccd1 vccd1 vssd1 sky130_fd_sc_hd__fill_2$1
XFILLER_0_615 vccd1 vssd1 vccd1 vssd1 sky130_fd_sc_hd__fill_1$1
XFILLER_88_755 vccd1 vssd1 vccd1 vssd1 sky130_fd_sc_hd__fill_1$1
XFILLER_102_587 vccd1 vssd1 vccd1 vssd1 sky130_fd_sc_hd__fill_1$1
XFILLER_85_27 vssd1 vccd1 vccd1 vssd1 sky130_ef_sc_hd__decap_40_12$1
XFILLER_75_405 vssd1 vccd1 vccd1 vssd1 sky130_ef_sc_hd__decap_40_12$1
XFILLER_29_800 vssd1 vccd1 vccd1 vssd1 sky130_fd_sc_hd__fill_8$1
XFILLER_56_630 vssd1 vccd1 vccd1 vssd1 sky130_ef_sc_hd__decap_40_12$1
XFILLER_28_321 vssd1 vccd1 vccd1 vssd1 sky130_ef_sc_hd__decap_40_12$1
XFILLER_90_419 vccd1 vssd1 vccd1 vssd1 sky130_fd_sc_hd__fill_1$1
XFILLER_18_65 vssd1 vccd1 vccd1 vssd1 sky130_ef_sc_hd__decap_40_12$1
XFILLER_28_365 vssd1 vccd1 vccd1 vssd1 sky130_ef_sc_hd__decap_40_12$1
XFILLER_44_825 vccd1 vssd1 vccd1 vssd1 sky130_fd_sc_hd__fill_1$1
XFILLER_83_493 vccd1 vssd1 vccd1 vssd1 sky130_fd_sc_hd__fill_1$1
XTAP_TAPCELL_ROW_39_883 vccd1 vssd1 sky130_fd_sc_hd__tapvpwrvgnd_1$1
XFILLER_43_335 vccd1 vssd1 vccd1 vssd1 sky130_fd_sc_hd__fill_1$1
XTAP_TAPCELL_ROW_48_1014 vccd1 vssd1 sky130_fd_sc_hd__tapvpwrvgnd_1$1
XTAP_TAPCELL_ROW_48_1025 vccd1 vssd1 sky130_fd_sc_hd__tapvpwrvgnd_1$1
XFILLER_70_121 vssd1 vccd1 vccd1 vssd1 sky130_ef_sc_hd__decap_40_12$1
XFILLER_70_165 vssd1 vccd1 vccd1 vssd1 sky130_ef_sc_hd__decap_40_12$1
XTAP_TAPCELL_ROW_61_1214 vccd1 vssd1 sky130_fd_sc_hd__tapvpwrvgnd_1$1
XFILLER_34_53 vssd1 vccd1 vccd1 vssd1 sky130_ef_sc_hd__decap_40_12$1
XFILLER_11_221 vssd1 vccd1 vccd1 vssd1 sky130_fd_sc_hd__fill_2$1
XFILLER_12_755 vccd1 vssd1 vccd1 vssd1 sky130_fd_sc_hd__fill_1$1
XFILLER_34_97 vssd1 vccd1 vccd1 vssd1 sky130_ef_sc_hd__decap_40_12$1
XFILLER_8_737 vssd1 vccd1 vccd1 vssd1 sky130_ef_sc_hd__decap_40_12$1
XFILLER_50_41 vssd1 vccd1 vccd1 vssd1 sky130_ef_sc_hd__decap_40_12$1
XFILLER_7_225 vssd1 vccd1 vccd1 vssd1 sky130_ef_sc_hd__decap_40_12$1
XFILLER_50_85 vssd1 vccd1 vccd1 vssd1 sky130_ef_sc_hd__decap_40_12$1
XFILLER_137_484 vssd1 vccd1 vccd1 vssd1 sky130_ef_sc_hd__decap_40_12$1
XFILLER_112_307 vccd1 vssd1 vccd1 vssd1 sky130_fd_sc_hd__fill_1$1
XTAP_TAPCELL_ROW_59_1187 vccd1 vssd1 sky130_fd_sc_hd__tapvpwrvgnd_1$1
XFILLER_124_189 vssd1 vccd1 vccd1 vssd1 sky130_fd_sc_hd__fill_4$1
XFILLER_79_711 vssd1 vccd1 vccd1 vssd1 sky130_ef_sc_hd__decap_40_12$1
XFILLER_3_497 vssd1 vccd1 vccd1 vssd1 sky130_fd_sc_hd__fill_4$1
XFILLER_121_841 vccd1 vssd1 vccd1 vssd1 sky130_fd_sc_hd__fill_1$1
XFILLER_78_221 vssd1 vccd1 vccd1 vssd1 sky130_ef_sc_hd__decap_40_12$1
XTAP_TAPCELL_ROW_72_1387 vccd1 vssd1 sky130_fd_sc_hd__tapvpwrvgnd_1$1
XTAP_TAPCELL_ROW_72_1376 vccd1 vssd1 sky130_fd_sc_hd__tapvpwrvgnd_1$1
XFILLER_94_725 vssd1 vccd1 vccd1 vssd1 sky130_ef_sc_hd__decap_40_12$1
XFILLER_78_265 vssd1 vccd1 vccd1 vssd1 sky130_ef_sc_hd__decap_40_12$1
XFILLER_39_619 vccd1 vssd1 vccd1 vssd1 sky130_fd_sc_hd__fill_1$1
XFILLER_94_769 vssd1 vccd1 vccd1 vssd1 sky130_ef_sc_hd__decap_40_12$1
XFILLER_47_641 vssd1 vccd1 vccd1 vssd1 sky130_ef_sc_hd__decap_40_12$1
XFILLER_93_279 vccd1 vssd1 vccd1 vssd1 sky130_fd_sc_hd__fill_1$1
XFILLER_81_408 vssd1 vccd1 vccd1 vssd1 sky130_ef_sc_hd__decap_40_12$1
X_1020_ _1774_/A _1020_/X _1052_/B vssd1 vccd1 vccd1 vssd1 sky130_fd_sc_hd__or2_1$1
XFILLER_75_93 vssd1 vccd1 vccd1 vssd1 sky130_ef_sc_hd__decap_40_12$1
XFILLER_47_685 vssd1 vccd1 vccd1 vssd1 sky130_fd_sc_hd__fill_8$1
XTAP_TAPCELL_ROW_17_555 vccd1 vssd1 sky130_fd_sc_hd__tapvpwrvgnd_1$1
XFILLER_34_357 vssd1 vccd1 vccd1 vssd1 sky130_fd_sc_hd__fill_4$1
XFILLER_46_195 vccd1 vssd1 vccd1 vssd1 sky130_fd_sc_hd__fill_1$1
XFILLER_62_699 vccd1 vssd1 vccd1 vssd1 sky130_fd_sc_hd__fill_1$1
XFILLER_61_165 vssd1 vccd1 vccd1 vssd1 sky130_fd_sc_hd__fill_2$1
XFILLER_91_81 vssd1 vccd1 vccd1 vssd1 sky130_ef_sc_hd__decap_40_12$1
X_1853_ _1853_/A _1853_/X vssd1 vccd1 vccd1 vssd1 sky130_fd_sc_hd__clkbuf_2$1
X_0804_ _1832_/A _0878_/B1 _0804_/X _1677_/Q _0875_/B1 vccd1 vssd1 vccd1 vssd1 sky130_fd_sc_hd__a22o_1$1
XFILLER_30_585 vssd1 vccd1 vccd1 vssd1 sky130_fd_sc_hd__fill_2$1
X_1784_ vccd1 vssd1 _1784_/X _1784_/A vccd1 vssd1 sky130_fd_sc_hd__buf_1$1
XFILLER_7_781 vssd1 vccd1 vccd1 vssd1 sky130_fd_sc_hd__fill_2$1
XFILLER_115_167 vccd1 vssd1 vccd1 vssd1 sky130_fd_sc_hd__fill_1$1
XFILLER_103_329 vssd1 vccd1 vccd1 vssd1 sky130_fd_sc_hd__fill_4$1
XFILLER_130_137 vssd1 vccd1 vccd1 vssd1 sky130_fd_sc_hd__fill_2$1
XFILLER_97_541 vssd1 vccd1 vccd1 vssd1 sky130_ef_sc_hd__decap_40_12$1
XFILLER_69_221 vssd1 vccd1 vccd1 vssd1 sky130_fd_sc_hd__fill_2$1
XFILLER_97_563 vccd1 vssd1 vccd1 vssd1 sky130_fd_sc_hd__fill_1$1
XFILLER_85_725 vssd1 vccd1 vccd1 vssd1 sky130_fd_sc_hd__fill_2$1
XFILLER_57_449 vssd1 vccd1 vccd1 vssd1 sky130_ef_sc_hd__decap_40_12$1
XFILLER_57_438 vssd1 vccd1 vccd1 vssd1 sky130_fd_sc_hd__fill_8$1
XFILLER_38_641 vssd1 vccd1 vccd1 vssd1 sky130_fd_sc_hd__fill_2$1
X_1218_ _1639_/Q _1218_/X _1270_/B vssd1 vccd1 vccd1 vssd1 sky130_fd_sc_hd__or2_1$1
XFILLER_52_121 vssd1 vccd1 vccd1 vssd1 sky130_ef_sc_hd__decap_40_12$1
XFILLER_25_335 vccd1 vssd1 vccd1 vssd1 sky130_fd_sc_hd__fill_1$1
XTAP_TAPCELL_ROW_36_842 vccd1 vssd1 sky130_fd_sc_hd__tapvpwrvgnd_1$1
X_1149_ _1289_/C1 _1148_/X _1189_/A2 hold78/X _1605_/D vssd1 vccd1 vccd1 vssd1 sky130_fd_sc_hd__o211a_1$1
XFILLER_111_69 vssd1 vccd1 vccd1 vssd1 sky130_ef_sc_hd__decap_40_12$1
XTAP_TAPCELL_ROW_101_1815 vccd1 vssd1 sky130_fd_sc_hd__tapvpwrvgnd_1$1
XFILLER_52_165 vssd1 vccd1 vccd1 vssd1 sky130_ef_sc_hd__decap_40_12$1
XFILLER_40_305 vssd1 vccd1 vccd1 vssd1 sky130_fd_sc_hd__fill_2$1
XFILLER_21_541 vssd1 vccd1 vccd1 vssd1 sky130_ef_sc_hd__decap_40_12$1
XTAP_TAPCELL_ROW_134_2314 vccd1 vssd1 sky130_fd_sc_hd__tapvpwrvgnd_1$1
XTAP_TAPCELL_ROW_134_2303 vccd1 vssd1 sky130_fd_sc_hd__tapvpwrvgnd_1$1
XFILLER_21_585 vssd1 vccd1 vccd1 vssd1 sky130_ef_sc_hd__decap_40_12$1
XFILLER_5_729 vssd1 vccd1 vccd1 vssd1 sky130_ef_sc_hd__decap_40_12$1
XFILLER_134_421 vssd1 vccd1 vccd1 vssd1 sky130_fd_sc_hd__fill_4$1
XFILLER_20_77 vssd1 vccd1 vccd1 vssd1 sky130_fd_sc_hd__fill_4$1
XFILLER_136_77 vssd1 vccd1 vccd1 vssd1 sky130_fd_sc_hd__fill_4$1
XFILLER_106_189 vssd1 vccd1 vccd1 vssd1 sky130_fd_sc_hd__fill_4$1
XFILLER_96_15 vssd1 vccd1 vccd1 vssd1 sky130_ef_sc_hd__decap_40_12$1
XFILLER_136_99 vssd1 vccd1 vccd1 vssd1 sky130_ef_sc_hd__decap_40_12$1
XFILLER_121_137 vssd1 vccd1 vccd1 vssd1 sky130_ef_sc_hd__decap_40_12$1
XTAP_TAPCELL_ROW_112_1977 vccd1 vssd1 sky130_fd_sc_hd__tapvpwrvgnd_1$1
XFILLER_103_841 vccd1 vssd1 vccd1 vssd1 sky130_fd_sc_hd__fill_1$1
Xhold20 wbs_dat_i[13] hold20/X vssd1 vccd1 vccd1 vssd1 sky130_fd_sc_hd__dlygate4sd3_1$1
Xhold31 wbs_dat_i[16] hold31/X vssd1 vccd1 vccd1 vssd1 sky130_fd_sc_hd__dlygate4sd3_1$1
XFILLER_76_725 vssd1 vccd1 vccd1 vssd1 sky130_ef_sc_hd__decap_40_12$1
Xhold64 hold64/A hold64/X vssd1 vccd1 vccd1 vssd1 sky130_fd_sc_hd__dlygate4sd3_1$1
Xhold42 hold42/A hold42/X vssd1 vccd1 vccd1 vssd1 sky130_fd_sc_hd__dlygate4sd3_1$1
Xhold53 hold53/A hold53/X vssd1 vccd1 vccd1 vssd1 sky130_fd_sc_hd__dlygate4sd3_1$1
XFILLER_76_769 vssd1 vccd1 vccd1 vssd1 sky130_fd_sc_hd__fill_2$1
Xhold97 wbs_dat_i[18] hold97/X vssd1 vccd1 vccd1 vssd1 sky130_fd_sc_hd__dlygate4sd3_1$1
Xhold75 hold75/A hold75/X vssd1 vccd1 vccd1 vssd1 sky130_fd_sc_hd__dlygate4sd3_1$1
Xhold86 hold86/A hold86/X vssd1 vccd1 vccd1 vssd1 sky130_fd_sc_hd__dlygate4sd3_1$1
XFILLER_91_706 vssd1 vccd1 vccd1 vssd1 sky130_ef_sc_hd__decap_40_12$1
XFILLER_75_279 vccd1 vssd1 vccd1 vssd1 sky130_fd_sc_hd__fill_1$1
XFILLER_29_641 vssd1 vccd1 vccd1 vssd1 sky130_ef_sc_hd__decap_40_12$1
XFILLER_29_685 vssd1 vccd1 vccd1 vssd1 sky130_ef_sc_hd__decap_40_12$1
XFILLER_90_249 vssd1 vccd1 vccd1 vssd1 sky130_fd_sc_hd__fill_2$1
XFILLER_16_357 vssd1 vccd1 vccd1 vssd1 sky130_fd_sc_hd__fill_4$1
XFILLER_28_195 vccd1 vssd1 vccd1 vssd1 sky130_fd_sc_hd__fill_1$1
XTAP_TAPCELL_ROW_14_503 vccd1 vssd1 sky130_fd_sc_hd__tapvpwrvgnd_1$1
XFILLER_31_305 vssd1 vccd1 vccd1 vssd1 sky130_ef_sc_hd__decap_40_12$1
XFILLER_43_165 vssd1 vccd1 vccd1 vssd1 sky130_fd_sc_hd__fill_2$1
XTAP_TAPCELL_ROW_14_514 vccd1 vssd1 sky130_fd_sc_hd__tapvpwrvgnd_1$1
XFILLER_31_349 vssd1 vccd1 vccd1 vssd1 sky130_ef_sc_hd__decap_40_12$1
XFILLER_61_51 vssd1 vccd1 vccd1 vssd1 sky130_fd_sc_hd__fill_4$1
XFILLER_8_501 vssd1 vccd1 vccd1 vssd1 sky130_ef_sc_hd__decap_40_12$1
XFILLER_129_237 vssd1 vccd1 vccd1 vssd1 sky130_fd_sc_hd__fill_8$1
XFILLER_8_545 vssd1 vccd1 vccd1 vssd1 sky130_ef_sc_hd__decap_40_12$1
XFILLER_12_585 vssd1 vccd1 vccd1 vssd1 sky130_fd_sc_hd__fill_2$1
XFILLER_8_589 vssd1 vccd1 vccd1 vssd1 sky130_ef_sc_hd__decap_40_12$1
XFILLER_137_281 vssd1 vccd1 vccd1 vssd1 sky130_fd_sc_hd__fill_2$1
XANTENNA_6 input7/X vssd1 vccd1 vccd1 vssd1 sky130_fd_sc_hd__diode_2$1
XFILLER_113_605 vssd1 vccd1 vccd1 vssd1 sky130_fd_sc_hd__fill_8$1
XFILLER_98_305 vssd1 vccd1 vccd1 vssd1 sky130_fd_sc_hd__fill_2$1
XTAP_TAPCELL_ROW_74_1416 vccd1 vssd1 sky130_fd_sc_hd__tapvpwrvgnd_1$1
XTAP_TAPCELL_ROW_74_1405 vccd1 vssd1 sky130_fd_sc_hd__tapvpwrvgnd_1$1
XFILLER_113_649 vssd1 vccd1 vccd1 vssd1 sky130_ef_sc_hd__decap_40_12$1
XFILLER_3_261 vssd1 vccd1 vccd1 vssd1 sky130_ef_sc_hd__decap_40_12$1
XFILLER_112_137 vssd1 vccd1 vccd1 vssd1 sky130_fd_sc_hd__fill_2$1
XFILLER_79_541 vssd1 vccd1 vccd1 vssd1 sky130_ef_sc_hd__decap_40_12$1
XFILLER_79_585 vssd1 vccd1 vccd1 vssd1 sky130_ef_sc_hd__decap_40_12$1
XFILLER_39_405 vssd1 vccd1 vccd1 vssd1 sky130_ef_sc_hd__decap_40_12$1
XFILLER_94_533 vssd1 vccd1 vccd1 vssd1 sky130_ef_sc_hd__decap_40_12$1
XFILLER_86_81 vssd1 vccd1 vccd1 vssd1 sky130_fd_sc_hd__fill_2$1
XFILLER_39_449 vssd1 vccd1 vccd1 vssd1 sky130_ef_sc_hd__decap_40_12$1
XFILLER_54_419 vccd1 vssd1 vccd1 vssd1 sky130_fd_sc_hd__fill_1$1
X_1003_ _1471_/C1 _1002_/X _1013_/A2 hold83/X hold84/A vssd1 vccd1 vccd1 vssd1 sky130_fd_sc_hd__o211a_1$1
XFILLER_81_205 vssd1 vccd1 vccd1 vssd1 sky130_ef_sc_hd__decap_40_12$1
XFILLER_35_633 vssd1 vccd1 vccd1 vssd1 sky130_fd_sc_hd__fill_4$1
XFILLER_90_750 vssd1 vccd1 vccd1 vssd1 sky130_fd_sc_hd__fill_4$1
XFILLER_81_249 vssd1 vccd1 vccd1 vssd1 sky130_ef_sc_hd__decap_40_12$1
XFILLER_23_806 vssd1 vccd1 vccd1 vssd1 sky130_fd_sc_hd__fill_2$1
XFILLER_34_121 vssd1 vccd1 vccd1 vssd1 sky130_ef_sc_hd__decap_40_12$1
XFILLER_35_655 vccd1 vssd1 vccd1 vssd1 sky130_fd_sc_hd__fill_1$1
XTAP_TAPCELL_ROW_85_1578 vccd1 vssd1 sky130_fd_sc_hd__tapvpwrvgnd_1$1
XFILLER_22_305 vssd1 vccd1 vccd1 vssd1 sky130_fd_sc_hd__fill_2$1
XFILLER_34_165 vssd1 vccd1 vccd1 vssd1 sky130_ef_sc_hd__decap_40_12$1
XTAP_TAPCELL_ROW_33_801 vccd1 vssd1 sky130_fd_sc_hd__tapvpwrvgnd_1$1
XTAP_TAPCELL_ROW_116_2044 vccd1 vssd1 sky130_fd_sc_hd__tapvpwrvgnd_1$1
XTAP_TAPCELL_ROW_116_2033 vccd1 vssd1 sky130_fd_sc_hd__tapvpwrvgnd_1$1
X_1836_ vccd1 vssd1 _1836_/X _1836_/A vccd1 vssd1 sky130_fd_sc_hd__buf_1$1
XPHY_EDGE_ROW_6_Right_6 vccd1 vssd1 vccd1 vssd1 sky130_fd_sc_hd__decap_3$1
XFILLER_116_421 vssd1 vccd1 vccd1 vssd1 sky130_ef_sc_hd__decap_40_12$1
XFILLER_131_424 vccd1 vssd1 vccd1 vssd1 sky130_fd_sc_hd__fill_1$1
X_1698_ _1698_/Q _1747_/CLK _1698_/D vccd1 vssd1 vccd1 vssd1 sky130_fd_sc_hd__dfxtp_1$1
XFILLER_89_305 vssd1 vccd1 vccd1 vssd1 sky130_ef_sc_hd__decap_40_12$1
XFILLER_103_137 vssd1 vccd1 vccd1 vssd1 sky130_ef_sc_hd__decap_40_12$1
XFILLER_89_349 vssd1 vccd1 vccd1 vssd1 sky130_ef_sc_hd__decap_40_12$1
XFILLER_85_500 vssd1 vccd1 vccd1 vssd1 sky130_fd_sc_hd__fill_4$1
XFILLER_111_181 vssd1 vccd1 vccd1 vssd1 sky130_ef_sc_hd__decap_40_12$1
XFILLER_66_29 vssd1 vccd1 vccd1 vssd1 sky130_ef_sc_hd__decap_40_12$1
XFILLER_58_747 vccd1 vssd1 vccd1 vssd1 sky130_fd_sc_hd__fill_1$1
XFILLER_57_279 vccd1 vssd1 vccd1 vssd1 sky130_fd_sc_hd__fill_1$1
XFILLER_72_249 vssd1 vccd1 vccd1 vssd1 sky130_fd_sc_hd__fill_2$1
XFILLER_81_783 vccd1 vssd1 vccd1 vssd1 sky130_fd_sc_hd__fill_1$1
XTAP_TAPCELL_ROW_0_286 vccd1 vssd1 sky130_fd_sc_hd__tapvpwrvgnd_1$1
XTAP_TAPCELL_ROW_0_297 vccd1 vssd1 sky130_fd_sc_hd__tapvpwrvgnd_1$1
XFILLER_13_305 vssd1 vccd1 vccd1 vssd1 sky130_ef_sc_hd__decap_40_12$1
XFILLER_25_165 vssd1 vccd1 vccd1 vssd1 sky130_fd_sc_hd__fill_2$1
XFILLER_41_603 vssd1 vccd1 vccd1 vssd1 sky130_ef_sc_hd__decap_40_12$1
XFILLER_13_349 vssd1 vccd1 vccd1 vssd1 sky130_ef_sc_hd__decap_40_12$1
XFILLER_15_55 vccd1 vssd1 vccd1 vssd1 sky130_fd_sc_hd__fill_1$1
XFILLER_21_393 vssd1 vccd1 vccd1 vssd1 sky130_ef_sc_hd__decap_40_12$1
XFILLER_119_281 vssd1 vccd1 vccd1 vssd1 sky130_ef_sc_hd__decap_40_12$1
XFILLER_110_3 vssd1 vccd1 vccd1 vssd1 sky130_ef_sc_hd__decap_40_12$1
XFILLER_5_559 vccd1 vssd1 vccd1 vssd1 sky130_fd_sc_hd__fill_1$1
XFILLER_134_251 vccd1 vssd1 vccd1 vssd1 sky130_fd_sc_hd__fill_1$1
XFILLER_107_476 vssd1 vccd1 vccd1 vssd1 sky130_ef_sc_hd__decap_40_12$1
XTAP_TAPCELL_ROW_56_1146 vccd1 vssd1 sky130_fd_sc_hd__tapvpwrvgnd_1$1
XTAP_TAPCELL_ROW_56_1135 vccd1 vssd1 sky130_fd_sc_hd__tapvpwrvgnd_1$1
Xoutput65 _1846_/X analog_ctrl[113] vssd1 vccd1 vccd1 vssd1 sky130_fd_sc_hd__buf_12$1
XFILLER_96_809 vssd1 vccd1 vccd1 vssd1 sky130_fd_sc_hd__fill_2$1
Xoutput54 _1772_/X analog_ctrl[0] vssd1 vccd1 vccd1 vssd1 sky130_fd_sc_hd__buf_12$1
XFILLER_1_721 vssd1 vccd1 vccd1 vssd1 sky130_fd_sc_hd__fill_4$1
Xoutput76 _1783_/X analog_ctrl[12] vssd1 vccd1 vccd1 vssd1 sky130_fd_sc_hd__buf_12$1
XFILLER_103_671 vccd1 vssd1 vccd1 vssd1 sky130_fd_sc_hd__fill_1$1
XFILLER_0_253 vssd1 vccd1 vccd1 vssd1 sky130_ef_sc_hd__decap_40_12$1
XFILLER_1_765 vssd1 vccd1 vccd1 vssd1 sky130_ef_sc_hd__decap_40_12$1
Xoutput87 _1793_/X analog_ctrl[22] vssd1 vccd1 vccd1 vssd1 sky130_fd_sc_hd__buf_12$1
Xoutput98 _1803_/X analog_ctrl[32] vssd1 vccd1 vccd1 vssd1 sky130_fd_sc_hd__buf_12$1
XFILLER_76_544 vssd1 vccd1 vccd1 vssd1 sky130_ef_sc_hd__decap_40_12$1
XFILLER_76_533 vssd1 vccd1 vccd1 vssd1 sky130_fd_sc_hd__fill_2$1
XFILLER_91_503 vccd1 vssd1 vccd1 vssd1 sky130_fd_sc_hd__fill_1$1
XFILLER_63_205 vssd1 vccd1 vccd1 vssd1 sky130_ef_sc_hd__decap_40_12$1
XFILLER_36_419 vccd1 vssd1 vccd1 vssd1 sky130_fd_sc_hd__fill_1$1
XFILLER_63_249 vssd1 vccd1 vccd1 vssd1 sky130_ef_sc_hd__decap_40_12$1
XFILLER_16_121 vssd1 vccd1 vccd1 vssd1 sky130_ef_sc_hd__decap_40_12$1
XFILLER_16_165 vssd1 vccd1 vccd1 vssd1 sky130_ef_sc_hd__decap_40_12$1
XFILLER_71_293 vssd1 vccd1 vccd1 vssd1 sky130_ef_sc_hd__decap_40_12$1
XFILLER_31_113 vssd1 vccd1 vccd1 vssd1 sky130_ef_sc_hd__decap_40_12$1
XFILLER_32_625 vssd1 vccd1 vccd1 vssd1 sky130_fd_sc_hd__fill_8$1
XFILLER_72_83 vccd1 vssd1 vccd1 vssd1 sky130_fd_sc_hd__fill_1$1
XTAP_TAPCELL_ROW_80_1497 vccd1 vssd1 sky130_fd_sc_hd__tapvpwrvgnd_1$1
XPHY_EDGE_ROW_59_Right_59 vccd1 vssd1 vccd1 vssd1 sky130_fd_sc_hd__decap_3$1
XFILLER_9_821 vssd1 vccd1 vccd1 vssd1 sky130_fd_sc_hd__fill_2$1
X_1621_ hold38/A _1756_/CLK _1621_/D vccd1 vssd1 vccd1 vssd1 sky130_fd_sc_hd__dfxtp_1$1
XFILLER_125_273 vssd1 vccd1 vccd1 vssd1 sky130_fd_sc_hd__fill_4$1
XFILLER_113_413 vssd1 vccd1 vccd1 vssd1 sky130_fd_sc_hd__fill_4$1
XFILLER_99_614 vssd1 vccd1 vccd1 vssd1 sky130_fd_sc_hd__fill_2$1
X_1552_ _1552_/Q clkload6/A _1552_/D vccd1 vssd1 vccd1 vssd1 sky130_fd_sc_hd__dfxtp_1$1
X_1483_ _1483_/D clkload9/A _1483_/Q vssd1 vccd1 vccd1 vssd1 sky130_fd_sc_hd__dfxtp_4$1
XFILLER_4_581 vssd1 vccd1 vccd1 vssd1 sky130_fd_sc_hd__fill_4$1
XFILLER_79_382 vssd1 vccd1 vccd1 vssd1 sky130_fd_sc_hd__fill_2$1
XPHY_EDGE_ROW_68_Right_68 vccd1 vssd1 vccd1 vssd1 sky130_fd_sc_hd__decap_3$1
XTAP_TAPCELL_ROW_87_1607 vccd1 vssd1 sky130_fd_sc_hd__tapvpwrvgnd_1$1
XFILLER_94_363 vccd1 vssd1 vccd1 vssd1 sky130_fd_sc_hd__fill_1$1
XFILLER_67_599 vccd1 vssd1 vccd1 vssd1 sky130_fd_sc_hd__fill_1$1
XFILLER_39_279 vccd1 vssd1 vccd1 vssd1 sky130_fd_sc_hd__fill_1$1
XFILLER_54_249 vssd1 vccd1 vccd1 vssd1 sky130_fd_sc_hd__fill_2$1
XFILLER_35_441 vssd1 vccd1 vccd1 vssd1 sky130_fd_sc_hd__fill_4$1
XFILLER_50_433 vssd1 vccd1 vccd1 vssd1 sky130_ef_sc_hd__decap_40_12$1
XFILLER_35_485 vssd1 vccd1 vccd1 vssd1 sky130_ef_sc_hd__decap_40_12$1
XTAP_TAPCELL_ROW_46_992 vccd1 vssd1 sky130_fd_sc_hd__tapvpwrvgnd_1$1
XPHY_EDGE_ROW_77_Right_77 vccd1 vssd1 vccd1 vssd1 sky130_fd_sc_hd__decap_3$1
XFILLER_50_455 vccd1 vssd1 vccd1 vssd1 sky130_fd_sc_hd__fill_1$1
XFILLER_11_809 vssd1 vccd1 vccd1 vssd1 sky130_ef_sc_hd__decap_40_12$1
XFILLER_23_669 vssd1 vccd1 vccd1 vssd1 sky130_fd_sc_hd__fill_2$1
XFILLER_50_477 vssd1 vccd1 vccd1 vssd1 sky130_fd_sc_hd__fill_8$1
XTAP_TAPCELL_ROW_98_1769 vccd1 vssd1 sky130_fd_sc_hd__tapvpwrvgnd_1$1
XFILLER_117_741 vssd1 vccd1 vccd1 vssd1 sky130_fd_sc_hd__fill_2$1
X_1819_ vccd1 vssd1 _1819_/X _1819_/A vccd1 vssd1 sky130_fd_sc_hd__buf_1$1
XFILLER_117_785 vssd1 vccd1 vccd1 vssd1 sky130_fd_sc_hd__fill_2$1
XFILLER_116_251 vccd1 vssd1 vccd1 vssd1 sky130_fd_sc_hd__fill_1$1
XFILLER_104_413 vccd1 vssd1 vccd1 vssd1 sky130_fd_sc_hd__fill_1$1
XFILLER_89_113 vssd1 vccd1 vccd1 vssd1 sky130_ef_sc_hd__decap_40_12$1
XFILLER_2_529 vssd1 vccd1 vccd1 vssd1 sky130_fd_sc_hd__fill_2$1
XFILLER_132_733 vssd1 vccd1 vccd1 vssd1 sky130_fd_sc_hd__fill_2$1
XFILLER_131_221 vssd1 vccd1 vccd1 vssd1 sky130_fd_sc_hd__fill_2$1
XFILLER_117_57 vssd1 vccd1 vccd1 vssd1 sky130_ef_sc_hd__decap_40_12$1
XFILLER_78_809 vssd1 vccd1 vccd1 vssd1 sky130_fd_sc_hd__fill_2$1
XFILLER_132_777 vssd1 vccd1 vccd1 vssd1 sky130_fd_sc_hd__fill_2$1
XFILLER_104_457 vssd1 vccd1 vccd1 vssd1 sky130_fd_sc_hd__fill_8$1
XPHY_EDGE_ROW_86_Right_86 vccd1 vssd1 vccd1 vssd1 sky130_fd_sc_hd__decap_3$1
XFILLER_77_39 vssd1 vccd1 vccd1 vssd1 sky130_ef_sc_hd__decap_40_12$1
XTAP_TAPCELL_ROW_129_2235 vccd1 vssd1 sky130_fd_sc_hd__tapvpwrvgnd_1$1
XFILLER_58_577 vssd1 vccd1 vccd1 vssd1 sky130_fd_sc_hd__fill_8$1
XTAP_TAPCELL_ROW_51_1065 vccd1 vssd1 sky130_fd_sc_hd__tapvpwrvgnd_1$1
XTAP_TAPCELL_ROW_5_378 vccd1 vssd1 sky130_fd_sc_hd__tapvpwrvgnd_1$1
XFILLER_93_27 vssd1 vccd1 vccd1 vssd1 sky130_ef_sc_hd__decap_40_12$1
XFILLER_85_385 vssd1 vccd1 vccd1 vssd1 sky130_fd_sc_hd__fill_4$1
XFILLER_73_525 vssd1 vccd1 vccd1 vssd1 sky130_fd_sc_hd__fill_8$1
XFILLER_73_503 vccd1 vssd1 vccd1 vssd1 sky130_fd_sc_hd__fill_1$1
XFILLER_18_419 vccd1 vssd1 vccd1 vssd1 sky130_fd_sc_hd__fill_1$1
XFILLER_39_780 vssd1 vccd1 vccd1 vssd1 sky130_fd_sc_hd__fill_4$1
XFILLER_45_205 vssd1 vccd1 vccd1 vssd1 sky130_ef_sc_hd__decap_40_12$1
XFILLER_61_709 vssd1 vccd1 vccd1 vssd1 sky130_fd_sc_hd__fill_4$1
XFILLER_45_249 vssd1 vccd1 vccd1 vssd1 sky130_ef_sc_hd__decap_40_12$1
XFILLER_26_65 vssd1 vccd1 vccd1 vssd1 sky130_ef_sc_hd__decap_40_12$1
XTAP_TAPCELL_ROW_107_1898 vccd1 vssd1 sky130_fd_sc_hd__tapvpwrvgnd_1$1
XPHY_EDGE_ROW_95_Right_95 vccd1 vssd1 vccd1 vssd1 sky130_fd_sc_hd__decap_3$1
XFILLER_53_293 vssd1 vccd1 vccd1 vssd1 sky130_ef_sc_hd__decap_40_12$1
XFILLER_13_113 vssd1 vccd1 vccd1 vssd1 sky130_ef_sc_hd__decap_40_12$1
XFILLER_14_625 vssd1 vccd1 vccd1 vssd1 sky130_ef_sc_hd__decap_40_12$1
XFILLER_14_669 vssd1 vccd1 vccd1 vssd1 sky130_ef_sc_hd__decap_40_12$1
XTAP_TAPCELL_ROW_24_653 vccd1 vssd1 sky130_fd_sc_hd__tapvpwrvgnd_1$1
XTAP_TAPCELL_ROW_24_664 vccd1 vssd1 sky130_fd_sc_hd__tapvpwrvgnd_1$1
XFILLER_42_53 vssd1 vccd1 vccd1 vssd1 sky130_ef_sc_hd__decap_40_12$1
XFILLER_127_505 vssd1 vccd1 vccd1 vssd1 sky130_ef_sc_hd__decap_40_12$1
XFILLER_6_813 vssd1 vccd1 vccd1 vssd1 sky130_ef_sc_hd__decap_40_12$1
XFILLER_42_97 vssd1 vccd1 vccd1 vssd1 sky130_ef_sc_hd__decap_40_12$1
XFILLER_108_785 vssd1 vccd1 vccd1 vssd1 sky130_ef_sc_hd__decap_40_12$1
XFILLER_107_273 vssd1 vccd1 vccd1 vssd1 sky130_fd_sc_hd__fill_4$1
XFILLER_5_389 vssd1 vccd1 vccd1 vssd1 sky130_fd_sc_hd__fill_2$1
XPHY_EDGE_ROW_2_Left_141 vccd1 vssd1 vccd1 vssd1 sky130_fd_sc_hd__decap_3$1
XPHY_EDGE_ROW_39_Left_178 vccd1 vssd1 vccd1 vssd1 sky130_fd_sc_hd__decap_3$1
XFILLER_122_221 vssd1 vccd1 vccd1 vssd1 sky130_ef_sc_hd__decap_40_12$1
XFILLER_122_265 vssd1 vccd1 vccd1 vssd1 sky130_ef_sc_hd__decap_40_12$1
XFILLER_95_105 vssd1 vccd1 vccd1 vssd1 sky130_fd_sc_hd__fill_4$1
XFILLER_110_438 vssd1 vccd1 vccd1 vssd1 sky130_ef_sc_hd__decap_40_12$1
XFILLER_3_69 vssd1 vccd1 vccd1 vssd1 sky130_ef_sc_hd__decap_40_12$1
XFILLER_1_573 vssd1 vccd1 vccd1 vssd1 sky130_ef_sc_hd__decap_40_12$1
XFILLER_95_149 vssd1 vccd1 vccd1 vssd1 sky130_ef_sc_hd__decap_40_12$1
XFILLER_76_363 vccd1 vssd1 vccd1 vssd1 sky130_fd_sc_hd__fill_1$1
XTAP_TAPCELL_ROW_69_1337 vccd1 vssd1 sky130_fd_sc_hd__tapvpwrvgnd_1$1
XFILLER_64_525 vssd1 vccd1 vccd1 vssd1 sky130_fd_sc_hd__fill_4$1
XFILLER_91_333 vssd1 vccd1 vccd1 vssd1 sky130_fd_sc_hd__fill_2$1
XFILLER_64_569 vssd1 vccd1 vccd1 vssd1 sky130_fd_sc_hd__fill_2$1
XFILLER_52_709 vssd1 vccd1 vccd1 vssd1 sky130_ef_sc_hd__decap_40_12$1
XFILLER_36_249 vssd1 vccd1 vccd1 vssd1 sky130_fd_sc_hd__fill_2$1
XFILLER_17_441 vssd1 vccd1 vccd1 vssd1 sky130_fd_sc_hd__fill_4$1
XFILLER_45_783 vccd1 vssd1 vccd1 vssd1 sky130_fd_sc_hd__fill_1$1
XPHY_EDGE_ROW_48_Left_187 vccd1 vssd1 vccd1 vssd1 sky130_fd_sc_hd__decap_3$1
XFILLER_83_93 vssd1 vccd1 vccd1 vssd1 sky130_ef_sc_hd__decap_40_12$1
XTAP_TAPCELL_ROW_82_1537 vccd1 vssd1 sky130_fd_sc_hd__tapvpwrvgnd_1$1
XTAP_TAPCELL_ROW_82_1526 vccd1 vssd1 sky130_fd_sc_hd__tapvpwrvgnd_1$1
XFILLER_72_580 vssd1 vccd1 vccd1 vssd1 sky130_fd_sc_hd__fill_8$1
XFILLER_17_485 vssd1 vccd1 vccd1 vssd1 sky130_ef_sc_hd__decap_40_12$1
XFILLER_32_433 vssd1 vccd1 vccd1 vssd1 sky130_ef_sc_hd__decap_40_12$1
XTAP_TAPCELL_ROW_43_940 vccd1 vssd1 sky130_fd_sc_hd__tapvpwrvgnd_1$1
XTAP_TAPCELL_ROW_43_951 vccd1 vssd1 sky130_fd_sc_hd__tapvpwrvgnd_1$1
X_0983_ _0739_/D _0982_/X _1013_/A2 hold32/X _1525_/D vssd1 vccd1 vccd1 vssd1 sky130_fd_sc_hd__o211a_1$1
XFILLER_32_477 vssd1 vccd1 vccd1 vssd1 sky130_ef_sc_hd__decap_40_12$1
XFILLER_73_3 vssd1 vccd1 vccd1 vssd1 sky130_ef_sc_hd__decap_40_12$1
XFILLER_9_673 vssd1 vccd1 vccd1 vssd1 sky130_ef_sc_hd__decap_40_12$1
XPHY_EDGE_ROW_57_Left_196 vccd1 vssd1 vccd1 vssd1 sky130_fd_sc_hd__decap_3$1
X_1604_ _1604_/Q _1763_/CLK hold11/X vccd1 vssd1 vccd1 vssd1 sky130_fd_sc_hd__dfxtp_1$1
XFILLER_113_221 vssd1 vccd1 vccd1 vssd1 sky130_fd_sc_hd__fill_2$1
X_1535_ _1535_/Q _1729_/CLK hold84/X vccd1 vssd1 vccd1 vssd1 sky130_fd_sc_hd__dfxtp_1$1
XFILLER_99_422 vssd1 vccd1 vccd1 vssd1 sky130_ef_sc_hd__decap_40_12$1
XTAP_TAPCELL_ROW_93_1699 vccd1 vssd1 sky130_fd_sc_hd__tapvpwrvgnd_1$1
XTAP_TAPCELL_ROW_93_1688 vccd1 vssd1 sky130_fd_sc_hd__tapvpwrvgnd_1$1
XFILLER_87_617 vssd1 vccd1 vccd1 vssd1 sky130_ef_sc_hd__decap_40_12$1
X_1466_ _1760_/Q _1466_/X _1474_/B vssd1 vccd1 vccd1 vssd1 sky130_fd_sc_hd__or2_1$1
XFILLER_101_416 vssd1 vccd1 vccd1 vssd1 sky130_ef_sc_hd__decap_40_12$1
X_1397_ _1471_/C1 _1396_/X _1409_/A2 hold81/X _1726_/D vssd1 vccd1 vccd1 vssd1 sky130_fd_sc_hd__o211a_1$1
XFILLER_101_449 vssd1 vccd1 vccd1 vssd1 sky130_ef_sc_hd__decap_40_12$1
XFILLER_103_15 vssd1 vccd1 vccd1 vssd1 sky130_ef_sc_hd__decap_40_12$1
XFILLER_67_385 vssd1 vccd1 vccd1 vssd1 sky130_fd_sc_hd__fill_4$1
XFILLER_55_503 vccd1 vssd1 vccd1 vssd1 sky130_fd_sc_hd__fill_1$1
XTAP_TAPCELL_ROW_2_337 vccd1 vssd1 sky130_fd_sc_hd__tapvpwrvgnd_1$1
XTAP_TAPCELL_ROW_2_326 vccd1 vssd1 sky130_fd_sc_hd__tapvpwrvgnd_1$1
XFILLER_27_205 vssd1 vccd1 vccd1 vssd1 sky130_ef_sc_hd__decap_40_12$1
XTAP_TAPCELL_ROW_124_2154 vccd1 vssd1 sky130_fd_sc_hd__tapvpwrvgnd_1$1
XFILLER_94_193 vssd1 vccd1 vccd1 vssd1 sky130_fd_sc_hd__fill_2$1
XFILLER_82_333 vssd1 vccd1 vccd1 vssd1 sky130_ef_sc_hd__decap_40_12$1
XFILLER_27_249 vssd1 vccd1 vccd1 vssd1 sky130_ef_sc_hd__decap_40_12$1
XTAP_TAPCELL_ROW_124_2165 vccd1 vssd1 sky130_fd_sc_hd__tapvpwrvgnd_1$1
XFILLER_70_506 vssd1 vccd1 vccd1 vssd1 sky130_ef_sc_hd__decap_40_12$1
XFILLER_36_794 vccd1 vssd1 vccd1 vssd1 sky130_fd_sc_hd__fill_1$1
XFILLER_35_293 vssd1 vccd1 vccd1 vssd1 sky130_ef_sc_hd__decap_40_12$1
XFILLER_51_797 vssd1 vccd1 vccd1 vssd1 sky130_fd_sc_hd__fill_8$1
XFILLER_11_617 vssd1 vccd1 vccd1 vssd1 sky130_ef_sc_hd__decap_40_12$1
XTAP_TAPCELL_ROW_21_612 vccd1 vssd1 sky130_fd_sc_hd__tapvpwrvgnd_1$1
XFILLER_137_803 vssd1 vccd1 vccd1 vssd1 sky130_fd_sc_hd__fill_8$1
XFILLER_109_505 vssd1 vccd1 vccd1 vssd1 sky130_ef_sc_hd__decap_40_12$1
XFILLER_6_109 vssd1 vccd1 vccd1 vssd1 sky130_ef_sc_hd__decap_40_12$1
XFILLER_136_357 vssd1 vccd1 vccd1 vssd1 sky130_fd_sc_hd__fill_4$1
XFILLER_88_27 vccd1 vssd1 vccd1 vssd1 sky130_fd_sc_hd__fill_1$1
Xhold150 _1565_/Q _1064_/A vssd1 vccd1 vccd1 vssd1 sky130_fd_sc_hd__dlygate4sd3_1$1
XFILLER_105_755 vssd1 vccd1 vccd1 vssd1 sky130_ef_sc_hd__decap_40_12$1
Xhold161 _1538_/Q _1008_/A vssd1 vccd1 vccd1 vssd1 sky130_fd_sc_hd__dlygate4sd3_1$1
XFILLER_104_221 vssd1 vccd1 vccd1 vssd1 sky130_ef_sc_hd__decap_40_12$1
Xhold172 input25/X hold172/X vssd1 vccd1 vccd1 vssd1 sky130_fd_sc_hd__dlygate4sd3_1$1
Xhold183 input50/X hold183/X vssd1 vccd1 vccd1 vssd1 sky130_fd_sc_hd__dlygate4sd3_1$1
XFILLER_104_265 vssd1 vccd1 vccd1 vssd1 sky130_ef_sc_hd__decap_40_12$1
Xhold194 _1620_/Q _1178_/A vssd1 vccd1 vccd1 vssd1 sky130_fd_sc_hd__dlygate4sd3_1$1
XFILLER_132_585 vssd1 vccd1 vccd1 vssd1 sky130_fd_sc_hd__fill_2$1
XFILLER_120_725 vssd1 vccd1 vccd1 vssd1 sky130_ef_sc_hd__decap_40_12$1
XFILLER_77_105 vssd1 vccd1 vccd1 vssd1 sky130_fd_sc_hd__fill_4$1
XFILLER_93_609 vssd1 vccd1 vccd1 vssd1 sky130_fd_sc_hd__fill_4$1
XFILLER_86_650 vssd1 vccd1 vccd1 vssd1 sky130_ef_sc_hd__decap_40_12$1
XFILLER_77_149 vssd1 vccd1 vccd1 vssd1 sky130_ef_sc_hd__decap_40_12$1
XTAP_TAPCELL_ROW_109_1938 vccd1 vssd1 sky130_fd_sc_hd__tapvpwrvgnd_1$1
XFILLER_58_363 vccd1 vssd1 vccd1 vssd1 sky130_fd_sc_hd__fill_1$1
XFILLER_85_193 vssd1 vccd1 vccd1 vssd1 sky130_ef_sc_hd__decap_40_12$1
XFILLER_73_333 vssd1 vccd1 vccd1 vssd1 sky130_fd_sc_hd__fill_2$1
XFILLER_18_249 vssd1 vccd1 vccd1 vssd1 sky130_fd_sc_hd__fill_2$1
XTAP_TAPCELL_ROW_29_734 vccd1 vssd1 sky130_fd_sc_hd__tapvpwrvgnd_1$1
XFILLER_61_517 vssd1 vccd1 vccd1 vssd1 sky130_ef_sc_hd__decap_40_12$1
XFILLER_46_569 vssd1 vccd1 vccd1 vssd1 sky130_ef_sc_hd__decap_40_12$1
XFILLER_73_388 vssd1 vccd1 vccd1 vssd1 sky130_fd_sc_hd__fill_4$1
XFILLER_27_783 vccd1 vssd1 vccd1 vssd1 sky130_fd_sc_hd__fill_1$1
XTAP_TAPCELL_ROW_64_1267 vccd1 vssd1 sky130_fd_sc_hd__tapvpwrvgnd_1$1
XTAP_TAPCELL_ROW_64_1256 vccd1 vssd1 sky130_fd_sc_hd__tapvpwrvgnd_1$1
XFILLER_14_433 vssd1 vccd1 vccd1 vssd1 sky130_ef_sc_hd__decap_40_12$1
XFILLER_14_477 vssd1 vccd1 vccd1 vssd1 sky130_ef_sc_hd__decap_40_12$1
XFILLER_42_797 vssd1 vccd1 vccd1 vssd1 sky130_fd_sc_hd__fill_4$1
XFILLER_128_825 vccd1 vssd1 vccd1 vssd1 sky130_fd_sc_hd__fill_1$1
XFILLER_127_335 vccd1 vssd1 vccd1 vssd1 sky130_fd_sc_hd__fill_1$1
XFILLER_6_643 vccd1 vssd1 vccd1 vssd1 sky130_fd_sc_hd__fill_1$1
XFILLER_69_617 vssd1 vccd1 vccd1 vssd1 sky130_fd_sc_hd__fill_8$1
X_1320_ _1320_/A _1320_/X _1330_/B vssd1 vccd1 vccd1 vssd1 sky130_fd_sc_hd__or2_1$1
XFILLER_111_725 vssd1 vccd1 vccd1 vssd1 sky130_fd_sc_hd__fill_2$1
X_1251_ _1455_/C1 _1250_/X _1277_/A2 hold98/X _1655_/D vssd1 vccd1 vccd1 vssd1 sky130_fd_sc_hd__o211a_1$1
X_1182_ _1622_/Q _1182_/X _1210_/B vssd1 vccd1 vccd1 vssd1 sky130_fd_sc_hd__or2_1$1
XFILLER_65_823 vccd1 vssd1 vccd1 vssd1 sky130_fd_sc_hd__fill_1$1
XFILLER_37_503 vccd1 vssd1 vccd1 vssd1 sky130_fd_sc_hd__fill_1$1
XFILLER_94_81 vssd1 vccd1 vccd1 vssd1 sky130_fd_sc_hd__fill_2$1
XFILLER_76_193 vssd1 vccd1 vccd1 vssd1 sky130_fd_sc_hd__fill_2$1
XFILLER_64_333 vssd1 vccd1 vccd1 vssd1 sky130_ef_sc_hd__decap_40_12$1
XFILLER_37_558 vssd1 vccd1 vccd1 vssd1 sky130_fd_sc_hd__fill_2$1
XFILLER_49_385 vssd1 vccd1 vccd1 vssd1 sky130_fd_sc_hd__fill_4$1
XFILLER_64_377 vssd1 vccd1 vccd1 vssd1 sky130_fd_sc_hd__fill_4$1
XFILLER_92_697 vssd1 vccd1 vccd1 vssd1 sky130_fd_sc_hd__fill_2$1
XFILLER_17_293 vssd1 vccd1 vccd1 vssd1 sky130_ef_sc_hd__decap_40_12$1
Xclkbuf_leaf_9_wb_clk_i _1757_/CLK clkbuf_leaf_9_wb_clk_i/A vssd1 vccd1 vccd1 vssd1
+ sky130_fd_sc_hd__clkbuf_8$1
XPHY_EDGE_ROW_65_Left_204 vccd1 vssd1 vccd1 vssd1 sky130_fd_sc_hd__decap_3$1
XFILLER_20_469 vssd1 vccd1 vccd1 vssd1 sky130_fd_sc_hd__fill_4$1
X_0966_ _0966_/A _0966_/X _0990_/B vssd1 vccd1 vccd1 vssd1 sky130_fd_sc_hd__or2_1$1
XFILLER_118_357 vssd1 vccd1 vccd1 vssd1 sky130_fd_sc_hd__fill_4$1
XTAP_TAPCELL_ROW_95_1728 vccd1 vssd1 sky130_fd_sc_hd__tapvpwrvgnd_1$1
Xoutput200 _1484_/Q wbs_dat_o[7] vssd1 vccd1 vccd1 vssd1 sky130_fd_sc_hd__buf_12$1
XFILLER_133_305 vssd1 vccd1 vccd1 vssd1 sky130_ef_sc_hd__decap_40_12$1
X_0897_ _0945_/A _0897_/X _0897_/B _0897_/C vccd1 vssd1 vccd1 vssd1 sky130_fd_sc_hd__or3_1$1
XFILLER_133_349 vssd1 vccd1 vccd1 vssd1 sky130_ef_sc_hd__decap_40_12$1
XTAP_TAPCELL_ROW_7_407 vccd1 vssd1 sky130_fd_sc_hd__tapvpwrvgnd_1$1
XFILLER_114_585 vssd1 vccd1 vccd1 vssd1 sky130_fd_sc_hd__fill_2$1
XFILLER_102_725 vssd1 vccd1 vccd1 vssd1 sky130_ef_sc_hd__decap_40_12$1
X_1518_ _1518_/Q clkload3/A _1518_/D vccd1 vssd1 vccd1 vssd1 sky130_fd_sc_hd__dfxtp_1$1
XFILLER_59_105 vssd1 vccd1 vccd1 vssd1 sky130_fd_sc_hd__fill_4$1
X_1449_ _1449_/C1 _1448_/X _1465_/A2 hold98/X _1751_/D vssd1 vccd1 vccd1 vssd1 sky130_fd_sc_hd__o211a_1$1
XFILLER_59_149 vssd1 vccd1 vccd1 vssd1 sky130_ef_sc_hd__decap_40_12$1
XFILLER_101_279 vccd1 vssd1 vccd1 vssd1 sky130_fd_sc_hd__fill_1$1
XPHY_EDGE_ROW_74_Left_213 vccd1 vssd1 vccd1 vssd1 sky130_fd_sc_hd__decap_3$1
XFILLER_74_29 vssd1 vccd1 vccd1 vssd1 sky130_ef_sc_hd__decap_40_12$1
XFILLER_67_193 vssd1 vccd1 vccd1 vssd1 sky130_ef_sc_hd__decap_40_12$1
XFILLER_55_333 vssd1 vccd1 vccd1 vssd1 sky130_fd_sc_hd__fill_2$1
XFILLER_28_525 vssd1 vccd1 vccd1 vssd1 sky130_fd_sc_hd__fill_4$1
XFILLER_82_141 vssd1 vccd1 vccd1 vssd1 sky130_ef_sc_hd__decap_40_12$1
XFILLER_28_569 vssd1 vccd1 vccd1 vssd1 sky130_ef_sc_hd__decap_40_12$1
XFILLER_43_517 vssd1 vccd1 vccd1 vssd1 sky130_ef_sc_hd__decap_40_12$1
XTAP_TAPCELL_ROW_104_1857 vccd1 vssd1 sky130_fd_sc_hd__tapvpwrvgnd_1$1
XPHY_EDGE_ROW_83_Left_222 vccd1 vssd1 vccd1 vssd1 sky130_fd_sc_hd__decap_3$1
XFILLER_51_594 vssd1 vccd1 vccd1 vssd1 sky130_ef_sc_hd__decap_40_12$1
XFILLER_11_447 vccd1 vssd1 vccd1 vssd1 sky130_fd_sc_hd__fill_1$1
XFILLER_23_55 vccd1 vssd1 vccd1 vssd1 sky130_fd_sc_hd__fill_1$1
XFILLER_137_611 vssd1 vccd1 vccd1 vssd1 sky130_fd_sc_hd__fill_4$1
XTAP_TAPCELL_ROW_137_2356 vccd1 vssd1 sky130_fd_sc_hd__tapvpwrvgnd_1$1
XFILLER_7_429 vssd1 vccd1 vccd1 vssd1 sky130_ef_sc_hd__decap_40_12$1
XFILLER_109_335 vccd1 vssd1 vccd1 vssd1 sky130_fd_sc_hd__fill_1$1
XFILLER_99_15 vssd1 vccd1 vccd1 vssd1 sky130_ef_sc_hd__decap_40_12$1
XFILLER_136_165 vssd1 vccd1 vccd1 vssd1 sky130_ef_sc_hd__decap_40_12$1
XFILLER_124_305 vssd1 vccd1 vccd1 vssd1 sky130_fd_sc_hd__fill_2$1
XFILLER_3_613 vssd1 vccd1 vccd1 vssd1 sky130_fd_sc_hd__fill_2$1
XFILLER_105_541 vssd1 vccd1 vccd1 vssd1 sky130_ef_sc_hd__decap_40_12$1
XFILLER_3_3 vssd1 vccd1 vccd1 vssd1 sky130_ef_sc_hd__decap_40_12$1
XPHY_EDGE_ROW_92_Left_231 vccd1 vssd1 vccd1 vssd1 sky130_fd_sc_hd__decap_3$1
XFILLER_2_189 vssd1 vccd1 vccd1 vssd1 sky130_fd_sc_hd__fill_4$1
XFILLER_120_533 vssd1 vccd1 vccd1 vssd1 sky130_ef_sc_hd__decap_40_12$1
XFILLER_48_41 vssd1 vccd1 vccd1 vssd1 sky130_ef_sc_hd__decap_40_12$1
XFILLER_19_503 vccd1 vssd1 vccd1 vssd1 sky130_fd_sc_hd__fill_1$1
XFILLER_48_85 vssd1 vccd1 vccd1 vssd1 sky130_ef_sc_hd__decap_40_12$1
XFILLER_74_631 vccd1 vssd1 vccd1 vssd1 sky130_fd_sc_hd__fill_1$1
XFILLER_58_193 vssd1 vccd1 vccd1 vssd1 sky130_fd_sc_hd__fill_2$1
XFILLER_0_15 vssd1 vccd1 vccd1 vssd1 sky130_ef_sc_hd__decap_40_12$1
XFILLER_46_333 vssd1 vccd1 vccd1 vssd1 sky130_ef_sc_hd__decap_40_12$1
XFILLER_74_697 vssd1 vccd1 vccd1 vssd1 sky130_fd_sc_hd__fill_2$1
XFILLER_46_377 vssd1 vccd1 vccd1 vssd1 sky130_ef_sc_hd__decap_40_12$1
XFILLER_15_753 vssd1 vccd1 vccd1 vssd1 sky130_ef_sc_hd__decap_40_12$1
XFILLER_15_797 vssd1 vccd1 vccd1 vssd1 sky130_ef_sc_hd__decap_40_12$1
XFILLER_30_701 vssd1 vccd1 vccd1 vssd1 sky130_ef_sc_hd__decap_40_12$1
XFILLER_9_57 vssd1 vccd1 vccd1 vssd1 sky130_ef_sc_hd__decap_40_12$1
XFILLER_128_600 vssd1 vccd1 vccd1 vssd1 sky130_fd_sc_hd__fill_2$1
XFILLER_128_611 vssd1 vccd1 vccd1 vssd1 sky130_ef_sc_hd__decap_40_12$1
XFILLER_80_83 vccd1 vssd1 vccd1 vssd1 sky130_fd_sc_hd__fill_1$1
X_0820_ _1820_/A _0878_/A2 _0820_/X _1852_/A _0881_/B1 vccd1 vssd1 vccd1 vssd1 sky130_fd_sc_hd__a22o_1$1
X_0751_ hold5/A hold8/A _0752_/B hold17/A hold24/A vccd1 vssd1 vccd1 vssd1 sky130_fd_sc_hd__or4_2$1
XFILLER_116_806 vccd1 vssd1 vccd1 vssd1 sky130_fd_sc_hd__fill_1$1
XTAP_TAPCELL_ROW_12_475 vccd1 vssd1 sky130_fd_sc_hd__tapvpwrvgnd_1$1
XTAP_TAPCELL_ROW_12_486 vccd1 vssd1 sky130_fd_sc_hd__tapvpwrvgnd_1$1
XFILLER_128_699 vccd1 vssd1 vccd1 vssd1 sky130_fd_sc_hd__fill_1$1
XFILLER_127_165 vssd1 vccd1 vccd1 vssd1 sky130_fd_sc_hd__fill_2$1
XFILLER_115_305 vssd1 vccd1 vccd1 vssd1 sky130_ef_sc_hd__decap_40_12$1
XFILLER_115_349 vssd1 vccd1 vccd1 vssd1 sky130_ef_sc_hd__decap_40_12$1
XTAP_TAPCELL_ROW_77_1458 vccd1 vssd1 sky130_fd_sc_hd__tapvpwrvgnd_1$1
XFILLER_6_473 vssd1 vccd1 vccd1 vssd1 sky130_fd_sc_hd__fill_2$1
XFILLER_89_81 vssd1 vccd1 vccd1 vssd1 sky130_ef_sc_hd__decap_40_12$1
XTAP_TAPCELL_ROW_90_1647 vccd1 vssd1 sky130_fd_sc_hd__tapvpwrvgnd_1$1
XFILLER_36_3 vssd1 vccd1 vccd1 vssd1 sky130_ef_sc_hd__decap_40_12$1
XFILLER_97_778 vssd1 vccd1 vccd1 vssd1 sky130_fd_sc_hd__fill_4$1
XFILLER_96_233 vssd1 vccd1 vccd1 vssd1 sky130_ef_sc_hd__decap_40_12$1
XFILLER_57_609 vssd1 vccd1 vccd1 vssd1 sky130_fd_sc_hd__fill_4$1
X_1303_ _1387_/C1 _1302_/X _1331_/A2 hold210/X _1680_/D vssd1 vccd1 vccd1 vssd1 sky130_fd_sc_hd__o211a_1$1
XFILLER_96_277 vssd1 vccd1 vccd1 vssd1 sky130_ef_sc_hd__decap_40_12$1
X_1234_ _1647_/Q _1234_/X _1270_/B vssd1 vccd1 vccd1 vssd1 sky130_fd_sc_hd__or2_1$1
XFILLER_37_333 vssd1 vccd1 vccd1 vssd1 sky130_fd_sc_hd__fill_2$1
XFILLER_49_193 vssd1 vccd1 vccd1 vssd1 sky130_ef_sc_hd__decap_40_12$1
XFILLER_80_601 vssd1 vccd1 vccd1 vssd1 sky130_ef_sc_hd__decap_40_12$1
XFILLER_64_141 vssd1 vccd1 vccd1 vssd1 sky130_ef_sc_hd__decap_40_12$1
X_1165_ _1387_/C1 _1164_/X _1189_/A2 hold183/X _1613_/D vssd1 vccd1 vccd1 vssd1 sky130_fd_sc_hd__o211a_1$1
XTAP_TAPCELL_ROW_121_2113 vccd1 vssd1 sky130_fd_sc_hd__tapvpwrvgnd_1$1
XFILLER_65_697 vssd1 vccd1 vccd1 vssd1 sky130_ef_sc_hd__decap_40_12$1
XFILLER_25_517 vssd1 vccd1 vccd1 vssd1 sky130_ef_sc_hd__decap_40_12$1
X_1096_ _1798_/A _1096_/X _1122_/B vssd1 vccd1 vccd1 vssd1 sky130_fd_sc_hd__or2_1$1
XFILLER_80_645 vssd1 vccd1 vccd1 vssd1 sky130_ef_sc_hd__decap_40_12$1
XFILLER_100_27 vccd1 vssd1 vccd1 vssd1 sky130_fd_sc_hd__fill_1$1
XFILLER_33_561 vssd1 vccd1 vccd1 vssd1 sky130_ef_sc_hd__decap_40_12$1
XFILLER_20_233 vssd1 vccd1 vccd1 vssd1 sky130_ef_sc_hd__decap_40_12$1
XFILLER_138_419 vccd1 vssd1 vccd1 vssd1 sky130_fd_sc_hd__fill_1$1
XTAP_TAPCELL_ROW_31_762 vccd1 vssd1 sky130_fd_sc_hd__tapvpwrvgnd_1$1
XTAP_TAPCELL_ROW_119_2086 vccd1 vssd1 sky130_fd_sc_hd__tapvpwrvgnd_1$1
XFILLER_118_121 vssd1 vccd1 vccd1 vssd1 sky130_ef_sc_hd__decap_40_12$1
XFILLER_20_277 vssd1 vccd1 vccd1 vssd1 sky130_ef_sc_hd__decap_40_12$1
XFILLER_118_165 vssd1 vccd1 vccd1 vssd1 sky130_ef_sc_hd__decap_40_12$1
X_0949_ _0949_/Y _0949_/A _1411_/B vssd1 vccd1 vccd1 vssd1 sky130_fd_sc_hd__nand2_2$1
XFILLER_106_305 vssd1 vccd1 vccd1 vssd1 sky130_fd_sc_hd__fill_2$1
XFILLER_133_113 vssd1 vccd1 vccd1 vssd1 sky130_ef_sc_hd__decap_40_12$1
XFILLER_109_69 vssd1 vccd1 vccd1 vssd1 sky130_ef_sc_hd__decap_40_12$1
XTAP_TAPCELL_ROW_132_2286 vccd1 vssd1 sky130_fd_sc_hd__tapvpwrvgnd_1$1
XTAP_TAPCELL_ROW_132_2275 vccd1 vssd1 sky130_fd_sc_hd__tapvpwrvgnd_1$1
XFILLER_122_809 vssd1 vccd1 vccd1 vssd1 sky130_fd_sc_hd__fill_2$1
XFILLER_88_701 vssd1 vccd1 vccd1 vssd1 sky130_ef_sc_hd__decap_40_12$1
XFILLER_125_57 vssd1 vccd1 vccd1 vssd1 sky130_ef_sc_hd__decap_40_12$1
XFILLER_87_277 vssd1 vccd1 vccd1 vssd1 sky130_fd_sc_hd__fill_2$1
XFILLER_85_39 vssd1 vccd1 vccd1 vssd1 sky130_ef_sc_hd__decap_40_12$1
XFILLER_75_417 vssd1 vccd1 vccd1 vssd1 sky130_ef_sc_hd__decap_40_12$1
XFILLER_56_642 vssd1 vccd1 vccd1 vssd1 sky130_fd_sc_hd__fill_2$1
XFILLER_28_333 vssd1 vccd1 vccd1 vssd1 sky130_ef_sc_hd__decap_40_12$1
XFILLER_83_461 vssd1 vccd1 vccd1 vssd1 sky130_ef_sc_hd__decap_40_12$1
XFILLER_18_77 vssd1 vccd1 vccd1 vssd1 sky130_fd_sc_hd__fill_4$1
XFILLER_56_697 vssd1 vccd1 vccd1 vssd1 sky130_fd_sc_hd__fill_2$1
XFILLER_28_377 vssd1 vccd1 vccd1 vssd1 sky130_ef_sc_hd__decap_40_12$1
XTAP_TAPCELL_ROW_39_884 vccd1 vssd1 sky130_fd_sc_hd__tapvpwrvgnd_1$1
XTAP_TAPCELL_ROW_48_1015 vccd1 vssd1 sky130_fd_sc_hd__tapvpwrvgnd_1$1
XTAP_TAPCELL_ROW_48_1026 vccd1 vssd1 sky130_fd_sc_hd__tapvpwrvgnd_1$1
XFILLER_70_133 vssd1 vccd1 vccd1 vssd1 sky130_fd_sc_hd__fill_4$1
XFILLER_71_689 vssd1 vccd1 vccd1 vssd1 sky130_fd_sc_hd__fill_2$1
XFILLER_70_177 vssd1 vccd1 vccd1 vssd1 sky130_ef_sc_hd__decap_40_12$1
XTAP_TAPCELL_ROW_61_1215 vccd1 vssd1 sky130_fd_sc_hd__tapvpwrvgnd_1$1
XFILLER_12_701 vssd1 vccd1 vccd1 vssd1 sky130_ef_sc_hd__decap_40_12$1
XFILLER_51_391 vccd1 vssd1 vccd1 vssd1 sky130_fd_sc_hd__fill_1$1
XFILLER_34_65 vssd1 vccd1 vccd1 vssd1 sky130_ef_sc_hd__decap_40_12$1
XFILLER_11_277 vssd1 vccd1 vccd1 vssd1 sky130_fd_sc_hd__fill_2$1
XFILLER_8_749 vssd1 vccd1 vccd1 vssd1 sky130_fd_sc_hd__fill_4$1
XFILLER_7_237 vssd1 vccd1 vccd1 vssd1 sky130_ef_sc_hd__decap_40_12$1
XFILLER_125_614 vssd1 vccd1 vccd1 vssd1 sky130_fd_sc_hd__fill_2$1
XFILLER_109_165 vssd1 vccd1 vccd1 vssd1 sky130_fd_sc_hd__fill_2$1
XFILLER_50_53 vssd1 vccd1 vccd1 vssd1 sky130_ef_sc_hd__decap_40_12$1
XFILLER_137_496 vssd1 vccd1 vccd1 vssd1 sky130_fd_sc_hd__fill_8$1
XFILLER_50_97 vssd1 vccd1 vccd1 vssd1 sky130_ef_sc_hd__decap_40_12$1
XFILLER_113_809 vssd1 vccd1 vccd1 vssd1 sky130_ef_sc_hd__decap_40_12$1
XTAP_TAPCELL_ROW_59_1188 vccd1 vssd1 sky130_fd_sc_hd__tapvpwrvgnd_1$1
XFILLER_79_723 vssd1 vccd1 vccd1 vssd1 sky130_fd_sc_hd__fill_4$1
XFILLER_59_51 vssd1 vccd1 vccd1 vssd1 sky130_fd_sc_hd__fill_4$1
XFILLER_105_393 vssd1 vccd1 vccd1 vssd1 sky130_fd_sc_hd__fill_4$1
XFILLER_78_233 vssd1 vccd1 vccd1 vssd1 sky130_ef_sc_hd__decap_40_12$1
XTAP_TAPCELL_ROW_72_1377 vccd1 vssd1 sky130_fd_sc_hd__tapvpwrvgnd_1$1
XFILLER_120_363 vccd1 vssd1 vccd1 vssd1 sky130_fd_sc_hd__fill_1$1
XFILLER_94_737 vssd1 vccd1 vccd1 vssd1 sky130_fd_sc_hd__fill_8$1
XFILLER_78_277 vssd1 vccd1 vccd1 vssd1 sky130_ef_sc_hd__decap_40_12$1
XFILLER_93_225 vssd1 vccd1 vccd1 vssd1 sky130_ef_sc_hd__decap_40_12$1
XFILLER_19_333 vssd1 vccd1 vccd1 vssd1 sky130_fd_sc_hd__fill_2$1
XFILLER_46_141 vssd1 vccd1 vccd1 vssd1 sky130_ef_sc_hd__decap_40_12$1
XFILLER_47_653 vssd1 vccd1 vccd1 vssd1 sky130_ef_sc_hd__decap_40_12$1
XFILLER_74_461 vssd1 vccd1 vccd1 vssd1 sky130_ef_sc_hd__decap_40_12$1
XFILLER_62_601 vssd1 vccd1 vccd1 vssd1 sky130_ef_sc_hd__decap_40_12$1
XFILLER_62_645 vssd1 vccd1 vccd1 vssd1 sky130_ef_sc_hd__decap_40_12$1
XFILLER_61_111 vccd1 vssd1 vccd1 vssd1 sky130_fd_sc_hd__fill_1$1
XFILLER_15_561 vssd1 vccd1 vccd1 vssd1 sky130_ef_sc_hd__decap_40_12$1
XTAP_TAPCELL_ROW_17_556 vccd1 vssd1 sky130_fd_sc_hd__tapvpwrvgnd_1$1
XFILLER_91_93 vssd1 vccd1 vccd1 vssd1 sky130_ef_sc_hd__decap_40_12$1
XFILLER_30_531 vccd1 vssd1 vccd1 vssd1 sky130_fd_sc_hd__fill_1$1
X_1852_ vccd1 vssd1 _1852_/X _1852_/A vccd1 vssd1 sky130_fd_sc_hd__buf_2$1
X_0803_ _0803_/X _0906_/B1 _1549_/Q _1645_/Q _0866_/B1 vssd1 vccd1 _0802_/X vccd1
+ vssd1 sky130_fd_sc_hd__a221o_1$1
XFILLER_128_452 vssd1 vccd1 vccd1 vssd1 sky130_ef_sc_hd__decap_40_12$1
X_1783_ _1783_/A _1783_/X vssd1 vccd1 vccd1 vssd1 sky130_fd_sc_hd__clkbuf_2$1
XFILLER_115_113 vssd1 vccd1 vccd1 vssd1 sky130_ef_sc_hd__decap_40_12$1
XFILLER_131_617 vssd1 vccd1 vccd1 vssd1 sky130_ef_sc_hd__decap_40_12$1
XFILLER_97_553 vssd1 vccd1 vccd1 vssd1 sky130_fd_sc_hd__fill_4$1
XFILLER_69_277 vssd1 vccd1 vccd1 vssd1 sky130_fd_sc_hd__fill_2$1
XFILLER_85_759 vssd1 vccd1 vccd1 vssd1 sky130_ef_sc_hd__decap_40_12$1
X_1217_ _1441_/C1 _1216_/X _1273_/A2 hold73/X _1638_/D vssd1 vccd1 vccd1 vssd1 sky130_fd_sc_hd__o211a_1$1
XFILLER_93_781 vssd1 vccd1 vccd1 vssd1 sky130_fd_sc_hd__fill_2$1
XFILLER_65_461 vssd1 vccd1 vccd1 vssd1 sky130_ef_sc_hd__decap_40_12$1
XFILLER_38_697 vssd1 vccd1 vccd1 vssd1 sky130_fd_sc_hd__fill_2$1
XFILLER_111_15 vssd1 vccd1 vccd1 vssd1 sky130_ef_sc_hd__decap_40_12$1
XFILLER_52_133 vssd1 vccd1 vccd1 vssd1 sky130_fd_sc_hd__fill_4$1
XTAP_TAPCELL_ROW_36_843 vccd1 vssd1 sky130_fd_sc_hd__tapvpwrvgnd_1$1
X_1148_ _1792_/A _1148_/X _1188_/B vssd1 vccd1 vccd1 vssd1 sky130_fd_sc_hd__or2_1$1
X_1079_ _1409_/C1 _1078_/X _1079_/A2 hold2/X _1572_/D vssd1 vccd1 vccd1 vssd1 sky130_fd_sc_hd__o211a_1$1
XTAP_TAPCELL_ROW_101_1816 vccd1 vssd1 sky130_fd_sc_hd__tapvpwrvgnd_1$1
XFILLER_53_689 vssd1 vccd1 vccd1 vssd1 sky130_ef_sc_hd__decap_40_12$1
XFILLER_52_177 vssd1 vccd1 vccd1 vssd1 sky130_ef_sc_hd__decap_40_12$1
XFILLER_33_391 vccd1 vssd1 vccd1 vssd1 sky130_fd_sc_hd__fill_1$1
XFILLER_21_553 vssd1 vccd1 vccd1 vssd1 sky130_fd_sc_hd__fill_4$1
XFILLER_138_249 vssd1 vccd1 vccd1 vssd1 sky130_fd_sc_hd__fill_2$1
XTAP_TAPCELL_ROW_134_2315 vccd1 vssd1 sky130_fd_sc_hd__tapvpwrvgnd_1$1
XTAP_TAPCELL_ROW_134_2304 vccd1 vssd1 sky130_fd_sc_hd__tapvpwrvgnd_1$1
XFILLER_21_597 vssd1 vccd1 vccd1 vssd1 sky130_ef_sc_hd__decap_40_12$1
XFILLER_119_463 vccd1 vssd1 vccd1 vssd1 sky130_fd_sc_hd__fill_1$1
XFILLER_121_105 vssd1 vccd1 vccd1 vssd1 sky130_fd_sc_hd__fill_4$1
XFILLER_136_89 vssd1 vccd1 vccd1 vssd1 sky130_fd_sc_hd__fill_2$1
XFILLER_121_149 vssd1 vccd1 vccd1 vssd1 sky130_ef_sc_hd__decap_40_12$1
XTAP_TAPCELL_ROW_112_1978 vccd1 vssd1 sky130_fd_sc_hd__tapvpwrvgnd_1$1
XFILLER_96_27 vccd1 vssd1 vccd1 vssd1 sky130_fd_sc_hd__fill_1$1
Xhold10 hold10/A hold10/X vssd1 vccd1 vccd1 vssd1 sky130_fd_sc_hd__dlygate4sd3_1$1
Xhold32 hold32/A hold32/X vssd1 vccd1 vccd1 vssd1 sky130_fd_sc_hd__dlygate4sd3_1$1
Xhold21 hold21/A hold21/X vssd1 vccd1 vccd1 vssd1 sky130_fd_sc_hd__dlygate4sd3_1$1
XFILLER_102_363 vccd1 vssd1 vccd1 vssd1 sky130_fd_sc_hd__fill_1$1
XFILLER_48_417 vssd1 vccd1 vccd1 vssd1 sky130_fd_sc_hd__fill_2$1
Xhold54 wbs_dat_i[12] hold54/X vssd1 vccd1 vccd1 vssd1 sky130_fd_sc_hd__dlygate4sd3_1$1
Xhold65 hold65/A hold65/X vssd1 vccd1 vccd1 vssd1 sky130_fd_sc_hd__dlygate4sd3_1$1
Xhold43 hold43/A hold43/X vssd1 vccd1 vccd1 vssd1 sky130_fd_sc_hd__dlygate4sd3_1$1
XFILLER_76_737 vssd1 vccd1 vccd1 vssd1 sky130_fd_sc_hd__fill_2$1
XFILLER_75_225 vssd1 vccd1 vccd1 vssd1 sky130_ef_sc_hd__decap_40_12$1
Xhold76 hold76/A hold76/X vssd1 vccd1 vccd1 vssd1 sky130_fd_sc_hd__dlygate4sd3_1$1
Xhold98 hold98/A hold98/X vssd1 vccd1 vccd1 vssd1 sky130_fd_sc_hd__dlygate4sd3_1$1
Xhold87 hold87/A hold87/X vssd1 vccd1 vccd1 vssd1 sky130_fd_sc_hd__dlygate4sd3_1$1
XFILLER_91_718 vccd1 vssd1 vccd1 vssd1 sky130_fd_sc_hd__fill_1$1
XFILLER_28_141 vssd1 vccd1 vccd1 vssd1 sky130_ef_sc_hd__decap_40_12$1
XFILLER_29_653 vssd1 vccd1 vccd1 vssd1 sky130_ef_sc_hd__decap_40_12$1
XFILLER_84_781 vssd1 vccd1 vccd1 vssd1 sky130_ef_sc_hd__decap_40_12$1
XFILLER_29_697 vssd1 vccd1 vccd1 vssd1 sky130_ef_sc_hd__decap_40_12$1
XFILLER_44_601 vssd1 vccd1 vccd1 vssd1 sky130_ef_sc_hd__decap_40_12$1
XFILLER_43_111 vccd1 vssd1 vccd1 vssd1 sky130_fd_sc_hd__fill_1$1
XFILLER_44_645 vssd1 vccd1 vccd1 vssd1 sky130_fd_sc_hd__fill_8$1
XTAP_TAPCELL_ROW_14_504 vccd1 vssd1 sky130_fd_sc_hd__tapvpwrvgnd_1$1
XFILLER_31_317 vssd1 vccd1 vccd1 vssd1 sky130_ef_sc_hd__decap_40_12$1
XTAP_TAPCELL_ROW_14_515 vccd1 vssd1 sky130_fd_sc_hd__tapvpwrvgnd_1$1
XFILLER_129_205 vssd1 vccd1 vccd1 vssd1 sky130_ef_sc_hd__decap_40_12$1
XFILLER_101_81 vssd1 vccd1 vccd1 vssd1 sky130_ef_sc_hd__decap_40_12$1
XFILLER_8_513 vssd1 vccd1 vccd1 vssd1 sky130_ef_sc_hd__decap_40_12$1
XFILLER_12_531 vccd1 vssd1 vccd1 vssd1 sky130_fd_sc_hd__fill_1$1
XFILLER_8_557 vssd1 vccd1 vccd1 vssd1 sky130_ef_sc_hd__decap_40_12$1
XANTENNA_7 hold78/A vssd1 vccd1 vccd1 vssd1 sky130_fd_sc_hd__diode_2$1
XPHY_EDGE_ROW_20_Left_159 vccd1 vssd1 vccd1 vssd1 sky130_fd_sc_hd__decap_3$1
XFILLER_99_807 vccd1 vssd1 vccd1 vssd1 sky130_fd_sc_hd__fill_1$1
XTAP_TAPCELL_ROW_74_1417 vccd1 vssd1 sky130_fd_sc_hd__tapvpwrvgnd_1$1
XTAP_TAPCELL_ROW_74_1406 vccd1 vssd1 sky130_fd_sc_hd__tapvpwrvgnd_1$1
XFILLER_106_691 vssd1 vccd1 vccd1 vssd1 sky130_fd_sc_hd__fill_8$1
XFILLER_3_273 vssd1 vccd1 vccd1 vssd1 sky130_fd_sc_hd__fill_4$1
XFILLER_79_553 vssd1 vccd1 vccd1 vssd1 sky130_fd_sc_hd__fill_4$1
XFILLER_39_417 vssd1 vccd1 vccd1 vssd1 sky130_ef_sc_hd__decap_40_12$1
XFILLER_94_545 vssd1 vccd1 vccd1 vssd1 sky130_ef_sc_hd__decap_40_12$1
Xclkbuf_leaf_23_wb_clk_i _1737_/CLK clkbuf_2_3__f_wb_clk_i/X vssd1 vccd1 vccd1 vssd1
+ sky130_fd_sc_hd__clkbuf_8$1
XFILLER_79_597 vssd1 vccd1 vccd1 vssd1 sky130_ef_sc_hd__decap_40_12$1
XFILLER_120_193 vssd1 vccd1 vccd1 vssd1 sky130_fd_sc_hd__fill_2$1
X_1002_ _1535_/Q _1002_/X _1012_/B vssd1 vccd1 vccd1 vssd1 sky130_fd_sc_hd__or2_1$1
XFILLER_94_589 vssd1 vccd1 vccd1 vssd1 sky130_ef_sc_hd__decap_40_12$1
XFILLER_81_217 vssd1 vccd1 vccd1 vssd1 sky130_fd_sc_hd__fill_4$1
XFILLER_47_461 vssd1 vccd1 vccd1 vssd1 sky130_ef_sc_hd__decap_40_12$1
XFILLER_34_133 vssd1 vccd1 vccd1 vssd1 sky130_fd_sc_hd__fill_4$1
XTAP_TAPCELL_ROW_85_1579 vccd1 vssd1 sky130_fd_sc_hd__tapvpwrvgnd_1$1
XTAP_TAPCELL_ROW_85_1568 vccd1 vssd1 sky130_fd_sc_hd__tapvpwrvgnd_1$1
XFILLER_62_475 vccd1 vssd1 vccd1 vssd1 sky130_fd_sc_hd__fill_1$1
XTAP_TAPCELL_ROW_33_802 vccd1 vssd1 sky130_fd_sc_hd__tapvpwrvgnd_1$1
XFILLER_35_678 vssd1 vccd1 vccd1 vssd1 sky130_ef_sc_hd__decap_40_12$1
XFILLER_34_177 vssd1 vccd1 vccd1 vssd1 sky130_ef_sc_hd__decap_40_12$1
XFILLER_15_391 vccd1 vssd1 vccd1 vssd1 sky130_fd_sc_hd__fill_1$1
XFILLER_30_361 vssd1 vccd1 vccd1 vssd1 sky130_fd_sc_hd__fill_2$1
XTAP_TAPCELL_ROW_116_2034 vccd1 vssd1 sky130_fd_sc_hd__tapvpwrvgnd_1$1
X_1835_ _1835_/A _1835_/X vssd1 vccd1 vccd1 vssd1 sky130_fd_sc_hd__clkbuf_2$1
XFILLER_129_783 vccd1 vssd1 vccd1 vssd1 sky130_fd_sc_hd__fill_1$1
XTAP_TAPCELL_ROW_116_2045 vccd1 vssd1 sky130_fd_sc_hd__tapvpwrvgnd_1$1
XFILLER_116_477 vssd1 vccd1 vccd1 vssd1 sky130_ef_sc_hd__decap_40_12$1
X_1697_ hold52/A _1729_/CLK _1697_/D vccd1 vssd1 vccd1 vssd1 sky130_fd_sc_hd__dfxtp_1$1
XFILLER_103_105 vssd1 vccd1 vccd1 vssd1 sky130_fd_sc_hd__fill_4$1
XFILLER_89_317 vssd1 vccd1 vccd1 vssd1 sky130_ef_sc_hd__decap_40_12$1
XFILLER_131_458 vssd1 vccd1 vccd1 vssd1 sky130_ef_sc_hd__decap_40_12$1
XFILLER_131_447 vccd1 vssd1 vccd1 vssd1 sky130_fd_sc_hd__fill_1$1
XFILLER_106_15 vssd1 vccd1 vccd1 vssd1 sky130_ef_sc_hd__decap_40_12$1
XFILLER_103_149 vssd1 vccd1 vccd1 vssd1 sky130_ef_sc_hd__decap_40_12$1
XFILLER_97_361 vssd1 vccd1 vccd1 vssd1 sky130_fd_sc_hd__fill_8$1
XFILLER_57_225 vssd1 vccd1 vccd1 vssd1 sky130_ef_sc_hd__decap_40_12$1
XFILLER_111_193 vssd1 vccd1 vccd1 vssd1 sky130_ef_sc_hd__decap_40_12$1
XFILLER_73_707 vssd1 vccd1 vccd1 vssd1 sky130_ef_sc_hd__decap_40_12$1
XFILLER_73_729 vssd1 vccd1 vccd1 vssd1 sky130_fd_sc_hd__fill_2$1
XFILLER_66_781 vssd1 vccd1 vccd1 vssd1 sky130_ef_sc_hd__decap_40_12$1
XFILLER_26_601 vssd1 vccd1 vccd1 vssd1 sky130_ef_sc_hd__decap_40_12$1
XFILLER_82_29 vssd1 vccd1 vccd1 vssd1 sky130_ef_sc_hd__decap_40_12$1
XFILLER_25_111 vccd1 vssd1 vccd1 vssd1 sky130_fd_sc_hd__fill_1$1
XFILLER_26_645 vssd1 vccd1 vccd1 vssd1 sky130_fd_sc_hd__fill_8$1
XTAP_TAPCELL_ROW_0_287 vccd1 vssd1 sky130_fd_sc_hd__tapvpwrvgnd_1$1
XFILLER_26_667 vssd1 vccd1 vccd1 vssd1 sky130_ef_sc_hd__decap_40_12$1
XFILLER_41_615 vccd1 vssd1 vccd1 vssd1 sky130_fd_sc_hd__fill_1$1
XTAP_TAPCELL_ROW_0_298 vccd1 vssd1 sky130_fd_sc_hd__tapvpwrvgnd_1$1
XFILLER_13_317 vssd1 vccd1 vccd1 vssd1 sky130_ef_sc_hd__decap_40_12$1
XFILLER_41_648 vssd1 vccd1 vccd1 vssd1 sky130_ef_sc_hd__decap_40_12$1
XFILLER_22_840 vssd1 vccd1 vccd1 vssd1 sky130_fd_sc_hd__fill_2$1
XFILLER_21_361 vssd1 vccd1 vccd1 vssd1 sky130_ef_sc_hd__decap_40_12$1
XFILLER_5_505 vssd1 vccd1 vccd1 vssd1 sky130_ef_sc_hd__decap_40_12$1
XFILLER_31_55 vccd1 vssd1 vccd1 vssd1 sky130_fd_sc_hd__fill_1$1
XFILLER_119_293 vssd1 vccd1 vccd1 vssd1 sky130_ef_sc_hd__decap_40_12$1
XFILLER_107_488 vssd1 vccd1 vccd1 vssd1 sky130_ef_sc_hd__decap_40_12$1
XFILLER_103_3 vssd1 vccd1 vccd1 vssd1 sky130_ef_sc_hd__decap_40_12$1
XTAP_TAPCELL_ROW_56_1147 vccd1 vssd1 sky130_fd_sc_hd__tapvpwrvgnd_1$1
XTAP_TAPCELL_ROW_56_1136 vccd1 vssd1 sky130_fd_sc_hd__tapvpwrvgnd_1$1
Xoutput66 _1847_/X analog_ctrl[114] vssd1 vccd1 vccd1 vssd1 sky130_fd_sc_hd__buf_12$1
Xoutput55 _1837_/X analog_ctrl[104] vssd1 vccd1 vccd1 vssd1 sky130_fd_sc_hd__buf_12$1
XFILLER_0_221 vssd1 vccd1 vccd1 vssd1 sky130_fd_sc_hd__fill_2$1
XFILLER_88_361 vssd1 vccd1 vccd1 vssd1 sky130_fd_sc_hd__fill_2$1
XFILLER_1_777 vssd1 vccd1 vccd1 vssd1 sky130_fd_sc_hd__fill_4$1
Xoutput77 _1784_/X analog_ctrl[13] vssd1 vccd1 vccd1 vssd1 sky130_fd_sc_hd__buf_12$1
Xoutput88 _1794_/X analog_ctrl[23] vssd1 vccd1 vccd1 vssd1 sky130_fd_sc_hd__buf_12$1
Xoutput99 _1804_/X analog_ctrl[33] vssd1 vccd1 vccd1 vssd1 sky130_fd_sc_hd__buf_12$1
XFILLER_49_759 vccd1 vssd1 vccd1 vssd1 sky130_fd_sc_hd__fill_1$1
XFILLER_0_265 vssd1 vccd1 vccd1 vssd1 sky130_ef_sc_hd__decap_40_12$1
XFILLER_102_193 vssd1 vccd1 vccd1 vssd1 sky130_fd_sc_hd__fill_2$1
XFILLER_76_556 vssd1 vccd1 vccd1 vssd1 sky130_ef_sc_hd__decap_40_12$1
XFILLER_56_41 vssd1 vccd1 vccd1 vssd1 sky130_ef_sc_hd__decap_40_12$1
XFILLER_76_589 vccd1 vssd1 vccd1 vssd1 sky130_fd_sc_hd__fill_1$1
XFILLER_63_217 vssd1 vccd1 vccd1 vssd1 sky130_fd_sc_hd__fill_4$1
XFILLER_57_781 vssd1 vccd1 vccd1 vssd1 sky130_fd_sc_hd__fill_2$1
XFILLER_29_461 vssd1 vccd1 vccd1 vssd1 sky130_ef_sc_hd__decap_40_12$1
XFILLER_91_559 vccd1 vssd1 vccd1 vssd1 sky130_fd_sc_hd__fill_1$1
XFILLER_56_85 vssd1 vccd1 vccd1 vssd1 sky130_ef_sc_hd__decap_40_12$1
XFILLER_16_133 vssd1 vccd1 vccd1 vssd1 sky130_fd_sc_hd__fill_4$1
XFILLER_44_475 vccd1 vssd1 vccd1 vssd1 sky130_fd_sc_hd__fill_1$1
XFILLER_71_261 vssd1 vccd1 vccd1 vssd1 sky130_ef_sc_hd__decap_40_12$1
XTAP_TAPCELL_ROW_67_1298 vccd1 vssd1 sky130_fd_sc_hd__tapvpwrvgnd_1$1
XFILLER_16_177 vssd1 vccd1 vccd1 vssd1 sky130_ef_sc_hd__decap_40_12$1
XFILLER_31_125 vssd1 vccd1 vccd1 vssd1 sky130_ef_sc_hd__decap_40_12$1
XFILLER_8_321 vssd1 vccd1 vccd1 vssd1 sky130_ef_sc_hd__decap_40_12$1
XFILLER_12_361 vssd1 vccd1 vccd1 vssd1 sky130_fd_sc_hd__fill_2$1
XFILLER_31_169 vssd1 vccd1 vccd1 vssd1 sky130_ef_sc_hd__decap_40_12$1
XTAP_TAPCELL_ROW_80_1498 vccd1 vssd1 sky130_fd_sc_hd__tapvpwrvgnd_1$1
X_1620_ _1620_/Q _1716_/CLK _1620_/D vccd1 vssd1 vccd1 vssd1 sky130_fd_sc_hd__dfxtp_1$1
XFILLER_8_365 vssd1 vccd1 vccd1 vssd1 sky130_ef_sc_hd__decap_40_12$1
XFILLER_138_591 vccd1 vssd1 vccd1 vssd1 sky130_fd_sc_hd__fill_1$1
XFILLER_126_731 vccd1 vssd1 vccd1 vssd1 sky130_fd_sc_hd__fill_1$1
X_1551_ _1551_/Q _1742_/CLK _1551_/D vccd1 vssd1 vccd1 vssd1 sky130_fd_sc_hd__dfxtp_1$1
XFILLER_113_447 vccd1 vssd1 vccd1 vssd1 sky130_fd_sc_hd__fill_1$1
X_1482_ _1482_/D _1738_/CLK _1482_/Q vssd1 vccd1 vccd1 vssd1 sky130_fd_sc_hd__dfxtp_4$1
XFILLER_101_609 vssd1 vccd1 vccd1 vssd1 sky130_fd_sc_hd__fill_4$1
XFILLER_97_81 vssd1 vccd1 vccd1 vssd1 sky130_ef_sc_hd__decap_40_12$1
XFILLER_86_309 vssd1 vccd1 vccd1 vssd1 sky130_ef_sc_hd__decap_40_12$1
XFILLER_79_361 vssd1 vccd1 vccd1 vssd1 sky130_ef_sc_hd__decap_40_12$1
XFILLER_67_501 vssd1 vccd1 vccd1 vssd1 sky130_fd_sc_hd__fill_2$1
XFILLER_39_225 vssd1 vccd1 vccd1 vssd1 sky130_ef_sc_hd__decap_40_12$1
XTAP_TAPCELL_ROW_87_1608 vccd1 vssd1 sky130_fd_sc_hd__tapvpwrvgnd_1$1
XFILLER_67_545 vssd1 vccd1 vccd1 vssd1 sky130_ef_sc_hd__decap_40_12$1
XFILLER_55_729 vssd1 vccd1 vccd1 vssd1 sky130_ef_sc_hd__decap_40_12$1
XFILLER_23_615 vccd1 vssd1 vccd1 vssd1 sky130_fd_sc_hd__fill_1$1
XFILLER_50_401 vssd1 vccd1 vccd1 vssd1 sky130_ef_sc_hd__decap_40_12$1
XFILLER_35_497 vssd1 vccd1 vccd1 vssd1 sky130_fd_sc_hd__fill_4$1
XTAP_TAPCELL_ROW_46_993 vccd1 vssd1 sky130_fd_sc_hd__tapvpwrvgnd_1$1
XFILLER_50_445 vssd1 vccd1 vccd1 vssd1 sky130_fd_sc_hd__fill_8$1
XFILLER_10_309 vssd1 vccd1 vccd1 vssd1 sky130_ef_sc_hd__decap_40_12$1
X_1818_ _1818_/A _1818_/X vssd1 vccd1 vccd1 vssd1 sky130_fd_sc_hd__clkbuf_2$1
XFILLER_132_701 vssd1 vccd1 vccd1 vssd1 sky130_ef_sc_hd__decap_40_12$1
X_1749_ hold42/A _1749_/CLK _1749_/D vccd1 vssd1 vccd1 vssd1 sky130_fd_sc_hd__dfxtp_1$1
XFILLER_117_69 vssd1 vccd1 vccd1 vssd1 sky130_ef_sc_hd__decap_40_12$1
XFILLER_89_125 vssd1 vccd1 vccd1 vssd1 sky130_ef_sc_hd__decap_40_12$1
XFILLER_89_169 vssd1 vccd1 vccd1 vssd1 sky130_ef_sc_hd__decap_40_12$1
XFILLER_131_277 vssd1 vccd1 vccd1 vssd1 sky130_fd_sc_hd__fill_2$1
XTAP_TAPCELL_ROW_129_2236 vccd1 vssd1 sky130_fd_sc_hd__tapvpwrvgnd_1$1
XFILLER_98_681 vssd1 vccd1 vccd1 vssd1 sky130_fd_sc_hd__fill_2$1
XFILLER_86_810 vssd1 vccd1 vccd1 vssd1 sky130_fd_sc_hd__fill_2$1
XFILLER_58_501 vssd1 vccd1 vccd1 vssd1 sky130_ef_sc_hd__decap_40_12$1
XFILLER_133_57 vssd1 vccd1 vccd1 vssd1 sky130_ef_sc_hd__decap_40_12$1
XTAP_TAPCELL_ROW_51_1066 vccd1 vssd1 sky130_fd_sc_hd__tapvpwrvgnd_1$1
XTAP_TAPCELL_ROW_5_379 vccd1 vssd1 sky130_fd_sc_hd__tapvpwrvgnd_1$1
XTAP_TAPCELL_ROW_5_368 vccd1 vssd1 sky130_fd_sc_hd__tapvpwrvgnd_1$1
XFILLER_93_39 vssd1 vccd1 vccd1 vssd1 sky130_ef_sc_hd__decap_40_12$1
XFILLER_58_589 vccd1 vssd1 vccd1 vssd1 sky130_fd_sc_hd__fill_1$1
XFILLER_45_217 vssd1 vccd1 vccd1 vssd1 sky130_fd_sc_hd__fill_4$1
XFILLER_73_559 vccd1 vssd1 vccd1 vssd1 sky130_fd_sc_hd__fill_1$1
XFILLER_60_209 vssd1 vccd1 vccd1 vssd1 sky130_ef_sc_hd__decap_40_12$1
XTAP_TAPCELL_ROW_107_1899 vccd1 vssd1 sky130_fd_sc_hd__tapvpwrvgnd_1$1
XFILLER_81_570 vssd1 vccd1 vccd1 vssd1 sky130_ef_sc_hd__decap_40_12$1
XFILLER_53_261 vssd1 vccd1 vccd1 vssd1 sky130_ef_sc_hd__decap_40_12$1
XFILLER_14_637 vssd1 vccd1 vccd1 vssd1 sky130_fd_sc_hd__fill_4$1
XFILLER_26_77 vssd1 vccd1 vccd1 vssd1 sky130_fd_sc_hd__fill_4$1
XFILLER_26_475 vccd1 vssd1 vccd1 vssd1 sky130_fd_sc_hd__fill_1$1
XFILLER_13_125 vssd1 vccd1 vccd1 vssd1 sky130_ef_sc_hd__decap_40_12$1
XTAP_TAPCELL_ROW_24_654 vccd1 vssd1 sky130_fd_sc_hd__tapvpwrvgnd_1$1
XFILLER_41_445 vssd1 vccd1 vccd1 vssd1 sky130_fd_sc_hd__fill_2$1
XFILLER_13_169 vssd1 vccd1 vccd1 vssd1 sky130_ef_sc_hd__decap_40_12$1
XTAP_TAPCELL_ROW_24_665 vccd1 vssd1 sky130_fd_sc_hd__tapvpwrvgnd_1$1
XFILLER_22_681 vssd1 vccd1 vccd1 vssd1 sky130_ef_sc_hd__decap_40_12$1
XFILLER_42_65 vssd1 vccd1 vccd1 vssd1 sky130_ef_sc_hd__decap_40_12$1
XFILLER_127_517 vssd1 vccd1 vccd1 vssd1 sky130_ef_sc_hd__decap_40_12$1
XFILLER_6_825 vssd1 vccd1 vccd1 vssd1 sky130_ef_sc_hd__decap_40_12$1
XFILLER_5_335 vccd1 vssd1 vccd1 vssd1 sky130_fd_sc_hd__fill_1$1
XFILLER_135_550 vccd1 vssd1 vccd1 vssd1 sky130_fd_sc_hd__fill_1$1
XFILLER_135_561 vssd1 vccd1 vccd1 vssd1 sky130_fd_sc_hd__fill_2$1
XFILLER_122_233 vssd1 vccd1 vccd1 vssd1 sky130_ef_sc_hd__decap_40_12$1
XFILLER_68_309 vssd1 vccd1 vccd1 vssd1 sky130_ef_sc_hd__decap_40_12$1
XFILLER_3_15 vssd1 vccd1 vccd1 vssd1 sky130_ef_sc_hd__decap_40_12$1
XFILLER_1_541 vssd1 vccd1 vccd1 vssd1 sky130_ef_sc_hd__decap_40_12$1
XFILLER_122_277 vssd1 vccd1 vccd1 vssd1 sky130_ef_sc_hd__decap_40_12$1
XFILLER_77_821 vssd1 vccd1 vccd1 vssd1 sky130_fd_sc_hd__fill_2$1
XFILLER_67_51 vssd1 vccd1 vccd1 vssd1 sky130_fd_sc_hd__fill_4$1
XFILLER_1_585 vssd1 vccd1 vccd1 vssd1 sky130_ef_sc_hd__decap_40_12$1
XFILLER_92_813 vssd1 vccd1 vccd1 vssd1 sky130_fd_sc_hd__fill_8$1
XFILLER_37_729 vssd1 vccd1 vccd1 vssd1 sky130_ef_sc_hd__decap_40_12$1
XTAP_TAPCELL_ROW_69_1338 vccd1 vssd1 sky130_fd_sc_hd__tapvpwrvgnd_1$1
XPHY_EDGE_ROW_103_Left_242 vccd1 vssd1 vccd1 vssd1 sky130_fd_sc_hd__decap_3$1
XFILLER_91_389 vssd1 vccd1 vccd1 vssd1 sky130_fd_sc_hd__fill_2$1
XTAP_TAPCELL_ROW_82_1527 vccd1 vssd1 sky130_fd_sc_hd__tapvpwrvgnd_1$1
XFILLER_60_721 vssd1 vccd1 vccd1 vssd1 sky130_ef_sc_hd__decap_40_12$1
XFILLER_17_497 vssd1 vccd1 vccd1 vssd1 sky130_fd_sc_hd__fill_4$1
XFILLER_32_401 vssd1 vccd1 vccd1 vssd1 sky130_ef_sc_hd__decap_40_12$1
XFILLER_32_445 vssd1 vccd1 vccd1 vssd1 sky130_ef_sc_hd__decap_40_12$1
XTAP_TAPCELL_ROW_43_941 vccd1 vssd1 sky130_fd_sc_hd__tapvpwrvgnd_1$1
XTAP_TAPCELL_ROW_43_952 vccd1 vssd1 sky130_fd_sc_hd__tapvpwrvgnd_1$1
X_0982_ hold43/X _0982_/X _1012_/B vssd1 vccd1 vccd1 vssd1 sky130_fd_sc_hd__or2_1$1
XFILLER_32_489 vssd1 vccd1 vccd1 vssd1 sky130_ef_sc_hd__decap_40_12$1
XFILLER_9_641 vssd1 vccd1 vccd1 vssd1 sky130_ef_sc_hd__decap_40_12$1
XPHY_EDGE_ROW_132_Right_132 vccd1 vssd1 vccd1 vssd1 sky130_fd_sc_hd__decap_3$1
XFILLER_9_685 vssd1 vccd1 vccd1 vssd1 sky130_ef_sc_hd__decap_40_12$1
XFILLER_66_3 vssd1 vccd1 vccd1 vssd1 sky130_ef_sc_hd__decap_40_12$1
XFILLER_8_195 vccd1 vssd1 vccd1 vssd1 sky130_fd_sc_hd__fill_1$1
X_1603_ hold93/A _1761_/CLK _1603_/D vccd1 vssd1 vccd1 vssd1 sky130_fd_sc_hd__dfxtp_1$1
XFILLER_114_701 vssd1 vccd1 vccd1 vssd1 sky130_ef_sc_hd__decap_40_12$1
XPHY_EDGE_ROW_112_Left_251 vccd1 vssd1 vccd1 vssd1 sky130_fd_sc_hd__decap_3$1
X_1534_ _1534_/Q _1726_/CLK _1534_/D vccd1 vssd1 vccd1 vssd1 sky130_fd_sc_hd__dfxtp_1$1
XFILLER_99_434 vssd1 vccd1 vccd1 vssd1 sky130_ef_sc_hd__decap_40_12$1
XTAP_TAPCELL_ROW_93_1689 vccd1 vssd1 sky130_fd_sc_hd__tapvpwrvgnd_1$1
X_1465_ _1465_/C1 _1464_/X _1465_/A2 hold83/X _1759_/D vssd1 vccd1 vccd1 vssd1 sky130_fd_sc_hd__o211a_1$1
XFILLER_113_277 vssd1 vccd1 vccd1 vssd1 sky130_fd_sc_hd__fill_2$1
XFILLER_101_428 vssd1 vccd1 vccd1 vssd1 sky130_ef_sc_hd__decap_40_12$1
XFILLER_87_629 vssd1 vccd1 vccd1 vssd1 sky130_ef_sc_hd__decap_40_12$1
XFILLER_68_832 vssd1 vccd1 vccd1 vssd1 sky130_fd_sc_hd__fill_8$1
X_1396_ _1396_/A _1396_/X _1408_/B vssd1 vccd1 vccd1 vssd1 sky130_fd_sc_hd__or2_1$1
XFILLER_86_139 vccd1 vssd1 vccd1 vssd1 sky130_fd_sc_hd__fill_1$1
XFILLER_95_673 vssd1 vccd1 vccd1 vssd1 sky130_ef_sc_hd__decap_40_12$1
XFILLER_82_301 vssd1 vccd1 vccd1 vssd1 sky130_fd_sc_hd__fill_4$1
XTAP_TAPCELL_ROW_2_327 vccd1 vssd1 sky130_fd_sc_hd__tapvpwrvgnd_1$1
XFILLER_27_217 vssd1 vccd1 vccd1 vssd1 sky130_fd_sc_hd__fill_4$1
XPHY_EDGE_ROW_121_Left_260 vccd1 vssd1 vccd1 vssd1 sky130_fd_sc_hd__decap_3$1
XFILLER_103_27 vssd1 vccd1 vccd1 vssd1 sky130_ef_sc_hd__decap_40_12$1
XFILLER_82_345 vssd1 vccd1 vccd1 vssd1 sky130_ef_sc_hd__decap_40_12$1
XFILLER_55_559 vccd1 vssd1 vccd1 vssd1 sky130_fd_sc_hd__fill_1$1
XTAP_TAPCELL_ROW_124_2166 vccd1 vssd1 sky130_fd_sc_hd__tapvpwrvgnd_1$1
XTAP_TAPCELL_ROW_124_2155 vccd1 vssd1 sky130_fd_sc_hd__tapvpwrvgnd_1$1
XFILLER_70_518 vssd1 vccd1 vccd1 vssd1 sky130_ef_sc_hd__decap_40_12$1
XFILLER_42_209 vssd1 vccd1 vccd1 vssd1 sky130_ef_sc_hd__decap_40_12$1
XFILLER_63_592 vssd1 vccd1 vccd1 vssd1 sky130_ef_sc_hd__decap_40_12$1
XFILLER_35_261 vssd1 vccd1 vccd1 vssd1 sky130_ef_sc_hd__decap_40_12$1
XFILLER_23_445 vssd1 vccd1 vccd1 vssd1 sky130_fd_sc_hd__fill_2$1
XFILLER_50_253 vssd1 vccd1 vccd1 vssd1 sky130_ef_sc_hd__decap_40_12$1
XFILLER_11_629 vssd1 vccd1 vccd1 vssd1 sky130_ef_sc_hd__decap_40_12$1
XFILLER_10_139 vccd1 vssd1 vccd1 vssd1 sky130_fd_sc_hd__fill_1$1
XTAP_TAPCELL_ROW_21_613 vccd1 vssd1 sky130_fd_sc_hd__tapvpwrvgnd_1$1
XFILLER_109_517 vccd1 vssd1 vccd1 vssd1 sky130_fd_sc_hd__fill_1$1
XFILLER_117_561 vssd1 vccd1 vccd1 vssd1 sky130_fd_sc_hd__fill_8$1
XFILLER_2_305 vssd1 vccd1 vccd1 vssd1 sky130_fd_sc_hd__fill_2$1
XFILLER_132_531 vccd1 vssd1 vccd1 vssd1 sky130_fd_sc_hd__fill_1$1
Xhold140 _1759_/Q _1464_/A vssd1 vccd1 vccd1 vssd1 sky130_fd_sc_hd__dlygate4sd3_1$1
XFILLER_105_734 vssd1 vccd1 vccd1 vssd1 sky130_fd_sc_hd__fill_4$1
XFILLER_105_745 vssd1 vccd1 vccd1 vssd1 sky130_fd_sc_hd__fill_4$1
Xhold162 _1720_/Q _1384_/A vssd1 vccd1 vccd1 vssd1 sky130_fd_sc_hd__dlygate4sd3_1$1
Xhold151 _1686_/Q _1314_/A vssd1 vccd1 vccd1 vssd1 sky130_fd_sc_hd__dlygate4sd3_1$1
XFILLER_3_839 vccd1 vssd1 vccd1 vssd1 sky130_fd_sc_hd__fill_1$1
XFILLER_105_767 vssd1 vccd1 vccd1 vssd1 sky130_ef_sc_hd__decap_40_12$1
XFILLER_104_233 vssd1 vccd1 vccd1 vssd1 sky130_ef_sc_hd__decap_40_12$1
Xhold195 _1523_/Q _0978_/A vssd1 vccd1 vccd1 vssd1 sky130_fd_sc_hd__dlygate4sd3_1$1
Xhold173 _1375_/X _1715_/D vssd1 vccd1 vccd1 vssd1 sky130_fd_sc_hd__dlygate4sd3_1$1
Xhold184 _1033_/X _1549_/D vssd1 vccd1 vccd1 vssd1 sky130_fd_sc_hd__dlygate4sd3_1$1
XFILLER_120_737 vssd1 vccd1 vccd1 vssd1 sky130_ef_sc_hd__decap_40_12$1
XFILLER_104_277 vssd1 vccd1 vccd1 vssd1 sky130_ef_sc_hd__decap_40_12$1
XTAP_TAPCELL_ROW_109_1928 vccd1 vssd1 sky130_fd_sc_hd__tapvpwrvgnd_1$1
XFILLER_92_109 vssd1 vccd1 vccd1 vssd1 sky130_ef_sc_hd__decap_40_12$1
XFILLER_86_662 vssd1 vccd1 vccd1 vssd1 sky130_ef_sc_hd__decap_40_12$1
XFILLER_85_161 vssd1 vccd1 vccd1 vssd1 sky130_fd_sc_hd__fill_4$1
XFILLER_74_813 vssd1 vccd1 vccd1 vssd1 sky130_ef_sc_hd__decap_40_12$1
XFILLER_19_729 vssd1 vccd1 vccd1 vssd1 sky130_ef_sc_hd__decap_40_12$1
XTAP_TAPCELL_ROW_109_1939 vccd1 vssd1 sky130_fd_sc_hd__tapvpwrvgnd_1$1
XTAP_TAPCELL_ROW_29_735 vccd1 vssd1 sky130_fd_sc_hd__tapvpwrvgnd_1$1
XFILLER_61_529 vssd1 vccd1 vccd1 vssd1 sky130_fd_sc_hd__fill_2$1
XFILLER_14_401 vssd1 vccd1 vccd1 vssd1 sky130_ef_sc_hd__decap_40_12$1
XTAP_TAPCELL_ROW_64_1257 vccd1 vssd1 sky130_fd_sc_hd__tapvpwrvgnd_1$1
XFILLER_14_445 vssd1 vccd1 vccd1 vssd1 sky130_ef_sc_hd__decap_40_12$1
XFILLER_14_489 vssd1 vccd1 vccd1 vssd1 sky130_ef_sc_hd__decap_40_12$1
XTAP_TAPCELL_ROW_40_900 vccd1 vssd1 sky130_fd_sc_hd__tapvpwrvgnd_1$1
XFILLER_6_699 vccd1 vssd1 vccd1 vssd1 sky130_fd_sc_hd__fill_1$1
XFILLER_5_165 vssd1 vccd1 vccd1 vssd1 sky130_fd_sc_hd__fill_2$1
XFILLER_78_83 vccd1 vssd1 vccd1 vssd1 sky130_fd_sc_hd__fill_1$1
XFILLER_111_759 vssd1 vccd1 vccd1 vssd1 sky130_ef_sc_hd__decap_40_12$1
X_1250_ _1655_/Q _1250_/X _1276_/B vssd1 vccd1 vccd1 vssd1 sky130_fd_sc_hd__or2_1$1
XFILLER_68_139 vccd1 vssd1 vccd1 vssd1 sky130_fd_sc_hd__fill_1$1
XFILLER_1_393 vssd1 vccd1 vccd1 vssd1 sky130_ef_sc_hd__decap_40_12$1
X_1181_ _0739_/D _1180_/X _1211_/A2 hold32/X _1621_/D vssd1 vccd1 vccd1 vssd1 sky130_fd_sc_hd__o211a_1$1
XFILLER_83_109 vssd1 vccd1 vccd1 vssd1 sky130_fd_sc_hd__fill_2$1
XFILLER_77_673 vssd1 vccd1 vccd1 vssd1 sky130_ef_sc_hd__decap_40_12$1
XFILLER_64_301 vssd1 vccd1 vccd1 vssd1 sky130_fd_sc_hd__fill_4$1
XFILLER_80_805 vssd1 vccd1 vccd1 vssd1 sky130_fd_sc_hd__fill_4$1
XFILLER_64_345 vssd1 vccd1 vccd1 vssd1 sky130_ef_sc_hd__decap_40_12$1
XFILLER_24_209 vssd1 vccd1 vccd1 vssd1 sky130_ef_sc_hd__decap_40_12$1
XFILLER_17_261 vssd1 vccd1 vccd1 vssd1 sky130_ef_sc_hd__decap_40_12$1
XFILLER_33_754 vssd1 vccd1 vccd1 vssd1 sky130_ef_sc_hd__decap_40_12$1
XFILLER_32_253 vssd1 vccd1 vccd1 vssd1 sky130_ef_sc_hd__decap_40_12$1
X_0965_ _1305_/C1 _0964_/X _0991_/A2 hold199/X _1516_/D vssd1 vccd1 vccd1 vssd1 sky130_fd_sc_hd__o211a_1$1
X_0896_ hold33/A _1147_/A _0897_/C _1660_/Q _1213_/A vccd1 vssd1 vccd1 vssd1 sky130_fd_sc_hd__a22o_1$1
XTAP_TAPCELL_ROW_95_1729 vccd1 vssd1 sky130_fd_sc_hd__tapvpwrvgnd_1$1
XTAP_TAPCELL_ROW_95_1718 vccd1 vssd1 sky130_fd_sc_hd__tapvpwrvgnd_1$1
Xoutput201 _1485_/Q wbs_dat_o[8] vssd1 vccd1 vccd1 vssd1 sky130_fd_sc_hd__buf_12$1
XFILLER_133_317 vssd1 vccd1 vccd1 vssd1 sky130_ef_sc_hd__decap_40_12$1
XFILLER_114_531 vccd1 vssd1 vccd1 vssd1 sky130_fd_sc_hd__fill_1$1
XTAP_TAPCELL_ROW_7_408 vccd1 vssd1 sky130_fd_sc_hd__tapvpwrvgnd_1$1
XFILLER_0_809 vssd1 vccd1 vccd1 vssd1 sky130_fd_sc_hd__fill_2$1
XFILLER_102_737 vssd1 vccd1 vccd1 vssd1 sky130_fd_sc_hd__fill_8$1
X_1517_ _1517_/Q _1721_/CLK _1517_/D vccd1 vssd1 vccd1 vssd1 sky130_fd_sc_hd__dfxtp_1$1
XFILLER_114_15 vssd1 vccd1 vccd1 vssd1 sky130_ef_sc_hd__decap_40_12$1
XFILLER_101_225 vssd1 vccd1 vccd1 vssd1 sky130_ef_sc_hd__decap_40_12$1
XFILLER_87_459 vccd1 vssd1 vccd1 vssd1 sky130_fd_sc_hd__fill_1$1
X_1448_ _1448_/A _1448_/X _1464_/B vssd1 vccd1 vccd1 vssd1 sky130_fd_sc_hd__or2_1$1
XFILLER_74_109 vssd1 vccd1 vccd1 vssd1 sky130_ef_sc_hd__decap_40_12$1
XFILLER_68_651 vccd1 vssd1 vccd1 vssd1 sky130_fd_sc_hd__fill_1$1
X_1379_ _0739_/D _1378_/X _1399_/A2 hold32/X _1717_/D vssd1 vccd1 vccd1 vssd1 sky130_fd_sc_hd__o211a_1$1
XFILLER_110_781 vssd1 vccd1 vccd1 vssd1 sky130_fd_sc_hd__fill_4$1
XFILLER_83_643 vssd1 vccd1 vccd1 vssd1 sky130_ef_sc_hd__decap_40_12$1
XFILLER_67_161 vssd1 vccd1 vccd1 vssd1 sky130_fd_sc_hd__fill_4$1
XFILLER_82_153 vssd1 vccd1 vccd1 vssd1 sky130_ef_sc_hd__decap_40_12$1
XFILLER_36_581 vssd1 vccd1 vccd1 vssd1 sky130_fd_sc_hd__fill_4$1
XFILLER_43_529 vssd1 vccd1 vccd1 vssd1 sky130_ef_sc_hd__decap_40_12$1
XTAP_TAPCELL_ROW_104_1858 vccd1 vssd1 sky130_fd_sc_hd__tapvpwrvgnd_1$1
XFILLER_82_197 vssd1 vccd1 vccd1 vssd1 sky130_ef_sc_hd__decap_40_12$1
XFILLER_24_754 vssd1 vccd1 vccd1 vssd1 sky130_fd_sc_hd__fill_2$1
XFILLER_90_29 vssd1 vccd1 vccd1 vssd1 sky130_ef_sc_hd__decap_40_12$1
XFILLER_137_623 vssd1 vccd1 vccd1 vssd1 sky130_ef_sc_hd__decap_40_12$1
XTAP_TAPCELL_ROW_137_2357 vccd1 vssd1 sky130_fd_sc_hd__tapvpwrvgnd_1$1
XFILLER_136_111 vssd1 vccd1 vccd1 vssd1 sky130_ef_sc_hd__decap_40_12$1
XFILLER_99_27 vssd1 vccd1 vccd1 vssd1 sky130_ef_sc_hd__decap_40_12$1
XFILLER_137_689 vssd1 vccd1 vccd1 vssd1 sky130_fd_sc_hd__fill_2$1
XFILLER_136_177 vssd1 vccd1 vccd1 vssd1 sky130_fd_sc_hd__fill_2$1
XFILLER_105_553 vssd1 vccd1 vccd1 vssd1 sky130_fd_sc_hd__fill_4$1
XFILLER_3_669 vssd1 vccd1 vccd1 vssd1 sky130_fd_sc_hd__fill_2$1
XFILLER_132_361 vssd1 vccd1 vccd1 vssd1 sky130_fd_sc_hd__fill_2$1
XFILLER_120_501 vssd1 vccd1 vccd1 vssd1 sky130_fd_sc_hd__fill_4$1
XFILLER_120_545 vssd1 vccd1 vccd1 vssd1 sky130_ef_sc_hd__decap_40_12$1
XFILLER_120_589 vssd1 vccd1 vccd1 vssd1 sky130_ef_sc_hd__decap_40_12$1
XFILLER_65_109 vssd1 vccd1 vccd1 vssd1 sky130_fd_sc_hd__fill_2$1
XFILLER_59_673 vssd1 vccd1 vccd1 vssd1 sky130_ef_sc_hd__decap_40_12$1
XFILLER_48_53 vssd1 vccd1 vccd1 vssd1 sky130_ef_sc_hd__decap_40_12$1
XFILLER_101_781 vssd1 vccd1 vccd1 vssd1 sky130_fd_sc_hd__fill_2$1
XFILLER_86_492 vccd1 vssd1 vccd1 vssd1 sky130_fd_sc_hd__fill_1$1
XFILLER_46_301 vssd1 vccd1 vccd1 vssd1 sky130_fd_sc_hd__fill_4$1
XFILLER_48_97 vssd1 vccd1 vccd1 vssd1 sky130_ef_sc_hd__decap_40_12$1
XFILLER_104_81 vssd1 vccd1 vccd1 vssd1 sky130_fd_sc_hd__fill_2$1
XFILLER_0_27 vccd1 vssd1 vccd1 vssd1 sky130_fd_sc_hd__fill_1$1
XFILLER_19_559 vccd1 vssd1 vccd1 vssd1 sky130_fd_sc_hd__fill_1$1
XFILLER_46_345 vssd1 vccd1 vccd1 vssd1 sky130_ef_sc_hd__decap_40_12$1
XFILLER_64_41 vssd1 vccd1 vccd1 vssd1 sky130_ef_sc_hd__decap_40_12$1
XFILLER_15_721 vssd1 vccd1 vccd1 vssd1 sky130_fd_sc_hd__fill_4$1
XFILLER_34_529 vssd1 vccd1 vccd1 vssd1 sky130_fd_sc_hd__fill_2$1
XFILLER_46_389 vssd1 vccd1 vccd1 vssd1 sky130_ef_sc_hd__decap_40_12$1
XFILLER_64_85 vssd1 vccd1 vccd1 vssd1 sky130_ef_sc_hd__decap_40_12$1
XFILLER_61_337 vssd1 vccd1 vccd1 vssd1 sky130_ef_sc_hd__decap_40_12$1
XFILLER_14_253 vssd1 vccd1 vccd1 vssd1 sky130_ef_sc_hd__decap_40_12$1
XFILLER_15_765 vssd1 vccd1 vccd1 vssd1 sky130_fd_sc_hd__fill_2$1
XFILLER_30_713 vssd1 vccd1 vccd1 vssd1 sky130_ef_sc_hd__decap_40_12$1
XFILLER_9_69 vssd1 vccd1 vccd1 vssd1 sky130_ef_sc_hd__decap_40_12$1
XFILLER_30_757 vssd1 vccd1 vccd1 vssd1 sky130_ef_sc_hd__decap_40_12$1
XFILLER_128_623 vssd1 vccd1 vccd1 vssd1 sky130_ef_sc_hd__decap_40_12$1
X_0750_ _0947_/B _0947_/D _1476_/Q _0947_/C _0750_/X vssd1 vccd1 vccd1 vssd1 sky130_fd_sc_hd__or4bb_4$1
XFILLER_127_111 vccd1 vssd1 vccd1 vssd1 sky130_fd_sc_hd__fill_1$1
XTAP_TAPCELL_ROW_12_476 vccd1 vssd1 sky130_fd_sc_hd__tapvpwrvgnd_1$1
XTAP_TAPCELL_ROW_12_487 vccd1 vssd1 sky130_fd_sc_hd__tapvpwrvgnd_1$1
XTAP_TAPCELL_ROW_77_1448 vccd1 vssd1 sky130_fd_sc_hd__tapvpwrvgnd_1$1
XFILLER_115_317 vssd1 vccd1 vccd1 vssd1 sky130_ef_sc_hd__decap_40_12$1
XTAP_TAPCELL_ROW_77_1459 vccd1 vssd1 sky130_fd_sc_hd__tapvpwrvgnd_1$1
XFILLER_89_93 vssd1 vccd1 vccd1 vssd1 sky130_ef_sc_hd__decap_40_12$1
XFILLER_130_309 vssd1 vccd1 vccd1 vssd1 sky130_ef_sc_hd__decap_40_12$1
XFILLER_123_361 vssd1 vccd1 vccd1 vssd1 sky130_ef_sc_hd__decap_40_12$1
XTAP_TAPCELL_ROW_90_1648 vccd1 vssd1 sky130_fd_sc_hd__tapvpwrvgnd_1$1
XFILLER_69_426 vssd1 vccd1 vccd1 vssd1 sky130_ef_sc_hd__decap_40_12$1
XFILLER_96_245 vssd1 vccd1 vccd1 vssd1 sky130_fd_sc_hd__fill_4$1
X_1302_ _1302_/A _1302_/X _1330_/B vssd1 vccd1 vccd1 vssd1 sky130_fd_sc_hd__or2_1$1
XFILLER_84_429 vssd1 vccd1 vccd1 vssd1 sky130_ef_sc_hd__decap_40_12$1
XFILLER_84_418 vssd1 vccd1 vccd1 vssd1 sky130_fd_sc_hd__fill_2$1
X_1233_ _1431_/C1 _1232_/X _1277_/A2 hold155/X _1646_/D vssd1 vccd1 vccd1 vssd1 sky130_fd_sc_hd__o211a_1$1
XFILLER_56_109 vssd1 vccd1 vccd1 vssd1 sky130_ef_sc_hd__decap_40_12$1
XFILLER_29_3 vssd1 vccd1 vccd1 vssd1 sky130_ef_sc_hd__decap_40_12$1
XFILLER_38_813 vssd1 vccd1 vccd1 vssd1 sky130_ef_sc_hd__decap_40_12$1
XFILLER_96_289 vssd1 vccd1 vccd1 vssd1 sky130_ef_sc_hd__decap_40_12$1
XFILLER_49_161 vssd1 vccd1 vccd1 vssd1 sky130_fd_sc_hd__fill_4$1
X_1164_ _1817_/A _1164_/X _1188_/B vssd1 vccd1 vccd1 vssd1 sky130_fd_sc_hd__or2_1$1
XTAP_TAPCELL_ROW_121_2114 vccd1 vssd1 sky130_fd_sc_hd__tapvpwrvgnd_1$1
XFILLER_80_613 vccd1 vssd1 vccd1 vssd1 sky130_fd_sc_hd__fill_1$1
XFILLER_64_153 vssd1 vccd1 vccd1 vssd1 sky130_ef_sc_hd__decap_40_12$1
XFILLER_25_529 vssd1 vccd1 vccd1 vssd1 sky130_ef_sc_hd__decap_40_12$1
X_1095_ _1305_/C1 _1094_/X _1123_/A2 hold197/X _1579_/D vssd1 vccd1 vccd1 vssd1 sky130_fd_sc_hd__o211a_1$1
XFILLER_37_389 vssd1 vccd1 vccd1 vssd1 sky130_fd_sc_hd__fill_2$1
XFILLER_80_657 vssd1 vccd1 vccd1 vssd1 sky130_ef_sc_hd__decap_40_12$1
XFILLER_64_197 vssd1 vccd1 vccd1 vssd1 sky130_ef_sc_hd__decap_40_12$1
XFILLER_18_581 vssd1 vccd1 vccd1 vssd1 sky130_fd_sc_hd__fill_4$1
XFILLER_33_573 vssd1 vccd1 vccd1 vssd1 sky130_ef_sc_hd__decap_40_12$1
XFILLER_20_245 vssd1 vccd1 vccd1 vssd1 sky130_fd_sc_hd__fill_4$1
XTAP_TAPCELL_ROW_119_2087 vccd1 vssd1 sky130_fd_sc_hd__tapvpwrvgnd_1$1
X_0948_ _0948_/X _1411_/B _0949_/A vccd1 vssd1 vccd1 vssd1 sky130_fd_sc_hd__and2_1$1
XFILLER_20_289 vssd1 vccd1 vccd1 vssd1 sky130_ef_sc_hd__decap_40_12$1
XTAP_TAPCELL_ROW_31_763 vccd1 vssd1 sky130_fd_sc_hd__tapvpwrvgnd_1$1
XFILLER_134_604 vssd1 vccd1 vccd1 vssd1 sky130_ef_sc_hd__decap_40_12$1
XFILLER_118_133 vssd1 vccd1 vccd1 vssd1 sky130_fd_sc_hd__fill_4$1
XFILLER_109_15 vssd1 vccd1 vccd1 vssd1 sky130_ef_sc_hd__decap_40_12$1
XFILLER_133_125 vssd1 vccd1 vccd1 vssd1 sky130_ef_sc_hd__decap_40_12$1
XFILLER_118_177 vssd1 vccd1 vccd1 vssd1 sky130_ef_sc_hd__decap_40_12$1
X_0879_ _0879_/B1 _0879_/X _0878_/X _1811_/A _0879_/A2 _0875_/X vssd1 vccd1 vccd1
+ vssd1 sky130_fd_sc_hd__a2111o_1$1
XTAP_TAPCELL_ROW_132_2287 vccd1 vssd1 sky130_fd_sc_hd__tapvpwrvgnd_1$1
XTAP_TAPCELL_ROW_132_2276 vccd1 vssd1 sky130_fd_sc_hd__tapvpwrvgnd_1$1
XFILLER_133_169 vssd1 vccd1 vccd1 vssd1 sky130_ef_sc_hd__decap_40_12$1
XFILLER_114_361 vssd1 vccd1 vccd1 vssd1 sky130_fd_sc_hd__fill_2$1
XFILLER_88_713 vssd1 vccd1 vccd1 vssd1 sky130_ef_sc_hd__decap_40_12$1
XFILLER_0_617 vssd1 vccd1 vccd1 vssd1 sky130_fd_sc_hd__fill_4$1
XFILLER_87_223 vccd1 vssd1 vccd1 vssd1 sky130_fd_sc_hd__fill_1$1
XFILLER_125_69 vssd1 vccd1 vccd1 vssd1 sky130_ef_sc_hd__decap_40_12$1
XFILLER_102_589 vssd1 vccd1 vccd1 vssd1 sky130_ef_sc_hd__decap_40_12$1
XFILLER_47_109 vssd1 vccd1 vccd1 vssd1 sky130_fd_sc_hd__fill_2$1
XFILLER_75_429 vssd1 vccd1 vccd1 vssd1 sky130_fd_sc_hd__fill_2$1
XFILLER_68_470 vssd1 vccd1 vccd1 vssd1 sky130_fd_sc_hd__fill_4$1
XFILLER_28_301 vssd1 vccd1 vccd1 vssd1 sky130_fd_sc_hd__fill_4$1
XFILLER_28_345 vssd1 vccd1 vccd1 vssd1 sky130_ef_sc_hd__decap_40_12$1
XFILLER_44_805 vssd1 vccd1 vccd1 vssd1 sky130_fd_sc_hd__fill_2$1
XFILLER_83_473 vssd1 vccd1 vccd1 vssd1 sky130_fd_sc_hd__fill_8$1
XFILLER_16_529 vssd1 vccd1 vccd1 vssd1 sky130_fd_sc_hd__fill_2$1
XFILLER_28_389 vssd1 vccd1 vccd1 vssd1 sky130_ef_sc_hd__decap_40_12$1
XTAP_TAPCELL_ROW_39_885 vccd1 vssd1 sky130_fd_sc_hd__tapvpwrvgnd_1$1
XTAP_TAPCELL_ROW_48_1016 vccd1 vssd1 sky130_fd_sc_hd__tapvpwrvgnd_1$1
XTAP_TAPCELL_ROW_48_1027 vccd1 vssd1 sky130_fd_sc_hd__tapvpwrvgnd_1$1
XFILLER_43_337 vssd1 vccd1 vccd1 vssd1 sky130_ef_sc_hd__decap_40_12$1
XFILLER_12_713 vssd1 vccd1 vccd1 vssd1 sky130_ef_sc_hd__decap_40_12$1
XFILLER_70_189 vssd1 vccd1 vccd1 vssd1 sky130_fd_sc_hd__fill_4$1
XTAP_TAPCELL_ROW_61_1216 vccd1 vssd1 sky130_fd_sc_hd__tapvpwrvgnd_1$1
XFILLER_11_223 vccd1 vssd1 vccd1 vssd1 sky130_fd_sc_hd__fill_1$1
XFILLER_34_77 vssd1 vccd1 vccd1 vssd1 sky130_fd_sc_hd__fill_4$1
XFILLER_133_3 vssd1 vccd1 vccd1 vssd1 sky130_ef_sc_hd__decap_40_12$1
XFILLER_7_205 vssd1 vccd1 vccd1 vssd1 sky130_ef_sc_hd__decap_40_12$1
XFILLER_12_757 vssd1 vccd1 vccd1 vssd1 sky130_ef_sc_hd__decap_40_12$1
XFILLER_109_111 vccd1 vssd1 vccd1 vssd1 sky130_fd_sc_hd__fill_1$1
XFILLER_50_65 vssd1 vccd1 vccd1 vssd1 sky130_ef_sc_hd__decap_40_12$1
XFILLER_7_249 vssd1 vccd1 vccd1 vssd1 sky130_ef_sc_hd__decap_40_12$1
XFILLER_125_659 vssd1 vccd1 vccd1 vssd1 sky130_ef_sc_hd__decap_40_12$1
XTAP_TAPCELL_ROW_59_1189 vccd1 vssd1 sky130_fd_sc_hd__tapvpwrvgnd_1$1
XTAP_TAPCELL_ROW_59_1178 vccd1 vssd1 sky130_fd_sc_hd__tapvpwrvgnd_1$1
XFILLER_133_670 vssd1 vccd1 vccd1 vssd1 sky130_fd_sc_hd__fill_2$1
XFILLER_112_309 vssd1 vccd1 vccd1 vssd1 sky130_ef_sc_hd__decap_40_12$1
XFILLER_105_361 vssd1 vccd1 vccd1 vssd1 sky130_ef_sc_hd__decap_40_12$1
XFILLER_78_245 vssd1 vccd1 vccd1 vssd1 sky130_fd_sc_hd__fill_4$1
XTAP_TAPCELL_ROW_72_1378 vccd1 vssd1 sky130_fd_sc_hd__tapvpwrvgnd_1$1
XFILLER_38_109 vssd1 vccd1 vccd1 vssd1 sky130_ef_sc_hd__decap_40_12$1
XFILLER_93_237 vssd1 vccd1 vccd1 vssd1 sky130_ef_sc_hd__decap_40_12$1
XFILLER_78_289 vssd1 vccd1 vccd1 vssd1 sky130_ef_sc_hd__decap_40_12$1
XFILLER_75_51 vssd1 vccd1 vccd1 vssd1 sky130_fd_sc_hd__fill_4$1
XFILLER_47_665 vssd1 vccd1 vccd1 vssd1 sky130_fd_sc_hd__fill_4$1
XFILLER_74_473 vssd1 vccd1 vccd1 vssd1 sky130_fd_sc_hd__fill_2$1
XFILLER_62_613 vssd1 vccd1 vccd1 vssd1 sky130_ef_sc_hd__decap_40_12$1
XFILLER_19_389 vssd1 vccd1 vccd1 vssd1 sky130_fd_sc_hd__fill_2$1
XFILLER_46_153 vssd1 vccd1 vccd1 vssd1 sky130_ef_sc_hd__decap_40_12$1
XFILLER_62_657 vssd1 vccd1 vccd1 vssd1 sky130_ef_sc_hd__decap_40_12$1
XFILLER_46_197 vssd1 vccd1 vccd1 vssd1 sky130_ef_sc_hd__decap_40_12$1
XFILLER_61_167 vccd1 vssd1 vccd1 vssd1 sky130_fd_sc_hd__fill_1$1
XTAP_TAPCELL_ROW_17_557 vccd1 vssd1 sky130_fd_sc_hd__tapvpwrvgnd_1$1
XFILLER_15_573 vssd1 vccd1 vccd1 vssd1 sky130_ef_sc_hd__decap_40_12$1
X_1851_ vccd1 vssd1 _1851_/X _1851_/A vccd1 vssd1 sky130_fd_sc_hd__buf_2$1
XFILLER_30_587 vccd1 vssd1 vccd1 vssd1 sky130_fd_sc_hd__fill_1$1
X_0802_ _1799_/A _0879_/A2 _0802_/X input11/X _0826_/B1 vccd1 vssd1 vccd1 vssd1 sky130_fd_sc_hd__a22o_1$1
XFILLER_128_464 vssd1 vccd1 vccd1 vssd1 sky130_ef_sc_hd__decap_40_12$1
X_1782_ vccd1 vssd1 _1782_/X _1782_/A vccd1 vssd1 sky130_fd_sc_hd__buf_1$1
XFILLER_116_637 vssd1 vccd1 vccd1 vssd1 sky130_fd_sc_hd__fill_4$1
XFILLER_7_783 vccd1 vssd1 vccd1 vssd1 sky130_fd_sc_hd__fill_1$1
XFILLER_115_125 vssd1 vccd1 vccd1 vssd1 sky130_ef_sc_hd__decap_40_12$1
XFILLER_131_629 vssd1 vccd1 vccd1 vssd1 sky130_ef_sc_hd__decap_40_12$1
XFILLER_115_169 vssd1 vccd1 vccd1 vssd1 sky130_ef_sc_hd__decap_40_12$1
XFILLER_130_139 vccd1 vssd1 vccd1 vssd1 sky130_fd_sc_hd__fill_1$1
XFILLER_124_681 vssd1 vccd1 vccd1 vssd1 sky130_ef_sc_hd__decap_40_12$1
XFILLER_69_223 vccd1 vssd1 vccd1 vssd1 sky130_fd_sc_hd__fill_1$1
XFILLER_85_727 vccd1 vssd1 vccd1 vssd1 sky130_fd_sc_hd__fill_1$1
XFILLER_85_705 vssd1 vccd1 vccd1 vssd1 sky130_ef_sc_hd__decap_40_12$1
XFILLER_29_109 vssd1 vccd1 vccd1 vssd1 sky130_fd_sc_hd__fill_2$1
X_1216_ _1638_/Q _1216_/X _1270_/B vssd1 vccd1 vccd1 vssd1 sky130_fd_sc_hd__or2_1$1
XFILLER_38_643 vccd1 vssd1 vccd1 vssd1 sky130_fd_sc_hd__fill_1$1
X_1147_ _1147_/Y _1147_/A _1411_/B vssd1 vccd1 vccd1 vssd1 sky130_fd_sc_hd__nand2_2$1
XFILLER_65_473 vssd1 vccd1 vccd1 vssd1 sky130_fd_sc_hd__fill_8$1
XFILLER_1_81 vssd1 vccd1 vccd1 vssd1 sky130_ef_sc_hd__decap_40_12$1
XFILLER_111_27 vssd1 vccd1 vccd1 vssd1 sky130_ef_sc_hd__decap_40_12$1
XFILLER_80_421 vssd1 vccd1 vccd1 vssd1 sky130_ef_sc_hd__decap_40_12$1
XFILLER_25_337 vssd1 vccd1 vccd1 vssd1 sky130_ef_sc_hd__decap_40_12$1
XTAP_TAPCELL_ROW_36_833 vccd1 vssd1 sky130_fd_sc_hd__tapvpwrvgnd_1$1
XTAP_TAPCELL_ROW_36_844 vccd1 vssd1 sky130_fd_sc_hd__tapvpwrvgnd_1$1
X_1078_ hold15/X _1078_/X _1078_/B vssd1 vccd1 vccd1 vssd1 sky130_fd_sc_hd__or2_1$1
XFILLER_40_307 vccd1 vssd1 vccd1 vssd1 sky130_fd_sc_hd__fill_1$1
XTAP_TAPCELL_ROW_101_1817 vccd1 vssd1 sky130_fd_sc_hd__tapvpwrvgnd_1$1
XFILLER_52_189 vssd1 vccd1 vccd1 vssd1 sky130_fd_sc_hd__fill_4$1
XTAP_TAPCELL_ROW_134_2316 vccd1 vssd1 sky130_fd_sc_hd__tapvpwrvgnd_1$1
XTAP_TAPCELL_ROW_134_2305 vccd1 vssd1 sky130_fd_sc_hd__tapvpwrvgnd_1$1
XFILLER_5_709 vssd1 vccd1 vccd1 vssd1 sky130_ef_sc_hd__decap_40_12$1
XTAP_TAPCELL_ROW_112_1979 vccd1 vssd1 sky130_fd_sc_hd__tapvpwrvgnd_1$1
XFILLER_103_821 vssd1 vccd1 vccd1 vssd1 sky130_fd_sc_hd__fill_2$1
XFILLER_88_521 vssd1 vccd1 vccd1 vssd1 sky130_fd_sc_hd__fill_2$1
XFILLER_130_640 vssd1 vccd1 vccd1 vssd1 sky130_fd_sc_hd__fill_4$1
Xhold11 hold11/A hold11/X vssd1 vccd1 vccd1 vssd1 sky130_fd_sc_hd__dlygate4sd3_1$1
Xhold22 hold22/A hold22/X vssd1 vccd1 vccd1 vssd1 sky130_fd_sc_hd__dlygate4sd3_1$1
XFILLER_0_447 vccd1 vssd1 vccd1 vssd1 sky130_fd_sc_hd__fill_1$1
Xhold33 hold33/A hold33/X vssd1 vccd1 vccd1 vssd1 sky130_fd_sc_hd__dlygate4sd3_1$1
Xhold55 hold55/A hold55/X vssd1 vccd1 vccd1 vssd1 sky130_fd_sc_hd__dlygate4sd3_1$1
Xhold44 hold44/A hold44/X vssd1 vccd1 vccd1 vssd1 sky130_fd_sc_hd__dlygate4sd3_1$1
XFILLER_75_237 vssd1 vccd1 vccd1 vssd1 sky130_ef_sc_hd__decap_40_12$1
XFILLER_29_55 vccd1 vssd1 vccd1 vssd1 sky130_fd_sc_hd__fill_1$1
Xhold77 wbs_dat_i[0] hold77/X vssd1 vccd1 vccd1 vssd1 sky130_fd_sc_hd__dlygate4sd3_1$1
Xhold66 wbs_dat_i[3] hold66/X vssd1 vccd1 vccd1 vssd1 sky130_fd_sc_hd__dlygate4sd3_1$1
Xhold88 hold88/A hold88/X vssd1 vccd1 vccd1 vssd1 sky130_fd_sc_hd__dlygate4sd3_1$1
Xhold99 hold99/A hold99/X vssd1 vccd1 vccd1 vssd1 sky130_fd_sc_hd__dlygate4sd3_1$1
XFILLER_29_665 vssd1 vccd1 vccd1 vssd1 sky130_fd_sc_hd__fill_4$1
XFILLER_56_473 vssd1 vccd1 vccd1 vssd1 sky130_fd_sc_hd__fill_2$1
XFILLER_28_153 vssd1 vccd1 vccd1 vssd1 sky130_ef_sc_hd__decap_40_12$1
XFILLER_44_613 vssd1 vccd1 vccd1 vssd1 sky130_ef_sc_hd__decap_40_12$1
XFILLER_83_281 vssd1 vccd1 vccd1 vssd1 sky130_ef_sc_hd__decap_40_12$1
XFILLER_28_197 vssd1 vccd1 vccd1 vssd1 sky130_ef_sc_hd__decap_40_12$1
XFILLER_43_167 vccd1 vssd1 vccd1 vssd1 sky130_fd_sc_hd__fill_1$1
XTAP_TAPCELL_ROW_14_505 vccd1 vssd1 sky130_fd_sc_hd__tapvpwrvgnd_1$1
XTAP_TAPCELL_ROW_14_516 vccd1 vssd1 sky130_fd_sc_hd__tapvpwrvgnd_1$1
XFILLER_31_329 vssd1 vccd1 vccd1 vssd1 sky130_fd_sc_hd__fill_4$1
XFILLER_129_217 vssd1 vccd1 vccd1 vssd1 sky130_fd_sc_hd__fill_4$1
XFILLER_101_93 vssd1 vccd1 vccd1 vssd1 sky130_ef_sc_hd__decap_40_12$1
XFILLER_40_841 vccd1 vssd1 vccd1 vssd1 sky130_fd_sc_hd__fill_1$1
XFILLER_8_525 vssd1 vccd1 vccd1 vssd1 sky130_fd_sc_hd__fill_4$1
XFILLER_12_587 vccd1 vssd1 vccd1 vssd1 sky130_fd_sc_hd__fill_1$1
XFILLER_8_569 vssd1 vccd1 vccd1 vssd1 sky130_ef_sc_hd__decap_40_12$1
XFILLER_6_15 vssd1 vccd1 vccd1 vssd1 sky130_ef_sc_hd__decap_40_12$1
XANTENNA_8 input21/X vssd1 vccd1 vccd1 vssd1 sky130_fd_sc_hd__diode_2$1
XFILLER_125_445 vssd1 vccd1 vccd1 vssd1 sky130_fd_sc_hd__fill_2$1
XTAP_TAPCELL_ROW_74_1407 vccd1 vssd1 sky130_fd_sc_hd__tapvpwrvgnd_1$1
XFILLER_4_753 vssd1 vccd1 vccd1 vssd1 sky130_fd_sc_hd__fill_2$1
XFILLER_98_307 vccd1 vssd1 vccd1 vssd1 sky130_fd_sc_hd__fill_1$1
XFILLER_112_139 vccd1 vssd1 vccd1 vssd1 sky130_fd_sc_hd__fill_1$1
XFILLER_121_673 vssd1 vccd1 vccd1 vssd1 sky130_ef_sc_hd__decap_40_12$1
XFILLER_86_83 vccd1 vssd1 vccd1 vssd1 sky130_fd_sc_hd__fill_1$1
XFILLER_39_429 vssd1 vccd1 vccd1 vssd1 sky130_ef_sc_hd__decap_40_12$1
XFILLER_94_557 vssd1 vccd1 vccd1 vssd1 sky130_ef_sc_hd__decap_40_12$1
X_1001_ _1471_/C1 _1000_/X _1013_/A2 hold81/X _1534_/D vssd1 vccd1 vccd1 vssd1 sky130_fd_sc_hd__o211a_1$1
XFILLER_47_473 vssd1 vccd1 vccd1 vssd1 sky130_ef_sc_hd__decap_40_12$1
XFILLER_62_421 vssd1 vccd1 vccd1 vssd1 sky130_ef_sc_hd__decap_40_12$1
XTAP_TAPCELL_ROW_85_1569 vccd1 vssd1 sky130_fd_sc_hd__tapvpwrvgnd_1$1
XFILLER_22_307 vccd1 vssd1 vccd1 vssd1 sky130_fd_sc_hd__fill_1$1
XFILLER_96_3 vssd1 vccd1 vccd1 vssd1 sky130_ef_sc_hd__decap_40_12$1
XFILLER_50_638 vssd1 vccd1 vccd1 vssd1 sky130_fd_sc_hd__fill_4$1
XFILLER_34_189 vssd1 vccd1 vccd1 vssd1 sky130_fd_sc_hd__fill_4$1
XFILLER_31_841 vccd1 vssd1 vccd1 vssd1 sky130_fd_sc_hd__fill_1$1
XTAP_TAPCELL_ROW_116_2035 vccd1 vssd1 sky130_fd_sc_hd__tapvpwrvgnd_1$1
X_1834_ vccd1 vssd1 _1834_/X _1834_/A vccd1 vssd1 sky130_fd_sc_hd__buf_1$1
XTAP_TAPCELL_ROW_116_2046 vccd1 vssd1 sky130_fd_sc_hd__tapvpwrvgnd_1$1
XFILLER_116_456 vssd1 vccd1 vccd1 vssd1 sky130_fd_sc_hd__fill_2$1
Xmax_cap255 hold9/X _0944_/A2 vssd1 vccd1 vccd1 vssd1 sky130_fd_sc_hd__clkbuf_2$1
XFILLER_116_489 vssd1 vccd1 vccd1 vssd1 sky130_ef_sc_hd__decap_40_12$1
X_1696_ _1696_/Q _1729_/CLK _1696_/D vccd1 vssd1 vccd1 vssd1 sky130_fd_sc_hd__dfxtp_1$1
XFILLER_89_329 vssd1 vccd1 vccd1 vssd1 sky130_fd_sc_hd__fill_4$1
XFILLER_106_27 vccd1 vssd1 vccd1 vssd1 sky130_fd_sc_hd__fill_1$1
XFILLER_111_161 vssd1 vccd1 vccd1 vssd1 sky130_fd_sc_hd__fill_4$1
XFILLER_85_557 vssd1 vccd1 vccd1 vssd1 sky130_fd_sc_hd__fill_2$1
XFILLER_57_237 vssd1 vccd1 vccd1 vssd1 sky130_ef_sc_hd__decap_40_12$1
XFILLER_122_15 vssd1 vccd1 vccd1 vssd1 sky130_ef_sc_hd__decap_40_12$1
XFILLER_73_719 vssd1 vccd1 vccd1 vssd1 sky130_fd_sc_hd__fill_8$1
XFILLER_26_613 vssd1 vccd1 vccd1 vssd1 sky130_ef_sc_hd__decap_40_12$1
XFILLER_38_473 vssd1 vccd1 vccd1 vssd1 sky130_fd_sc_hd__fill_2$1
XFILLER_81_741 vssd1 vccd1 vccd1 vssd1 sky130_ef_sc_hd__decap_40_12$1
XFILLER_66_793 vssd1 vccd1 vccd1 vssd1 sky130_fd_sc_hd__fill_2$1
XFILLER_65_281 vssd1 vccd1 vccd1 vssd1 sky130_ef_sc_hd__decap_40_12$1
XFILLER_53_432 vssd1 vccd1 vccd1 vssd1 sky130_fd_sc_hd__fill_2$1
XFILLER_53_421 vssd1 vccd1 vccd1 vssd1 sky130_fd_sc_hd__fill_2$1
XFILLER_81_785 vssd1 vccd1 vccd1 vssd1 sky130_ef_sc_hd__decap_40_12$1
XFILLER_80_251 vccd1 vssd1 vccd1 vssd1 sky130_fd_sc_hd__fill_1$1
XFILLER_53_443 vssd1 vccd1 vccd1 vssd1 sky130_fd_sc_hd__fill_4$1
XTAP_TAPCELL_ROW_0_288 vccd1 vssd1 sky130_fd_sc_hd__tapvpwrvgnd_1$1
XFILLER_25_167 vccd1 vssd1 vccd1 vssd1 sky130_fd_sc_hd__fill_1$1
XFILLER_26_679 vssd1 vccd1 vccd1 vssd1 sky130_ef_sc_hd__decap_40_12$1
XFILLER_53_498 vssd1 vccd1 vccd1 vssd1 sky130_fd_sc_hd__fill_4$1
XTAP_TAPCELL_ROW_0_299 vccd1 vssd1 sky130_fd_sc_hd__tapvpwrvgnd_1$1
XFILLER_13_329 vssd1 vccd1 vccd1 vssd1 sky130_fd_sc_hd__fill_4$1
XFILLER_15_57 vssd1 vccd1 vccd1 vssd1 sky130_ef_sc_hd__decap_40_12$1
XFILLER_40_137 vssd1 vccd1 vccd1 vssd1 sky130_fd_sc_hd__fill_2$1
XFILLER_21_373 vssd1 vccd1 vccd1 vssd1 sky130_ef_sc_hd__decap_40_12$1
XFILLER_126_209 vssd1 vccd1 vccd1 vssd1 sky130_ef_sc_hd__decap_40_12$1
XFILLER_119_261 vssd1 vccd1 vccd1 vssd1 sky130_ef_sc_hd__decap_40_12$1
XFILLER_5_517 vssd1 vccd1 vccd1 vssd1 sky130_ef_sc_hd__decap_40_12$1
XFILLER_107_445 vssd1 vccd1 vccd1 vssd1 sky130_fd_sc_hd__fill_2$1
XFILLER_134_253 vssd1 vccd1 vccd1 vssd1 sky130_ef_sc_hd__decap_40_12$1
XTAP_TAPCELL_ROW_56_1137 vccd1 vssd1 sky130_fd_sc_hd__tapvpwrvgnd_1$1
Xoutput67 _1848_/X analog_ctrl[115] vssd1 vccd1 vccd1 vssd1 sky130_fd_sc_hd__buf_12$1
Xoutput56 _1838_/X analog_ctrl[105] vssd1 vccd1 vccd1 vssd1 sky130_fd_sc_hd__buf_12$1
XFILLER_89_841 vccd1 vssd1 vccd1 vssd1 sky130_fd_sc_hd__fill_1$1
Xoutput78 _1785_/X analog_ctrl[14] vssd1 vccd1 vccd1 vssd1 sky130_fd_sc_hd__buf_12$1
Xoutput89 _1795_/X analog_ctrl[24] vssd1 vccd1 vccd1 vssd1 sky130_fd_sc_hd__buf_12$1
XFILLER_103_673 vssd1 vccd1 vccd1 vssd1 sky130_ef_sc_hd__decap_40_12$1
XFILLER_76_535 vccd1 vssd1 vccd1 vssd1 sky130_fd_sc_hd__fill_1$1
XFILLER_76_502 vssd1 vccd1 vccd1 vssd1 sky130_ef_sc_hd__decap_40_12$1
XFILLER_49_727 vccd1 vssd1 vccd1 vssd1 sky130_fd_sc_hd__fill_1$1
XFILLER_0_277 vssd1 vccd1 vccd1 vssd1 sky130_fd_sc_hd__fill_2$1
XFILLER_76_568 vssd1 vccd1 vccd1 vssd1 sky130_ef_sc_hd__decap_40_12$1
XFILLER_91_505 vssd1 vccd1 vccd1 vssd1 sky130_ef_sc_hd__decap_40_12$1
XFILLER_56_53 vssd1 vccd1 vccd1 vssd1 sky130_ef_sc_hd__decap_40_12$1
XFILLER_17_613 vssd1 vccd1 vccd1 vssd1 sky130_fd_sc_hd__fill_2$1
XFILLER_29_473 vssd1 vccd1 vccd1 vssd1 sky130_ef_sc_hd__decap_40_12$1
XFILLER_56_97 vssd1 vccd1 vccd1 vssd1 sky130_ef_sc_hd__decap_40_12$1
XFILLER_44_421 vssd1 vccd1 vccd1 vssd1 sky130_ef_sc_hd__decap_40_12$1
XPHY_EDGE_ROW_113_Right_113 vccd1 vssd1 vccd1 vssd1 sky130_fd_sc_hd__decap_3$1
XFILLER_44_465 vssd1 vccd1 vccd1 vssd1 sky130_fd_sc_hd__fill_8$1
XFILLER_112_81 vssd1 vccd1 vccd1 vssd1 sky130_fd_sc_hd__fill_2$1
XFILLER_72_41 vssd1 vccd1 vccd1 vssd1 sky130_ef_sc_hd__decap_40_12$1
XFILLER_71_273 vssd1 vccd1 vccd1 vssd1 sky130_fd_sc_hd__fill_4$1
XTAP_TAPCELL_ROW_67_1299 vccd1 vssd1 sky130_fd_sc_hd__tapvpwrvgnd_1$1
XFILLER_16_189 vssd1 vccd1 vccd1 vssd1 sky130_fd_sc_hd__fill_4$1
XFILLER_72_85 vssd1 vccd1 vccd1 vssd1 sky130_ef_sc_hd__decap_40_12$1
XFILLER_13_841 vccd1 vssd1 vccd1 vssd1 sky130_fd_sc_hd__fill_1$1
XFILLER_31_137 vssd1 vccd1 vccd1 vssd1 sky130_ef_sc_hd__decap_40_12$1
XFILLER_9_823 vccd1 vssd1 vccd1 vssd1 sky130_fd_sc_hd__fill_1$1
XTAP_TAPCELL_ROW_80_1499 vccd1 vssd1 sky130_fd_sc_hd__tapvpwrvgnd_1$1
XFILLER_8_333 vssd1 vccd1 vccd1 vssd1 sky130_ef_sc_hd__decap_40_12$1
XFILLER_8_377 vssd1 vccd1 vccd1 vssd1 sky130_ef_sc_hd__decap_40_12$1
X_1550_ _1550_/Q clkload3/A _1550_/D vccd1 vssd1 vccd1 vssd1 sky130_fd_sc_hd__dfxtp_1$1
XFILLER_126_765 vssd1 vccd1 vccd1 vssd1 sky130_ef_sc_hd__decap_40_12$1
XFILLER_98_137 vssd1 vccd1 vccd1 vssd1 sky130_fd_sc_hd__fill_2$1
X_1481_ _1481_/D _1739_/CLK _1481_/Q vssd1 vccd1 vccd1 vssd1 sky130_fd_sc_hd__dfxtp_4$1
XFILLER_100_109 vssd1 vccd1 vccd1 vssd1 sky130_ef_sc_hd__decap_40_12$1
XFILLER_97_93 vssd1 vccd1 vccd1 vssd1 sky130_ef_sc_hd__decap_40_12$1
XFILLER_79_373 vccd1 vssd1 vccd1 vssd1 sky130_fd_sc_hd__fill_1$1
XFILLER_94_321 vssd1 vccd1 vccd1 vssd1 sky130_ef_sc_hd__decap_40_12$1
XTAP_TAPCELL_ROW_87_1609 vccd1 vssd1 sky130_fd_sc_hd__tapvpwrvgnd_1$1
XFILLER_67_557 vssd1 vccd1 vccd1 vssd1 sky130_fd_sc_hd__fill_2$1
XFILLER_67_535 vssd1 vccd1 vccd1 vssd1 sky130_fd_sc_hd__fill_2$1
XFILLER_11_3 vssd1 vccd1 vccd1 vssd1 sky130_ef_sc_hd__decap_40_12$1
XFILLER_39_237 vssd1 vccd1 vccd1 vssd1 sky130_ef_sc_hd__decap_40_12$1
XFILLER_94_365 vssd1 vccd1 vccd1 vssd1 sky130_ef_sc_hd__decap_40_12$1
XFILLER_82_505 vccd1 vssd1 vccd1 vssd1 sky130_fd_sc_hd__fill_1$1
XFILLER_82_538 vssd1 vccd1 vccd1 vssd1 sky130_ef_sc_hd__decap_40_12$1
XFILLER_63_741 vssd1 vccd1 vccd1 vssd1 sky130_ef_sc_hd__decap_40_12$1
XFILLER_47_281 vssd1 vccd1 vccd1 vssd1 sky130_ef_sc_hd__decap_40_12$1
XFILLER_62_251 vccd1 vssd1 vccd1 vssd1 sky130_fd_sc_hd__fill_1$1
XFILLER_50_413 vssd1 vccd1 vccd1 vssd1 sky130_fd_sc_hd__fill_4$1
XTAP_TAPCELL_ROW_46_983 vccd1 vssd1 sky130_fd_sc_hd__tapvpwrvgnd_1$1
XTAP_TAPCELL_ROW_46_994 vccd1 vssd1 sky130_fd_sc_hd__tapvpwrvgnd_1$1
XFILLER_22_137 vssd1 vccd1 vccd1 vssd1 sky130_fd_sc_hd__fill_2$1
XFILLER_31_671 vccd1 vssd1 vccd1 vssd1 sky130_fd_sc_hd__fill_1$1
XFILLER_108_209 vssd1 vccd1 vccd1 vssd1 sky130_ef_sc_hd__decap_40_12$1
X_1817_ _1817_/A _1817_/X vssd1 vccd1 vccd1 vssd1 sky130_fd_sc_hd__clkbuf_2$1
XFILLER_117_743 vccd1 vssd1 vccd1 vssd1 sky130_fd_sc_hd__fill_1$1
XFILLER_132_713 vssd1 vccd1 vccd1 vssd1 sky130_ef_sc_hd__decap_40_12$1
XFILLER_117_787 vccd1 vssd1 vccd1 vssd1 sky130_fd_sc_hd__fill_1$1
XFILLER_117_15 vssd1 vccd1 vccd1 vssd1 sky130_ef_sc_hd__decap_40_12$1
XFILLER_116_253 vssd1 vccd1 vccd1 vssd1 sky130_ef_sc_hd__decap_40_12$1
X_1748_ _1748_/Q _1748_/CLK _1748_/D vccd1 vssd1 vccd1 vssd1 sky130_fd_sc_hd__dfxtp_1$1
XFILLER_132_735 vccd1 vssd1 vccd1 vssd1 sky130_fd_sc_hd__fill_1$1
XFILLER_131_223 vccd1 vssd1 vccd1 vssd1 sky130_fd_sc_hd__fill_1$1
XFILLER_89_137 vssd1 vccd1 vccd1 vssd1 sky130_ef_sc_hd__decap_40_12$1
X_1679_ _1679_/Q _1679_/CLK _1679_/D vccd1 vssd1 vccd1 vssd1 sky130_fd_sc_hd__dfxtp_1$1
XFILLER_132_779 vccd1 vssd1 vccd1 vssd1 sky130_fd_sc_hd__fill_1$1
XFILLER_132_757 vssd1 vccd1 vccd1 vssd1 sky130_ef_sc_hd__decap_40_12$1
XTAP_TAPCELL_ROW_129_2237 vccd1 vssd1 sky130_fd_sc_hd__tapvpwrvgnd_1$1
XFILLER_58_513 vssd1 vccd1 vccd1 vssd1 sky130_ef_sc_hd__decap_40_12$1
XFILLER_100_621 vssd1 vccd1 vccd1 vssd1 sky130_fd_sc_hd__fill_4$1
XFILLER_97_181 vssd1 vccd1 vccd1 vssd1 sky130_ef_sc_hd__decap_40_12$1
XTAP_TAPCELL_ROW_51_1067 vccd1 vssd1 sky130_fd_sc_hd__tapvpwrvgnd_1$1
XTAP_TAPCELL_ROW_5_369 vccd1 vssd1 sky130_fd_sc_hd__tapvpwrvgnd_1$1
XFILLER_133_69 vssd1 vccd1 vccd1 vssd1 sky130_ef_sc_hd__decap_40_12$1
XFILLER_73_505 vssd1 vccd1 vccd1 vssd1 sky130_fd_sc_hd__fill_8$1
XFILLER_26_421 vssd1 vccd1 vccd1 vssd1 sky130_ef_sc_hd__decap_40_12$1
XFILLER_81_582 vssd1 vccd1 vccd1 vssd1 sky130_ef_sc_hd__decap_40_12$1
XFILLER_53_273 vssd1 vccd1 vccd1 vssd1 sky130_fd_sc_hd__fill_4$1
XFILLER_13_137 vssd1 vccd1 vccd1 vssd1 sky130_ef_sc_hd__decap_40_12$1
XFILLER_10_811 vccd1 vssd1 vccd1 vssd1 sky130_fd_sc_hd__fill_1$1
XTAP_TAPCELL_ROW_24_655 vccd1 vssd1 sky130_fd_sc_hd__tapvpwrvgnd_1$1
XTAP_TAPCELL_ROW_24_666 vccd1 vssd1 sky130_fd_sc_hd__tapvpwrvgnd_1$1
XFILLER_21_181 vssd1 vccd1 vccd1 vssd1 sky130_ef_sc_hd__decap_40_12$1
XFILLER_22_693 vssd1 vccd1 vccd1 vssd1 sky130_fd_sc_hd__fill_4$1
XFILLER_42_77 vssd1 vccd1 vccd1 vssd1 sky130_fd_sc_hd__fill_4$1
XFILLER_127_529 vssd1 vccd1 vccd1 vssd1 sky130_ef_sc_hd__decap_40_12$1
XFILLER_6_837 vssd1 vccd1 vccd1 vssd1 sky130_fd_sc_hd__fill_4$1
XFILLER_122_245 vssd1 vccd1 vccd1 vssd1 sky130_fd_sc_hd__fill_4$1
XFILLER_3_27 vssd1 vccd1 vccd1 vssd1 sky130_ef_sc_hd__decap_40_12$1
XFILLER_1_553 vssd1 vccd1 vccd1 vssd1 sky130_fd_sc_hd__fill_4$1
XFILLER_122_289 vssd1 vccd1 vccd1 vssd1 sky130_ef_sc_hd__decap_40_12$1
XFILLER_107_81 vssd1 vccd1 vccd1 vssd1 sky130_ef_sc_hd__decap_40_12$1
XFILLER_89_671 vccd1 vssd1 vccd1 vssd1 sky130_fd_sc_hd__fill_1$1
XFILLER_76_321 vssd1 vccd1 vccd1 vssd1 sky130_ef_sc_hd__decap_40_12$1
XFILLER_1_597 vssd1 vccd1 vccd1 vssd1 sky130_ef_sc_hd__decap_40_12$1
XFILLER_76_365 vssd1 vccd1 vccd1 vssd1 sky130_ef_sc_hd__decap_40_12$1
XTAP_TAPCELL_ROW_69_1328 vccd1 vssd1 sky130_fd_sc_hd__tapvpwrvgnd_1$1
XFILLER_91_335 vccd1 vssd1 vccd1 vssd1 sky130_fd_sc_hd__fill_1$1
XTAP_TAPCELL_ROW_69_1339 vccd1 vssd1 sky130_fd_sc_hd__tapvpwrvgnd_1$1
XFILLER_29_281 vssd1 vccd1 vccd1 vssd1 sky130_ef_sc_hd__decap_40_12$1
XFILLER_83_51 vssd1 vccd1 vccd1 vssd1 sky130_fd_sc_hd__fill_4$1
XFILLER_45_741 vssd1 vccd1 vccd1 vssd1 sky130_ef_sc_hd__decap_40_12$1
XTAP_TAPCELL_ROW_82_1528 vccd1 vssd1 sky130_fd_sc_hd__tapvpwrvgnd_1$1
XFILLER_60_733 vccd1 vssd1 vccd1 vssd1 sky130_fd_sc_hd__fill_1$1
XFILLER_32_413 vssd1 vccd1 vccd1 vssd1 sky130_fd_sc_hd__fill_4$1
XFILLER_44_251 vccd1 vssd1 vccd1 vssd1 sky130_fd_sc_hd__fill_1$1
XFILLER_45_785 vssd1 vccd1 vccd1 vssd1 sky130_ef_sc_hd__decap_40_12$1
XFILLER_60_755 vccd1 vssd1 vccd1 vssd1 sky130_fd_sc_hd__fill_1$1
XFILLER_32_457 vssd1 vccd1 vccd1 vssd1 sky130_ef_sc_hd__decap_40_12$1
XTAP_TAPCELL_ROW_43_942 vccd1 vssd1 sky130_fd_sc_hd__tapvpwrvgnd_1$1
X_0981_ _1443_/C1 _0980_/X _1013_/A2 hold90/X _1524_/D vssd1 vccd1 vccd1 vssd1 sky130_fd_sc_hd__o211a_1$1
XFILLER_13_671 vccd1 vssd1 vccd1 vssd1 sky130_fd_sc_hd__fill_1$1
XFILLER_9_653 vssd1 vccd1 vccd1 vssd1 sky130_ef_sc_hd__decap_40_12$1
XFILLER_8_141 vssd1 vccd1 vccd1 vssd1 sky130_ef_sc_hd__decap_40_12$1
X_1602_ _1602_/Q _1762_/CLK _1602_/D vccd1 vssd1 vccd1 vssd1 sky130_fd_sc_hd__dfxtp_1$1
XTAP_TAPCELL_ROW_97_1760 vccd1 vssd1 sky130_fd_sc_hd__tapvpwrvgnd_1$1
XFILLER_9_697 vssd1 vccd1 vccd1 vssd1 sky130_ef_sc_hd__decap_40_12$1
XFILLER_114_713 vssd1 vccd1 vccd1 vssd1 sky130_ef_sc_hd__decap_40_12$1
XFILLER_59_3 vssd1 vccd1 vccd1 vssd1 sky130_ef_sc_hd__decap_40_12$1
X_1533_ _1533_/Q _1757_/CLK _1533_/D vccd1 vssd1 vccd1 vssd1 sky130_fd_sc_hd__dfxtp_1$1
XFILLER_113_223 vccd1 vssd1 vccd1 vssd1 sky130_fd_sc_hd__fill_1$1
X_1464_ _1464_/A _1464_/X _1464_/B vssd1 vccd1 vccd1 vssd1 sky130_fd_sc_hd__or2_1$1
XFILLER_114_757 vssd1 vccd1 vccd1 vssd1 sky130_ef_sc_hd__decap_40_12$1
XFILLER_99_446 vssd1 vccd1 vccd1 vssd1 sky130_fd_sc_hd__fill_2$1
XFILLER_68_811 vccd1 vssd1 vccd1 vssd1 sky130_fd_sc_hd__fill_1$1
X_1395_ _1463_/C1 _1394_/X _1399_/A2 hold86/X _1725_/D vssd1 vccd1 vccd1 vssd1 sky130_fd_sc_hd__o211a_1$1
XFILLER_79_181 vssd1 vccd1 vccd1 vssd1 sky130_ef_sc_hd__decap_40_12$1
XFILLER_95_685 vssd1 vccd1 vccd1 vssd1 sky130_ef_sc_hd__decap_40_12$1
XFILLER_55_505 vssd1 vccd1 vccd1 vssd1 sky130_ef_sc_hd__decap_40_12$1
XTAP_TAPCELL_ROW_2_328 vccd1 vssd1 sky130_fd_sc_hd__tapvpwrvgnd_1$1
XFILLER_103_39 vssd1 vccd1 vccd1 vssd1 sky130_ef_sc_hd__decap_40_12$1
XFILLER_94_195 vccd1 vssd1 vccd1 vssd1 sky130_fd_sc_hd__fill_1$1
XTAP_TAPCELL_ROW_124_2167 vccd1 vssd1 sky130_fd_sc_hd__tapvpwrvgnd_1$1
XTAP_TAPCELL_ROW_124_2156 vccd1 vssd1 sky130_fd_sc_hd__tapvpwrvgnd_1$1
XFILLER_82_357 vssd1 vccd1 vccd1 vssd1 sky130_fd_sc_hd__fill_4$1
XFILLER_35_273 vssd1 vccd1 vccd1 vssd1 sky130_fd_sc_hd__fill_4$1
XFILLER_50_221 vssd1 vccd1 vccd1 vssd1 sky130_ef_sc_hd__decap_40_12$1
XFILLER_50_265 vssd1 vccd1 vccd1 vssd1 sky130_ef_sc_hd__decap_40_12$1
XTAP_TAPCELL_ROW_21_614 vccd1 vssd1 sky130_fd_sc_hd__tapvpwrvgnd_1$1
Xhold141 wbs_dat_i[10] input21/A vssd1 vccd1 vccd1 vssd1 sky130_fd_sc_hd__dlygate4sd3_1$1
Xhold130 _1597_/Q _1130_/A vssd1 vccd1 vccd1 vssd1 sky130_fd_sc_hd__dlygate4sd3_1$1
XFILLER_105_724 vssd1 vccd1 vccd1 vssd1 sky130_fd_sc_hd__fill_4$1
Xhold152 _1536_/Q _1004_/A vssd1 vccd1 vccd1 vssd1 sky130_fd_sc_hd__dlygate4sd3_1$1
XFILLER_88_29 vssd1 vccd1 vccd1 vssd1 sky130_ef_sc_hd__decap_40_12$1
Xhold174 _1762_/Q _1470_/A vssd1 vccd1 vccd1 vssd1 sky130_fd_sc_hd__dlygate4sd3_1$1
XFILLER_105_779 vssd1 vccd1 vccd1 vssd1 sky130_fd_sc_hd__fill_4$1
XFILLER_104_245 vssd1 vccd1 vccd1 vssd1 sky130_fd_sc_hd__fill_4$1
Xhold163 _1562_/Q _1058_/A vssd1 vccd1 vccd1 vssd1 sky130_fd_sc_hd__dlygate4sd3_1$1
Xhold185 _1677_/Q _1296_/A vssd1 vccd1 vccd1 vssd1 sky130_fd_sc_hd__dlygate4sd3_1$1
Xhold196 wbs_dat_i[6] input48/A vssd1 vccd1 vccd1 vssd1 sky130_fd_sc_hd__dlygate4sd3_1$1
XFILLER_132_587 vccd1 vssd1 vccd1 vssd1 sky130_fd_sc_hd__fill_1$1
XFILLER_104_289 vssd1 vccd1 vccd1 vssd1 sky130_ef_sc_hd__decap_40_12$1
XFILLER_120_749 vssd1 vccd1 vccd1 vssd1 sky130_fd_sc_hd__fill_4$1
XFILLER_86_641 vssd1 vccd1 vccd1 vssd1 sky130_fd_sc_hd__fill_2$1
XFILLER_58_321 vssd1 vccd1 vccd1 vssd1 sky130_ef_sc_hd__decap_40_12$1
XTAP_TAPCELL_ROW_109_1929 vccd1 vssd1 sky130_fd_sc_hd__tapvpwrvgnd_1$1
XFILLER_86_674 vssd1 vccd1 vccd1 vssd1 sky130_ef_sc_hd__decap_40_12$1
XFILLER_74_825 vccd1 vssd1 vccd1 vssd1 sky130_fd_sc_hd__fill_1$1
XFILLER_58_365 vssd1 vccd1 vccd1 vssd1 sky130_ef_sc_hd__decap_40_12$1
XFILLER_100_473 vssd1 vccd1 vccd1 vssd1 sky130_fd_sc_hd__fill_2$1
XFILLER_73_335 vccd1 vssd1 vccd1 vssd1 sky130_fd_sc_hd__fill_1$1
XTAP_TAPCELL_ROW_29_736 vccd1 vssd1 sky130_fd_sc_hd__tapvpwrvgnd_1$1
XFILLER_37_55 vccd1 vssd1 vccd1 vssd1 sky130_fd_sc_hd__fill_1$1
XFILLER_14_413 vssd1 vccd1 vccd1 vssd1 sky130_fd_sc_hd__fill_4$1
XFILLER_26_251 vccd1 vssd1 vccd1 vssd1 sky130_fd_sc_hd__fill_1$1
XFILLER_27_785 vssd1 vccd1 vccd1 vssd1 sky130_ef_sc_hd__decap_40_12$1
XTAP_TAPCELL_ROW_64_1258 vccd1 vssd1 sky130_fd_sc_hd__tapvpwrvgnd_1$1
XFILLER_41_221 vssd1 vccd1 vccd1 vssd1 sky130_fd_sc_hd__fill_2$1
XFILLER_42_755 vccd1 vssd1 vccd1 vssd1 sky130_fd_sc_hd__fill_1$1
XFILLER_14_457 vssd1 vccd1 vccd1 vssd1 sky130_ef_sc_hd__decap_40_12$1
XTAP_TAPCELL_ROW_40_901 vccd1 vssd1 sky130_fd_sc_hd__tapvpwrvgnd_1$1
XFILLER_10_641 vssd1 vccd1 vccd1 vssd1 sky130_fd_sc_hd__fill_2$1
XFILLER_6_601 vssd1 vccd1 vccd1 vssd1 sky130_ef_sc_hd__decap_40_12$1
XFILLER_127_337 vssd1 vccd1 vccd1 vssd1 sky130_ef_sc_hd__decap_40_12$1
XFILLER_6_645 vssd1 vccd1 vccd1 vssd1 sky130_ef_sc_hd__decap_40_12$1
XFILLER_5_111 vccd1 vssd1 vccd1 vssd1 sky130_fd_sc_hd__fill_1$1
XFILLER_123_521 vssd1 vccd1 vccd1 vssd1 sky130_fd_sc_hd__fill_2$1
XTAP_TAPCELL_ROW_79_1490 vccd1 vssd1 sky130_fd_sc_hd__tapvpwrvgnd_1$1
XFILLER_123_532 vssd1 vccd1 vccd1 vssd1 sky130_ef_sc_hd__decap_40_12$1
XFILLER_111_727 vccd1 vssd1 vccd1 vssd1 sky130_fd_sc_hd__fill_1$1
XFILLER_1_361 vssd1 vccd1 vccd1 vssd1 sky130_ef_sc_hd__decap_40_12$1
XFILLER_77_641 vssd1 vccd1 vccd1 vssd1 sky130_ef_sc_hd__decap_40_12$1
X_1180_ hold38/X _1180_/X _1210_/B vssd1 vccd1 vccd1 vssd1 sky130_fd_sc_hd__or2_1$1
XFILLER_37_505 vssd1 vccd1 vccd1 vssd1 sky130_ef_sc_hd__decap_40_12$1
XFILLER_77_685 vssd1 vccd1 vccd1 vssd1 sky130_ef_sc_hd__decap_40_12$1
XFILLER_37_549 vssd1 vccd1 vccd1 vssd1 sky130_fd_sc_hd__fill_2$1
XFILLER_94_83 vccd1 vssd1 vccd1 vssd1 sky130_fd_sc_hd__fill_1$1
XFILLER_76_195 vccd1 vssd1 vccd1 vssd1 sky130_fd_sc_hd__fill_1$1
XFILLER_64_357 vssd1 vccd1 vccd1 vssd1 sky130_fd_sc_hd__fill_4$1
XFILLER_92_699 vccd1 vssd1 vccd1 vssd1 sky130_fd_sc_hd__fill_1$1
XFILLER_91_165 vssd1 vccd1 vccd1 vssd1 sky130_fd_sc_hd__fill_2$1
XFILLER_17_273 vssd1 vccd1 vccd1 vssd1 sky130_fd_sc_hd__fill_4$1
XFILLER_32_221 vssd1 vccd1 vccd1 vssd1 sky130_ef_sc_hd__decap_40_12$1
XFILLER_32_265 vssd1 vccd1 vccd1 vssd1 sky130_ef_sc_hd__decap_40_12$1
XFILLER_33_766 vssd1 vccd1 vccd1 vssd1 sky130_ef_sc_hd__decap_40_12$1
XFILLER_9_461 vssd1 vccd1 vccd1 vssd1 sky130_ef_sc_hd__decap_40_12$1
X_0964_ _1783_/A _0964_/X _0990_/B vssd1 vccd1 vccd1 vssd1 sky130_fd_sc_hd__or2_1$1
X_0895_ hold41/A _1344_/A _0897_/B hold35/A _1279_/A vccd1 vssd1 vccd1 vssd1 sky130_fd_sc_hd__a22o_1$1
XTAP_TAPCELL_ROW_95_1719 vccd1 vssd1 sky130_fd_sc_hd__tapvpwrvgnd_1$1
Xoutput202 _1486_/Q wbs_dat_o[9] vssd1 vccd1 vccd1 vssd1 sky130_fd_sc_hd__buf_12$1
XFILLER_133_329 vssd1 vccd1 vccd1 vssd1 sky130_fd_sc_hd__fill_4$1
XFILLER_114_521 vccd1 vssd1 vccd1 vssd1 sky130_fd_sc_hd__fill_1$1
XFILLER_99_221 vssd1 vccd1 vccd1 vssd1 sky130_fd_sc_hd__fill_2$1
XTAP_TAPCELL_ROW_7_409 vccd1 vssd1 sky130_fd_sc_hd__tapvpwrvgnd_1$1
X_1516_ _1783_/A _1579_/CLK _1516_/D vccd1 vssd1 vccd1 vssd1 sky130_fd_sc_hd__dfxtp_1$1
XFILLER_114_587 vccd1 vssd1 vccd1 vssd1 sky130_fd_sc_hd__fill_1$1
XFILLER_87_405 vssd1 vccd1 vccd1 vssd1 sky130_fd_sc_hd__fill_8$1
XFILLER_101_237 vssd1 vccd1 vccd1 vssd1 sky130_ef_sc_hd__decap_40_12$1
XFILLER_87_449 vssd1 vccd1 vccd1 vssd1 sky130_fd_sc_hd__fill_8$1
XFILLER_68_641 vssd1 vccd1 vccd1 vssd1 sky130_fd_sc_hd__fill_2$1
X_1447_ _1447_/C1 _1446_/X _1465_/A2 hold46/X _1750_/D vssd1 vccd1 vccd1 vssd1 sky130_fd_sc_hd__o211a_1$1
XFILLER_4_81 vssd1 vccd1 vccd1 vssd1 sky130_fd_sc_hd__fill_2$1
X_1378_ hold39/X _1378_/X _1398_/B vssd1 vccd1 vccd1 vssd1 sky130_fd_sc_hd__or2_1$1
XFILLER_114_27 vccd1 vssd1 vccd1 vssd1 sky130_fd_sc_hd__fill_1$1
XFILLER_83_633 vccd1 vssd1 vccd1 vssd1 sky130_fd_sc_hd__fill_1$1
XFILLER_68_685 vssd1 vccd1 vccd1 vssd1 sky130_ef_sc_hd__decap_40_12$1
XFILLER_83_655 vssd1 vccd1 vccd1 vssd1 sky130_fd_sc_hd__fill_8$1
XFILLER_82_121 vssd1 vccd1 vccd1 vssd1 sky130_ef_sc_hd__decap_40_12$1
XFILLER_55_335 vccd1 vssd1 vccd1 vssd1 sky130_fd_sc_hd__fill_1$1
XFILLER_130_15 vssd1 vccd1 vccd1 vssd1 sky130_ef_sc_hd__decap_40_12$1
XFILLER_82_165 vssd1 vccd1 vccd1 vssd1 sky130_ef_sc_hd__decap_40_12$1
XFILLER_70_305 vssd1 vccd1 vccd1 vssd1 sky130_fd_sc_hd__fill_2$1
XTAP_TAPCELL_ROW_104_1859 vccd1 vssd1 sky130_fd_sc_hd__tapvpwrvgnd_1$1
XFILLER_51_541 vssd1 vccd1 vccd1 vssd1 sky130_ef_sc_hd__decap_40_12$1
XFILLER_23_221 vssd1 vccd1 vccd1 vssd1 sky130_fd_sc_hd__fill_2$1
XFILLER_36_593 vssd1 vccd1 vccd1 vssd1 sky130_ef_sc_hd__decap_40_12$1
XFILLER_11_405 vssd1 vccd1 vccd1 vssd1 sky130_ef_sc_hd__decap_40_12$1
XTAP_TAPCELL_ROW_137_2358 vccd1 vssd1 sky130_fd_sc_hd__tapvpwrvgnd_1$1
XFILLER_11_449 vssd1 vccd1 vccd1 vssd1 sky130_ef_sc_hd__decap_40_12$1
XFILLER_23_57 vssd1 vccd1 vccd1 vssd1 sky130_ef_sc_hd__decap_40_12$1
XFILLER_137_635 vssd1 vccd1 vccd1 vssd1 sky130_fd_sc_hd__fill_8$1
XFILLER_136_123 vssd1 vccd1 vccd1 vssd1 sky130_ef_sc_hd__decap_40_12$1
XFILLER_109_337 vssd1 vccd1 vccd1 vssd1 sky130_ef_sc_hd__decap_40_12$1
XFILLER_124_307 vccd1 vssd1 vccd1 vssd1 sky130_fd_sc_hd__fill_1$1
XFILLER_99_39 vssd1 vccd1 vccd1 vssd1 sky130_ef_sc_hd__decap_40_12$1
XFILLER_3_615 vccd1 vssd1 vccd1 vssd1 sky130_fd_sc_hd__fill_1$1
XFILLER_133_841 vccd1 vssd1 vccd1 vssd1 sky130_fd_sc_hd__fill_1$1
XFILLER_105_565 vccd1 vssd1 vccd1 vssd1 sky130_fd_sc_hd__fill_1$1
XFILLER_132_395 vssd1 vccd1 vccd1 vssd1 sky130_ef_sc_hd__decap_40_12$1
XFILLER_120_557 vssd1 vccd1 vccd1 vssd1 sky130_ef_sc_hd__decap_40_12$1
XFILLER_19_505 vssd1 vccd1 vccd1 vssd1 sky130_ef_sc_hd__decap_40_12$1
XFILLER_48_65 vssd1 vccd1 vccd1 vssd1 sky130_ef_sc_hd__decap_40_12$1
XFILLER_59_685 vssd1 vccd1 vccd1 vssd1 sky130_fd_sc_hd__fill_2$1
XFILLER_62_806 vssd1 vccd1 vccd1 vssd1 sky130_fd_sc_hd__fill_4$1
XFILLER_58_195 vccd1 vssd1 vccd1 vssd1 sky130_fd_sc_hd__fill_1$1
XFILLER_46_357 vssd1 vccd1 vccd1 vssd1 sky130_fd_sc_hd__fill_4$1
XFILLER_74_699 vccd1 vssd1 vccd1 vssd1 sky130_fd_sc_hd__fill_1$1
XFILLER_73_165 vssd1 vccd1 vccd1 vssd1 sky130_fd_sc_hd__fill_2$1
XFILLER_64_53 vssd1 vccd1 vccd1 vssd1 sky130_ef_sc_hd__decap_40_12$1
XFILLER_61_305 vssd1 vccd1 vccd1 vssd1 sky130_ef_sc_hd__decap_40_12$1
XFILLER_64_97 vssd1 vccd1 vccd1 vssd1 sky130_ef_sc_hd__decap_40_12$1
XFILLER_61_349 vssd1 vccd1 vccd1 vssd1 sky130_ef_sc_hd__decap_40_12$1
XFILLER_14_221 vssd1 vccd1 vccd1 vssd1 sky130_ef_sc_hd__decap_40_12$1
XFILLER_9_15 vssd1 vccd1 vccd1 vssd1 sky130_ef_sc_hd__decap_40_12$1
XFILLER_14_265 vssd1 vccd1 vccd1 vssd1 sky130_ef_sc_hd__decap_40_12$1
XFILLER_42_541 vssd1 vccd1 vccd1 vssd1 sky130_fd_sc_hd__fill_2$1
XFILLER_120_81 vssd1 vccd1 vccd1 vssd1 sky130_fd_sc_hd__fill_2$1
XFILLER_80_41 vssd1 vccd1 vccd1 vssd1 sky130_ef_sc_hd__decap_40_12$1
XFILLER_30_725 vssd1 vccd1 vccd1 vssd1 sky130_ef_sc_hd__decap_40_12$1
XFILLER_128_602 vccd1 vssd1 vccd1 vssd1 sky130_fd_sc_hd__fill_1$1
XFILLER_30_769 vssd1 vccd1 vccd1 vssd1 sky130_ef_sc_hd__decap_40_12$1
XFILLER_128_635 vccd1 vssd1 vccd1 vssd1 sky130_fd_sc_hd__fill_1$1
XFILLER_80_85 vssd1 vccd1 vccd1 vssd1 sky130_ef_sc_hd__decap_40_12$1
XTAP_TAPCELL_ROW_12_477 vccd1 vssd1 sky130_fd_sc_hd__tapvpwrvgnd_1$1
Xclkbuf_leaf_17_wb_clk_i _1762_/CLK clkbuf_2_3__f_wb_clk_i/X vssd1 vccd1 vccd1 vssd1
+ sky130_fd_sc_hd__clkbuf_8$1
XFILLER_127_167 vccd1 vssd1 vccd1 vssd1 sky130_fd_sc_hd__fill_1$1
XFILLER_115_329 vssd1 vccd1 vccd1 vssd1 sky130_fd_sc_hd__fill_4$1
XTAP_TAPCELL_ROW_77_1449 vccd1 vssd1 sky130_fd_sc_hd__tapvpwrvgnd_1$1
XFILLER_6_475 vccd1 vssd1 vccd1 vssd1 sky130_fd_sc_hd__fill_1$1
XFILLER_123_373 vssd1 vccd1 vccd1 vssd1 sky130_ef_sc_hd__decap_40_12$1
XFILLER_111_502 vssd1 vccd1 vccd1 vssd1 sky130_fd_sc_hd__fill_2$1
XFILLER_111_513 vssd1 vccd1 vccd1 vssd1 sky130_ef_sc_hd__decap_40_12$1
XFILLER_97_725 vssd1 vccd1 vccd1 vssd1 sky130_fd_sc_hd__fill_2$1
XTAP_TAPCELL_ROW_90_1649 vccd1 vssd1 sky130_fd_sc_hd__tapvpwrvgnd_1$1
XFILLER_69_405 vssd1 vccd1 vccd1 vssd1 sky130_ef_sc_hd__decap_40_12$1
XFILLER_69_438 vccd1 vssd1 vccd1 vssd1 sky130_fd_sc_hd__fill_1$1
X_1301_ _1305_/C1 _1300_/X _1343_/A2 hold142/X _1679_/D vssd1 vccd1 vccd1 vssd1 sky130_fd_sc_hd__o211a_1$1
XFILLER_2_681 vssd1 vccd1 vccd1 vssd1 sky130_ef_sc_hd__decap_40_12$1
XFILLER_111_557 vssd1 vccd1 vccd1 vssd1 sky130_fd_sc_hd__fill_2$1
X_1232_ _1646_/Q _1232_/X _1276_/B vssd1 vccd1 vccd1 vssd1 sky130_fd_sc_hd__or2_1$1
XFILLER_38_825 vccd1 vssd1 vccd1 vssd1 sky130_fd_sc_hd__fill_1$1
XFILLER_64_121 vssd1 vccd1 vccd1 vssd1 sky130_ef_sc_hd__decap_40_12$1
XFILLER_37_335 vccd1 vssd1 vccd1 vssd1 sky130_fd_sc_hd__fill_1$1
X_1163_ _1289_/C1 _1162_/X _1189_/A2 hold199/X _1612_/D vssd1 vccd1 vccd1 vssd1 sky130_fd_sc_hd__o211a_1$1
XTAP_TAPCELL_ROW_121_2115 vccd1 vssd1 sky130_fd_sc_hd__tapvpwrvgnd_1$1
XFILLER_64_165 vssd1 vccd1 vccd1 vssd1 sky130_ef_sc_hd__decap_40_12$1
XFILLER_52_305 vssd1 vccd1 vccd1 vssd1 sky130_fd_sc_hd__fill_2$1
X_1094_ _1797_/A _1094_/X _1122_/B vssd1 vccd1 vccd1 vssd1 sky130_fd_sc_hd__or2_1$1
XFILLER_80_669 vssd1 vccd1 vccd1 vssd1 sky130_ef_sc_hd__decap_40_12$1
XFILLER_33_541 vssd1 vccd1 vccd1 vssd1 sky130_ef_sc_hd__decap_40_12$1
XFILLER_100_29 vssd1 vccd1 vccd1 vssd1 sky130_ef_sc_hd__decap_40_12$1
XFILLER_21_725 vssd1 vccd1 vccd1 vssd1 sky130_fd_sc_hd__fill_2$1
XFILLER_33_585 vssd1 vccd1 vccd1 vssd1 sky130_ef_sc_hd__decap_40_12$1
XFILLER_119_613 vssd1 vccd1 vccd1 vssd1 sky130_fd_sc_hd__fill_2$1
X_0947_ _1411_/B _0947_/D _0947_/C _0947_/B _1476_/Q vssd1 vccd1 vccd1 vssd1 sky130_fd_sc_hd__and4b_4$1
XTAP_TAPCELL_ROW_31_764 vccd1 vssd1 sky130_fd_sc_hd__tapvpwrvgnd_1$1
XTAP_TAPCELL_ROW_119_2088 vccd1 vssd1 sky130_fd_sc_hd__tapvpwrvgnd_1$1
XFILLER_109_27 vssd1 vccd1 vccd1 vssd1 sky130_ef_sc_hd__decap_40_12$1
XFILLER_134_616 vssd1 vccd1 vccd1 vssd1 sky130_ef_sc_hd__decap_40_12$1
XFILLER_118_189 vssd1 vccd1 vccd1 vssd1 sky130_fd_sc_hd__fill_4$1
XFILLER_106_307 vccd1 vssd1 vccd1 vssd1 sky130_fd_sc_hd__fill_1$1
X_0878_ _1625_/Q _0878_/A2 _0878_/X _1721_/Q _0878_/B1 vccd1 vssd1 vccd1 vssd1 sky130_fd_sc_hd__a22o_1$1
XTAP_TAPCELL_ROW_132_2277 vccd1 vssd1 sky130_fd_sc_hd__tapvpwrvgnd_1$1
XFILLER_133_137 vssd1 vccd1 vccd1 vssd1 sky130_ef_sc_hd__decap_40_12$1
XFILLER_115_841 vccd1 vssd1 vccd1 vssd1 sky130_fd_sc_hd__fill_1$1
XFILLER_130_811 vccd1 vssd1 vccd1 vssd1 sky130_fd_sc_hd__fill_1$1
XFILLER_125_15 vssd1 vccd1 vccd1 vssd1 sky130_ef_sc_hd__decap_40_12$1
XFILLER_88_725 vssd1 vccd1 vccd1 vssd1 sky130_ef_sc_hd__decap_40_12$1
XFILLER_87_279 vccd1 vssd1 vccd1 vssd1 sky130_fd_sc_hd__fill_1$1
XFILLER_83_441 vssd1 vccd1 vccd1 vssd1 sky130_fd_sc_hd__fill_4$1
XFILLER_28_357 vssd1 vccd1 vccd1 vssd1 sky130_fd_sc_hd__fill_4$1
XFILLER_56_699 vccd1 vssd1 vccd1 vssd1 sky130_fd_sc_hd__fill_1$1
XFILLER_55_165 vssd1 vccd1 vccd1 vssd1 sky130_fd_sc_hd__fill_2$1
XTAP_TAPCELL_ROW_39_886 vccd1 vssd1 sky130_fd_sc_hd__tapvpwrvgnd_1$1
XFILLER_43_305 vssd1 vccd1 vccd1 vssd1 sky130_ef_sc_hd__decap_40_12$1
XTAP_TAPCELL_ROW_48_1017 vccd1 vssd1 sky130_fd_sc_hd__tapvpwrvgnd_1$1
XFILLER_43_349 vssd1 vccd1 vccd1 vssd1 sky130_ef_sc_hd__decap_40_12$1
XTAP_TAPCELL_ROW_61_1217 vccd1 vssd1 sky130_fd_sc_hd__tapvpwrvgnd_1$1
XFILLER_12_725 vssd1 vccd1 vccd1 vssd1 sky130_ef_sc_hd__decap_40_12$1
XFILLER_24_585 vssd1 vccd1 vccd1 vssd1 sky130_fd_sc_hd__fill_2$1
XFILLER_51_393 vssd1 vccd1 vccd1 vssd1 sky130_ef_sc_hd__decap_40_12$1
XFILLER_12_769 vssd1 vccd1 vccd1 vssd1 sky130_ef_sc_hd__decap_40_12$1
XFILLER_126_3 vssd1 vccd1 vccd1 vssd1 sky130_ef_sc_hd__decap_40_12$1
Xclkload0 clkload0/A clkload0/Y vssd1 vccd1 vccd1 vssd1 sky130_fd_sc_hd__inv_8$1
XFILLER_11_279 vccd1 vssd1 vccd1 vssd1 sky130_fd_sc_hd__fill_1$1
XFILLER_7_217 vssd1 vccd1 vccd1 vssd1 sky130_fd_sc_hd__fill_4$1
XFILLER_137_465 vssd1 vccd1 vccd1 vssd1 sky130_fd_sc_hd__fill_2$1
XFILLER_109_167 vccd1 vssd1 vccd1 vssd1 sky130_fd_sc_hd__fill_1$1
XFILLER_50_77 vssd1 vccd1 vccd1 vssd1 sky130_fd_sc_hd__fill_4$1
XFILLER_124_137 vssd1 vccd1 vccd1 vssd1 sky130_fd_sc_hd__fill_2$1
XTAP_TAPCELL_ROW_59_1179 vccd1 vssd1 sky130_fd_sc_hd__tapvpwrvgnd_1$1
XFILLER_3_445 vssd1 vccd1 vccd1 vssd1 sky130_fd_sc_hd__fill_2$1
XFILLER_120_321 vssd1 vccd1 vccd1 vssd1 sky130_ef_sc_hd__decap_40_12$1
XFILLER_105_373 vssd1 vccd1 vccd1 vssd1 sky130_fd_sc_hd__fill_2$1
XFILLER_120_365 vssd1 vccd1 vccd1 vssd1 sky130_fd_sc_hd__fill_4$1
XTAP_TAPCELL_ROW_72_1379 vccd1 vssd1 sky130_fd_sc_hd__tapvpwrvgnd_1$1
XFILLER_66_408 vssd1 vccd1 vccd1 vssd1 sky130_ef_sc_hd__decap_40_12$1
Xfanout270 vccd1 vssd1 _1461_/C1 _0739_/D vccd1 vssd1 sky130_fd_sc_hd__buf_2$1
XFILLER_115_81 vssd1 vccd1 vccd1 vssd1 sky130_ef_sc_hd__decap_40_12$1
XFILLER_93_205 vssd1 vccd1 vccd1 vssd1 sky130_ef_sc_hd__decap_40_12$1
XFILLER_59_471 vccd1 vssd1 vccd1 vssd1 sky130_fd_sc_hd__fill_1$1
XFILLER_93_249 vssd1 vccd1 vccd1 vssd1 sky130_ef_sc_hd__decap_40_12$1
XFILLER_59_493 vssd1 vccd1 vccd1 vssd1 sky130_fd_sc_hd__fill_2$1
XFILLER_19_335 vccd1 vssd1 vccd1 vssd1 sky130_fd_sc_hd__fill_1$1
XFILLER_46_121 vssd1 vccd1 vccd1 vssd1 sky130_ef_sc_hd__decap_40_12$1
XFILLER_62_625 vssd1 vccd1 vccd1 vssd1 sky130_ef_sc_hd__decap_40_12$1
XFILLER_34_305 vssd1 vccd1 vccd1 vssd1 sky130_fd_sc_hd__fill_2$1
XFILLER_46_165 vssd1 vccd1 vccd1 vssd1 sky130_ef_sc_hd__decap_40_12$1
XFILLER_61_113 vssd1 vccd1 vccd1 vssd1 sky130_ef_sc_hd__decap_40_12$1
XFILLER_91_51 vssd1 vccd1 vccd1 vssd1 sky130_fd_sc_hd__fill_4$1
XFILLER_62_669 vssd1 vccd1 vccd1 vssd1 sky130_ef_sc_hd__decap_40_12$1
XFILLER_15_541 vssd1 vccd1 vccd1 vssd1 sky130_ef_sc_hd__decap_40_12$1
XTAP_TAPCELL_ROW_17_558 vccd1 vssd1 sky130_fd_sc_hd__tapvpwrvgnd_1$1
XFILLER_15_585 vssd1 vccd1 vccd1 vssd1 sky130_ef_sc_hd__decap_40_12$1
X_1850_ vccd1 vssd1 _1850_/X _1850_/A vccd1 vssd1 sky130_fd_sc_hd__buf_2$1
XFILLER_30_533 vssd1 vccd1 vccd1 vssd1 sky130_ef_sc_hd__decap_40_12$1
XFILLER_128_421 vssd1 vccd1 vccd1 vssd1 sky130_fd_sc_hd__fill_4$1
X_0801_ _0880_/A2 _1484_/D _0798_/X _1431_/C1 _1484_/Q _0800_/X vssd1 vccd1 vccd1
+ vssd1 sky130_fd_sc_hd__o221a_1$1
X_1781_ _1781_/A _1781_/X vssd1 vccd1 vccd1 vssd1 sky130_fd_sc_hd__clkbuf_2$1
XFILLER_115_137 vssd1 vccd1 vccd1 vssd1 sky130_ef_sc_hd__decap_40_12$1
XFILLER_112_811 vccd1 vssd1 vccd1 vssd1 sky130_fd_sc_hd__fill_1$1
XFILLER_41_3 vssd1 vccd1 vccd1 vssd1 sky130_ef_sc_hd__decap_40_12$1
XFILLER_124_693 vssd1 vccd1 vccd1 vssd1 sky130_fd_sc_hd__fill_4$1
XFILLER_123_181 vssd1 vccd1 vccd1 vssd1 sky130_ef_sc_hd__decap_40_12$1
XFILLER_85_717 vssd1 vccd1 vccd1 vssd1 sky130_fd_sc_hd__fill_8$1
XPHY_EDGE_ROW_127_Right_127 vccd1 vssd1 vccd1 vssd1 sky130_fd_sc_hd__decap_3$1
XFILLER_69_279 vccd1 vssd1 vccd1 vssd1 sky130_fd_sc_hd__fill_1$1
XFILLER_84_249 vssd1 vccd1 vccd1 vssd1 sky130_fd_sc_hd__fill_2$1
X_1215_ _1421_/C1 _1214_/X _1273_/A2 hold78/X _1637_/D vssd1 vccd1 vccd1 vssd1 sky130_fd_sc_hd__o211a_1$1
X_1146_ _1146_/X _1411_/B _1147_/A vccd1 vssd1 vccd1 vssd1 sky130_fd_sc_hd__and2_1$1
XFILLER_93_783 vccd1 vssd1 vccd1 vssd1 sky130_fd_sc_hd__fill_1$1
XFILLER_25_305 vssd1 vccd1 vccd1 vssd1 sky130_ef_sc_hd__decap_40_12$1
XFILLER_37_165 vssd1 vccd1 vccd1 vssd1 sky130_fd_sc_hd__fill_2$1
XFILLER_38_699 vccd1 vssd1 vccd1 vssd1 sky130_fd_sc_hd__fill_1$1
XFILLER_80_433 vssd1 vccd1 vccd1 vssd1 sky130_fd_sc_hd__fill_2$1
XFILLER_1_93 vssd1 vccd1 vccd1 vssd1 sky130_ef_sc_hd__decap_40_12$1
XFILLER_25_349 vssd1 vccd1 vccd1 vssd1 sky130_ef_sc_hd__decap_40_12$1
XTAP_TAPCELL_ROW_36_834 vccd1 vssd1 sky130_fd_sc_hd__tapvpwrvgnd_1$1
XTAP_TAPCELL_ROW_36_845 vccd1 vssd1 sky130_fd_sc_hd__tapvpwrvgnd_1$1
X_1077_ _1475_/C1 _1076_/X _1079_/A2 hold64/X _1571_/D vssd1 vccd1 vccd1 vssd1 sky130_fd_sc_hd__o211a_1$1
XFILLER_111_39 vssd1 vccd1 vccd1 vssd1 sky130_ef_sc_hd__decap_40_12$1
XFILLER_80_477 vssd1 vccd1 vccd1 vssd1 sky130_ef_sc_hd__decap_40_12$1
XTAP_TAPCELL_ROW_101_1818 vccd1 vssd1 sky130_fd_sc_hd__tapvpwrvgnd_1$1
XFILLER_33_393 vssd1 vccd1 vccd1 vssd1 sky130_ef_sc_hd__decap_40_12$1
XTAP_TAPCELL_ROW_134_2306 vccd1 vssd1 sky130_fd_sc_hd__tapvpwrvgnd_1$1
XTAP_TAPCELL_ROW_134_2317 vccd1 vssd1 sky130_fd_sc_hd__tapvpwrvgnd_1$1
XFILLER_119_498 vssd1 vccd1 vccd1 vssd1 sky130_fd_sc_hd__fill_4$1
XFILLER_4_209 vssd1 vccd1 vccd1 vssd1 sky130_ef_sc_hd__decap_40_12$1
XFILLER_106_137 vssd1 vccd1 vccd1 vssd1 sky130_fd_sc_hd__fill_2$1
XFILLER_115_671 vccd1 vssd1 vccd1 vssd1 sky130_fd_sc_hd__fill_1$1
XFILLER_102_321 vssd1 vccd1 vccd1 vssd1 sky130_ef_sc_hd__decap_40_12$1
XFILLER_96_29 vssd1 vccd1 vccd1 vssd1 sky130_ef_sc_hd__decap_40_12$1
Xhold23 wbs_adr_i[5] hold23/X vssd1 vccd1 vccd1 vssd1 sky130_fd_sc_hd__dlygate4sd3_1$1
Xhold12 hold12/A hold12/X vssd1 vccd1 vccd1 vssd1 sky130_fd_sc_hd__dlygate4sd3_1$1
XFILLER_88_566 vssd1 vccd1 vccd1 vssd1 sky130_fd_sc_hd__fill_2$1
Xhold45 wbs_dat_i[17] hold45/X vssd1 vccd1 vccd1 vssd1 sky130_fd_sc_hd__dlygate4sd3_1$1
Xhold34 hold34/A hold34/X vssd1 vccd1 vccd1 vssd1 sky130_fd_sc_hd__dlygate4sd3_1$1
XFILLER_102_365 vssd1 vccd1 vccd1 vssd1 sky130_ef_sc_hd__decap_40_12$1
Xhold56 hold56/A hold56/X vssd1 vccd1 vccd1 vssd1 sky130_fd_sc_hd__dlygate4sd3_1$1
XFILLER_76_739 vccd1 vssd1 vccd1 vssd1 sky130_fd_sc_hd__fill_1$1
XFILLER_75_205 vssd1 vccd1 vccd1 vssd1 sky130_ef_sc_hd__decap_40_12$1
XFILLER_48_419 vccd1 vssd1 vccd1 vssd1 sky130_fd_sc_hd__fill_1$1
Xhold89 wbs_dat_i[15] hold89/X vssd1 vccd1 vccd1 vssd1 sky130_fd_sc_hd__dlygate4sd3_1$1
Xhold67 hold67/X vccd1 vssd1 hold67/A vccd1 vssd1 sky130_fd_sc_hd__buf_4$1
Xhold78 hold78/X vccd1 vssd1 hold78/A vccd1 vssd1 sky130_fd_sc_hd__buf_4$1
XFILLER_75_249 vssd1 vccd1 vccd1 vssd1 sky130_ef_sc_hd__decap_40_12$1
XFILLER_28_121 vssd1 vccd1 vccd1 vssd1 sky130_ef_sc_hd__decap_40_12$1
XFILLER_16_305 vssd1 vccd1 vccd1 vssd1 sky130_fd_sc_hd__fill_2$1
XFILLER_28_165 vssd1 vccd1 vccd1 vssd1 sky130_ef_sc_hd__decap_40_12$1
XFILLER_83_293 vssd1 vccd1 vccd1 vssd1 sky130_ef_sc_hd__decap_40_12$1
XFILLER_43_113 vssd1 vccd1 vccd1 vssd1 sky130_ef_sc_hd__decap_40_12$1
XFILLER_44_625 vssd1 vccd1 vccd1 vssd1 sky130_ef_sc_hd__decap_40_12$1
XFILLER_45_55 vccd1 vssd1 vccd1 vssd1 sky130_fd_sc_hd__fill_1$1
XFILLER_71_444 vssd1 vccd1 vccd1 vssd1 sky130_fd_sc_hd__fill_4$1
XFILLER_52_680 vssd1 vccd1 vccd1 vssd1 sky130_ef_sc_hd__decap_40_12$1
XTAP_TAPCELL_ROW_14_506 vccd1 vssd1 sky130_fd_sc_hd__tapvpwrvgnd_1$1
XTAP_TAPCELL_ROW_14_517 vccd1 vssd1 sky130_fd_sc_hd__tapvpwrvgnd_1$1
XFILLER_12_533 vssd1 vccd1 vccd1 vssd1 sky130_ef_sc_hd__decap_40_12$1
XFILLER_138_785 vssd1 vccd1 vccd1 vssd1 sky130_fd_sc_hd__fill_2$1
XFILLER_6_27 vccd1 vssd1 vccd1 vssd1 sky130_fd_sc_hd__fill_1$1
XANTENNA_9 hold73/A vssd1 vccd1 vccd1 vssd1 sky130_fd_sc_hd__diode_2$1
XFILLER_125_457 vssd1 vccd1 vccd1 vssd1 sky130_fd_sc_hd__fill_2$1
XTAP_TAPCELL_ROW_74_1408 vccd1 vssd1 sky130_fd_sc_hd__tapvpwrvgnd_1$1
XFILLER_121_641 vssd1 vccd1 vccd1 vssd1 sky130_fd_sc_hd__fill_4$1
XFILLER_105_181 vssd1 vccd1 vccd1 vssd1 sky130_ef_sc_hd__decap_40_12$1
XFILLER_121_685 vssd1 vccd1 vccd1 vssd1 sky130_ef_sc_hd__decap_40_12$1
XFILLER_120_195 vccd1 vssd1 vccd1 vssd1 sky130_fd_sc_hd__fill_1$1
XFILLER_94_569 vssd1 vccd1 vccd1 vssd1 sky130_ef_sc_hd__decap_40_12$1
XTAP_TAPCELL_ROW_89_1640 vccd1 vssd1 sky130_fd_sc_hd__tapvpwrvgnd_1$1
XFILLER_66_249 vssd1 vccd1 vccd1 vssd1 sky130_fd_sc_hd__fill_2$1
X_1000_ _1000_/A _1000_/X _1012_/B vssd1 vccd1 vccd1 vssd1 sky130_fd_sc_hd__or2_1$1
XFILLER_75_783 vccd1 vssd1 vccd1 vssd1 sky130_fd_sc_hd__fill_1$1
XFILLER_19_165 vssd1 vccd1 vccd1 vssd1 sky130_fd_sc_hd__fill_2$1
XFILLER_62_433 vssd1 vccd1 vccd1 vssd1 sky130_ef_sc_hd__decap_40_12$1
XFILLER_47_485 vssd1 vccd1 vccd1 vssd1 sky130_ef_sc_hd__decap_40_12$1
XFILLER_62_477 vssd1 vccd1 vccd1 vssd1 sky130_ef_sc_hd__decap_40_12$1
XFILLER_15_393 vssd1 vccd1 vccd1 vssd1 sky130_ef_sc_hd__decap_40_12$1
Xclkbuf_leaf_32_wb_clk_i _1608_/CLK clkload1/A vssd1 vccd1 vccd1 vssd1 sky130_fd_sc_hd__clkbuf_8$1
XFILLER_89_3 vssd1 vccd1 vccd1 vssd1 sky130_ef_sc_hd__decap_40_12$1
XFILLER_30_363 vccd1 vssd1 vccd1 vssd1 sky130_fd_sc_hd__fill_1$1
XFILLER_129_741 vssd1 vccd1 vccd1 vssd1 sky130_ef_sc_hd__decap_40_12$1
X_1833_ _1833_/A _1833_/X vssd1 vccd1 vccd1 vssd1 sky130_fd_sc_hd__clkbuf_2$1
XFILLER_129_785 vssd1 vccd1 vccd1 vssd1 sky130_ef_sc_hd__decap_40_12$1
XFILLER_128_251 vccd1 vssd1 vccd1 vssd1 sky130_fd_sc_hd__fill_1$1
X_1764_ hold12/A _1764_/CLK _1764_/D vccd1 vssd1 vccd1 vssd1 sky130_fd_sc_hd__dfxtp_1$1
XTAP_TAPCELL_ROW_116_2047 vccd1 vssd1 sky130_fd_sc_hd__tapvpwrvgnd_1$1
XTAP_TAPCELL_ROW_116_2036 vccd1 vssd1 sky130_fd_sc_hd__tapvpwrvgnd_1$1
X_1695_ _1695_/Q _1726_/CLK _1695_/D vccd1 vssd1 vccd1 vssd1 sky130_fd_sc_hd__dfxtp_1$1
XFILLER_112_641 vssd1 vccd1 vccd1 vssd1 sky130_fd_sc_hd__fill_2$1
XFILLER_57_205 vssd1 vccd1 vccd1 vssd1 sky130_ef_sc_hd__decap_40_12$1
XFILLER_57_249 vssd1 vccd1 vccd1 vssd1 sky130_ef_sc_hd__decap_40_12$1
XTAP_TAPCELL_ROW_127_2198 vccd1 vssd1 sky130_fd_sc_hd__tapvpwrvgnd_1$1
XFILLER_122_27 vccd1 vssd1 vccd1 vssd1 sky130_fd_sc_hd__fill_1$1
XFILLER_65_293 vssd1 vccd1 vccd1 vssd1 sky130_ef_sc_hd__decap_40_12$1
XFILLER_25_113 vssd1 vccd1 vccd1 vssd1 sky130_ef_sc_hd__decap_40_12$1
XFILLER_26_625 vssd1 vccd1 vccd1 vssd1 sky130_ef_sc_hd__decap_40_12$1
X_1129_ _1461_/C1 _1128_/X _1145_/A2 hold14/X _1596_/D vssd1 vccd1 vccd1 vssd1 sky130_fd_sc_hd__o211a_1$1
XFILLER_81_753 vssd1 vccd1 vccd1 vssd1 sky130_ef_sc_hd__decap_40_12$1
XTAP_TAPCELL_ROW_0_278 vccd1 vssd1 sky130_fd_sc_hd__tapvpwrvgnd_1$1
XFILLER_14_809 vssd1 vccd1 vccd1 vssd1 sky130_fd_sc_hd__fill_2$1
XFILLER_81_797 vssd1 vccd1 vccd1 vssd1 sky130_ef_sc_hd__decap_40_12$1
XTAP_TAPCELL_ROW_0_289 vccd1 vssd1 sky130_fd_sc_hd__tapvpwrvgnd_1$1
XFILLER_41_617 vssd1 vccd1 vccd1 vssd1 sky130_ef_sc_hd__decap_40_12$1
XFILLER_41_639 vssd1 vccd1 vccd1 vssd1 sky130_fd_sc_hd__fill_2$1
XFILLER_15_69 vssd1 vccd1 vccd1 vssd1 sky130_ef_sc_hd__decap_40_12$1
XFILLER_34_691 vccd1 vssd1 vccd1 vssd1 sky130_fd_sc_hd__fill_1$1
XFILLER_21_385 vssd1 vccd1 vccd1 vssd1 sky130_fd_sc_hd__fill_4$1
XFILLER_119_273 vssd1 vccd1 vccd1 vssd1 sky130_fd_sc_hd__fill_4$1
XFILLER_5_529 vssd1 vccd1 vccd1 vssd1 sky130_ef_sc_hd__decap_40_12$1
XFILLER_31_57 vssd1 vccd1 vccd1 vssd1 sky130_ef_sc_hd__decap_40_12$1
XFILLER_135_733 vssd1 vccd1 vccd1 vssd1 sky130_fd_sc_hd__fill_2$1
XFILLER_134_221 vssd1 vccd1 vccd1 vssd1 sky130_ef_sc_hd__decap_40_12$1
XFILLER_134_265 vssd1 vccd1 vccd1 vssd1 sky130_ef_sc_hd__decap_40_12$1
XTAP_TAPCELL_ROW_56_1138 vccd1 vssd1 sky130_fd_sc_hd__tapvpwrvgnd_1$1
Xoutput57 _1839_/X analog_ctrl[106] vssd1 vccd1 vccd1 vssd1 sky130_fd_sc_hd__buf_12$1
Xoutput68 _1849_/X analog_ctrl[116] vssd1 vccd1 vccd1 vssd1 sky130_fd_sc_hd__buf_12$1
XFILLER_103_641 vssd1 vccd1 vccd1 vssd1 sky130_ef_sc_hd__decap_40_12$1
XFILLER_0_223 vccd1 vssd1 vccd1 vssd1 sky130_fd_sc_hd__fill_1$1
Xoutput79 _1786_/X analog_ctrl[15] vssd1 vccd1 vccd1 vssd1 sky130_fd_sc_hd__buf_12$1
XFILLER_103_685 vssd1 vccd1 vccd1 vssd1 sky130_ef_sc_hd__decap_40_12$1
XFILLER_88_363 vccd1 vssd1 vccd1 vssd1 sky130_fd_sc_hd__fill_1$1
XFILLER_76_514 vssd1 vccd1 vccd1 vssd1 sky130_ef_sc_hd__decap_40_12$1
XFILLER_102_195 vccd1 vssd1 vccd1 vssd1 sky130_fd_sc_hd__fill_1$1
XFILLER_0_289 vssd1 vccd1 vccd1 vssd1 sky130_fd_sc_hd__fill_2$1
XFILLER_48_249 vssd1 vccd1 vccd1 vssd1 sky130_fd_sc_hd__fill_2$1
XFILLER_91_517 vssd1 vccd1 vccd1 vssd1 sky130_ef_sc_hd__decap_40_12$1
XFILLER_56_65 vssd1 vccd1 vccd1 vssd1 sky130_ef_sc_hd__decap_40_12$1
XFILLER_29_441 vssd1 vccd1 vccd1 vssd1 sky130_fd_sc_hd__fill_4$1
XFILLER_57_783 vccd1 vssd1 vccd1 vssd1 sky130_fd_sc_hd__fill_1$1
XFILLER_29_485 vssd1 vccd1 vccd1 vssd1 sky130_ef_sc_hd__decap_40_12$1
XFILLER_17_669 vssd1 vccd1 vccd1 vssd1 sky130_fd_sc_hd__fill_2$1
XPHY_EDGE_ROW_19_Right_19 vccd1 vssd1 vccd1 vssd1 sky130_fd_sc_hd__decap_3$1
XFILLER_44_433 vssd1 vccd1 vccd1 vssd1 sky130_ef_sc_hd__decap_40_12$1
XFILLER_72_53 vssd1 vccd1 vccd1 vssd1 sky130_ef_sc_hd__decap_40_12$1
XFILLER_31_105 vssd1 vccd1 vccd1 vssd1 sky130_fd_sc_hd__fill_4$1
XFILLER_44_477 vssd1 vccd1 vccd1 vssd1 sky130_ef_sc_hd__decap_40_12$1
XFILLER_31_149 vssd1 vccd1 vccd1 vssd1 sky130_ef_sc_hd__decap_40_12$1
XFILLER_72_97 vssd1 vccd1 vccd1 vssd1 sky130_ef_sc_hd__decap_40_12$1
XFILLER_8_301 vssd1 vccd1 vccd1 vssd1 sky130_fd_sc_hd__fill_4$1
XFILLER_12_363 vccd1 vssd1 vccd1 vssd1 sky130_fd_sc_hd__fill_1$1
XFILLER_8_345 vssd1 vccd1 vccd1 vssd1 sky130_ef_sc_hd__decap_40_12$1
XFILLER_125_221 vssd1 vccd1 vccd1 vssd1 sky130_fd_sc_hd__fill_2$1
XFILLER_8_389 vssd1 vccd1 vccd1 vssd1 sky130_ef_sc_hd__decap_40_12$1
XFILLER_126_777 vssd1 vccd1 vccd1 vssd1 sky130_ef_sc_hd__decap_40_12$1
XFILLER_99_606 vssd1 vccd1 vccd1 vssd1 sky130_fd_sc_hd__fill_8$1
XFILLER_99_617 vssd1 vccd1 vccd1 vssd1 sky130_ef_sc_hd__decap_40_12$1
XPHY_EDGE_ROW_28_Right_28 vccd1 vssd1 vccd1 vssd1 sky130_fd_sc_hd__decap_3$1
XFILLER_137_90 vccd1 vssd1 vccd1 vssd1 sky130_fd_sc_hd__fill_1$1
X_1480_ _1480_/D _1736_/CLK _1480_/Q vssd1 vccd1 vccd1 vssd1 sky130_fd_sc_hd__dfxtp_4$1
XFILLER_113_449 vssd1 vccd1 vccd1 vssd1 sky130_ef_sc_hd__decap_40_12$1
XFILLER_95_812 vssd1 vccd1 vccd1 vssd1 sky130_ef_sc_hd__decap_40_12$1
XFILLER_67_503 vccd1 vssd1 vccd1 vssd1 sky130_fd_sc_hd__fill_1$1
XFILLER_39_205 vssd1 vccd1 vccd1 vssd1 sky130_ef_sc_hd__decap_40_12$1
XFILLER_94_333 vssd1 vccd1 vccd1 vssd1 sky130_ef_sc_hd__decap_40_12$1
XFILLER_39_249 vssd1 vccd1 vccd1 vssd1 sky130_ef_sc_hd__decap_40_12$1
XFILLER_94_377 vssd1 vccd1 vccd1 vssd1 sky130_fd_sc_hd__fill_2$1
XFILLER_55_709 vssd1 vccd1 vccd1 vssd1 sky130_ef_sc_hd__decap_40_12$1
XFILLER_63_720 vssd1 vccd1 vccd1 vssd1 sky130_fd_sc_hd__fill_8$1
XPHY_EDGE_ROW_37_Right_37 vccd1 vssd1 vccd1 vssd1 sky130_fd_sc_hd__decap_3$1
XFILLER_63_753 vssd1 vccd1 vccd1 vssd1 sky130_ef_sc_hd__decap_40_12$1
XFILLER_47_293 vssd1 vccd1 vccd1 vssd1 sky130_ef_sc_hd__decap_40_12$1
XFILLER_23_617 vssd1 vccd1 vccd1 vssd1 sky130_ef_sc_hd__decap_40_12$1
XTAP_TAPCELL_ROW_46_984 vccd1 vssd1 sky130_fd_sc_hd__tapvpwrvgnd_1$1
XTAP_TAPCELL_ROW_46_995 vccd1 vssd1 sky130_fd_sc_hd__tapvpwrvgnd_1$1
X_1816_ _1816_/A _1816_/X vssd1 vccd1 vccd1 vssd1 sky130_fd_sc_hd__clkbuf_2$1
XFILLER_30_193 vssd1 vccd1 vccd1 vssd1 sky130_fd_sc_hd__fill_2$1
XPHY_EDGE_ROW_46_Right_46 vccd1 vssd1 vccd1 vssd1 sky130_fd_sc_hd__decap_3$1
XFILLER_116_221 vssd1 vccd1 vccd1 vssd1 sky130_ef_sc_hd__decap_40_12$1
XFILLER_7_81 vssd1 vccd1 vccd1 vssd1 sky130_ef_sc_hd__decap_40_12$1
XFILLER_117_27 vssd1 vccd1 vccd1 vssd1 sky130_ef_sc_hd__decap_40_12$1
X_1747_ _1855_/A _1747_/CLK _1747_/D vccd1 vssd1 vccd1 vssd1 sky130_fd_sc_hd__dfxtp_1$1
XFILLER_132_725 vssd1 vccd1 vccd1 vssd1 sky130_fd_sc_hd__fill_8$1
XFILLER_116_265 vssd1 vccd1 vccd1 vssd1 sky130_ef_sc_hd__decap_40_12$1
XFILLER_89_105 vssd1 vccd1 vccd1 vssd1 sky130_fd_sc_hd__fill_4$1
X_1678_ _1678_/Q clkload3/A _1678_/D vccd1 vssd1 vccd1 vssd1 sky130_fd_sc_hd__dfxtp_1$1
XFILLER_132_769 vssd1 vccd1 vccd1 vssd1 sky130_fd_sc_hd__fill_8$1
XFILLER_89_149 vssd1 vccd1 vccd1 vssd1 sky130_ef_sc_hd__decap_40_12$1
XFILLER_131_279 vccd1 vssd1 vccd1 vssd1 sky130_fd_sc_hd__fill_1$1
XTAP_TAPCELL_ROW_129_2238 vccd1 vssd1 sky130_fd_sc_hd__tapvpwrvgnd_1$1
XFILLER_98_683 vccd1 vssd1 vccd1 vssd1 sky130_fd_sc_hd__fill_1$1
XFILLER_58_525 vssd1 vccd1 vccd1 vssd1 sky130_fd_sc_hd__fill_4$1
XFILLER_133_15 vssd1 vccd1 vccd1 vssd1 sky130_ef_sc_hd__decap_40_12$1
XFILLER_97_193 vssd1 vccd1 vccd1 vssd1 sky130_ef_sc_hd__decap_40_12$1
XFILLER_85_333 vssd1 vccd1 vccd1 vssd1 sky130_fd_sc_hd__fill_2$1
XTAP_TAPCELL_ROW_51_1068 vccd1 vssd1 sky130_fd_sc_hd__tapvpwrvgnd_1$1
XPHY_EDGE_ROW_55_Right_55 vccd1 vssd1 vccd1 vssd1 sky130_fd_sc_hd__decap_3$1
XFILLER_100_699 vccd1 vssd1 vccd1 vssd1 sky130_fd_sc_hd__fill_1$1
XFILLER_54_753 vssd1 vccd1 vccd1 vssd1 sky130_fd_sc_hd__fill_2$1
XFILLER_26_433 vssd1 vccd1 vccd1 vssd1 sky130_ef_sc_hd__decap_40_12$1
XFILLER_54_797 vssd1 vccd1 vccd1 vssd1 sky130_fd_sc_hd__fill_2$1
XFILLER_13_105 vssd1 vccd1 vccd1 vssd1 sky130_fd_sc_hd__fill_4$1
XFILLER_26_477 vssd1 vccd1 vccd1 vssd1 sky130_ef_sc_hd__decap_40_12$1
XFILLER_13_149 vssd1 vccd1 vccd1 vssd1 sky130_ef_sc_hd__decap_40_12$1
XFILLER_41_447 vccd1 vssd1 vccd1 vssd1 sky130_fd_sc_hd__fill_1$1
XFILLER_9_109 vssd1 vccd1 vccd1 vssd1 sky130_fd_sc_hd__fill_2$1
XTAP_TAPCELL_ROW_24_656 vccd1 vssd1 sky130_fd_sc_hd__tapvpwrvgnd_1$1
XTAP_TAPCELL_ROW_24_667 vccd1 vssd1 sky130_fd_sc_hd__tapvpwrvgnd_1$1
XPHY_EDGE_ROW_64_Right_64 vccd1 vssd1 vccd1 vssd1 sky130_fd_sc_hd__decap_3$1
XFILLER_6_805 vssd1 vccd1 vccd1 vssd1 sky130_fd_sc_hd__fill_4$1
XFILLER_21_193 vssd1 vccd1 vccd1 vssd1 sky130_ef_sc_hd__decap_40_12$1
XFILLER_107_221 vssd1 vccd1 vccd1 vssd1 sky130_fd_sc_hd__fill_2$1
XFILLER_5_337 vssd1 vccd1 vccd1 vssd1 sky130_ef_sc_hd__decap_40_12$1
XFILLER_123_725 vssd1 vccd1 vccd1 vssd1 sky130_fd_sc_hd__fill_2$1
XFILLER_107_93 vssd1 vccd1 vccd1 vssd1 sky130_ef_sc_hd__decap_40_12$1
XFILLER_77_823 vccd1 vssd1 vccd1 vssd1 sky130_fd_sc_hd__fill_1$1
XFILLER_3_39 vssd1 vccd1 vccd1 vssd1 sky130_ef_sc_hd__decap_40_12$1
XFILLER_88_193 vssd1 vccd1 vccd1 vssd1 sky130_fd_sc_hd__fill_2$1
XFILLER_76_333 vssd1 vccd1 vccd1 vssd1 sky130_ef_sc_hd__decap_40_12$1
XPHY_EDGE_ROW_73_Right_73 vccd1 vssd1 vccd1 vssd1 sky130_fd_sc_hd__decap_3$1
XFILLER_49_547 vssd1 vccd1 vccd1 vssd1 sky130_ef_sc_hd__decap_40_12$1
XFILLER_76_377 vssd1 vccd1 vccd1 vssd1 sky130_ef_sc_hd__decap_40_12$1
XTAP_TAPCELL_ROW_69_1329 vccd1 vssd1 sky130_fd_sc_hd__tapvpwrvgnd_1$1
XFILLER_123_81 vssd1 vccd1 vccd1 vssd1 sky130_ef_sc_hd__decap_40_12$1
XFILLER_29_293 vssd1 vccd1 vccd1 vssd1 sky130_ef_sc_hd__decap_40_12$1
XFILLER_45_753 vssd1 vccd1 vccd1 vssd1 sky130_ef_sc_hd__decap_40_12$1
XTAP_TAPCELL_ROW_82_1529 vccd1 vssd1 sky130_fd_sc_hd__tapvpwrvgnd_1$1
XFILLER_45_797 vssd1 vccd1 vccd1 vssd1 sky130_fd_sc_hd__fill_4$1
XFILLER_72_594 vssd1 vccd1 vccd1 vssd1 sky130_ef_sc_hd__decap_40_12$1
XTAP_TAPCELL_ROW_43_943 vccd1 vssd1 sky130_fd_sc_hd__tapvpwrvgnd_1$1
X_0980_ _0980_/A _0980_/X _1012_/B vssd1 vccd1 vccd1 vssd1 sky130_fd_sc_hd__or2_1$1
XPHY_EDGE_ROW_82_Right_82 vccd1 vssd1 vccd1 vssd1 sky130_fd_sc_hd__decap_3$1
XPHY_EDGE_ROW_17_Left_156 vccd1 vssd1 vccd1 vssd1 sky130_fd_sc_hd__decap_3$1
XFILLER_32_469 vssd1 vccd1 vccd1 vssd1 sky130_fd_sc_hd__fill_4$1
XFILLER_12_193 vssd1 vccd1 vccd1 vssd1 sky130_fd_sc_hd__fill_2$1
XFILLER_9_665 vssd1 vccd1 vccd1 vssd1 sky130_fd_sc_hd__fill_4$1
XFILLER_8_153 vssd1 vccd1 vccd1 vssd1 sky130_ef_sc_hd__decap_40_12$1
X_1601_ hold53/A _1763_/CLK _1601_/D vccd1 vssd1 vccd1 vssd1 sky130_fd_sc_hd__dfxtp_1$1
XTAP_TAPCELL_ROW_97_1761 vccd1 vssd1 sky130_fd_sc_hd__tapvpwrvgnd_1$1
XTAP_TAPCELL_ROW_97_1750 vccd1 vssd1 sky130_fd_sc_hd__tapvpwrvgnd_1$1
XFILLER_8_197 vssd1 vccd1 vccd1 vssd1 sky130_ef_sc_hd__decap_40_12$1
X_1532_ hold36/A _1756_/CLK _1532_/D vccd1 vssd1 vccd1 vssd1 sky130_fd_sc_hd__dfxtp_1$1
XFILLER_126_585 vssd1 vccd1 vccd1 vssd1 sky130_fd_sc_hd__fill_2$1
XFILLER_114_725 vssd1 vccd1 vccd1 vssd1 sky130_fd_sc_hd__fill_8$1
X_1463_ _1463_/C1 _1462_/X _1465_/A2 hold81/X _1758_/D vssd1 vccd1 vccd1 vssd1 sky130_fd_sc_hd__o211a_1$1
XFILLER_114_769 vssd1 vccd1 vccd1 vssd1 sky130_ef_sc_hd__decap_40_12$1
XFILLER_113_279 vccd1 vssd1 vccd1 vssd1 sky130_fd_sc_hd__fill_1$1
XPHY_EDGE_ROW_91_Right_91 vccd1 vssd1 vccd1 vssd1 sky130_fd_sc_hd__decap_3$1
XFILLER_68_801 vssd1 vccd1 vccd1 vssd1 sky130_fd_sc_hd__fill_2$1
XPHY_EDGE_ROW_26_Left_165 vccd1 vssd1 vccd1 vssd1 sky130_fd_sc_hd__decap_3$1
X_1394_ _1394_/A _1394_/X _1398_/B vssd1 vccd1 vccd1 vssd1 sky130_fd_sc_hd__or2_1$1
XFILLER_79_193 vssd1 vccd1 vccd1 vssd1 sky130_ef_sc_hd__decap_40_12$1
XFILLER_67_333 vssd1 vccd1 vccd1 vssd1 sky130_fd_sc_hd__fill_2$1
XFILLER_94_141 vssd1 vccd1 vccd1 vssd1 sky130_ef_sc_hd__decap_40_12$1
XFILLER_55_517 vssd1 vccd1 vccd1 vssd1 sky130_fd_sc_hd__fill_4$1
XTAP_TAPCELL_ROW_2_329 vccd1 vssd1 sky130_fd_sc_hd__tapvpwrvgnd_1$1
XFILLER_28_709 vssd1 vccd1 vccd1 vssd1 sky130_fd_sc_hd__fill_2$1
XFILLER_95_697 vssd1 vccd1 vccd1 vssd1 sky130_ef_sc_hd__decap_40_12$1
XTAP_TAPCELL_ROW_124_2157 vccd1 vssd1 sky130_fd_sc_hd__tapvpwrvgnd_1$1
XFILLER_36_742 vssd1 vccd1 vccd1 vssd1 sky130_fd_sc_hd__fill_4$1
XFILLER_63_550 vssd1 vccd1 vccd1 vssd1 sky130_fd_sc_hd__fill_8$1
XFILLER_63_561 vssd1 vccd1 vccd1 vssd1 sky130_ef_sc_hd__decap_40_12$1
XTAP_TAPCELL_ROW_106_1890 vccd1 vssd1 sky130_fd_sc_hd__tapvpwrvgnd_1$1
XFILLER_51_745 vssd1 vccd1 vccd1 vssd1 sky130_ef_sc_hd__decap_40_12$1
XFILLER_50_233 vssd1 vccd1 vccd1 vssd1 sky130_ef_sc_hd__decap_40_12$1
XFILLER_23_447 vccd1 vssd1 vccd1 vssd1 sky130_fd_sc_hd__fill_1$1
XPHY_EDGE_ROW_35_Left_174 vccd1 vssd1 vccd1 vssd1 sky130_fd_sc_hd__decap_3$1
XFILLER_11_609 vssd1 vccd1 vccd1 vssd1 sky130_fd_sc_hd__fill_4$1
XFILLER_50_277 vssd1 vccd1 vccd1 vssd1 sky130_ef_sc_hd__decap_40_12$1
XTAP_TAPCELL_ROW_21_615 vccd1 vssd1 sky130_fd_sc_hd__tapvpwrvgnd_1$1
XFILLER_12_15 vssd1 vccd1 vccd1 vssd1 sky130_ef_sc_hd__decap_40_12$1
XFILLER_128_15 vssd1 vccd1 vccd1 vssd1 sky130_ef_sc_hd__decap_40_12$1
Xhold153 _1570_/Q _1074_/A vssd1 vccd1 vccd1 vssd1 sky130_fd_sc_hd__dlygate4sd3_1$1
Xhold131 _1533_/Q _0998_/A vssd1 vccd1 vccd1 vssd1 sky130_fd_sc_hd__dlygate4sd3_1$1
Xhold120 input30/X hold120/X vssd1 vccd1 vccd1 vssd1 sky130_fd_sc_hd__dlygate4sd3_1$1
Xhold142 input21/X hold142/X vssd1 vccd1 vccd1 vssd1 sky130_fd_sc_hd__dlygate4sd3_1$1
XFILLER_2_307 vccd1 vssd1 vccd1 vssd1 sky130_fd_sc_hd__fill_1$1
XPHY_EDGE_ROW_44_Left_183 vccd1 vssd1 vccd1 vssd1 sky130_fd_sc_hd__decap_3$1
XFILLER_132_533 vssd1 vccd1 vccd1 vssd1 sky130_ef_sc_hd__decap_40_12$1
XFILLER_78_609 vssd1 vccd1 vccd1 vssd1 sky130_ef_sc_hd__decap_40_12$1
Xhold164 _1554_/Q _1042_/A vssd1 vccd1 vccd1 vssd1 sky130_fd_sc_hd__dlygate4sd3_1$1
Xhold175 _1526_/Q _0984_/A vssd1 vccd1 vccd1 vssd1 sky130_fd_sc_hd__dlygate4sd3_1$1
Xhold186 _1517_/Q _0966_/A vssd1 vccd1 vccd1 vssd1 sky130_fd_sc_hd__dlygate4sd3_1$1
Xhold197 input48/X hold197/X vssd1 vccd1 vccd1 vssd1 sky130_fd_sc_hd__dlygate4sd3_1$1
XFILLER_58_333 vssd1 vccd1 vccd1 vssd1 sky130_ef_sc_hd__decap_40_12$1
XFILLER_19_709 vssd1 vccd1 vccd1 vssd1 sky130_ef_sc_hd__decap_40_12$1
XFILLER_86_686 vssd1 vccd1 vccd1 vssd1 sky130_ef_sc_hd__decap_40_12$1
XFILLER_58_377 vssd1 vccd1 vccd1 vssd1 sky130_fd_sc_hd__fill_4$1
XTAP_TAPCELL_ROW_29_737 vccd1 vssd1 sky130_fd_sc_hd__tapvpwrvgnd_1$1
XFILLER_73_369 vssd1 vccd1 vccd1 vssd1 sky130_fd_sc_hd__fill_2$1
XFILLER_39_591 vccd1 vssd1 vccd1 vssd1 sky130_fd_sc_hd__fill_1$1
XFILLER_54_561 vssd1 vccd1 vccd1 vssd1 sky130_fd_sc_hd__fill_8$1
XPHY_EDGE_ROW_53_Left_192 vccd1 vssd1 vccd1 vssd1 sky130_fd_sc_hd__decap_3$1
XFILLER_27_797 vssd1 vccd1 vccd1 vssd1 sky130_ef_sc_hd__decap_40_12$1
XFILLER_42_701 vssd1 vccd1 vccd1 vssd1 sky130_ef_sc_hd__decap_40_12$1
XFILLER_54_594 vssd1 vccd1 vccd1 vssd1 sky130_ef_sc_hd__decap_40_12$1
XTAP_TAPCELL_ROW_64_1259 vccd1 vssd1 sky130_fd_sc_hd__tapvpwrvgnd_1$1
XFILLER_53_55 vccd1 vssd1 vccd1 vssd1 sky130_fd_sc_hd__fill_1$1
XFILLER_14_469 vssd1 vccd1 vccd1 vssd1 sky130_fd_sc_hd__fill_4$1
XTAP_TAPCELL_ROW_40_902 vccd1 vssd1 sky130_fd_sc_hd__tapvpwrvgnd_1$1
XFILLER_41_277 vssd1 vccd1 vccd1 vssd1 sky130_fd_sc_hd__fill_2$1
XFILLER_127_305 vssd1 vccd1 vccd1 vssd1 sky130_ef_sc_hd__decap_40_12$1
XFILLER_127_349 vssd1 vccd1 vccd1 vssd1 sky130_ef_sc_hd__decap_40_12$1
XFILLER_6_613 vssd1 vccd1 vccd1 vssd1 sky130_ef_sc_hd__decap_40_12$1
XTAP_TAPCELL_ROW_79_1480 vccd1 vssd1 sky130_fd_sc_hd__tapvpwrvgnd_1$1
XFILLER_10_697 vssd1 vccd1 vccd1 vssd1 sky130_fd_sc_hd__fill_2$1
XFILLER_6_657 vssd1 vccd1 vccd1 vssd1 sky130_ef_sc_hd__decap_40_12$1
XFILLER_123_511 vccd1 vssd1 vccd1 vssd1 sky130_fd_sc_hd__fill_1$1
XTAP_TAPCELL_ROW_79_1491 vccd1 vssd1 sky130_fd_sc_hd__tapvpwrvgnd_1$1
XFILLER_5_167 vccd1 vssd1 vccd1 vssd1 sky130_fd_sc_hd__fill_1$1
XFILLER_135_382 vccd1 vssd1 vccd1 vssd1 sky130_fd_sc_hd__fill_1$1
XFILLER_123_544 vssd1 vccd1 vccd1 vssd1 sky130_fd_sc_hd__fill_8$1
XFILLER_118_81 vssd1 vccd1 vccd1 vssd1 sky130_fd_sc_hd__fill_2$1
XFILLER_78_41 vssd1 vccd1 vccd1 vssd1 sky130_ef_sc_hd__decap_40_12$1
XFILLER_69_609 vssd1 vccd1 vccd1 vssd1 sky130_fd_sc_hd__fill_4$1
XTAP_TAPCELL_ROW_9_440 vccd1 vssd1 sky130_fd_sc_hd__tapvpwrvgnd_1$1
XFILLER_2_841 vccd1 vssd1 vccd1 vssd1 sky130_fd_sc_hd__fill_1$1
XFILLER_96_417 vssd1 vccd1 vccd1 vssd1 sky130_fd_sc_hd__fill_2$1
XTAP_TAPCELL_ROW_92_1680 vccd1 vssd1 sky130_fd_sc_hd__tapvpwrvgnd_1$1
XFILLER_78_85 vssd1 vccd1 vccd1 vssd1 sky130_ef_sc_hd__decap_40_12$1
XFILLER_1_373 vssd1 vccd1 vccd1 vssd1 sky130_ef_sc_hd__decap_40_12$1
XFILLER_49_333 vssd1 vccd1 vccd1 vssd1 sky130_fd_sc_hd__fill_2$1
XFILLER_110_249 vssd1 vccd1 vccd1 vssd1 sky130_fd_sc_hd__fill_2$1
XFILLER_92_601 vssd1 vccd1 vccd1 vssd1 sky130_ef_sc_hd__decap_40_12$1
XFILLER_77_653 vssd1 vccd1 vccd1 vssd1 sky130_ef_sc_hd__decap_40_12$1
XFILLER_76_141 vssd1 vccd1 vccd1 vssd1 sky130_ef_sc_hd__decap_40_12$1
XFILLER_92_634 vccd1 vssd1 vccd1 vssd1 sky130_fd_sc_hd__fill_1$1
XFILLER_91_111 vccd1 vssd1 vccd1 vssd1 sky130_fd_sc_hd__fill_1$1
XFILLER_77_697 vssd1 vccd1 vccd1 vssd1 sky130_ef_sc_hd__decap_40_12$1
XFILLER_37_517 vssd1 vccd1 vccd1 vssd1 sky130_ef_sc_hd__decap_40_12$1
XFILLER_92_645 vssd1 vccd1 vccd1 vssd1 sky130_ef_sc_hd__decap_40_12$1
XFILLER_18_753 vssd1 vccd1 vccd1 vssd1 sky130_fd_sc_hd__fill_2$1
XFILLER_45_561 vssd1 vccd1 vccd1 vssd1 sky130_ef_sc_hd__decap_40_12$1
XFILLER_32_233 vssd1 vccd1 vccd1 vssd1 sky130_ef_sc_hd__decap_40_12$1
XFILLER_33_778 vssd1 vccd1 vccd1 vssd1 sky130_fd_sc_hd__fill_4$1
XFILLER_60_586 vssd1 vccd1 vccd1 vssd1 sky130_fd_sc_hd__fill_2$1
XFILLER_20_417 vssd1 vccd1 vccd1 vssd1 sky130_fd_sc_hd__fill_2$1
XFILLER_32_277 vssd1 vccd1 vccd1 vssd1 sky130_ef_sc_hd__decap_40_12$1
XFILLER_118_305 vssd1 vccd1 vccd1 vssd1 sky130_fd_sc_hd__fill_2$1
X_0963_ _1091_/C1 _0962_/X _0991_/A2 hold197/X _1515_/D vssd1 vccd1 vccd1 vssd1 sky130_fd_sc_hd__o211a_1$1
X_0894_ _0894_/X _1015_/A hold27/A hold40/A hold10/A vssd1 vccd1 _0893_/X vccd1 vssd1
+ sky130_fd_sc_hd__a221o_1$1
XFILLER_71_3 vssd1 vccd1 vccd1 vssd1 sky130_ef_sc_hd__decap_40_12$1
XFILLER_9_473 vssd1 vccd1 vccd1 vssd1 sky130_ef_sc_hd__decap_40_12$1
XFILLER_114_533 vssd1 vccd1 vccd1 vssd1 sky130_ef_sc_hd__decap_40_12$1
X_1515_ _1785_/A _1579_/CLK _1515_/D vccd1 vssd1 vccd1 vssd1 sky130_fd_sc_hd__dfxtp_1$1
XFILLER_114_577 vssd1 vccd1 vccd1 vssd1 sky130_fd_sc_hd__fill_8$1
XFILLER_101_205 vssd1 vccd1 vccd1 vssd1 sky130_ef_sc_hd__decap_40_12$1
XFILLER_99_277 vssd1 vccd1 vccd1 vssd1 sky130_fd_sc_hd__fill_2$1
X_1446_ _1446_/A _1446_/X _1464_/B vssd1 vccd1 vccd1 vssd1 sky130_fd_sc_hd__or2_1$1
XFILLER_101_249 vssd1 vccd1 vccd1 vssd1 sky130_ef_sc_hd__decap_40_12$1
X_1377_ _1449_/C1 _1376_/X _1399_/A2 hold90/X _1716_/D vssd1 vccd1 vccd1 vssd1 sky130_fd_sc_hd__o211a_1$1
XFILLER_110_794 vccd1 vssd1 vccd1 vssd1 sky130_fd_sc_hd__fill_1$1
XFILLER_68_697 vssd1 vccd1 vccd1 vssd1 sky130_fd_sc_hd__fill_2$1
XFILLER_82_133 vssd1 vccd1 vccd1 vssd1 sky130_fd_sc_hd__fill_4$1
XFILLER_130_27 vccd1 vssd1 vccd1 vssd1 sky130_fd_sc_hd__fill_1$1
XFILLER_83_689 vssd1 vccd1 vccd1 vssd1 sky130_ef_sc_hd__decap_40_12$1
XFILLER_82_177 vssd1 vccd1 vccd1 vssd1 sky130_ef_sc_hd__decap_40_12$1
XFILLER_24_701 vssd1 vccd1 vccd1 vssd1 sky130_ef_sc_hd__decap_40_12$1
XFILLER_24_723 vssd1 vccd1 vccd1 vssd1 sky130_ef_sc_hd__decap_40_12$1
XFILLER_51_553 vssd1 vccd1 vccd1 vssd1 sky130_fd_sc_hd__fill_4$1
XFILLER_11_417 vssd1 vccd1 vccd1 vssd1 sky130_ef_sc_hd__decap_40_12$1
XFILLER_23_277 vssd1 vccd1 vccd1 vssd1 sky130_fd_sc_hd__fill_2$1
XTAP_TAPCELL_ROW_137_2359 vccd1 vssd1 sky130_fd_sc_hd__tapvpwrvgnd_1$1
XTAP_TAPCELL_ROW_137_2348 vccd1 vssd1 sky130_fd_sc_hd__tapvpwrvgnd_1$1
XFILLER_109_305 vssd1 vccd1 vccd1 vssd1 sky130_ef_sc_hd__decap_40_12$1
XFILLER_23_69 vssd1 vccd1 vccd1 vssd1 sky130_ef_sc_hd__decap_40_12$1
XFILLER_136_135 vssd1 vccd1 vccd1 vssd1 sky130_fd_sc_hd__fill_4$1
XFILLER_109_349 vssd1 vccd1 vccd1 vssd1 sky130_ef_sc_hd__decap_40_12$1
XFILLER_2_137 vssd1 vccd1 vccd1 vssd1 sky130_fd_sc_hd__fill_2$1
XFILLER_132_363 vccd1 vssd1 vccd1 vssd1 sky130_fd_sc_hd__fill_1$1
XFILLER_132_341 vssd1 vccd1 vccd1 vssd1 sky130_ef_sc_hd__decap_40_12$1
XFILLER_105_588 vssd1 vccd1 vccd1 vssd1 sky130_ef_sc_hd__decap_40_12$1
XFILLER_78_417 vssd1 vccd1 vccd1 vssd1 sky130_fd_sc_hd__fill_2$1
XFILLER_120_569 vssd1 vccd1 vccd1 vssd1 sky130_ef_sc_hd__decap_40_12$1
XFILLER_58_141 vssd1 vccd1 vccd1 vssd1 sky130_ef_sc_hd__decap_40_12$1
XFILLER_101_783 vccd1 vssd1 vccd1 vssd1 sky130_fd_sc_hd__fill_1$1
XFILLER_59_697 vssd1 vccd1 vccd1 vssd1 sky130_fd_sc_hd__fill_8$1
XFILLER_19_517 vssd1 vccd1 vccd1 vssd1 sky130_ef_sc_hd__decap_40_12$1
XFILLER_48_77 vssd1 vccd1 vccd1 vssd1 sky130_fd_sc_hd__fill_4$1
XFILLER_74_645 vssd1 vccd1 vccd1 vssd1 sky130_ef_sc_hd__decap_40_12$1
XFILLER_73_111 vccd1 vssd1 vccd1 vssd1 sky130_fd_sc_hd__fill_1$1
XPHY_EDGE_ROW_61_Left_200 vccd1 vssd1 vccd1 vssd1 sky130_fd_sc_hd__decap_3$1
XFILLER_104_83 vccd1 vssd1 vccd1 vssd1 sky130_fd_sc_hd__fill_1$1
XFILLER_61_317 vssd1 vccd1 vccd1 vssd1 sky130_ef_sc_hd__decap_40_12$1
XFILLER_27_561 vssd1 vccd1 vccd1 vssd1 sky130_ef_sc_hd__decap_40_12$1
XFILLER_64_65 vssd1 vccd1 vccd1 vssd1 sky130_ef_sc_hd__decap_40_12$1
XFILLER_42_531 vccd1 vssd1 vccd1 vssd1 sky130_fd_sc_hd__fill_1$1
XFILLER_9_27 vssd1 vccd1 vccd1 vssd1 sky130_ef_sc_hd__decap_40_12$1
XFILLER_14_233 vssd1 vccd1 vccd1 vssd1 sky130_ef_sc_hd__decap_40_12$1
XFILLER_15_767 vccd1 vssd1 vccd1 vssd1 sky130_fd_sc_hd__fill_1$1
XFILLER_14_277 vssd1 vccd1 vccd1 vssd1 sky130_ef_sc_hd__decap_40_12$1
XFILLER_30_737 vssd1 vccd1 vccd1 vssd1 sky130_ef_sc_hd__decap_40_12$1
XFILLER_42_586 vssd1 vccd1 vccd1 vssd1 sky130_fd_sc_hd__fill_2$1
XFILLER_80_53 vssd1 vccd1 vccd1 vssd1 sky130_ef_sc_hd__decap_40_12$1
XFILLER_127_113 vssd1 vccd1 vccd1 vssd1 sky130_ef_sc_hd__decap_40_12$1
XFILLER_80_97 vssd1 vccd1 vccd1 vssd1 sky130_ef_sc_hd__decap_40_12$1
XTAP_TAPCELL_ROW_12_478 vccd1 vssd1 sky130_fd_sc_hd__tapvpwrvgnd_1$1
XFILLER_6_421 vssd1 vccd1 vccd1 vssd1 sky130_ef_sc_hd__decap_40_12$1
XPHY_EDGE_ROW_108_Right_108 vccd1 vssd1 vccd1 vssd1 sky130_fd_sc_hd__decap_3$1
XFILLER_89_51 vssd1 vccd1 vccd1 vssd1 sky130_fd_sc_hd__fill_4$1
XFILLER_136_691 vssd1 vccd1 vccd1 vssd1 sky130_fd_sc_hd__fill_8$1
XFILLER_97_715 vccd1 vssd1 vccd1 vssd1 sky130_fd_sc_hd__fill_1$1
XFILLER_69_417 vssd1 vccd1 vccd1 vssd1 sky130_fd_sc_hd__fill_4$1
XFILLER_111_525 vssd1 vccd1 vccd1 vssd1 sky130_ef_sc_hd__decap_40_12$1
X_1300_ _1300_/A _1300_/X _1342_/B vssd1 vccd1 vccd1 vssd1 sky130_fd_sc_hd__or2_1$1
XFILLER_2_693 vssd1 vccd1 vccd1 vssd1 sky130_fd_sc_hd__fill_4$1
X_1231_ _1447_/C1 _1230_/X _1277_/A2 hold183/X _1645_/D vssd1 vccd1 vccd1 vssd1 sky130_fd_sc_hd__o211a_1$1
XFILLER_1_181 vssd1 vccd1 vccd1 vssd1 sky130_ef_sc_hd__decap_40_12$1
XFILLER_65_667 vssd1 vccd1 vccd1 vssd1 sky130_fd_sc_hd__fill_4$1
XFILLER_65_645 vccd1 vssd1 vccd1 vssd1 sky130_fd_sc_hd__fill_1$1
XFILLER_64_133 vssd1 vccd1 vccd1 vssd1 sky130_fd_sc_hd__fill_4$1
X_1162_ _1816_/A _1162_/X _1188_/B vssd1 vccd1 vccd1 vssd1 sky130_fd_sc_hd__or2_1$1
XTAP_TAPCELL_ROW_121_2116 vccd1 vssd1 sky130_fd_sc_hd__tapvpwrvgnd_1$1
XFILLER_92_475 vccd1 vssd1 vccd1 vssd1 sky130_fd_sc_hd__fill_1$1
XFILLER_64_177 vssd1 vccd1 vccd1 vssd1 sky130_ef_sc_hd__decap_40_12$1
X_1093_ _1289_/C1 _1092_/X _1123_/A2 hold30/X _1578_/D vssd1 vccd1 vccd1 vssd1 sky130_fd_sc_hd__o211a_1$1
XFILLER_33_553 vssd1 vccd1 vccd1 vssd1 sky130_fd_sc_hd__fill_4$1
XFILLER_45_391 vccd1 vssd1 vccd1 vssd1 sky130_fd_sc_hd__fill_1$1
XFILLER_60_361 vssd1 vccd1 vccd1 vssd1 sky130_fd_sc_hd__fill_2$1
XFILLER_33_597 vssd1 vccd1 vccd1 vssd1 sky130_ef_sc_hd__decap_40_12$1
X_0946_ _0752_/A _1508_/D _0942_/X _1409_/C1 _1508_/Q _0945_/X vssd1 vccd1 vccd1 vssd1
+ sky130_fd_sc_hd__o221a_1$1
XTAP_TAPCELL_ROW_119_2078 vccd1 vssd1 sky130_fd_sc_hd__tapvpwrvgnd_1$1
XTAP_TAPCELL_ROW_31_765 vccd1 vssd1 sky130_fd_sc_hd__tapvpwrvgnd_1$1
XTAP_TAPCELL_ROW_119_2089 vccd1 vssd1 sky130_fd_sc_hd__tapvpwrvgnd_1$1
XFILLER_119_669 vssd1 vccd1 vccd1 vssd1 sky130_fd_sc_hd__fill_2$1
XFILLER_107_809 vssd1 vccd1 vccd1 vssd1 sky130_ef_sc_hd__decap_40_12$1
XFILLER_9_281 vssd1 vccd1 vccd1 vssd1 sky130_ef_sc_hd__decap_40_12$1
XFILLER_134_628 vssd1 vccd1 vccd1 vssd1 sky130_fd_sc_hd__fill_2$1
XFILLER_133_105 vssd1 vccd1 vccd1 vssd1 sky130_fd_sc_hd__fill_4$1
XFILLER_109_39 vssd1 vccd1 vccd1 vssd1 sky130_ef_sc_hd__decap_40_12$1
Xclkload40 clkload40/Y _1747_/CLK vccd1 vssd1 vccd1 vssd1 sky130_fd_sc_hd__clkinv_2$1
X_0877_ _1015_/A _1561_/Q _0876_/X _0877_/X vccd1 vssd1 vccd1 vssd1 sky130_fd_sc_hd__a21o_1$1
XTAP_TAPCELL_ROW_132_2278 vccd1 vssd1 sky130_fd_sc_hd__tapvpwrvgnd_1$1
XFILLER_133_149 vssd1 vccd1 vccd1 vssd1 sky130_ef_sc_hd__decap_40_12$1
XFILLER_114_363 vccd1 vssd1 vccd1 vssd1 sky130_fd_sc_hd__fill_1$1
XFILLER_125_27 vssd1 vccd1 vccd1 vssd1 sky130_ef_sc_hd__decap_40_12$1
XFILLER_88_737 vssd1 vccd1 vccd1 vssd1 sky130_ef_sc_hd__decap_40_12$1
XFILLER_87_225 vssd1 vccd1 vccd1 vssd1 sky130_ef_sc_hd__decap_40_12$1
X_1429_ _1447_/C1 _1428_/X _1465_/A2 hold183/X _1741_/D vssd1 vccd1 vccd1 vssd1 sky130_fd_sc_hd__o211a_1$1
XFILLER_56_645 vssd1 vccd1 vccd1 vssd1 sky130_ef_sc_hd__decap_40_12$1
XFILLER_55_111 vccd1 vssd1 vccd1 vssd1 sky130_fd_sc_hd__fill_1$1
XFILLER_71_604 vssd1 vccd1 vccd1 vssd1 sky130_ef_sc_hd__decap_40_12$1
XTAP_TAPCELL_ROW_39_887 vccd1 vssd1 sky130_fd_sc_hd__tapvpwrvgnd_1$1
XFILLER_43_317 vssd1 vccd1 vccd1 vssd1 sky130_ef_sc_hd__decap_40_12$1
XTAP_TAPCELL_ROW_48_1018 vccd1 vssd1 sky130_fd_sc_hd__tapvpwrvgnd_1$1
XFILLER_24_531 vccd1 vssd1 vccd1 vssd1 sky130_fd_sc_hd__fill_1$1
XTAP_TAPCELL_ROW_61_1218 vccd1 vssd1 sky130_fd_sc_hd__tapvpwrvgnd_1$1
XFILLER_51_361 vssd1 vccd1 vccd1 vssd1 sky130_ef_sc_hd__decap_40_12$1
XFILLER_12_737 vssd1 vccd1 vccd1 vssd1 sky130_ef_sc_hd__decap_40_12$1
XFILLER_11_225 vssd1 vccd1 vccd1 vssd1 sky130_ef_sc_hd__decap_40_12$1
XFILLER_109_113 vssd1 vccd1 vccd1 vssd1 sky130_ef_sc_hd__decap_40_12$1
Xclkload1 clkload1/A clkload1/Y vccd1 vssd1 vccd1 vssd1 sky130_fd_sc_hd__clkinvlp_4$1
XFILLER_137_433 vssd1 vccd1 vccd1 vssd1 sky130_ef_sc_hd__decap_40_12$1
XFILLER_20_781 vssd1 vccd1 vccd1 vssd1 sky130_fd_sc_hd__fill_4$1
XFILLER_125_617 vssd1 vccd1 vccd1 vssd1 sky130_ef_sc_hd__decap_40_12$1
XFILLER_119_3 vssd1 vccd1 vccd1 vssd1 sky130_ef_sc_hd__decap_40_12$1
XFILLER_1_3 vssd1 vccd1 vccd1 vssd1 sky130_ef_sc_hd__decap_40_12$1
XFILLER_79_759 vssd1 vccd1 vccd1 vssd1 sky130_ef_sc_hd__decap_40_12$1
XFILLER_79_737 vssd1 vccd1 vccd1 vssd1 sky130_fd_sc_hd__fill_2$1
XFILLER_132_193 vssd1 vccd1 vccd1 vssd1 sky130_fd_sc_hd__fill_2$1
XFILLER_120_333 vssd1 vccd1 vccd1 vssd1 sky130_ef_sc_hd__decap_40_12$1
Xfanout271 _0739_/D vccd1 vssd1 _1319_/C1 vccd1 vssd1 sky130_fd_sc_hd__buf_4$1
XFILLER_93_217 vssd1 vccd1 vccd1 vssd1 sky130_fd_sc_hd__fill_4$1
Xfanout260 _1387_/C1 vccd1 vssd1 _1319_/C1 vccd1 vssd1 sky130_fd_sc_hd__buf_4$1
XFILLER_115_93 vssd1 vccd1 vccd1 vssd1 sky130_ef_sc_hd__decap_40_12$1
XFILLER_46_133 vssd1 vccd1 vccd1 vssd1 sky130_fd_sc_hd__fill_4$1
XFILLER_74_475 vccd1 vssd1 vccd1 vssd1 sky130_fd_sc_hd__fill_1$1
XFILLER_62_637 vssd1 vccd1 vccd1 vssd1 sky130_fd_sc_hd__fill_4$1
XFILLER_61_125 vssd1 vccd1 vccd1 vssd1 sky130_ef_sc_hd__decap_40_12$1
XFILLER_46_177 vssd1 vccd1 vccd1 vssd1 sky130_ef_sc_hd__decap_40_12$1
XFILLER_131_81 vssd1 vccd1 vccd1 vssd1 sky130_ef_sc_hd__decap_40_12$1
XFILLER_61_169 vssd1 vccd1 vccd1 vssd1 sky130_ef_sc_hd__decap_40_12$1
XFILLER_15_553 vssd1 vccd1 vccd1 vssd1 sky130_fd_sc_hd__fill_4$1
XTAP_TAPCELL_ROW_17_548 vccd1 vssd1 sky130_fd_sc_hd__tapvpwrvgnd_1$1
XTAP_TAPCELL_ROW_17_559 vccd1 vssd1 sky130_fd_sc_hd__tapvpwrvgnd_1$1
XFILLER_27_391 vccd1 vssd1 vccd1 vssd1 sky130_fd_sc_hd__fill_1$1
XFILLER_70_681 vccd1 vssd1 vccd1 vssd1 sky130_fd_sc_hd__fill_1$1
XFILLER_15_597 vssd1 vccd1 vccd1 vssd1 sky130_ef_sc_hd__decap_40_12$1
XFILLER_30_501 vssd1 vccd1 vccd1 vssd1 sky130_ef_sc_hd__decap_40_12$1
XFILLER_42_361 vssd1 vccd1 vccd1 vssd1 sky130_fd_sc_hd__fill_2$1
XFILLER_30_545 vssd1 vccd1 vccd1 vssd1 sky130_ef_sc_hd__decap_40_12$1
XFILLER_128_411 vssd1 vccd1 vccd1 vssd1 sky130_fd_sc_hd__fill_8$1
X_0800_ _0879_/B1 _0800_/X _0799_/X _1848_/A _0881_/B1 _0796_/X vssd1 vccd1 vccd1
+ vssd1 sky130_fd_sc_hd__a2111o_1$1
X_1780_ vccd1 vssd1 _1780_/X _1780_/A vccd1 vssd1 sky130_fd_sc_hd__buf_1$1
XFILLER_30_589 vssd1 vccd1 vccd1 vssd1 sky130_ef_sc_hd__decap_40_12$1
XFILLER_11_781 vssd1 vccd1 vccd1 vssd1 sky130_fd_sc_hd__fill_2$1
XFILLER_7_741 vssd1 vccd1 vccd1 vssd1 sky130_ef_sc_hd__decap_40_12$1
XFILLER_128_477 vssd1 vccd1 vccd1 vssd1 sky130_ef_sc_hd__decap_40_12$1
XFILLER_115_105 vssd1 vccd1 vccd1 vssd1 sky130_fd_sc_hd__fill_4$1
XFILLER_7_785 vssd1 vccd1 vccd1 vssd1 sky130_ef_sc_hd__decap_40_12$1
XFILLER_6_251 vccd1 vssd1 vccd1 vssd1 sky130_fd_sc_hd__fill_1$1
XFILLER_115_149 vssd1 vccd1 vccd1 vssd1 sky130_ef_sc_hd__decap_40_12$1
XFILLER_131_609 vssd1 vccd1 vccd1 vssd1 sky130_fd_sc_hd__fill_4$1
XFILLER_97_501 vssd1 vccd1 vccd1 vssd1 sky130_fd_sc_hd__fill_2$1
XFILLER_69_225 vssd1 vccd1 vccd1 vssd1 sky130_ef_sc_hd__decap_40_12$1
XFILLER_34_3 vssd1 vccd1 vccd1 vssd1 sky130_ef_sc_hd__decap_40_12$1
XFILLER_123_193 vssd1 vccd1 vccd1 vssd1 sky130_ef_sc_hd__decap_40_12$1
XFILLER_111_333 vssd1 vccd1 vccd1 vssd1 sky130_fd_sc_hd__fill_2$1
XFILLER_85_729 vccd1 vssd1 vccd1 vssd1 sky130_fd_sc_hd__fill_1$1
XFILLER_78_781 vssd1 vccd1 vccd1 vssd1 sky130_ef_sc_hd__decap_40_12$1
XFILLER_38_601 vssd1 vccd1 vccd1 vssd1 sky130_ef_sc_hd__decap_40_12$1
X_1214_ _1637_/Q _1214_/X _1270_/B vssd1 vccd1 vccd1 vssd1 sky130_fd_sc_hd__or2_1$1
XFILLER_37_111 vccd1 vssd1 vccd1 vssd1 sky130_fd_sc_hd__fill_1$1
XFILLER_38_645 vssd1 vccd1 vccd1 vssd1 sky130_ef_sc_hd__decap_40_12$1
X_1145_ _1475_/C1 _1144_/X _1145_/A2 hold2/X hold11/A vssd1 vccd1 vccd1 vssd1 sky130_fd_sc_hd__o211a_1$1
XFILLER_53_604 vssd1 vccd1 vccd1 vssd1 sky130_ef_sc_hd__decap_40_12$1
XFILLER_25_317 vssd1 vccd1 vccd1 vssd1 sky130_ef_sc_hd__decap_40_12$1
XTAP_TAPCELL_ROW_36_835 vccd1 vssd1 sky130_fd_sc_hd__tapvpwrvgnd_1$1
X_1076_ hold68/X _1076_/X _1078_/B vssd1 vccd1 vccd1 vssd1 sky130_fd_sc_hd__or2_1$1
XPHY_EDGE_ROW_9_Left_148 vccd1 vssd1 vccd1 vssd1 sky130_fd_sc_hd__decap_3$1
XTAP_TAPCELL_ROW_36_846 vccd1 vssd1 sky130_fd_sc_hd__tapvpwrvgnd_1$1
XTAP_TAPCELL_ROW_101_1819 vccd1 vssd1 sky130_fd_sc_hd__tapvpwrvgnd_1$1
XTAP_TAPCELL_ROW_101_1808 vccd1 vssd1 sky130_fd_sc_hd__tapvpwrvgnd_1$1
XFILLER_80_489 vssd1 vccd1 vccd1 vssd1 sky130_ef_sc_hd__decap_40_12$1
XFILLER_61_670 vssd1 vccd1 vccd1 vssd1 sky130_fd_sc_hd__fill_2$1
XFILLER_21_501 vssd1 vccd1 vccd1 vssd1 sky130_fd_sc_hd__fill_2$1
XFILLER_33_361 vssd1 vccd1 vccd1 vssd1 sky130_ef_sc_hd__decap_40_12$1
XFILLER_40_309 vssd1 vccd1 vccd1 vssd1 sky130_ef_sc_hd__decap_40_12$1
XTAP_TAPCELL_ROW_134_2307 vccd1 vssd1 sky130_fd_sc_hd__tapvpwrvgnd_1$1
X_0929_ _1634_/Q _1147_/A _0933_/B _1666_/Q hold6/X vccd1 vssd1 vccd1 vssd1 sky130_fd_sc_hd__a22o_1$1
XFILLER_20_15 vssd1 vccd1 vccd1 vssd1 sky130_ef_sc_hd__decap_40_12$1
XFILLER_136_15 vssd1 vccd1 vccd1 vssd1 sky130_ef_sc_hd__decap_40_12$1
XFILLER_134_425 vccd1 vssd1 vccd1 vssd1 sky130_fd_sc_hd__fill_1$1
XFILLER_88_501 vssd1 vccd1 vccd1 vssd1 sky130_ef_sc_hd__decap_40_12$1
XFILLER_103_823 vccd1 vssd1 vccd1 vssd1 sky130_fd_sc_hd__fill_1$1
XFILLER_88_523 vccd1 vssd1 vccd1 vssd1 sky130_fd_sc_hd__fill_1$1
XFILLER_0_405 vssd1 vccd1 vccd1 vssd1 sky130_ef_sc_hd__decap_40_12$1
XFILLER_0_427 vssd1 vccd1 vccd1 vssd1 sky130_ef_sc_hd__decap_40_12$1
Xhold13 wbs_dat_i[23] hold13/X vssd1 vccd1 vccd1 vssd1 sky130_fd_sc_hd__dlygate4sd3_1$1
XFILLER_114_193 vssd1 vccd1 vccd1 vssd1 sky130_fd_sc_hd__fill_2$1
XFILLER_102_333 vssd1 vccd1 vccd1 vssd1 sky130_ef_sc_hd__decap_40_12$1
XFILLER_0_449 vssd1 vccd1 vccd1 vssd1 sky130_ef_sc_hd__decap_40_12$1
Xhold24 hold24/A hold24/X vssd1 vccd1 vccd1 vssd1 sky130_fd_sc_hd__dlygate4sd3_1$1
Xhold46 hold46/A hold46/X vssd1 vccd1 vccd1 vssd1 sky130_fd_sc_hd__dlygate4sd3_1$1
Xhold35 hold35/A hold35/X vssd1 vccd1 vccd1 vssd1 sky130_fd_sc_hd__dlygate4sd3_1$1
XFILLER_102_377 vssd1 vccd1 vccd1 vssd1 sky130_ef_sc_hd__decap_40_12$1
Xclkbuf_leaf_2_wb_clk_i _1720_/CLK clkbuf_leaf_9_wb_clk_i/A vssd1 vccd1 vccd1 vssd1
+ sky130_fd_sc_hd__clkbuf_8$1
XFILLER_75_217 vssd1 vccd1 vccd1 vssd1 sky130_fd_sc_hd__fill_4$1
XFILLER_29_57 vssd1 vccd1 vccd1 vssd1 sky130_ef_sc_hd__decap_40_12$1
Xhold68 hold68/A hold68/X vssd1 vccd1 vccd1 vssd1 sky130_fd_sc_hd__dlygate4sd3_1$1
Xhold79 hold79/A hold79/X vssd1 vccd1 vccd1 vssd1 sky130_fd_sc_hd__dlygate4sd3_1$1
Xhold57 hold57/A hold57/X vssd1 vccd1 vccd1 vssd1 sky130_fd_sc_hd__dlygate4sd3_1$1
XFILLER_69_792 vssd1 vccd1 vccd1 vssd1 sky130_ef_sc_hd__decap_40_12$1
XFILLER_90_209 vssd1 vccd1 vccd1 vssd1 sky130_ef_sc_hd__decap_40_12$1
XFILLER_56_475 vccd1 vssd1 vccd1 vssd1 sky130_fd_sc_hd__fill_1$1
XFILLER_28_133 vssd1 vccd1 vccd1 vssd1 sky130_fd_sc_hd__fill_4$1
XFILLER_83_261 vssd1 vccd1 vccd1 vssd1 sky130_ef_sc_hd__decap_40_12$1
XFILLER_71_401 vssd1 vccd1 vccd1 vssd1 sky130_ef_sc_hd__decap_40_12$1
XFILLER_28_177 vssd1 vccd1 vccd1 vssd1 sky130_ef_sc_hd__decap_40_12$1
XFILLER_43_125 vssd1 vccd1 vccd1 vssd1 sky130_ef_sc_hd__decap_40_12$1
XFILLER_44_637 vssd1 vccd1 vccd1 vssd1 sky130_fd_sc_hd__fill_4$1
XFILLER_101_51 vssd1 vccd1 vccd1 vssd1 sky130_fd_sc_hd__fill_4$1
XFILLER_12_501 vssd1 vccd1 vccd1 vssd1 sky130_ef_sc_hd__decap_40_12$1
XTAP_TAPCELL_ROW_14_507 vccd1 vssd1 sky130_fd_sc_hd__tapvpwrvgnd_1$1
XFILLER_24_361 vssd1 vccd1 vccd1 vssd1 sky130_fd_sc_hd__fill_2$1
XFILLER_43_169 vssd1 vccd1 vccd1 vssd1 sky130_ef_sc_hd__decap_40_12$1
XFILLER_52_692 vssd1 vccd1 vccd1 vssd1 sky130_fd_sc_hd__fill_8$1
XFILLER_12_545 vssd1 vccd1 vccd1 vssd1 sky130_ef_sc_hd__decap_40_12$1
XFILLER_61_55 vccd1 vssd1 vccd1 vssd1 sky130_fd_sc_hd__fill_1$1
XFILLER_12_589 vssd1 vccd1 vccd1 vssd1 sky130_ef_sc_hd__decap_40_12$1
XFILLER_138_753 vssd1 vccd1 vccd1 vssd1 sky130_fd_sc_hd__fill_2$1
XFILLER_125_447 vccd1 vssd1 vccd1 vssd1 sky130_fd_sc_hd__fill_1$1
XTAP_TAPCELL_ROW_74_1409 vccd1 vssd1 sky130_fd_sc_hd__tapvpwrvgnd_1$1
XFILLER_106_661 vccd1 vssd1 vccd1 vssd1 sky130_fd_sc_hd__fill_1$1
XFILLER_98_309 vssd1 vccd1 vccd1 vssd1 sky130_ef_sc_hd__decap_40_12$1
XFILLER_4_755 vccd1 vssd1 vccd1 vssd1 sky130_fd_sc_hd__fill_1$1
XFILLER_3_221 vssd1 vccd1 vccd1 vssd1 sky130_fd_sc_hd__fill_2$1
XFILLER_10_81 vssd1 vccd1 vccd1 vssd1 sky130_fd_sc_hd__fill_2$1
XFILLER_133_491 vssd1 vccd1 vccd1 vssd1 sky130_ef_sc_hd__decap_40_12$1
XFILLER_126_81 vssd1 vccd1 vccd1 vssd1 sky130_fd_sc_hd__fill_2$1
XFILLER_105_193 vssd1 vccd1 vccd1 vssd1 sky130_ef_sc_hd__decap_40_12$1
XFILLER_121_697 vssd1 vccd1 vccd1 vssd1 sky130_ef_sc_hd__decap_40_12$1
XFILLER_121_664 vssd1 vccd1 vccd1 vssd1 sky130_fd_sc_hd__fill_8$1
XFILLER_120_141 vssd1 vccd1 vccd1 vssd1 sky130_ef_sc_hd__decap_40_12$1
XFILLER_86_41 vssd1 vccd1 vccd1 vssd1 sky130_ef_sc_hd__decap_40_12$1
XFILLER_67_729 vssd1 vccd1 vccd1 vssd1 sky130_ef_sc_hd__decap_40_12$1
XTAP_TAPCELL_ROW_89_1641 vccd1 vssd1 sky130_fd_sc_hd__tapvpwrvgnd_1$1
XTAP_TAPCELL_ROW_89_1630 vccd1 vssd1 sky130_fd_sc_hd__tapvpwrvgnd_1$1
XFILLER_86_85 vssd1 vccd1 vccd1 vssd1 sky130_ef_sc_hd__decap_40_12$1
XFILLER_19_111 vccd1 vssd1 vccd1 vssd1 sky130_fd_sc_hd__fill_1$1
XFILLER_62_401 vssd1 vccd1 vccd1 vssd1 sky130_ef_sc_hd__decap_40_12$1
XFILLER_35_637 vssd1 vccd1 vccd1 vssd1 sky130_fd_sc_hd__fill_2$1
XFILLER_47_497 vssd1 vccd1 vccd1 vssd1 sky130_fd_sc_hd__fill_4$1
XFILLER_90_754 vssd1 vccd1 vccd1 vssd1 sky130_fd_sc_hd__fill_2$1
XFILLER_62_445 vssd1 vccd1 vccd1 vssd1 sky130_ef_sc_hd__decap_40_12$1
XFILLER_62_489 vssd1 vccd1 vccd1 vssd1 sky130_ef_sc_hd__decap_40_12$1
XFILLER_15_361 vssd1 vccd1 vccd1 vssd1 sky130_ef_sc_hd__decap_40_12$1
XFILLER_22_309 vssd1 vccd1 vccd1 vssd1 sky130_ef_sc_hd__decap_40_12$1
X_1832_ _1832_/A _1832_/X vssd1 vccd1 vccd1 vssd1 sky130_fd_sc_hd__clkbuf_2$1
XFILLER_129_753 vssd1 vccd1 vccd1 vssd1 sky130_ef_sc_hd__decap_40_12$1
XFILLER_129_797 vssd1 vccd1 vccd1 vssd1 sky130_fd_sc_hd__fill_4$1
XTAP_TAPCELL_ROW_116_2037 vccd1 vssd1 sky130_fd_sc_hd__tapvpwrvgnd_1$1
X_1763_ hold74/A _1763_/CLK _1763_/D vccd1 vssd1 vccd1 vssd1 sky130_fd_sc_hd__dfxtp_1$1
X_1694_ _1694_/Q _1759_/CLK _1694_/D vccd1 vssd1 vccd1 vssd1 sky130_fd_sc_hd__dfxtp_1$1
XFILLER_116_458 vccd1 vssd1 vccd1 vssd1 sky130_fd_sc_hd__fill_1$1
XFILLER_98_821 vccd1 vssd1 vccd1 vssd1 sky130_fd_sc_hd__fill_1$1
XFILLER_106_29 vssd1 vccd1 vccd1 vssd1 sky130_ef_sc_hd__decap_40_12$1
XTAP_TAPCELL_ROW_111_1970 vccd1 vssd1 sky130_fd_sc_hd__tapvpwrvgnd_1$1
XFILLER_58_729 vssd1 vccd1 vccd1 vssd1 sky130_fd_sc_hd__fill_2$1
XFILLER_57_217 vssd1 vccd1 vccd1 vssd1 sky130_fd_sc_hd__fill_4$1
XFILLER_85_559 vccd1 vssd1 vccd1 vssd1 sky130_fd_sc_hd__fill_1$1
XFILLER_72_209 vssd1 vccd1 vccd1 vssd1 sky130_ef_sc_hd__decap_40_12$1
XTAP_TAPCELL_ROW_127_2199 vccd1 vssd1 sky130_fd_sc_hd__tapvpwrvgnd_1$1
XFILLER_66_795 vccd1 vssd1 vccd1 vssd1 sky130_fd_sc_hd__fill_1$1
XFILLER_65_261 vssd1 vccd1 vccd1 vssd1 sky130_ef_sc_hd__decap_40_12$1
XFILLER_53_423 vccd1 vssd1 vccd1 vssd1 sky130_fd_sc_hd__fill_1$1
XFILLER_26_637 vssd1 vccd1 vccd1 vssd1 sky130_fd_sc_hd__fill_4$1
XFILLER_38_475 vccd1 vssd1 vccd1 vssd1 sky130_fd_sc_hd__fill_1$1
X_1128_ hold27/X _1128_/X _1144_/B vssd1 vccd1 vccd1 vssd1 sky130_fd_sc_hd__or2_1$1
XFILLER_81_765 vssd1 vccd1 vccd1 vssd1 sky130_ef_sc_hd__decap_40_12$1
XFILLER_53_434 vccd1 vssd1 vccd1 vssd1 sky130_fd_sc_hd__fill_1$1
XTAP_TAPCELL_ROW_0_279 vccd1 vssd1 sky130_fd_sc_hd__tapvpwrvgnd_1$1
XFILLER_25_125 vssd1 vccd1 vccd1 vssd1 sky130_ef_sc_hd__decap_40_12$1
X_1059_ _1437_/C1 _1058_/X _1079_/A2 hold107/X _1562_/D vssd1 vccd1 vccd1 vssd1 sky130_fd_sc_hd__o211a_1$1
XFILLER_80_253 vssd1 vccd1 vccd1 vssd1 sky130_ef_sc_hd__decap_40_12$1
XFILLER_53_489 vccd1 vssd1 vccd1 vssd1 sky130_fd_sc_hd__fill_1$1
XFILLER_15_15 vssd1 vccd1 vccd1 vssd1 sky130_ef_sc_hd__decap_40_12$1
XFILLER_25_169 vssd1 vccd1 vccd1 vssd1 sky130_ef_sc_hd__decap_40_12$1
XFILLER_41_629 vssd1 vccd1 vccd1 vssd1 sky130_fd_sc_hd__fill_2$1
XFILLER_22_832 vssd1 vccd1 vccd1 vssd1 sky130_fd_sc_hd__fill_8$1
XFILLER_40_139 vccd1 vssd1 vccd1 vssd1 sky130_fd_sc_hd__fill_1$1
XFILLER_135_701 vssd1 vccd1 vccd1 vssd1 sky130_fd_sc_hd__fill_2$1
XFILLER_107_447 vccd1 vssd1 vccd1 vssd1 sky130_fd_sc_hd__fill_1$1
XFILLER_31_69 vssd1 vccd1 vccd1 vssd1 sky130_ef_sc_hd__decap_40_12$1
XFILLER_134_233 vssd1 vccd1 vccd1 vssd1 sky130_ef_sc_hd__decap_40_12$1
XTAP_TAPCELL_ROW_56_1139 vccd1 vssd1 sky130_fd_sc_hd__tapvpwrvgnd_1$1
XFILLER_134_277 vssd1 vccd1 vccd1 vssd1 sky130_ef_sc_hd__decap_40_12$1
XFILLER_122_428 vssd1 vccd1 vccd1 vssd1 sky130_ef_sc_hd__decap_40_12$1
Xoutput58 _1840_/X analog_ctrl[107] vssd1 vccd1 vccd1 vssd1 sky130_fd_sc_hd__buf_12$1
XFILLER_1_725 vssd1 vccd1 vccd1 vssd1 sky130_fd_sc_hd__fill_2$1
Xoutput69 _1850_/X analog_ctrl[117] vssd1 vccd1 vccd1 vssd1 sky130_fd_sc_hd__buf_12$1
XFILLER_115_480 vssd1 vccd1 vccd1 vssd1 sky130_ef_sc_hd__decap_40_12$1
XFILLER_103_653 vssd1 vccd1 vccd1 vssd1 sky130_ef_sc_hd__decap_40_12$1
XFILLER_102_141 vssd1 vccd1 vccd1 vssd1 sky130_ef_sc_hd__decap_40_12$1
XFILLER_76_526 vssd1 vccd1 vccd1 vssd1 sky130_fd_sc_hd__fill_4$1
XFILLER_49_729 vssd1 vccd1 vccd1 vssd1 sky130_ef_sc_hd__decap_40_12$1
XFILLER_0_279 vccd1 vssd1 vccd1 vssd1 sky130_fd_sc_hd__fill_1$1
XFILLER_103_697 vssd1 vccd1 vccd1 vssd1 sky130_fd_sc_hd__fill_8$1
XFILLER_91_529 vssd1 vccd1 vccd1 vssd1 sky130_ef_sc_hd__decap_40_12$1
XFILLER_56_77 vssd1 vccd1 vccd1 vssd1 sky130_fd_sc_hd__fill_4$1
XFILLER_17_615 vccd1 vssd1 vccd1 vssd1 sky130_fd_sc_hd__fill_1$1
XFILLER_29_497 vssd1 vccd1 vccd1 vssd1 sky130_fd_sc_hd__fill_4$1
XFILLER_44_401 vssd1 vccd1 vccd1 vssd1 sky130_ef_sc_hd__decap_40_12$1
XFILLER_44_445 vssd1 vccd1 vccd1 vssd1 sky130_fd_sc_hd__fill_4$1
XFILLER_112_83 vccd1 vssd1 vccd1 vssd1 sky130_fd_sc_hd__fill_1$1
XTAP_TAPCELL_ROW_84_1560 vccd1 vssd1 sky130_fd_sc_hd__tapvpwrvgnd_1$1
XFILLER_44_489 vssd1 vccd1 vccd1 vssd1 sky130_ef_sc_hd__decap_40_12$1
XFILLER_72_65 vssd1 vccd1 vccd1 vssd1 sky130_ef_sc_hd__decap_40_12$1
XTAP_TAPCELL_ROW_27_698 vccd1 vssd1 sky130_fd_sc_hd__tapvpwrvgnd_1$1
XFILLER_40_662 vssd1 vccd1 vccd1 vssd1 sky130_ef_sc_hd__decap_40_12$1
XFILLER_8_357 vssd1 vccd1 vccd1 vssd1 sky130_fd_sc_hd__fill_4$1
XFILLER_126_789 vccd1 vssd1 vccd1 vssd1 sky130_fd_sc_hd__fill_1$1
XFILLER_125_277 vssd1 vccd1 vccd1 vssd1 sky130_fd_sc_hd__fill_2$1
XFILLER_113_417 vssd1 vccd1 vccd1 vssd1 sky130_fd_sc_hd__fill_2$1
XFILLER_99_629 vssd1 vccd1 vccd1 vssd1 sky130_fd_sc_hd__fill_2$1
XFILLER_4_585 vssd1 vccd1 vccd1 vssd1 sky130_fd_sc_hd__fill_2$1
XFILLER_98_139 vccd1 vssd1 vccd1 vssd1 sky130_fd_sc_hd__fill_1$1
XFILLER_97_51 vssd1 vccd1 vccd1 vssd1 sky130_fd_sc_hd__fill_4$1
XFILLER_121_461 vssd1 vccd1 vccd1 vssd1 sky130_fd_sc_hd__fill_8$1
XFILLER_94_301 vssd1 vccd1 vccd1 vssd1 sky130_fd_sc_hd__fill_4$1
XFILLER_67_559 vccd1 vssd1 vccd1 vssd1 sky130_fd_sc_hd__fill_1$1
XFILLER_39_217 vssd1 vccd1 vccd1 vssd1 sky130_fd_sc_hd__fill_4$1
XFILLER_94_345 vssd1 vccd1 vccd1 vssd1 sky130_ef_sc_hd__decap_40_12$1
XFILLER_54_209 vssd1 vccd1 vccd1 vssd1 sky130_ef_sc_hd__decap_40_12$1
XFILLER_47_261 vssd1 vccd1 vccd1 vssd1 sky130_ef_sc_hd__decap_40_12$1
XFILLER_63_765 vssd1 vccd1 vccd1 vssd1 sky130_fd_sc_hd__fill_2$1
XFILLER_35_445 vssd1 vccd1 vccd1 vssd1 sky130_fd_sc_hd__fill_2$1
XFILLER_63_798 vssd1 vccd1 vccd1 vssd1 sky130_fd_sc_hd__fill_2$1
XFILLER_62_253 vssd1 vccd1 vccd1 vssd1 sky130_ef_sc_hd__decap_40_12$1
XFILLER_23_629 vssd1 vccd1 vccd1 vssd1 sky130_ef_sc_hd__decap_40_12$1
XTAP_TAPCELL_ROW_46_985 vccd1 vssd1 sky130_fd_sc_hd__tapvpwrvgnd_1$1
XFILLER_16_681 vssd1 vccd1 vccd1 vssd1 sky130_ef_sc_hd__decap_40_12$1
XFILLER_22_139 vccd1 vssd1 vccd1 vssd1 sky130_fd_sc_hd__fill_1$1
XTAP_TAPCELL_ROW_46_996 vccd1 vssd1 sky130_fd_sc_hd__tapvpwrvgnd_1$1
XPHY_EDGE_ROW_99_Left_238 vccd1 vssd1 vccd1 vssd1 sky130_fd_sc_hd__decap_3$1
XFILLER_31_673 vssd1 vccd1 vccd1 vssd1 sky130_ef_sc_hd__decap_40_12$1
XFILLER_129_561 vssd1 vccd1 vccd1 vssd1 sky130_ef_sc_hd__decap_40_12$1
X_1815_ vccd1 vssd1 _1815_/X _1815_/A vccd1 vssd1 sky130_fd_sc_hd__buf_1$1
X_1746_ _1854_/A _1748_/CLK _1746_/D vccd1 vssd1 vccd1 vssd1 sky130_fd_sc_hd__dfxtp_1$1
XFILLER_116_233 vssd1 vccd1 vccd1 vssd1 sky130_ef_sc_hd__decap_40_12$1
XFILLER_7_93 vssd1 vccd1 vccd1 vssd1 sky130_ef_sc_hd__decap_40_12$1
XFILLER_117_39 vssd1 vccd1 vccd1 vssd1 sky130_ef_sc_hd__decap_40_12$1
XFILLER_116_277 vssd1 vccd1 vccd1 vssd1 sky130_ef_sc_hd__decap_40_12$1
X_1677_ _1677_/Q clkload2/A _1677_/D vccd1 vssd1 vccd1 vssd1 sky130_fd_sc_hd__dfxtp_1$1
XFILLER_131_225 vssd1 vccd1 vccd1 vssd1 sky130_ef_sc_hd__decap_40_12$1
XTAP_TAPCELL_ROW_129_2239 vccd1 vssd1 sky130_fd_sc_hd__tapvpwrvgnd_1$1
XTAP_TAPCELL_ROW_129_2228 vccd1 vssd1 sky130_fd_sc_hd__tapvpwrvgnd_1$1
XFILLER_97_161 vssd1 vccd1 vccd1 vssd1 sky130_fd_sc_hd__fill_4$1
XFILLER_86_802 vssd1 vccd1 vccd1 vssd1 sky130_fd_sc_hd__fill_8$1
XFILLER_86_813 vssd1 vccd1 vccd1 vssd1 sky130_ef_sc_hd__decap_40_12$1
XFILLER_133_27 vssd1 vccd1 vccd1 vssd1 sky130_ef_sc_hd__decap_40_12$1
XFILLER_100_645 vssd1 vccd1 vccd1 vssd1 sky130_fd_sc_hd__fill_4$1
XTAP_TAPCELL_ROW_51_1069 vccd1 vssd1 sky130_fd_sc_hd__tapvpwrvgnd_1$1
XTAP_TAPCELL_ROW_51_1058 vccd1 vssd1 sky130_fd_sc_hd__tapvpwrvgnd_1$1
XFILLER_85_389 vssd1 vccd1 vccd1 vssd1 sky130_fd_sc_hd__fill_2$1
XFILLER_66_581 vssd1 vccd1 vccd1 vssd1 sky130_fd_sc_hd__fill_4$1
XFILLER_54_721 vssd1 vccd1 vccd1 vssd1 sky130_ef_sc_hd__decap_40_12$1
XFILLER_26_401 vssd1 vccd1 vccd1 vssd1 sky130_ef_sc_hd__decap_40_12$1
XFILLER_26_445 vssd1 vccd1 vccd1 vssd1 sky130_ef_sc_hd__decap_40_12$1
XFILLER_26_489 vssd1 vccd1 vccd1 vssd1 sky130_ef_sc_hd__decap_40_12$1
XTAP_TAPCELL_ROW_66_1290 vccd1 vssd1 sky130_fd_sc_hd__tapvpwrvgnd_1$1
XTAP_TAPCELL_ROW_24_657 vccd1 vssd1 sky130_fd_sc_hd__tapvpwrvgnd_1$1
XFILLER_10_813 vssd1 vccd1 vccd1 vssd1 sky130_ef_sc_hd__decap_40_12$1
XFILLER_21_161 vssd1 vccd1 vccd1 vssd1 sky130_fd_sc_hd__fill_4$1
XFILLER_108_701 vssd1 vccd1 vccd1 vssd1 sky130_ef_sc_hd__decap_40_12$1
XFILLER_5_305 vssd1 vccd1 vccd1 vssd1 sky130_ef_sc_hd__decap_40_12$1
XFILLER_5_349 vssd1 vccd1 vccd1 vssd1 sky130_ef_sc_hd__decap_40_12$1
XFILLER_123_737 vccd1 vssd1 vccd1 vssd1 sky130_fd_sc_hd__fill_1$1
XFILLER_107_277 vssd1 vccd1 vccd1 vssd1 sky130_fd_sc_hd__fill_2$1
XFILLER_101_3 vssd1 vccd1 vccd1 vssd1 sky130_ef_sc_hd__decap_40_12$1
XFILLER_95_109 vssd1 vccd1 vccd1 vssd1 sky130_fd_sc_hd__fill_2$1
XFILLER_89_673 vssd1 vccd1 vccd1 vssd1 sky130_ef_sc_hd__decap_40_12$1
XFILLER_89_651 vssd1 vccd1 vccd1 vssd1 sky130_ef_sc_hd__decap_40_12$1
XFILLER_76_301 vssd1 vccd1 vccd1 vssd1 sky130_fd_sc_hd__fill_4$1
XFILLER_76_345 vssd1 vccd1 vccd1 vssd1 sky130_ef_sc_hd__decap_40_12$1
XFILLER_49_559 vccd1 vssd1 vccd1 vssd1 sky130_fd_sc_hd__fill_1$1
XTAP_TAPCELL_ROW_4_360 vccd1 vssd1 sky130_fd_sc_hd__tapvpwrvgnd_1$1
XFILLER_76_389 vssd1 vccd1 vccd1 vssd1 sky130_ef_sc_hd__decap_40_12$1
XFILLER_64_529 vssd1 vccd1 vccd1 vssd1 sky130_fd_sc_hd__fill_2$1
XFILLER_29_261 vssd1 vccd1 vccd1 vssd1 sky130_ef_sc_hd__decap_40_12$1
XFILLER_36_209 vssd1 vccd1 vccd1 vssd1 sky130_ef_sc_hd__decap_40_12$1
XFILLER_123_93 vssd1 vccd1 vccd1 vssd1 sky130_ef_sc_hd__decap_40_12$1
XFILLER_91_337 vssd1 vccd1 vccd1 vssd1 sky130_ef_sc_hd__decap_40_12$1
XFILLER_17_445 vssd1 vccd1 vccd1 vssd1 sky130_fd_sc_hd__fill_2$1
XFILLER_44_253 vssd1 vccd1 vccd1 vssd1 sky130_ef_sc_hd__decap_40_12$1
XFILLER_45_765 vssd1 vccd1 vccd1 vssd1 sky130_ef_sc_hd__decap_40_12$1
XFILLER_60_757 vssd1 vccd1 vccd1 vssd1 sky130_ef_sc_hd__decap_40_12$1
XTAP_TAPCELL_ROW_43_944 vccd1 vssd1 sky130_fd_sc_hd__tapvpwrvgnd_1$1
XFILLER_8_121 vssd1 vccd1 vccd1 vssd1 sky130_ef_sc_hd__decap_40_12$1
XFILLER_13_673 vssd1 vccd1 vccd1 vssd1 sky130_ef_sc_hd__decap_40_12$1
X_1600_ _1600_/Q _1760_/CLK _1600_/D vccd1 vssd1 vccd1 vssd1 sky130_fd_sc_hd__dfxtp_1$1
XTAP_TAPCELL_ROW_97_1751 vccd1 vssd1 sky130_fd_sc_hd__tapvpwrvgnd_1$1
XFILLER_8_165 vssd1 vccd1 vccd1 vssd1 sky130_ef_sc_hd__decap_40_12$1
XFILLER_138_391 vccd1 vssd1 vccd1 vssd1 sky130_fd_sc_hd__fill_1$1
XFILLER_126_531 vccd1 vssd1 vccd1 vssd1 sky130_fd_sc_hd__fill_1$1
XTAP_TAPCELL_ROW_97_1762 vccd1 vssd1 sky130_fd_sc_hd__tapvpwrvgnd_1$1
X_1531_ hold95/A _1755_/CLK _1531_/D vccd1 vssd1 vccd1 vssd1 sky130_fd_sc_hd__dfxtp_1$1
X_1462_ _1462_/A _1462_/X _1464_/B vssd1 vccd1 vccd1 vssd1 sky130_fd_sc_hd__or2_1$1
XFILLER_113_225 vssd1 vccd1 vccd1 vssd1 sky130_ef_sc_hd__decap_40_12$1
XFILLER_86_109 vssd1 vccd1 vccd1 vssd1 sky130_ef_sc_hd__decap_40_12$1
XFILLER_122_781 vssd1 vccd1 vccd1 vssd1 sky130_ef_sc_hd__decap_40_12$1
X_1393_ _0739_/D _1392_/X _1399_/A2 hold14/X _1724_/D vssd1 vccd1 vccd1 vssd1 sky130_fd_sc_hd__o211a_1$1
XFILLER_79_161 vssd1 vccd1 vccd1 vssd1 sky130_fd_sc_hd__fill_4$1
XFILLER_94_153 vssd1 vccd1 vccd1 vssd1 sky130_ef_sc_hd__decap_40_12$1
XFILLER_67_389 vssd1 vccd1 vccd1 vssd1 sky130_fd_sc_hd__fill_2$1
XTAP_TAPCELL_ROW_124_2158 vccd1 vssd1 sky130_fd_sc_hd__tapvpwrvgnd_1$1
XFILLER_94_197 vssd1 vccd1 vccd1 vssd1 sky130_ef_sc_hd__decap_40_12$1
XFILLER_36_754 vssd1 vccd1 vccd1 vssd1 sky130_fd_sc_hd__fill_2$1
XFILLER_63_573 vssd1 vccd1 vccd1 vssd1 sky130_fd_sc_hd__fill_4$1
XFILLER_51_702 vssd1 vccd1 vccd1 vssd1 sky130_ef_sc_hd__decap_40_12$1
XTAP_TAPCELL_ROW_106_1891 vccd1 vssd1 sky130_fd_sc_hd__tapvpwrvgnd_1$1
XFILLER_51_757 vssd1 vccd1 vccd1 vssd1 sky130_fd_sc_hd__fill_2$1
XFILLER_50_245 vssd1 vccd1 vccd1 vssd1 sky130_fd_sc_hd__fill_4$1
XFILLER_50_289 vssd1 vccd1 vccd1 vssd1 sky130_ef_sc_hd__decap_40_12$1
XFILLER_10_109 vssd1 vccd1 vccd1 vssd1 sky130_ef_sc_hd__decap_40_12$1
XTAP_TAPCELL_ROW_21_616 vccd1 vssd1 sky130_fd_sc_hd__tapvpwrvgnd_1$1
XFILLER_12_27 vccd1 vssd1 vccd1 vssd1 sky130_fd_sc_hd__fill_1$1
XFILLER_128_27 vccd1 vssd1 vccd1 vssd1 sky130_fd_sc_hd__fill_1$1
XFILLER_129_391 vccd1 vssd1 vccd1 vssd1 sky130_fd_sc_hd__fill_1$1
Xhold110 _1207_/X _1634_/D vssd1 vccd1 vccd1 vssd1 sky130_fd_sc_hd__dlygate4sd3_1$1
XFILLER_3_809 vssd1 vccd1 vccd1 vssd1 sky130_ef_sc_hd__decap_40_12$1
XFILLER_132_501 vssd1 vccd1 vccd1 vssd1 sky130_fd_sc_hd__fill_8$1
X_1729_ hold57/A _1729_/CLK _1729_/D vccd1 vssd1 vccd1 vssd1 sky130_fd_sc_hd__dfxtp_1$1
Xhold121 _1055_/X _1560_/D vssd1 vccd1 vccd1 vssd1 sky130_fd_sc_hd__dlygate4sd3_1$1
Xhold143 _1722_/Q _1388_/A vssd1 vccd1 vccd1 vssd1 sky130_fd_sc_hd__dlygate4sd3_1$1
Xhold132 _1713_/Q _1370_/A vssd1 vccd1 vccd1 vssd1 sky130_fd_sc_hd__dlygate4sd3_1$1
Xhold154 wbs_dat_i[9] input51/A vssd1 vccd1 vccd1 vssd1 sky130_fd_sc_hd__dlygate4sd3_1$1
XFILLER_132_545 vssd1 vccd1 vccd1 vssd1 sky130_ef_sc_hd__decap_40_12$1
Xhold176 _1632_/Q _1202_/A vssd1 vccd1 vccd1 vssd1 sky130_fd_sc_hd__dlygate4sd3_1$1
Xhold165 _1558_/Q _1050_/A vssd1 vccd1 vccd1 vssd1 sky130_fd_sc_hd__dlygate4sd3_1$1
Xhold198 wbs_dat_i[7] input49/A vssd1 vccd1 vccd1 vssd1 sky130_fd_sc_hd__dlygate4sd3_1$1
Xhold187 wbs_dat_i[1] hold72/A vssd1 vccd1 vccd1 vssd1 sky130_fd_sc_hd__dlygate4sd3_1$1
XFILLER_132_589 vssd1 vccd1 vccd1 vssd1 sky130_ef_sc_hd__decap_40_12$1
XFILLER_77_109 vssd1 vccd1 vccd1 vssd1 sky130_fd_sc_hd__fill_2$1
XFILLER_113_781 vssd1 vccd1 vccd1 vssd1 sky130_fd_sc_hd__fill_2$1
XFILLER_58_301 vssd1 vccd1 vccd1 vssd1 sky130_fd_sc_hd__fill_4$1
XFILLER_86_643 vccd1 vssd1 vccd1 vssd1 sky130_fd_sc_hd__fill_1$1
XFILLER_74_805 vssd1 vccd1 vccd1 vssd1 sky130_fd_sc_hd__fill_4$1
XFILLER_58_345 vssd1 vccd1 vccd1 vssd1 sky130_ef_sc_hd__decap_40_12$1
XFILLER_100_475 vccd1 vssd1 vccd1 vssd1 sky130_fd_sc_hd__fill_1$1
XFILLER_86_698 vssd1 vccd1 vccd1 vssd1 sky130_fd_sc_hd__fill_2$1
XFILLER_18_209 vssd1 vccd1 vccd1 vssd1 sky130_ef_sc_hd__decap_40_12$1
XFILLER_37_57 vssd1 vccd1 vccd1 vssd1 sky130_ef_sc_hd__decap_40_12$1
XFILLER_39_581 vssd1 vccd1 vccd1 vssd1 sky130_fd_sc_hd__fill_8$1
XFILLER_73_337 vssd1 vccd1 vccd1 vssd1 sky130_ef_sc_hd__decap_40_12$1
XTAP_TAPCELL_ROW_29_738 vccd1 vssd1 sky130_fd_sc_hd__tapvpwrvgnd_1$1
XFILLER_26_253 vssd1 vccd1 vccd1 vssd1 sky130_ef_sc_hd__decap_40_12$1
XFILLER_41_223 vccd1 vssd1 vccd1 vssd1 sky130_fd_sc_hd__fill_1$1
XTAP_TAPCELL_ROW_40_903 vccd1 vssd1 sky130_fd_sc_hd__tapvpwrvgnd_1$1
XFILLER_42_757 vssd1 vccd1 vccd1 vssd1 sky130_ef_sc_hd__decap_40_12$1
XFILLER_10_643 vccd1 vssd1 vccd1 vssd1 sky130_fd_sc_hd__fill_1$1
XFILLER_127_317 vssd1 vccd1 vccd1 vssd1 sky130_ef_sc_hd__decap_40_12$1
XFILLER_6_625 vssd1 vccd1 vccd1 vssd1 sky130_ef_sc_hd__decap_40_12$1
XFILLER_5_113 vssd1 vccd1 vccd1 vssd1 sky130_ef_sc_hd__decap_40_12$1
XFILLER_6_669 vssd1 vccd1 vccd1 vssd1 sky130_ef_sc_hd__decap_40_12$1
XFILLER_135_350 vssd1 vccd1 vccd1 vssd1 sky130_ef_sc_hd__decap_40_12$1
XFILLER_123_501 vssd1 vccd1 vccd1 vssd1 sky130_fd_sc_hd__fill_2$1
XTAP_TAPCELL_ROW_79_1492 vccd1 vssd1 sky130_fd_sc_hd__tapvpwrvgnd_1$1
XTAP_TAPCELL_ROW_79_1481 vccd1 vssd1 sky130_fd_sc_hd__tapvpwrvgnd_1$1
XTAP_TAPCELL_ROW_9_441 vccd1 vssd1 sky130_fd_sc_hd__tapvpwrvgnd_1$1
XTAP_TAPCELL_ROW_9_430 vccd1 vssd1 sky130_fd_sc_hd__tapvpwrvgnd_1$1
XFILLER_111_729 vssd1 vccd1 vccd1 vssd1 sky130_fd_sc_hd__fill_4$1
XTAP_TAPCELL_ROW_92_1681 vccd1 vssd1 sky130_fd_sc_hd__tapvpwrvgnd_1$1
XFILLER_78_53 vssd1 vccd1 vccd1 vssd1 sky130_ef_sc_hd__decap_40_12$1
XFILLER_68_109 vssd1 vccd1 vccd1 vssd1 sky130_ef_sc_hd__decap_40_12$1
XFILLER_78_97 vssd1 vccd1 vccd1 vssd1 sky130_ef_sc_hd__decap_40_12$1
XFILLER_1_385 vssd1 vccd1 vccd1 vssd1 sky130_fd_sc_hd__fill_4$1
XFILLER_77_665 vssd1 vccd1 vccd1 vssd1 sky130_fd_sc_hd__fill_4$1
XFILLER_134_81 vssd1 vccd1 vccd1 vssd1 sky130_fd_sc_hd__fill_2$1
XFILLER_94_41 vssd1 vccd1 vccd1 vssd1 sky130_ef_sc_hd__decap_40_12$1
XFILLER_92_613 vssd1 vccd1 vccd1 vssd1 sky130_ef_sc_hd__decap_40_12$1
XFILLER_76_153 vssd1 vccd1 vccd1 vssd1 sky130_ef_sc_hd__decap_40_12$1
XFILLER_37_529 vssd1 vccd1 vccd1 vssd1 sky130_ef_sc_hd__decap_40_12$1
XFILLER_49_389 vssd1 vccd1 vccd1 vssd1 sky130_fd_sc_hd__fill_2$1
XFILLER_94_85 vssd1 vccd1 vccd1 vssd1 sky130_ef_sc_hd__decap_40_12$1
XFILLER_92_657 vssd1 vccd1 vccd1 vssd1 sky130_ef_sc_hd__decap_40_12$1
XFILLER_76_197 vssd1 vccd1 vccd1 vssd1 sky130_ef_sc_hd__decap_40_12$1
XFILLER_91_167 vccd1 vssd1 vccd1 vssd1 sky130_fd_sc_hd__fill_1$1
XFILLER_45_573 vssd1 vccd1 vccd1 vssd1 sky130_ef_sc_hd__decap_40_12$1
XFILLER_32_245 vssd1 vccd1 vccd1 vssd1 sky130_fd_sc_hd__fill_4$1
XFILLER_32_289 vssd1 vccd1 vccd1 vssd1 sky130_ef_sc_hd__decap_40_12$1
X_0962_ _1785_/A _0962_/X _0990_/B vssd1 vccd1 vccd1 vssd1 sky130_fd_sc_hd__or2_1$1
XFILLER_9_441 vssd1 vccd1 vccd1 vssd1 sky130_fd_sc_hd__fill_4$1
X_0893_ hold36/A _0949_/A _0893_/X hold37/A _1411_/A vccd1 vssd1 vccd1 vssd1 sky130_fd_sc_hd__a22o_1$1
XFILLER_9_485 vssd1 vccd1 vccd1 vssd1 sky130_ef_sc_hd__decap_40_12$1
XFILLER_64_3 vssd1 vccd1 vccd1 vssd1 sky130_ef_sc_hd__decap_40_12$1
XFILLER_126_361 vssd1 vccd1 vccd1 vssd1 sky130_fd_sc_hd__fill_2$1
XFILLER_114_501 vssd1 vccd1 vccd1 vssd1 sky130_ef_sc_hd__decap_40_12$1
XFILLER_114_545 vssd1 vccd1 vccd1 vssd1 sky130_ef_sc_hd__decap_40_12$1
XFILLER_99_223 vccd1 vssd1 vccd1 vssd1 sky130_fd_sc_hd__fill_1$1
X_1514_ _1784_/A _1671_/CLK _1514_/D vccd1 vssd1 vccd1 vssd1 sky130_fd_sc_hd__dfxtp_1$1
XFILLER_59_109 vssd1 vccd1 vccd1 vssd1 sky130_fd_sc_hd__fill_2$1
X_1445_ _0739_/D _1444_/X _1465_/A2 hold32/X _1749_/D vssd1 vccd1 vccd1 vssd1 sky130_fd_sc_hd__o211a_1$1
XFILLER_114_589 vssd1 vccd1 vccd1 vssd1 sky130_ef_sc_hd__decap_40_12$1
XFILLER_101_217 vssd1 vccd1 vccd1 vssd1 sky130_fd_sc_hd__fill_4$1
XFILLER_4_83 vccd1 vssd1 vccd1 vssd1 sky130_fd_sc_hd__fill_1$1
XFILLER_114_29 vssd1 vccd1 vccd1 vssd1 sky130_ef_sc_hd__decap_40_12$1
X_1376_ _1376_/A _1376_/X _1398_/B vssd1 vccd1 vccd1 vssd1 sky130_fd_sc_hd__or2_1$1
XFILLER_68_643 vccd1 vssd1 vccd1 vssd1 sky130_fd_sc_hd__fill_1$1
XFILLER_83_613 vssd1 vccd1 vccd1 vssd1 sky130_fd_sc_hd__fill_2$1
XFILLER_28_529 vssd1 vccd1 vccd1 vssd1 sky130_fd_sc_hd__fill_2$1
XTAP_TAPCELL_ROW_108_1920 vccd1 vssd1 sky130_fd_sc_hd__tapvpwrvgnd_1$1
XFILLER_95_495 vssd1 vccd1 vccd1 vssd1 sky130_fd_sc_hd__fill_8$1
XFILLER_55_337 vssd1 vccd1 vccd1 vssd1 sky130_ef_sc_hd__decap_40_12$1
XFILLER_71_819 vssd1 vccd1 vccd1 vssd1 sky130_fd_sc_hd__fill_4$1
XFILLER_70_307 vccd1 vssd1 vccd1 vssd1 sky130_fd_sc_hd__fill_1$1
XFILLER_24_713 vssd1 vccd1 vccd1 vssd1 sky130_fd_sc_hd__fill_4$1
XFILLER_82_189 vssd1 vccd1 vccd1 vssd1 sky130_fd_sc_hd__fill_4$1
XFILLER_23_223 vccd1 vssd1 vccd1 vssd1 sky130_fd_sc_hd__fill_1$1
XFILLER_24_735 vssd1 vccd1 vccd1 vssd1 sky130_fd_sc_hd__fill_4$1
XFILLER_24_757 vssd1 vccd1 vccd1 vssd1 sky130_ef_sc_hd__decap_40_12$1
XFILLER_11_429 vssd1 vccd1 vccd1 vssd1 sky130_ef_sc_hd__decap_40_12$1
XFILLER_23_15 vssd1 vccd1 vccd1 vssd1 sky130_ef_sc_hd__decap_40_12$1
XTAP_TAPCELL_ROW_137_2349 vccd1 vssd1 sky130_fd_sc_hd__tapvpwrvgnd_1$1
XFILLER_137_615 vccd1 vssd1 vccd1 vssd1 sky130_fd_sc_hd__fill_1$1
XFILLER_109_317 vssd1 vccd1 vccd1 vssd1 sky130_ef_sc_hd__decap_40_12$1
XFILLER_133_821 vssd1 vccd1 vccd1 vssd1 sky130_fd_sc_hd__fill_2$1
XFILLER_124_309 vssd1 vccd1 vccd1 vssd1 sky130_ef_sc_hd__decap_40_12$1
XFILLER_117_361 vssd1 vccd1 vccd1 vssd1 sky130_ef_sc_hd__decap_40_12$1
XFILLER_3_617 vssd1 vccd1 vccd1 vssd1 sky130_ef_sc_hd__decap_40_12$1
XFILLER_132_353 vssd1 vccd1 vccd1 vssd1 sky130_fd_sc_hd__fill_8$1
XFILLER_47_805 vssd1 vccd1 vccd1 vssd1 sky130_fd_sc_hd__fill_2$1
XFILLER_86_473 vssd1 vccd1 vccd1 vssd1 sky130_fd_sc_hd__fill_2$1
XFILLER_59_687 vccd1 vssd1 vccd1 vssd1 sky130_fd_sc_hd__fill_1$1
XFILLER_58_153 vssd1 vccd1 vccd1 vssd1 sky130_ef_sc_hd__decap_40_12$1
XFILLER_19_529 vssd1 vccd1 vccd1 vssd1 sky130_ef_sc_hd__decap_40_12$1
XFILLER_74_657 vssd1 vccd1 vccd1 vssd1 sky130_ef_sc_hd__decap_40_12$1
XFILLER_58_197 vssd1 vccd1 vccd1 vssd1 sky130_ef_sc_hd__decap_40_12$1
XFILLER_73_167 vccd1 vssd1 vccd1 vssd1 sky130_fd_sc_hd__fill_1$1
XFILLER_64_77 vssd1 vccd1 vccd1 vssd1 sky130_fd_sc_hd__fill_4$1
XFILLER_61_329 vssd1 vccd1 vccd1 vssd1 sky130_fd_sc_hd__fill_4$1
XFILLER_27_573 vssd1 vccd1 vccd1 vssd1 sky130_ef_sc_hd__decap_40_12$1
XFILLER_14_245 vssd1 vccd1 vccd1 vssd1 sky130_fd_sc_hd__fill_4$1
XFILLER_42_543 vccd1 vssd1 vccd1 vssd1 sky130_fd_sc_hd__fill_1$1
XFILLER_120_83 vccd1 vssd1 vccd1 vssd1 sky130_fd_sc_hd__fill_1$1
XFILLER_9_39 vssd1 vccd1 vccd1 vssd1 sky130_ef_sc_hd__decap_40_12$1
XFILLER_14_289 vssd1 vccd1 vccd1 vssd1 sky130_ef_sc_hd__decap_40_12$1
XFILLER_80_65 vssd1 vccd1 vccd1 vssd1 sky130_ef_sc_hd__decap_40_12$1
XFILLER_30_749 vssd1 vccd1 vccd1 vssd1 sky130_fd_sc_hd__fill_4$1
XTAP_TAPCELL_ROW_12_479 vccd1 vssd1 sky130_fd_sc_hd__tapvpwrvgnd_1$1
XFILLER_127_125 vssd1 vccd1 vccd1 vssd1 sky130_ef_sc_hd__decap_40_12$1
XFILLER_10_473 vssd1 vccd1 vccd1 vssd1 sky130_fd_sc_hd__fill_2$1
XFILLER_6_433 vssd1 vccd1 vccd1 vssd1 sky130_ef_sc_hd__decap_40_12$1
XFILLER_13_81 vssd1 vccd1 vccd1 vssd1 sky130_ef_sc_hd__decap_40_12$1
XFILLER_129_81 vssd1 vccd1 vccd1 vssd1 sky130_ef_sc_hd__decap_40_12$1
XFILLER_127_169 vssd1 vccd1 vccd1 vssd1 sky130_ef_sc_hd__decap_40_12$1
XFILLER_108_361 vssd1 vccd1 vccd1 vssd1 sky130_fd_sc_hd__fill_2$1
XTAP_TAPCELL_ROW_94_1710 vccd1 vssd1 sky130_fd_sc_hd__tapvpwrvgnd_1$1
XFILLER_6_477 vssd1 vccd1 vccd1 vssd1 sky130_ef_sc_hd__decap_40_12$1
XFILLER_124_821 vssd1 vccd1 vccd1 vssd1 sky130_fd_sc_hd__fill_4$1
XFILLER_97_727 vccd1 vssd1 vccd1 vssd1 sky130_fd_sc_hd__fill_1$1
XFILLER_111_537 vssd1 vccd1 vccd1 vssd1 sky130_ef_sc_hd__decap_40_12$1
XFILLER_111_559 vccd1 vssd1 vccd1 vssd1 sky130_fd_sc_hd__fill_1$1
X_1230_ _1645_/Q _1230_/X _1276_/B vssd1 vccd1 vccd1 vssd1 sky130_fd_sc_hd__or2_1$1
XFILLER_1_193 vssd1 vccd1 vccd1 vssd1 sky130_ef_sc_hd__decap_40_12$1
Xclkbuf_leaf_26_wb_clk_i _1740_/CLK clkbuf_2_3__f_wb_clk_i/X vssd1 vccd1 vccd1 vssd1
+ sky130_fd_sc_hd__clkbuf_8$1
X_1161_ _1421_/C1 _1160_/X _1189_/A2 hold197/X _1611_/D vssd1 vccd1 vccd1 vssd1 sky130_fd_sc_hd__o211a_1$1
XFILLER_92_421 vssd1 vccd1 vccd1 vssd1 sky130_ef_sc_hd__decap_40_12$1
XFILLER_37_337 vssd1 vccd1 vccd1 vssd1 sky130_ef_sc_hd__decap_40_12$1
XTAP_TAPCELL_ROW_121_2117 vccd1 vssd1 sky130_fd_sc_hd__tapvpwrvgnd_1$1
XFILLER_92_465 vssd1 vccd1 vccd1 vssd1 sky130_fd_sc_hd__fill_2$1
XFILLER_52_307 vccd1 vssd1 vccd1 vssd1 sky130_fd_sc_hd__fill_1$1
X_1092_ _1796_/A _1092_/X _1122_/B vssd1 vccd1 vccd1 vssd1 sky130_fd_sc_hd__or2_1$1
XFILLER_80_627 vssd1 vccd1 vccd1 vssd1 sky130_ef_sc_hd__decap_40_12$1
XFILLER_64_189 vssd1 vccd1 vccd1 vssd1 sky130_fd_sc_hd__fill_4$1
XFILLER_61_841 vccd1 vssd1 vccd1 vssd1 sky130_fd_sc_hd__fill_1$1
XTAP_TAPCELL_ROW_103_1850 vccd1 vssd1 sky130_fd_sc_hd__tapvpwrvgnd_1$1
XFILLER_21_727 vccd1 vssd1 vccd1 vssd1 sky130_fd_sc_hd__fill_1$1
X_0945_ _0945_/A _0945_/X _0945_/B _0945_/C vccd1 vssd1 vccd1 vssd1 sky130_fd_sc_hd__or3_1$1
XFILLER_119_615 vccd1 vssd1 vccd1 vssd1 sky130_fd_sc_hd__fill_1$1
XTAP_TAPCELL_ROW_31_766 vccd1 vssd1 sky130_fd_sc_hd__tapvpwrvgnd_1$1
XTAP_TAPCELL_ROW_119_2079 vccd1 vssd1 sky130_fd_sc_hd__tapvpwrvgnd_1$1
X_0876_ _1753_/Q _0881_/B1 _0876_/X _1657_/Q _1213_/A vccd1 vssd1 vccd1 vssd1 sky130_fd_sc_hd__a22o_1$1
XFILLER_9_293 vssd1 vccd1 vccd1 vssd1 sky130_ef_sc_hd__decap_40_12$1
XFILLER_127_670 vssd1 vccd1 vccd1 vssd1 sky130_fd_sc_hd__fill_2$1
Xclkload30 _1726_/CLK clkload30/Y vccd1 vssd1 vccd1 vssd1 sky130_fd_sc_hd__clkinvlp_4$1
XFILLER_106_309 vssd1 vccd1 vccd1 vssd1 sky130_ef_sc_hd__decap_40_12$1
Xclkload41 _1740_/CLK clkload41/Y vccd1 vssd1 vccd1 vssd1 sky130_fd_sc_hd__clkinvlp_4$1
XTAP_TAPCELL_ROW_132_2279 vccd1 vssd1 sky130_fd_sc_hd__tapvpwrvgnd_1$1
XFILLER_130_813 vssd1 vccd1 vccd1 vssd1 sky130_ef_sc_hd__decap_40_12$1
XFILLER_125_39 vssd1 vccd1 vccd1 vssd1 sky130_ef_sc_hd__decap_40_12$1
XFILLER_88_749 vssd1 vccd1 vccd1 vssd1 sky130_fd_sc_hd__fill_4$1
XFILLER_87_237 vssd1 vccd1 vccd1 vssd1 sky130_ef_sc_hd__decap_40_12$1
X_1428_ _1849_/A _1428_/X _1464_/B vssd1 vccd1 vccd1 vssd1 sky130_fd_sc_hd__or2_1$1
XFILLER_18_15 vssd1 vccd1 vccd1 vssd1 sky130_ef_sc_hd__decap_40_12$1
XFILLER_110_581 vssd1 vccd1 vccd1 vssd1 sky130_fd_sc_hd__fill_4$1
XFILLER_95_281 vssd1 vccd1 vccd1 vssd1 sky130_ef_sc_hd__decap_40_12$1
X_1359_ _1421_/C1 _1358_/X _1409_/A2 hold197/X _1707_/D vssd1 vccd1 vccd1 vssd1 sky130_fd_sc_hd__o211a_1$1
XFILLER_56_657 vssd1 vccd1 vccd1 vssd1 sky130_ef_sc_hd__decap_40_12$1
XFILLER_55_167 vccd1 vssd1 vccd1 vssd1 sky130_fd_sc_hd__fill_1$1
XTAP_TAPCELL_ROW_48_1019 vccd1 vssd1 sky130_fd_sc_hd__tapvpwrvgnd_1$1
XFILLER_71_638 vssd1 vccd1 vccd1 vssd1 sky130_ef_sc_hd__decap_40_12$1
XTAP_TAPCELL_ROW_39_888 vccd1 vssd1 sky130_fd_sc_hd__tapvpwrvgnd_1$1
XFILLER_43_329 vssd1 vccd1 vccd1 vssd1 sky130_fd_sc_hd__fill_4$1
XFILLER_70_137 vssd1 vccd1 vccd1 vssd1 sky130_fd_sc_hd__fill_2$1
XTAP_TAPCELL_ROW_19_590 vccd1 vssd1 sky130_fd_sc_hd__tapvpwrvgnd_1$1
XTAP_TAPCELL_ROW_61_1219 vccd1 vssd1 sky130_fd_sc_hd__tapvpwrvgnd_1$1
XTAP_TAPCELL_ROW_61_1208 vccd1 vssd1 sky130_fd_sc_hd__tapvpwrvgnd_1$1
XFILLER_51_373 vssd1 vccd1 vccd1 vssd1 sky130_ef_sc_hd__decap_40_12$1
XFILLER_24_587 vccd1 vssd1 vccd1 vssd1 sky130_fd_sc_hd__fill_1$1
XFILLER_11_237 vssd1 vccd1 vccd1 vssd1 sky130_ef_sc_hd__decap_40_12$1
XFILLER_12_749 vssd1 vccd1 vccd1 vssd1 sky130_fd_sc_hd__fill_4$1
Xclkload2 clkload2/X clkload2/A vssd1 vccd1 vccd1 vssd1 sky130_fd_sc_hd__clkbuf_4$1
XFILLER_137_445 vssd1 vccd1 vccd1 vssd1 sky130_fd_sc_hd__fill_2$1
XFILLER_109_125 vssd1 vccd1 vccd1 vssd1 sky130_ef_sc_hd__decap_40_12$1
XFILLER_137_467 vccd1 vssd1 vccd1 vssd1 sky130_fd_sc_hd__fill_1$1
XFILLER_125_629 vssd1 vccd1 vccd1 vssd1 sky130_ef_sc_hd__decap_40_12$1
XFILLER_109_169 vssd1 vccd1 vccd1 vssd1 sky130_ef_sc_hd__decap_40_12$1
XFILLER_124_139 vccd1 vssd1 vccd1 vssd1 sky130_fd_sc_hd__fill_1$1
XFILLER_106_821 vssd1 vccd1 vccd1 vssd1 sky130_fd_sc_hd__fill_2$1
XTAP_TAPCELL_ROW_76_1440 vccd1 vssd1 sky130_fd_sc_hd__tapvpwrvgnd_1$1
XFILLER_133_662 vssd1 vccd1 vccd1 vssd1 sky130_fd_sc_hd__fill_8$1
XFILLER_3_447 vccd1 vssd1 vccd1 vssd1 sky130_fd_sc_hd__fill_1$1
XFILLER_133_673 vssd1 vccd1 vccd1 vssd1 sky130_ef_sc_hd__decap_40_12$1
XFILLER_120_301 vssd1 vccd1 vccd1 vssd1 sky130_fd_sc_hd__fill_4$1
XFILLER_105_375 vccd1 vssd1 vccd1 vssd1 sky130_fd_sc_hd__fill_1$1
XFILLER_79_727 vccd1 vssd1 vccd1 vssd1 sky130_fd_sc_hd__fill_1$1
XFILLER_59_55 vccd1 vssd1 vccd1 vssd1 sky130_fd_sc_hd__fill_1$1
Xfanout250 _0949_/A vccd1 vssd1 wire252/X vccd1 vssd1 sky130_fd_sc_hd__buf_6$1
XFILLER_120_345 vssd1 vccd1 vccd1 vssd1 sky130_ef_sc_hd__decap_40_12$1
Xfanout272 _1437_/C1 vccd1 vssd1 _1417_/C1 vccd1 vssd1 sky130_fd_sc_hd__buf_4$1
Xfanout261 _1091_/C1 vccd1 vssd1 _1305_/C1 vccd1 vssd1 sky130_fd_sc_hd__buf_4$1
XFILLER_87_793 vssd1 vccd1 vccd1 vssd1 sky130_fd_sc_hd__fill_2$1
XFILLER_74_410 vssd1 vccd1 vccd1 vssd1 sky130_fd_sc_hd__fill_8$1
XFILLER_74_421 vssd1 vccd1 vccd1 vssd1 sky130_ef_sc_hd__decap_40_12$1
XFILLER_19_337 vssd1 vccd1 vccd1 vssd1 sky130_ef_sc_hd__decap_40_12$1
XFILLER_34_307 vccd1 vssd1 vccd1 vssd1 sky130_fd_sc_hd__fill_1$1
XFILLER_46_189 vssd1 vccd1 vccd1 vssd1 sky130_fd_sc_hd__fill_4$1
XFILLER_131_93 vssd1 vccd1 vccd1 vssd1 sky130_ef_sc_hd__decap_40_12$1
XFILLER_61_137 vssd1 vccd1 vccd1 vssd1 sky130_ef_sc_hd__decap_40_12$1
XTAP_TAPCELL_ROW_17_549 vccd1 vssd1 sky130_fd_sc_hd__tapvpwrvgnd_1$1
XFILLER_43_841 vccd1 vssd1 vccd1 vssd1 sky130_fd_sc_hd__fill_1$1
XFILLER_30_513 vssd1 vccd1 vccd1 vssd1 sky130_ef_sc_hd__decap_40_12$1
XFILLER_30_557 vssd1 vccd1 vccd1 vssd1 sky130_ef_sc_hd__decap_40_12$1
XFILLER_128_489 vssd1 vccd1 vccd1 vssd1 sky130_ef_sc_hd__decap_40_12$1
XFILLER_7_753 vssd1 vccd1 vccd1 vssd1 sky130_ef_sc_hd__decap_40_12$1
XFILLER_7_797 vssd1 vccd1 vccd1 vssd1 sky130_ef_sc_hd__decap_40_12$1
XFILLER_130_109 vssd1 vccd1 vccd1 vssd1 sky130_ef_sc_hd__decap_40_12$1
XFILLER_123_161 vssd1 vccd1 vccd1 vssd1 sky130_fd_sc_hd__fill_4$1
XFILLER_112_813 vssd1 vccd1 vccd1 vssd1 sky130_ef_sc_hd__decap_40_12$1
XFILLER_97_557 vssd1 vccd1 vccd1 vssd1 sky130_fd_sc_hd__fill_2$1
XFILLER_69_237 vssd1 vccd1 vccd1 vssd1 sky130_ef_sc_hd__decap_40_12$1
X_1213_ _1213_/Y _1213_/A _1411_/B vssd1 vccd1 vccd1 vssd1 sky130_fd_sc_hd__nand2_2$1
XFILLER_27_3 vssd1 vccd1 vccd1 vssd1 sky130_ef_sc_hd__decap_40_12$1
XFILLER_38_613 vssd1 vccd1 vccd1 vssd1 sky130_ef_sc_hd__decap_40_12$1
XFILLER_93_741 vssd1 vccd1 vccd1 vssd1 sky130_ef_sc_hd__decap_40_12$1
XFILLER_78_793 vssd1 vccd1 vccd1 vssd1 sky130_ef_sc_hd__decap_40_12$1
XFILLER_77_281 vssd1 vccd1 vccd1 vssd1 sky130_ef_sc_hd__decap_40_12$1
X_1144_ _1604_/Q _1144_/X _1144_/B vssd1 vccd1 vccd1 vssd1 sky130_fd_sc_hd__or2_1$1
XFILLER_92_251 vccd1 vssd1 vccd1 vssd1 sky130_fd_sc_hd__fill_1$1
XFILLER_1_51 vssd1 vccd1 vccd1 vssd1 sky130_fd_sc_hd__fill_4$1
XFILLER_38_657 vssd1 vccd1 vccd1 vssd1 sky130_ef_sc_hd__decap_40_12$1
X_1075_ _1409_/C1 _1074_/X _1079_/A2 hold109/X _1570_/D vssd1 vccd1 vccd1 vssd1 sky130_fd_sc_hd__o211a_1$1
XFILLER_93_785 vssd1 vccd1 vccd1 vssd1 sky130_ef_sc_hd__decap_40_12$1
XFILLER_25_329 vssd1 vccd1 vccd1 vssd1 sky130_fd_sc_hd__fill_4$1
XTAP_TAPCELL_ROW_36_836 vccd1 vssd1 sky130_fd_sc_hd__tapvpwrvgnd_1$1
XFILLER_37_167 vccd1 vssd1 vccd1 vssd1 sky130_fd_sc_hd__fill_1$1
XFILLER_80_435 vccd1 vssd1 vccd1 vssd1 sky130_fd_sc_hd__fill_1$1
XFILLER_52_137 vssd1 vccd1 vccd1 vssd1 sky130_fd_sc_hd__fill_2$1
XTAP_TAPCELL_ROW_36_847 vccd1 vssd1 sky130_fd_sc_hd__tapvpwrvgnd_1$1
XTAP_TAPCELL_ROW_101_1809 vccd1 vssd1 sky130_fd_sc_hd__tapvpwrvgnd_1$1
XPHY_EDGE_ROW_80_Left_219 vccd1 vssd1 vccd1 vssd1 sky130_fd_sc_hd__decap_3$1
XFILLER_33_373 vssd1 vccd1 vccd1 vssd1 sky130_ef_sc_hd__decap_40_12$1
XFILLER_21_557 vssd1 vccd1 vccd1 vssd1 sky130_fd_sc_hd__fill_2$1
XTAP_TAPCELL_ROW_134_2308 vccd1 vssd1 sky130_fd_sc_hd__tapvpwrvgnd_1$1
XFILLER_134_404 vssd1 vccd1 vccd1 vssd1 sky130_fd_sc_hd__fill_4$1
X_0928_ _0752_/A _1505_/D _0924_/X _1475_/C1 _1505_/Q _0927_/X vssd1 vccd1 vccd1 vssd1
+ sky130_fd_sc_hd__o221a_1$1
XFILLER_134_415 vssd1 vccd1 vccd1 vssd1 sky130_fd_sc_hd__fill_4$1
XFILLER_106_139 vccd1 vssd1 vccd1 vssd1 sky130_fd_sc_hd__fill_1$1
X_0859_ _0866_/B1 _1558_/Q _0858_/X _0859_/X vccd1 vssd1 vccd1 vssd1 sky130_fd_sc_hd__a21o_1$1
XFILLER_20_27 vccd1 vssd1 vccd1 vssd1 sky130_fd_sc_hd__fill_1$1
XFILLER_136_27 vccd1 vssd1 vccd1 vssd1 sky130_fd_sc_hd__fill_1$1
XTAP_TAPCELL_ROW_58_1170 vccd1 vssd1 sky130_fd_sc_hd__tapvpwrvgnd_1$1
XFILLER_121_109 vssd1 vccd1 vccd1 vssd1 sky130_fd_sc_hd__fill_2$1
XFILLER_115_673 vssd1 vccd1 vccd1 vssd1 sky130_ef_sc_hd__decap_40_12$1
XFILLER_103_813 vssd1 vccd1 vccd1 vssd1 sky130_fd_sc_hd__fill_8$1
XFILLER_102_301 vssd1 vccd1 vccd1 vssd1 sky130_fd_sc_hd__fill_4$1
XFILLER_88_513 vssd1 vccd1 vccd1 vssd1 sky130_fd_sc_hd__fill_8$1
XFILLER_0_417 vssd1 vccd1 vccd1 vssd1 sky130_fd_sc_hd__fill_2$1
Xhold14 hold14/A hold14/X vssd1 vccd1 vccd1 vssd1 sky130_fd_sc_hd__dlygate4sd3_1$1
XFILLER_102_345 vssd1 vccd1 vccd1 vssd1 sky130_ef_sc_hd__decap_40_12$1
XFILLER_88_568 vccd1 vssd1 vccd1 vssd1 sky130_fd_sc_hd__fill_1$1
XFILLER_0_439 vssd1 vccd1 vccd1 vssd1 sky130_fd_sc_hd__fill_8$1
Xhold36 hold36/A hold36/X vssd1 vccd1 vccd1 vssd1 sky130_fd_sc_hd__dlygate4sd3_1$1
Xhold25 hold25/A hold25/X vssd1 vccd1 vccd1 vssd1 sky130_fd_sc_hd__dlygate4sd3_1$1
Xhold47 hold47/A hold47/X vssd1 vccd1 vccd1 vssd1 sky130_fd_sc_hd__dlygate4sd3_1$1
XTAP_TAPCELL_ROW_71_1370 vccd1 vssd1 sky130_fd_sc_hd__tapvpwrvgnd_1$1
XFILLER_29_69 vssd1 vccd1 vccd1 vssd1 sky130_ef_sc_hd__decap_40_12$1
XFILLER_29_613 vssd1 vccd1 vccd1 vssd1 sky130_fd_sc_hd__fill_2$1
Xhold58 wbs_dat_i[22] hold58/X vssd1 vccd1 vccd1 vssd1 sky130_fd_sc_hd__dlygate4sd3_1$1
Xhold69 hold69/A hold69/X vssd1 vccd1 vccd1 vssd1 sky130_fd_sc_hd__dlygate4sd3_1$1
XFILLER_102_389 vssd1 vccd1 vccd1 vssd1 sky130_ef_sc_hd__decap_40_12$1
XFILLER_56_421 vssd1 vccd1 vccd1 vssd1 sky130_ef_sc_hd__decap_40_12$1
XFILLER_83_273 vssd1 vccd1 vccd1 vssd1 sky130_fd_sc_hd__fill_4$1
XFILLER_71_413 vssd1 vccd1 vccd1 vssd1 sky130_ef_sc_hd__decap_40_12$1
XFILLER_16_307 vccd1 vssd1 vccd1 vssd1 sky130_fd_sc_hd__fill_1$1
XFILLER_28_189 vssd1 vccd1 vccd1 vssd1 sky130_fd_sc_hd__fill_4$1
XPHY_EDGE_ROW_119_Left_258 vccd1 vssd1 vccd1 vssd1 sky130_fd_sc_hd__decap_3$1
XFILLER_25_841 vccd1 vssd1 vccd1 vssd1 sky130_fd_sc_hd__fill_1$1
XFILLER_43_137 vssd1 vccd1 vccd1 vssd1 sky130_ef_sc_hd__decap_40_12$1
XFILLER_45_57 vssd1 vccd1 vccd1 vssd1 sky130_ef_sc_hd__decap_40_12$1
XFILLER_52_671 vccd1 vssd1 vccd1 vssd1 sky130_fd_sc_hd__fill_1$1
XTAP_TAPCELL_ROW_14_508 vccd1 vssd1 sky130_fd_sc_hd__tapvpwrvgnd_1$1
XFILLER_40_811 vccd1 vssd1 vccd1 vssd1 sky130_fd_sc_hd__fill_1$1
XFILLER_51_181 vssd1 vccd1 vccd1 vssd1 sky130_ef_sc_hd__decap_40_12$1
XFILLER_12_513 vssd1 vccd1 vccd1 vssd1 sky130_ef_sc_hd__decap_40_12$1
XFILLER_131_3 vssd1 vccd1 vccd1 vssd1 sky130_ef_sc_hd__decap_40_12$1
XFILLER_12_557 vssd1 vccd1 vccd1 vssd1 sky130_ef_sc_hd__decap_40_12$1
XFILLER_137_220 vssd1 vccd1 vccd1 vssd1 sky130_fd_sc_hd__fill_4$1
XFILLER_6_29 vssd1 vccd1 vccd1 vssd1 sky130_ef_sc_hd__decap_40_12$1
XFILLER_4_701 vssd1 vccd1 vccd1 vssd1 sky130_ef_sc_hd__decap_40_12$1
XPHY_EDGE_ROW_128_Left_267 vccd1 vssd1 vccd1 vssd1 sky130_fd_sc_hd__decap_3$1
XFILLER_112_109 vssd1 vccd1 vccd1 vssd1 sky130_ef_sc_hd__decap_40_12$1
XFILLER_105_161 vssd1 vccd1 vccd1 vssd1 sky130_fd_sc_hd__fill_4$1
XFILLER_3_277 vssd1 vccd1 vccd1 vssd1 sky130_fd_sc_hd__fill_2$1
XFILLER_79_557 vssd1 vccd1 vccd1 vssd1 sky130_fd_sc_hd__fill_2$1
XFILLER_120_153 vssd1 vccd1 vccd1 vssd1 sky130_ef_sc_hd__decap_40_12$1
XFILLER_94_505 vssd1 vccd1 vccd1 vssd1 sky130_ef_sc_hd__decap_40_12$1
XFILLER_86_53 vssd1 vccd1 vccd1 vssd1 sky130_ef_sc_hd__decap_40_12$1
XFILLER_120_197 vssd1 vccd1 vccd1 vssd1 sky130_ef_sc_hd__decap_40_12$1
XTAP_TAPCELL_ROW_89_1631 vccd1 vssd1 sky130_fd_sc_hd__tapvpwrvgnd_1$1
XFILLER_87_590 vssd1 vccd1 vccd1 vssd1 sky130_ef_sc_hd__decap_40_12$1
XFILLER_86_97 vssd1 vccd1 vccd1 vssd1 sky130_ef_sc_hd__decap_40_12$1
XFILLER_59_281 vssd1 vccd1 vccd1 vssd1 sky130_ef_sc_hd__decap_40_12$1
XTAP_TAPCELL_ROW_89_1642 vccd1 vssd1 sky130_fd_sc_hd__tapvpwrvgnd_1$1
XFILLER_75_774 vccd1 vssd1 vccd1 vssd1 sky130_fd_sc_hd__fill_1$1
XFILLER_47_443 vssd1 vccd1 vccd1 vssd1 sky130_fd_sc_hd__fill_4$1
XPHY_EDGE_ROW_137_Left_276 vccd1 vssd1 vccd1 vssd1 sky130_fd_sc_hd__decap_3$1
XFILLER_75_785 vssd1 vccd1 vccd1 vssd1 sky130_ef_sc_hd__decap_40_12$1
XFILLER_74_251 vccd1 vssd1 vccd1 vssd1 sky130_fd_sc_hd__fill_1$1
XFILLER_62_413 vssd1 vccd1 vccd1 vssd1 sky130_fd_sc_hd__fill_4$1
XFILLER_19_167 vccd1 vssd1 vccd1 vssd1 sky130_fd_sc_hd__fill_1$1
XFILLER_62_457 vssd1 vccd1 vccd1 vssd1 sky130_ef_sc_hd__decap_40_12$1
XFILLER_34_137 vssd1 vccd1 vccd1 vssd1 sky130_fd_sc_hd__fill_2$1
XFILLER_43_671 vccd1 vssd1 vccd1 vssd1 sky130_fd_sc_hd__fill_1$1
XFILLER_15_373 vssd1 vccd1 vccd1 vssd1 sky130_ef_sc_hd__decap_40_12$1
XFILLER_30_321 vssd1 vccd1 vccd1 vssd1 sky130_ef_sc_hd__decap_40_12$1
XFILLER_43_682 vssd1 vccd1 vccd1 vssd1 sky130_ef_sc_hd__decap_40_12$1
XFILLER_129_721 vssd1 vccd1 vccd1 vssd1 sky130_fd_sc_hd__fill_4$1
X_1831_ _1831_/A _1831_/X vssd1 vccd1 vccd1 vssd1 sky130_fd_sc_hd__clkbuf_2$1
XFILLER_30_365 vssd1 vccd1 vccd1 vssd1 sky130_ef_sc_hd__decap_40_12$1
XFILLER_129_765 vssd1 vccd1 vccd1 vssd1 sky130_ef_sc_hd__decap_40_12$1
XFILLER_128_253 vssd1 vccd1 vccd1 vssd1 sky130_ef_sc_hd__decap_40_12$1
X_1762_ _1762_/Q _1762_/CLK _1762_/D vccd1 vssd1 vccd1 vssd1 sky130_fd_sc_hd__dfxtp_1$1
XTAP_TAPCELL_ROW_116_2038 vccd1 vssd1 sky130_fd_sc_hd__tapvpwrvgnd_1$1
X_1693_ hold94/A _1752_/CLK _1693_/D vccd1 vssd1 vccd1 vssd1 sky130_fd_sc_hd__dfxtp_1$1
XFILLER_7_561 vssd1 vccd1 vccd1 vssd1 sky130_ef_sc_hd__decap_40_12$1
XFILLER_116_448 vssd1 vccd1 vccd1 vssd1 sky130_fd_sc_hd__fill_8$1
XFILLER_103_109 vssd1 vccd1 vccd1 vssd1 sky130_fd_sc_hd__fill_2$1
XFILLER_98_811 vccd1 vssd1 vccd1 vssd1 sky130_fd_sc_hd__fill_1$1
Xclkbuf_leaf_41_wb_clk_i clkload4/A clkload0/A vssd1 vccd1 vccd1 vssd1 sky130_fd_sc_hd__clkbuf_8$1
XFILLER_112_643 vccd1 vssd1 vccd1 vssd1 sky130_fd_sc_hd__fill_1$1
XFILLER_112_687 vssd1 vccd1 vccd1 vssd1 sky130_ef_sc_hd__decap_40_12$1
XTAP_TAPCELL_ROW_111_1971 vccd1 vssd1 sky130_fd_sc_hd__tapvpwrvgnd_1$1
XTAP_TAPCELL_ROW_111_1960 vccd1 vssd1 sky130_fd_sc_hd__tapvpwrvgnd_1$1
XFILLER_85_505 vssd1 vccd1 vccd1 vssd1 sky130_ef_sc_hd__decap_40_12$1
XFILLER_66_730 vssd1 vccd1 vccd1 vssd1 sky130_ef_sc_hd__decap_40_12$1
XFILLER_38_421 vssd1 vccd1 vccd1 vssd1 sky130_ef_sc_hd__decap_40_12$1
XFILLER_122_29 vssd1 vccd1 vccd1 vssd1 sky130_ef_sc_hd__decap_40_12$1
X_1127_ _1463_/C1 _1126_/X _1145_/A2 hold59/X _1595_/D vssd1 vccd1 vccd1 vssd1 sky130_fd_sc_hd__o211a_1$1
XFILLER_65_273 vssd1 vccd1 vccd1 vssd1 sky130_fd_sc_hd__fill_4$1
XFILLER_80_221 vssd1 vccd1 vccd1 vssd1 sky130_ef_sc_hd__decap_40_12$1
XFILLER_25_137 vssd1 vccd1 vccd1 vssd1 sky130_ef_sc_hd__decap_40_12$1
X_1058_ _1058_/A _1058_/X _1078_/B vssd1 vccd1 vccd1 vssd1 sky130_fd_sc_hd__or2_1$1
XFILLER_81_777 vssd1 vccd1 vccd1 vssd1 sky130_fd_sc_hd__fill_4$1
XFILLER_80_265 vssd1 vccd1 vccd1 vssd1 sky130_ef_sc_hd__decap_40_12$1
XFILLER_15_27 vssd1 vccd1 vccd1 vssd1 sky130_ef_sc_hd__decap_40_12$1
XFILLER_22_811 vccd1 vssd1 vccd1 vssd1 sky130_fd_sc_hd__fill_1$1
XFILLER_33_181 vssd1 vccd1 vccd1 vssd1 sky130_ef_sc_hd__decap_40_12$1
XFILLER_31_15 vssd1 vccd1 vccd1 vssd1 sky130_ef_sc_hd__decap_40_12$1
XFILLER_135_735 vccd1 vssd1 vccd1 vssd1 sky130_fd_sc_hd__fill_1$1
XFILLER_135_768 vssd1 vccd1 vccd1 vssd1 sky130_ef_sc_hd__decap_40_12$1
XFILLER_134_245 vssd1 vccd1 vccd1 vssd1 sky130_fd_sc_hd__fill_4$1
XPHY_EDGE_ROW_1_Right_1 vccd1 vssd1 vccd1 vssd1 sky130_fd_sc_hd__decap_3$1
XFILLER_134_289 vssd1 vccd1 vccd1 vssd1 sky130_ef_sc_hd__decap_40_12$1
Xoutput59 _1841_/X analog_ctrl[108] vssd1 vccd1 vccd1 vssd1 sky130_fd_sc_hd__buf_12$1
XFILLER_115_492 vssd1 vccd1 vccd1 vssd1 sky130_ef_sc_hd__decap_40_12$1
XFILLER_88_321 vssd1 vccd1 vccd1 vssd1 sky130_ef_sc_hd__decap_40_12$1
XFILLER_130_451 vssd1 vccd1 vccd1 vssd1 sky130_ef_sc_hd__decap_40_12$1
XFILLER_103_665 vssd1 vccd1 vccd1 vssd1 sky130_fd_sc_hd__fill_4$1
XFILLER_102_153 vssd1 vccd1 vccd1 vssd1 sky130_ef_sc_hd__decap_40_12$1
XFILLER_88_365 vssd1 vccd1 vccd1 vssd1 sky130_fd_sc_hd__fill_2$1
XFILLER_102_197 vssd1 vccd1 vccd1 vssd1 sky130_ef_sc_hd__decap_40_12$1
XFILLER_57_741 vssd1 vccd1 vccd1 vssd1 sky130_fd_sc_hd__fill_4$1
XFILLER_84_560 vssd1 vccd1 vccd1 vssd1 sky130_ef_sc_hd__decap_40_12$1
XFILLER_56_251 vccd1 vssd1 vccd1 vssd1 sky130_fd_sc_hd__fill_1$1
XFILLER_44_413 vssd1 vccd1 vccd1 vssd1 sky130_fd_sc_hd__fill_4$1
XFILLER_72_744 vssd1 vccd1 vccd1 vssd1 sky130_ef_sc_hd__decap_40_12$1
XFILLER_72_733 vssd1 vccd1 vccd1 vssd1 sky130_fd_sc_hd__fill_2$1
XFILLER_71_221 vssd1 vccd1 vccd1 vssd1 sky130_fd_sc_hd__fill_2$1
XFILLER_16_137 vssd1 vccd1 vccd1 vssd1 sky130_fd_sc_hd__fill_2$1
XTAP_TAPCELL_ROW_84_1561 vccd1 vssd1 sky130_fd_sc_hd__tapvpwrvgnd_1$1
XFILLER_72_777 vssd1 vccd1 vccd1 vssd1 sky130_fd_sc_hd__fill_2$1
XFILLER_25_671 vccd1 vssd1 vccd1 vssd1 sky130_fd_sc_hd__fill_1$1
XFILLER_72_77 vssd1 vccd1 vccd1 vssd1 sky130_fd_sc_hd__fill_4$1
XFILLER_12_321 vssd1 vccd1 vccd1 vssd1 sky130_ef_sc_hd__decap_40_12$1
XTAP_TAPCELL_ROW_27_699 vccd1 vssd1 sky130_fd_sc_hd__tapvpwrvgnd_1$1
XFILLER_12_365 vssd1 vccd1 vccd1 vssd1 sky130_ef_sc_hd__decap_40_12$1
XFILLER_40_674 vssd1 vccd1 vccd1 vssd1 sky130_ef_sc_hd__decap_40_12$1
XFILLER_125_223 vccd1 vssd1 vccd1 vssd1 sky130_fd_sc_hd__fill_1$1
XFILLER_4_531 vccd1 vssd1 vccd1 vssd1 sky130_fd_sc_hd__fill_1$1
XFILLER_21_81 vssd1 vccd1 vccd1 vssd1 sky130_ef_sc_hd__decap_40_12$1
XFILLER_137_70 vssd1 vccd1 vccd1 vssd1 sky130_ef_sc_hd__decap_40_12$1
XFILLER_67_505 vssd1 vccd1 vccd1 vssd1 sky130_fd_sc_hd__fill_4$1
XFILLER_94_357 vssd1 vccd1 vccd1 vssd1 sky130_fd_sc_hd__fill_4$1
XFILLER_47_273 vssd1 vccd1 vccd1 vssd1 sky130_fd_sc_hd__fill_4$1
XFILLER_48_774 vssd1 vccd1 vccd1 vssd1 sky130_ef_sc_hd__decap_40_12$1
XFILLER_75_593 vccd1 vssd1 vccd1 vssd1 sky130_fd_sc_hd__fill_1$1
XFILLER_62_221 vssd1 vccd1 vccd1 vssd1 sky130_ef_sc_hd__decap_40_12$1
XFILLER_62_265 vssd1 vccd1 vccd1 vssd1 sky130_ef_sc_hd__decap_40_12$1
XTAP_TAPCELL_ROW_46_986 vccd1 vssd1 sky130_fd_sc_hd__tapvpwrvgnd_1$1
XFILLER_16_693 vssd1 vccd1 vccd1 vssd1 sky130_fd_sc_hd__fill_4$1
XTAP_TAPCELL_ROW_46_997 vccd1 vssd1 sky130_fd_sc_hd__tapvpwrvgnd_1$1
XFILLER_94_3 vssd1 vccd1 vccd1 vssd1 sky130_ef_sc_hd__decap_40_12$1
XFILLER_15_181 vssd1 vccd1 vccd1 vssd1 sky130_ef_sc_hd__decap_40_12$1
XFILLER_31_641 vssd1 vccd1 vccd1 vssd1 sky130_ef_sc_hd__decap_40_12$1
XFILLER_31_685 vssd1 vccd1 vccd1 vssd1 sky130_ef_sc_hd__decap_40_12$1
X_1814_ vccd1 vssd1 _1814_/X _1814_/A vccd1 vssd1 sky130_fd_sc_hd__buf_1$1
XFILLER_30_195 vccd1 vssd1 vccd1 vssd1 sky130_fd_sc_hd__fill_1$1
XFILLER_129_573 vssd1 vccd1 vccd1 vssd1 sky130_fd_sc_hd__fill_4$1
X_1745_ _1853_/A _1747_/CLK _1745_/D vccd1 vssd1 vccd1 vssd1 sky130_fd_sc_hd__dfxtp_1$1
XFILLER_116_245 vssd1 vccd1 vccd1 vssd1 sky130_fd_sc_hd__fill_4$1
XFILLER_7_391 vccd1 vssd1 vccd1 vssd1 sky130_fd_sc_hd__fill_1$1
XFILLER_116_289 vssd1 vccd1 vccd1 vssd1 sky130_ef_sc_hd__decap_40_12$1
XFILLER_104_407 vssd1 vccd1 vccd1 vssd1 sky130_fd_sc_hd__fill_4$1
X_1676_ _1676_/Q clkload9/A _1676_/D vccd1 vssd1 vccd1 vssd1 sky130_fd_sc_hd__dfxtp_1$1
XFILLER_131_237 vssd1 vccd1 vccd1 vssd1 sky130_ef_sc_hd__decap_40_12$1
XTAP_TAPCELL_ROW_129_2229 vccd1 vssd1 sky130_fd_sc_hd__tapvpwrvgnd_1$1
XFILLER_86_825 vccd1 vssd1 vccd1 vssd1 sky130_fd_sc_hd__fill_1$1
XFILLER_133_39 vssd1 vccd1 vccd1 vssd1 sky130_ef_sc_hd__decap_40_12$1
XFILLER_85_335 vccd1 vssd1 vccd1 vssd1 sky130_fd_sc_hd__fill_1$1
XTAP_TAPCELL_ROW_51_1059 vccd1 vssd1 sky130_fd_sc_hd__tapvpwrvgnd_1$1
XFILLER_39_741 vssd1 vccd1 vccd1 vssd1 sky130_fd_sc_hd__fill_4$1
XFILLER_26_15 vssd1 vccd1 vccd1 vssd1 sky130_ef_sc_hd__decap_40_12$1
XFILLER_26_413 vssd1 vccd1 vccd1 vssd1 sky130_fd_sc_hd__fill_4$1
XFILLER_38_251 vccd1 vssd1 vccd1 vssd1 sky130_fd_sc_hd__fill_1$1
XFILLER_39_785 vssd1 vccd1 vccd1 vssd1 sky130_ef_sc_hd__decap_40_12$1
XFILLER_81_541 vssd1 vccd1 vccd1 vssd1 sky130_fd_sc_hd__fill_2$1
XFILLER_54_755 vccd1 vssd1 vccd1 vssd1 sky130_fd_sc_hd__fill_1$1
XFILLER_54_733 vssd1 vccd1 vccd1 vssd1 sky130_ef_sc_hd__decap_40_12$1
XFILLER_53_221 vssd1 vccd1 vccd1 vssd1 sky130_fd_sc_hd__fill_2$1
XFILLER_54_799 vccd1 vssd1 vccd1 vssd1 sky130_fd_sc_hd__fill_1$1
XFILLER_26_457 vssd1 vccd1 vccd1 vssd1 sky130_ef_sc_hd__decap_40_12$1
XFILLER_41_405 vssd1 vccd1 vccd1 vssd1 sky130_ef_sc_hd__decap_40_12$1
XFILLER_41_449 vssd1 vccd1 vccd1 vssd1 sky130_ef_sc_hd__decap_40_12$1
XTAP_TAPCELL_ROW_66_1291 vccd1 vssd1 sky130_fd_sc_hd__tapvpwrvgnd_1$1
XFILLER_22_641 vssd1 vccd1 vccd1 vssd1 sky130_fd_sc_hd__fill_2$1
XTAP_TAPCELL_ROW_24_658 vccd1 vssd1 sky130_fd_sc_hd__tapvpwrvgnd_1$1
XFILLER_10_825 vccd1 vssd1 vccd1 vssd1 sky130_fd_sc_hd__fill_1$1
XFILLER_108_713 vssd1 vccd1 vccd1 vssd1 sky130_ef_sc_hd__decap_40_12$1
XFILLER_5_317 vssd1 vccd1 vccd1 vssd1 sky130_ef_sc_hd__decap_40_12$1
XFILLER_107_223 vccd1 vssd1 vccd1 vssd1 sky130_fd_sc_hd__fill_1$1
XFILLER_135_587 vssd1 vccd1 vccd1 vssd1 sky130_fd_sc_hd__fill_2$1
XFILLER_123_727 vccd1 vssd1 vccd1 vssd1 sky130_fd_sc_hd__fill_1$1
XFILLER_1_501 vssd1 vccd1 vccd1 vssd1 sky130_fd_sc_hd__fill_2$1
XFILLER_107_51 vssd1 vccd1 vccd1 vssd1 sky130_fd_sc_hd__fill_4$1
XFILLER_89_663 vssd1 vccd1 vccd1 vssd1 sky130_fd_sc_hd__fill_8$1
XFILLER_49_505 vssd1 vccd1 vccd1 vssd1 sky130_ef_sc_hd__decap_40_12$1
XFILLER_89_685 vssd1 vccd1 vccd1 vssd1 sky130_ef_sc_hd__decap_40_12$1
XFILLER_67_55 vccd1 vssd1 vccd1 vssd1 sky130_fd_sc_hd__fill_1$1
XFILLER_88_195 vccd1 vssd1 vccd1 vssd1 sky130_fd_sc_hd__fill_1$1
XFILLER_76_357 vssd1 vccd1 vccd1 vssd1 sky130_fd_sc_hd__fill_4$1
XFILLER_91_305 vssd1 vccd1 vccd1 vssd1 sky130_ef_sc_hd__decap_40_12$1
XTAP_TAPCELL_ROW_4_361 vccd1 vssd1 sky130_fd_sc_hd__tapvpwrvgnd_1$1
XFILLER_29_273 vssd1 vccd1 vccd1 vssd1 sky130_fd_sc_hd__fill_4$1
XFILLER_91_349 vssd1 vccd1 vccd1 vssd1 sky130_ef_sc_hd__decap_40_12$1
XFILLER_72_530 vssd1 vccd1 vccd1 vssd1 sky130_fd_sc_hd__fill_2$1
XFILLER_44_221 vssd1 vccd1 vccd1 vssd1 sky130_ef_sc_hd__decap_40_12$1
XFILLER_44_265 vssd1 vccd1 vccd1 vssd1 sky130_ef_sc_hd__decap_40_12$1
XFILLER_45_777 vssd1 vccd1 vccd1 vssd1 sky130_fd_sc_hd__fill_4$1
XTAP_TAPCELL_ROW_43_945 vccd1 vssd1 sky130_fd_sc_hd__tapvpwrvgnd_1$1
XFILLER_60_769 vssd1 vccd1 vccd1 vssd1 sky130_ef_sc_hd__decap_40_12$1
XFILLER_13_641 vssd1 vccd1 vccd1 vssd1 sky130_ef_sc_hd__decap_40_12$1
XFILLER_16_81 vssd1 vccd1 vccd1 vssd1 sky130_fd_sc_hd__fill_2$1
XFILLER_13_685 vssd1 vccd1 vccd1 vssd1 sky130_ef_sc_hd__decap_40_12$1
XFILLER_12_195 vccd1 vssd1 vccd1 vssd1 sky130_fd_sc_hd__fill_1$1
XFILLER_8_133 vssd1 vccd1 vccd1 vssd1 sky130_fd_sc_hd__fill_4$1
XTAP_TAPCELL_ROW_97_1752 vccd1 vssd1 sky130_fd_sc_hd__tapvpwrvgnd_1$1
XFILLER_8_177 vssd1 vccd1 vccd1 vssd1 sky130_ef_sc_hd__decap_40_12$1
XFILLER_126_587 vccd1 vssd1 vccd1 vssd1 sky130_fd_sc_hd__fill_1$1
X_1530_ _1530_/Q _1754_/CLK _1530_/D vccd1 vssd1 vccd1 vssd1 sky130_fd_sc_hd__dfxtp_1$1
XFILLER_4_361 vssd1 vccd1 vccd1 vssd1 sky130_fd_sc_hd__fill_2$1
X_1461_ _1461_/C1 _1460_/X _1465_/A2 hold86/X _1757_/D vssd1 vccd1 vccd1 vssd1 sky130_fd_sc_hd__o211a_1$1
XFILLER_113_237 vssd1 vccd1 vccd1 vssd1 sky130_ef_sc_hd__decap_40_12$1
XFILLER_99_449 vssd1 vccd1 vccd1 vssd1 sky130_ef_sc_hd__decap_40_12$1
X_1392_ hold41/X _1392_/X _1398_/B vssd1 vccd1 vccd1 vssd1 sky130_fd_sc_hd__or2_1$1
XFILLER_122_793 vssd1 vccd1 vccd1 vssd1 sky130_ef_sc_hd__decap_40_12$1
XFILLER_95_633 vssd1 vccd1 vccd1 vssd1 sky130_ef_sc_hd__decap_40_12$1
XFILLER_121_281 vssd1 vccd1 vccd1 vssd1 sky130_ef_sc_hd__decap_40_12$1
XFILLER_94_121 vssd1 vccd1 vccd1 vssd1 sky130_ef_sc_hd__decap_40_12$1
XFILLER_67_335 vccd1 vssd1 vccd1 vssd1 sky130_fd_sc_hd__fill_1$1
XFILLER_94_165 vssd1 vccd1 vccd1 vssd1 sky130_ef_sc_hd__decap_40_12$1
XFILLER_82_305 vssd1 vccd1 vccd1 vssd1 sky130_fd_sc_hd__fill_2$1
XTAP_TAPCELL_ROW_124_2159 vccd1 vssd1 sky130_fd_sc_hd__tapvpwrvgnd_1$1
XFILLER_35_221 vssd1 vccd1 vccd1 vssd1 sky130_fd_sc_hd__fill_2$1
XFILLER_48_593 vccd1 vssd1 vccd1 vssd1 sky130_fd_sc_hd__fill_1$1
XFILLER_51_714 vssd1 vccd1 vccd1 vssd1 sky130_fd_sc_hd__fill_4$1
XFILLER_23_405 vssd1 vccd1 vccd1 vssd1 sky130_ef_sc_hd__decap_40_12$1
XTAP_TAPCELL_ROW_106_1892 vccd1 vssd1 sky130_fd_sc_hd__tapvpwrvgnd_1$1
XFILLER_23_449 vssd1 vccd1 vccd1 vssd1 sky130_ef_sc_hd__decap_40_12$1
XTAP_TAPCELL_ROW_21_617 vccd1 vssd1 sky130_fd_sc_hd__tapvpwrvgnd_1$1
XFILLER_136_307 vccd1 vssd1 vccd1 vssd1 sky130_fd_sc_hd__fill_1$1
Xhold100 _1537_/Q _1006_/A vssd1 vccd1 vccd1 vssd1 sky130_fd_sc_hd__dlygate4sd3_1$1
X_1728_ _1728_/Q _1760_/CLK _1728_/D vccd1 vssd1 vccd1 vssd1 sky130_fd_sc_hd__dfxtp_1$1
Xhold133 _1630_/Q _1198_/A vssd1 vccd1 vccd1 vssd1 sky130_fd_sc_hd__dlygate4sd3_1$1
XFILLER_105_705 vssd1 vccd1 vccd1 vssd1 sky130_fd_sc_hd__fill_2$1
Xhold111 _1748_/Q _1442_/A vssd1 vccd1 vccd1 vssd1 sky130_fd_sc_hd__dlygate4sd3_1$1
Xhold122 _1624_/Q _1186_/A vssd1 vccd1 vccd1 vssd1 sky130_fd_sc_hd__dlygate4sd3_1$1
Xhold144 _1753_/Q _1452_/A vssd1 vccd1 vccd1 vssd1 sky130_fd_sc_hd__dlygate4sd3_1$1
XFILLER_2_309 vssd1 vccd1 vccd1 vssd1 sky130_ef_sc_hd__decap_40_12$1
X_1659_ _1659_/Q _1752_/CLK _1659_/D vccd1 vssd1 vccd1 vssd1 sky130_fd_sc_hd__dfxtp_2$1
Xhold155 input51/X hold155/X vssd1 vccd1 vccd1 vssd1 sky130_fd_sc_hd__dlygate4sd3_1$1
XFILLER_105_749 vccd1 vssd1 vccd1 vssd1 sky130_fd_sc_hd__fill_1$1
XFILLER_105_738 vssd1 vccd1 vccd1 vssd1 sky130_fd_sc_hd__fill_2$1
Xhold177 _1718_/Q _1380_/A vssd1 vccd1 vccd1 vssd1 sky130_fd_sc_hd__dlygate4sd3_1$1
Xhold166 _1679_/Q _1300_/A vssd1 vccd1 vccd1 vssd1 sky130_fd_sc_hd__dlygate4sd3_1$1
XFILLER_132_557 vssd1 vccd1 vccd1 vssd1 sky130_ef_sc_hd__decap_40_12$1
Xhold199 input49/X hold199/X vssd1 vccd1 vccd1 vssd1 sky130_fd_sc_hd__dlygate4sd3_1$1
Xhold188 _1681_/Q _1304_/A vssd1 vccd1 vccd1 vssd1 sky130_fd_sc_hd__dlygate4sd3_1$1
XFILLER_100_421 vssd1 vccd1 vccd1 vssd1 sky130_ef_sc_hd__decap_40_12$1
XFILLER_58_357 vssd1 vccd1 vccd1 vssd1 sky130_fd_sc_hd__fill_4$1
XFILLER_85_165 vssd1 vccd1 vccd1 vssd1 sky130_fd_sc_hd__fill_2$1
XFILLER_73_305 vssd1 vccd1 vccd1 vssd1 sky130_ef_sc_hd__decap_40_12$1
XTAP_TAPCELL_ROW_29_728 vccd1 vssd1 sky130_fd_sc_hd__tapvpwrvgnd_1$1
XFILLER_73_349 vssd1 vccd1 vccd1 vssd1 sky130_ef_sc_hd__decap_40_12$1
XTAP_TAPCELL_ROW_68_1320 vccd1 vssd1 sky130_fd_sc_hd__tapvpwrvgnd_1$1
XTAP_TAPCELL_ROW_1_320 vccd1 vssd1 sky130_fd_sc_hd__tapvpwrvgnd_1$1
XFILLER_26_221 vssd1 vccd1 vccd1 vssd1 sky130_ef_sc_hd__decap_40_12$1
XFILLER_27_733 vssd1 vccd1 vccd1 vssd1 sky130_ef_sc_hd__decap_40_12$1
XTAP_TAPCELL_ROW_29_739 vccd1 vssd1 sky130_fd_sc_hd__tapvpwrvgnd_1$1
XFILLER_37_69 vssd1 vccd1 vccd1 vssd1 sky130_ef_sc_hd__decap_40_12$1
XFILLER_81_382 vccd1 vssd1 vccd1 vssd1 sky130_fd_sc_hd__fill_1$1
XFILLER_26_265 vssd1 vccd1 vccd1 vssd1 sky130_ef_sc_hd__decap_40_12$1
XTAP_TAPCELL_ROW_81_1520 vccd1 vssd1 sky130_fd_sc_hd__tapvpwrvgnd_1$1
XFILLER_53_57 vssd1 vccd1 vccd1 vssd1 sky130_ef_sc_hd__decap_40_12$1
XTAP_TAPCELL_ROW_40_904 vccd1 vssd1 sky130_fd_sc_hd__tapvpwrvgnd_1$1
XFILLER_41_279 vccd1 vssd1 vccd1 vssd1 sky130_fd_sc_hd__fill_1$1
XFILLER_127_329 vssd1 vccd1 vccd1 vssd1 sky130_fd_sc_hd__fill_4$1
XFILLER_10_699 vccd1 vssd1 vccd1 vssd1 sky130_fd_sc_hd__fill_1$1
XFILLER_6_637 vssd1 vccd1 vccd1 vssd1 sky130_fd_sc_hd__fill_4$1
XFILLER_5_125 vssd1 vccd1 vccd1 vssd1 sky130_ef_sc_hd__decap_40_12$1
XFILLER_135_362 vssd1 vccd1 vccd1 vssd1 sky130_fd_sc_hd__fill_4$1
XFILLER_108_587 vccd1 vssd1 vccd1 vssd1 sky130_fd_sc_hd__fill_1$1
XTAP_TAPCELL_ROW_79_1482 vccd1 vssd1 sky130_fd_sc_hd__tapvpwrvgnd_1$1
XFILLER_5_169 vssd1 vccd1 vccd1 vssd1 sky130_ef_sc_hd__decap_40_12$1
XFILLER_118_83 vccd1 vssd1 vccd1 vssd1 sky130_fd_sc_hd__fill_1$1
XTAP_TAPCELL_ROW_9_442 vccd1 vssd1 sky130_fd_sc_hd__tapvpwrvgnd_1$1
XTAP_TAPCELL_ROW_9_431 vccd1 vssd1 sky130_fd_sc_hd__tapvpwrvgnd_1$1
XFILLER_96_419 vccd1 vssd1 vccd1 vssd1 sky130_fd_sc_hd__fill_1$1
XTAP_TAPCELL_ROW_92_1682 vccd1 vssd1 sky130_fd_sc_hd__tapvpwrvgnd_1$1
XFILLER_78_65 vssd1 vccd1 vccd1 vssd1 sky130_ef_sc_hd__decap_40_12$1
XFILLER_103_281 vssd1 vccd1 vccd1 vssd1 sky130_ef_sc_hd__decap_40_12$1
XFILLER_76_121 vssd1 vccd1 vccd1 vssd1 sky130_ef_sc_hd__decap_40_12$1
XFILLER_49_335 vccd1 vssd1 vccd1 vssd1 sky130_fd_sc_hd__fill_1$1
XFILLER_94_53 vssd1 vccd1 vccd1 vssd1 sky130_ef_sc_hd__decap_40_12$1
XFILLER_92_625 vccd1 vssd1 vccd1 vssd1 sky130_fd_sc_hd__fill_1$1
XFILLER_76_165 vssd1 vccd1 vccd1 vssd1 sky130_ef_sc_hd__decap_40_12$1
XFILLER_64_305 vssd1 vccd1 vccd1 vssd1 sky130_fd_sc_hd__fill_2$1
XFILLER_91_113 vssd1 vccd1 vccd1 vssd1 sky130_ef_sc_hd__decap_40_12$1
XFILLER_80_809 vssd1 vccd1 vccd1 vssd1 sky130_fd_sc_hd__fill_2$1
XFILLER_17_221 vssd1 vccd1 vccd1 vssd1 sky130_fd_sc_hd__fill_2$1
XFILLER_94_97 vssd1 vccd1 vccd1 vssd1 sky130_ef_sc_hd__decap_40_12$1
XFILLER_92_669 vssd1 vccd1 vccd1 vssd1 sky130_ef_sc_hd__decap_40_12$1
XFILLER_18_755 vccd1 vssd1 vccd1 vssd1 sky130_fd_sc_hd__fill_1$1
XFILLER_45_541 vssd1 vccd1 vccd1 vssd1 sky130_ef_sc_hd__decap_40_12$1
XFILLER_33_725 vssd1 vccd1 vccd1 vssd1 sky130_fd_sc_hd__fill_2$1
XFILLER_45_585 vssd1 vccd1 vccd1 vssd1 sky130_ef_sc_hd__decap_40_12$1
XFILLER_20_419 vccd1 vssd1 vccd1 vssd1 sky130_fd_sc_hd__fill_1$1
X_0961_ _1289_/C1 _0960_/X _0991_/A2 hold30/X _1514_/D vssd1 vccd1 vccd1 vssd1 sky130_fd_sc_hd__o211a_1$1
X_0892_ _0752_/A _1499_/D _0888_/X _1461_/C1 _1499_/Q _0891_/X vssd1 vccd1 vccd1 vssd1
+ sky130_fd_sc_hd__o221a_1$1
XFILLER_118_307 vccd1 vssd1 vccd1 vssd1 sky130_fd_sc_hd__fill_1$1
XFILLER_127_841 vccd1 vssd1 vccd1 vssd1 sky130_fd_sc_hd__fill_1$1
XFILLER_9_497 vssd1 vccd1 vccd1 vssd1 sky130_fd_sc_hd__fill_4$1
XFILLER_57_3 vssd1 vccd1 vccd1 vssd1 sky130_ef_sc_hd__decap_40_12$1
XFILLER_126_384 vssd1 vccd1 vccd1 vssd1 sky130_ef_sc_hd__decap_40_12$1
XFILLER_114_513 vssd1 vccd1 vccd1 vssd1 sky130_fd_sc_hd__fill_8$1
X_1513_ _1786_/A _1579_/CLK _1513_/D vccd1 vssd1 vccd1 vssd1 sky130_fd_sc_hd__dfxtp_1$1
XFILLER_114_557 vssd1 vccd1 vccd1 vssd1 sky130_fd_sc_hd__fill_4$1
X_1444_ hold42/X _1444_/X _1464_/B vssd1 vccd1 vccd1 vssd1 sky130_fd_sc_hd__or2_1$1
XFILLER_99_279 vccd1 vssd1 vccd1 vssd1 sky130_fd_sc_hd__fill_1$1
XFILLER_95_430 vccd1 vssd1 vccd1 vssd1 sky130_fd_sc_hd__fill_1$1
X_1375_ _1443_/C1 _1374_/X _1399_/A2 hold172/X _1375_/X vssd1 vccd1 vccd1 vssd1 sky130_fd_sc_hd__o211a_1$1
XFILLER_110_785 vccd1 vssd1 vccd1 vssd1 sky130_fd_sc_hd__fill_1$1
XFILLER_68_699 vccd1 vssd1 vccd1 vssd1 sky130_fd_sc_hd__fill_1$1
XFILLER_67_165 vssd1 vccd1 vccd1 vssd1 sky130_fd_sc_hd__fill_2$1
XFILLER_55_305 vssd1 vccd1 vccd1 vssd1 sky130_ef_sc_hd__decap_40_12$1
XTAP_TAPCELL_ROW_108_1921 vccd1 vssd1 sky130_fd_sc_hd__tapvpwrvgnd_1$1
XFILLER_55_349 vssd1 vccd1 vccd1 vssd1 sky130_ef_sc_hd__decap_40_12$1
XFILLER_71_809 vssd1 vccd1 vccd1 vssd1 sky130_fd_sc_hd__fill_2$1
XFILLER_130_29 vssd1 vccd1 vccd1 vssd1 sky130_ef_sc_hd__decap_40_12$1
XFILLER_36_585 vssd1 vccd1 vccd1 vssd1 sky130_fd_sc_hd__fill_2$1
XFILLER_24_769 vssd1 vccd1 vccd1 vssd1 sky130_ef_sc_hd__decap_40_12$1
XTAP_TAPCELL_ROW_63_1250 vccd1 vssd1 sky130_fd_sc_hd__tapvpwrvgnd_1$1
XFILLER_23_27 vssd1 vccd1 vccd1 vssd1 sky130_ef_sc_hd__decap_40_12$1
XFILLER_23_279 vccd1 vssd1 vccd1 vssd1 sky130_fd_sc_hd__fill_1$1
XFILLER_109_329 vssd1 vccd1 vccd1 vssd1 sky130_fd_sc_hd__fill_4$1
XFILLER_105_502 vssd1 vccd1 vccd1 vssd1 sky130_fd_sc_hd__fill_2$1
XFILLER_3_629 vssd1 vccd1 vccd1 vssd1 sky130_ef_sc_hd__decap_40_12$1
XFILLER_120_505 vssd1 vccd1 vccd1 vssd1 sky130_fd_sc_hd__fill_2$1
XFILLER_105_557 vssd1 vccd1 vccd1 vssd1 sky130_fd_sc_hd__fill_2$1
XFILLER_2_139 vccd1 vssd1 vccd1 vssd1 sky130_fd_sc_hd__fill_1$1
XFILLER_132_365 vssd1 vccd1 vccd1 vssd1 sky130_fd_sc_hd__fill_8$1
XFILLER_120_516 vssd1 vccd1 vccd1 vssd1 sky130_ef_sc_hd__decap_40_12$1
XFILLER_99_791 vssd1 vccd1 vccd1 vssd1 sky130_fd_sc_hd__fill_8$1
XFILLER_78_419 vccd1 vssd1 vccd1 vssd1 sky130_fd_sc_hd__fill_1$1
XFILLER_101_741 vssd1 vccd1 vccd1 vssd1 sky130_ef_sc_hd__decap_40_12$1
XFILLER_86_441 vssd1 vccd1 vccd1 vssd1 sky130_ef_sc_hd__decap_40_12$1
XFILLER_59_655 vssd1 vccd1 vccd1 vssd1 sky130_ef_sc_hd__decap_40_12$1
XFILLER_58_121 vssd1 vccd1 vccd1 vssd1 sky130_ef_sc_hd__decap_40_12$1
XPHY_EDGE_ROW_122_Right_122 vccd1 vssd1 vccd1 vssd1 sky130_fd_sc_hd__decap_3$1
XFILLER_101_785 vssd1 vccd1 vccd1 vssd1 sky130_ef_sc_hd__decap_40_12$1
XFILLER_100_251 vccd1 vssd1 vccd1 vssd1 sky130_fd_sc_hd__fill_1$1
XFILLER_58_165 vssd1 vccd1 vccd1 vssd1 sky130_ef_sc_hd__decap_40_12$1
XFILLER_46_305 vssd1 vccd1 vccd1 vssd1 sky130_fd_sc_hd__fill_2$1
XFILLER_104_41 vssd1 vccd1 vccd1 vssd1 sky130_ef_sc_hd__decap_40_12$1
XFILLER_73_113 vssd1 vccd1 vccd1 vssd1 sky130_ef_sc_hd__decap_40_12$1
XFILLER_104_85 vssd1 vccd1 vccd1 vssd1 sky130_ef_sc_hd__decap_40_12$1
XPHY_EDGE_ROW_100_Left_239 vccd1 vssd1 vccd1 vssd1 sky130_fd_sc_hd__decap_3$1
XFILLER_74_669 vssd1 vccd1 vccd1 vssd1 sky130_ef_sc_hd__decap_40_12$1
XFILLER_27_541 vssd1 vccd1 vccd1 vssd1 sky130_ef_sc_hd__decap_40_12$1
XFILLER_82_680 vssd1 vccd1 vccd1 vssd1 sky130_ef_sc_hd__decap_40_12$1
XFILLER_15_725 vssd1 vccd1 vccd1 vssd1 sky130_fd_sc_hd__fill_2$1
XFILLER_27_585 vssd1 vccd1 vccd1 vssd1 sky130_ef_sc_hd__decap_40_12$1
XFILLER_42_533 vssd1 vccd1 vccd1 vssd1 sky130_fd_sc_hd__fill_8$1
XFILLER_80_77 vssd1 vccd1 vccd1 vssd1 sky130_fd_sc_hd__fill_4$1
XFILLER_6_401 vssd1 vccd1 vccd1 vssd1 sky130_ef_sc_hd__decap_40_12$1
XFILLER_127_137 vssd1 vccd1 vccd1 vssd1 sky130_ef_sc_hd__decap_40_12$1
XFILLER_109_841 vccd1 vssd1 vccd1 vssd1 sky130_fd_sc_hd__fill_1$1
XFILLER_6_445 vssd1 vccd1 vccd1 vssd1 sky130_ef_sc_hd__decap_40_12$1
XFILLER_13_93 vssd1 vccd1 vccd1 vssd1 sky130_ef_sc_hd__decap_40_12$1
XFILLER_129_93 vssd1 vccd1 vccd1 vssd1 sky130_ef_sc_hd__decap_40_12$1
XTAP_TAPCELL_ROW_94_1711 vccd1 vssd1 sky130_fd_sc_hd__tapvpwrvgnd_1$1
XFILLER_135_181 vssd1 vccd1 vccd1 vssd1 sky130_ef_sc_hd__decap_40_12$1
XFILLER_6_489 vssd1 vccd1 vccd1 vssd1 sky130_ef_sc_hd__decap_40_12$1
XFILLER_1_161 vssd1 vccd1 vccd1 vssd1 sky130_fd_sc_hd__fill_4$1
XFILLER_111_549 vssd1 vccd1 vccd1 vssd1 sky130_fd_sc_hd__fill_8$1
XFILLER_96_249 vssd1 vccd1 vccd1 vssd1 sky130_fd_sc_hd__fill_2$1
XFILLER_77_441 vssd1 vccd1 vccd1 vssd1 sky130_fd_sc_hd__fill_4$1
X_1160_ _1815_/A _1160_/X _1188_/B vssd1 vccd1 vccd1 vssd1 sky130_fd_sc_hd__or2_1$1
XFILLER_37_305 vssd1 vccd1 vccd1 vssd1 sky130_ef_sc_hd__decap_40_12$1
XFILLER_49_165 vssd1 vccd1 vccd1 vssd1 sky130_fd_sc_hd__fill_2$1
XFILLER_92_433 vssd1 vccd1 vccd1 vssd1 sky130_ef_sc_hd__decap_40_12$1
XFILLER_37_349 vssd1 vccd1 vccd1 vssd1 sky130_ef_sc_hd__decap_40_12$1
XTAP_TAPCELL_ROW_121_2118 vccd1 vssd1 sky130_fd_sc_hd__tapvpwrvgnd_1$1
XFILLER_92_477 vssd1 vccd1 vccd1 vssd1 sky130_fd_sc_hd__fill_8$1
XFILLER_53_809 vssd1 vccd1 vccd1 vssd1 sky130_fd_sc_hd__fill_8$1
X_1091_ _1091_/C1 _1090_/X _1123_/A2 hold61/X _1577_/D vssd1 vccd1 vccd1 vssd1 sky130_fd_sc_hd__o211a_1$1
XFILLER_80_639 vssd1 vccd1 vccd1 vssd1 sky130_fd_sc_hd__fill_4$1
XFILLER_18_585 vssd1 vccd1 vccd1 vssd1 sky130_fd_sc_hd__fill_2$1
XFILLER_45_393 vssd1 vccd1 vccd1 vssd1 sky130_ef_sc_hd__decap_40_12$1
XTAP_TAPCELL_ROW_103_1851 vccd1 vssd1 sky130_fd_sc_hd__tapvpwrvgnd_1$1
XTAP_TAPCELL_ROW_103_1840 vccd1 vssd1 sky130_fd_sc_hd__tapvpwrvgnd_1$1
XFILLER_60_363 vccd1 vssd1 vccd1 vssd1 sky130_fd_sc_hd__fill_1$1
X_0944_ _1604_/Q _0944_/A2 _0945_/C _1668_/Q _1213_/A vccd1 vssd1 vccd1 vssd1 sky130_fd_sc_hd__a22o_1$1
XFILLER_9_261 vssd1 vccd1 vccd1 vssd1 sky130_ef_sc_hd__decap_40_12$1
XFILLER_20_249 vssd1 vccd1 vccd1 vssd1 sky130_fd_sc_hd__fill_2$1
XTAP_TAPCELL_ROW_31_767 vccd1 vssd1 sky130_fd_sc_hd__tapvpwrvgnd_1$1
XFILLER_118_137 vssd1 vccd1 vccd1 vssd1 sky130_fd_sc_hd__fill_2$1
Xclkload20 clkload20/X _1719_/CLK vssd1 vccd1 vccd1 vssd1 sky130_fd_sc_hd__clkbuf_4$1
X_0875_ _1529_/Q _0875_/A2 _0875_/X _1689_/Q _0875_/B1 vccd1 vssd1 vccd1 vssd1 sky130_fd_sc_hd__a22o_1$1
Xclkload31 clkload31/Y _1760_/CLK vccd1 vssd1 vccd1 vssd1 sky130_fd_sc_hd__clkinv_2$1
XFILLER_114_321 vssd1 vccd1 vccd1 vssd1 sky130_ef_sc_hd__decap_40_12$1
XFILLER_130_825 vccd1 vssd1 vccd1 vssd1 sky130_fd_sc_hd__fill_1$1
XFILLER_114_365 vssd1 vccd1 vccd1 vssd1 sky130_ef_sc_hd__decap_40_12$1
XFILLER_102_505 vssd1 vccd1 vccd1 vssd1 sky130_ef_sc_hd__decap_40_12$1
XFILLER_87_205 vssd1 vccd1 vccd1 vssd1 sky130_ef_sc_hd__decap_40_12$1
XFILLER_102_549 vssd1 vccd1 vccd1 vssd1 sky130_ef_sc_hd__decap_40_12$1
XFILLER_87_249 vssd1 vccd1 vccd1 vssd1 sky130_ef_sc_hd__decap_40_12$1
X_1427_ _1435_/C1 _1426_/X _1475_/A2 hold199/X _1740_/D vssd1 vccd1 vccd1 vssd1 sky130_fd_sc_hd__o211a_1$1
XFILLER_68_474 vssd1 vccd1 vccd1 vssd1 sky130_fd_sc_hd__fill_2$1
XFILLER_28_305 vssd1 vccd1 vccd1 vssd1 sky130_fd_sc_hd__fill_2$1
XFILLER_95_293 vssd1 vccd1 vccd1 vssd1 sky130_ef_sc_hd__decap_40_12$1
X_1358_ _1830_/A _1358_/X _1408_/B vssd1 vccd1 vccd1 vssd1 sky130_fd_sc_hd__or2_1$1
XFILLER_55_113 vssd1 vccd1 vccd1 vssd1 sky130_ef_sc_hd__decap_40_12$1
XFILLER_18_27 vccd1 vssd1 vccd1 vssd1 sky130_fd_sc_hd__fill_1$1
XFILLER_71_617 vssd1 vccd1 vccd1 vssd1 sky130_fd_sc_hd__fill_4$1
XFILLER_56_669 vssd1 vccd1 vccd1 vssd1 sky130_ef_sc_hd__decap_40_12$1
X_1289_ _1289_/C1 _1288_/X _1343_/A2 hold61/X _1673_/D vssd1 vccd1 vccd1 vssd1 sky130_fd_sc_hd__o211a_1$1
XTAP_TAPCELL_ROW_39_878 vccd1 vssd1 sky130_fd_sc_hd__tapvpwrvgnd_1$1
XTAP_TAPCELL_ROW_39_889 vccd1 vssd1 sky130_fd_sc_hd__tapvpwrvgnd_1$1
XTAP_TAPCELL_ROW_19_580 vccd1 vssd1 sky130_fd_sc_hd__tapvpwrvgnd_1$1
XTAP_TAPCELL_ROW_19_591 vccd1 vssd1 sky130_fd_sc_hd__tapvpwrvgnd_1$1
XFILLER_24_533 vssd1 vccd1 vccd1 vssd1 sky130_ef_sc_hd__decap_40_12$1
XFILLER_34_15 vssd1 vccd1 vccd1 vssd1 sky130_ef_sc_hd__decap_40_12$1
XTAP_TAPCELL_ROW_61_1209 vccd1 vssd1 sky130_fd_sc_hd__tapvpwrvgnd_1$1
XFILLER_11_205 vssd1 vccd1 vccd1 vssd1 sky130_ef_sc_hd__decap_40_12$1
XFILLER_51_385 vssd1 vccd1 vccd1 vssd1 sky130_fd_sc_hd__fill_4$1
Xclkload3 clkload3/Y clkload3/A vccd1 vssd1 vccd1 vssd1 sky130_fd_sc_hd__clkinv_2$1
XFILLER_11_249 vssd1 vccd1 vccd1 vssd1 sky130_ef_sc_hd__decap_40_12$1
XFILLER_109_137 vssd1 vccd1 vccd1 vssd1 sky130_ef_sc_hd__decap_40_12$1
XFILLER_137_457 vssd1 vccd1 vccd1 vssd1 sky130_fd_sc_hd__fill_8$1
XFILLER_106_811 vccd1 vssd1 vccd1 vssd1 sky130_fd_sc_hd__fill_1$1
XTAP_TAPCELL_ROW_76_1441 vccd1 vssd1 sky130_fd_sc_hd__tapvpwrvgnd_1$1
XFILLER_117_181 vssd1 vccd1 vccd1 vssd1 sky130_ef_sc_hd__decap_40_12$1
XFILLER_133_685 vssd1 vccd1 vccd1 vssd1 sky130_fd_sc_hd__fill_4$1
XFILLER_79_739 vccd1 vssd1 vccd1 vssd1 sky130_fd_sc_hd__fill_1$1
Xfanout240 _1015_/A vccd1 vssd1 _0866_/B1 vccd1 vssd1 sky130_fd_sc_hd__buf_6$1
XFILLER_132_195 vccd1 vssd1 vccd1 vssd1 sky130_fd_sc_hd__fill_1$1
XFILLER_78_249 vssd1 vccd1 vccd1 vssd1 sky130_fd_sc_hd__fill_2$1
XFILLER_120_357 vssd1 vccd1 vccd1 vssd1 sky130_fd_sc_hd__fill_4$1
XFILLER_115_51 vssd1 vccd1 vccd1 vssd1 sky130_fd_sc_hd__fill_4$1
Xfanout273 _1441_/C1 vccd1 vssd1 _1417_/C1 vccd1 vssd1 sky130_fd_sc_hd__buf_4$1
XFILLER_87_783 vccd1 vssd1 vccd1 vssd1 sky130_fd_sc_hd__fill_1$1
Xfanout251 _0875_/A2 _0742_/Y vssd1 vccd1 vccd1 vssd1 sky130_fd_sc_hd__clkbuf_8$1
XFILLER_19_305 vssd1 vccd1 vccd1 vssd1 sky130_ef_sc_hd__decap_40_12$1
XFILLER_47_614 vssd1 vccd1 vccd1 vssd1 sky130_fd_sc_hd__fill_2$1
Xfanout262 _1289_/C1 _1305_/C1 vssd1 vccd1 vccd1 vssd1 sky130_fd_sc_hd__clkbuf_4$1
XFILLER_75_55 vccd1 vssd1 vccd1 vssd1 sky130_fd_sc_hd__fill_1$1
XFILLER_74_433 vssd1 vccd1 vccd1 vssd1 sky130_fd_sc_hd__fill_4$1
XFILLER_74_400 vccd1 vssd1 vccd1 vssd1 sky130_fd_sc_hd__fill_1$1
XFILLER_19_349 vssd1 vccd1 vccd1 vssd1 sky130_ef_sc_hd__decap_40_12$1
XFILLER_35_809 vssd1 vccd1 vccd1 vssd1 sky130_ef_sc_hd__decap_40_12$1
XFILLER_47_669 vssd1 vccd1 vccd1 vssd1 sky130_fd_sc_hd__fill_2$1
XFILLER_74_477 vssd1 vccd1 vccd1 vssd1 sky130_ef_sc_hd__decap_40_12$1
XFILLER_61_105 vssd1 vccd1 vccd1 vssd1 sky130_fd_sc_hd__fill_4$1
XFILLER_61_149 vssd1 vccd1 vccd1 vssd1 sky130_ef_sc_hd__decap_40_12$1
XFILLER_27_393 vssd1 vccd1 vccd1 vssd1 sky130_ef_sc_hd__decap_40_12$1
XFILLER_42_363 vccd1 vssd1 vccd1 vssd1 sky130_fd_sc_hd__fill_1$1
XFILLER_30_525 vssd1 vccd1 vccd1 vssd1 sky130_fd_sc_hd__fill_4$1
XFILLER_24_81 vssd1 vccd1 vccd1 vssd1 sky130_fd_sc_hd__fill_2$1
XFILLER_30_569 vssd1 vccd1 vccd1 vssd1 sky130_ef_sc_hd__decap_40_12$1
XFILLER_11_783 vccd1 vssd1 vccd1 vssd1 sky130_fd_sc_hd__fill_1$1
XFILLER_7_721 vssd1 vccd1 vccd1 vssd1 sky130_fd_sc_hd__fill_4$1
XFILLER_7_765 vssd1 vccd1 vccd1 vssd1 sky130_ef_sc_hd__decap_40_12$1
XFILLER_6_253 vssd1 vccd1 vccd1 vssd1 sky130_ef_sc_hd__decap_40_12$1
XFILLER_109_671 vccd1 vssd1 vccd1 vssd1 sky130_fd_sc_hd__fill_1$1
XFILLER_112_825 vccd1 vssd1 vccd1 vssd1 sky130_fd_sc_hd__fill_1$1
XFILLER_97_503 vccd1 vssd1 vccd1 vssd1 sky130_fd_sc_hd__fill_1$1
XFILLER_69_205 vssd1 vccd1 vccd1 vssd1 sky130_ef_sc_hd__decap_40_12$1
XFILLER_111_335 vccd1 vssd1 vccd1 vssd1 sky130_fd_sc_hd__fill_1$1
XFILLER_69_249 vssd1 vccd1 vccd1 vssd1 sky130_ef_sc_hd__decap_40_12$1
X_1212_ _1213_/A _1272_/B _1411_/B vccd1 vssd1 vccd1 vssd1 sky130_fd_sc_hd__and2_2$1
XFILLER_65_411 vssd1 vccd1 vccd1 vssd1 sky130_ef_sc_hd__decap_40_12$1
XFILLER_37_113 vssd1 vccd1 vccd1 vssd1 sky130_ef_sc_hd__decap_40_12$1
XFILLER_38_625 vssd1 vccd1 vccd1 vssd1 sky130_ef_sc_hd__decap_40_12$1
X_1143_ _1475_/C1 _1142_/X _1145_/A2 hold64/X _1603_/D vssd1 vccd1 vccd1 vssd1 sky130_fd_sc_hd__o211a_1$1
XFILLER_93_753 vssd1 vccd1 vccd1 vssd1 sky130_ef_sc_hd__decap_40_12$1
XFILLER_77_293 vssd1 vccd1 vccd1 vssd1 sky130_ef_sc_hd__decap_40_12$1
XFILLER_26_809 vssd1 vccd1 vccd1 vssd1 sky130_fd_sc_hd__fill_2$1
XFILLER_38_669 vssd1 vccd1 vccd1 vssd1 sky130_ef_sc_hd__decap_40_12$1
X_1074_ _1074_/A _1074_/X _1078_/B vssd1 vccd1 vccd1 vssd1 sky130_fd_sc_hd__or2_1$1
XFILLER_93_797 vccd1 vssd1 vccd1 vssd1 sky130_fd_sc_hd__fill_1$1
XFILLER_80_414 vssd1 vccd1 vccd1 vssd1 sky130_fd_sc_hd__fill_4$1
XFILLER_65_499 vssd1 vccd1 vccd1 vssd1 sky130_fd_sc_hd__fill_4$1
XFILLER_53_617 vssd1 vccd1 vccd1 vssd1 sky130_ef_sc_hd__decap_40_12$1
XTAP_TAPCELL_ROW_36_837 vccd1 vssd1 sky130_fd_sc_hd__tapvpwrvgnd_1$1
XFILLER_21_503 vccd1 vssd1 vccd1 vssd1 sky130_fd_sc_hd__fill_1$1
XFILLER_33_385 vssd1 vccd1 vccd1 vssd1 sky130_fd_sc_hd__fill_4$1
XFILLER_60_193 vssd1 vccd1 vccd1 vssd1 sky130_fd_sc_hd__fill_2$1
XTAP_TAPCELL_ROW_134_2309 vccd1 vssd1 sky130_fd_sc_hd__tapvpwrvgnd_1$1
XFILLER_119_446 vssd1 vccd1 vccd1 vssd1 sky130_fd_sc_hd__fill_2$1
X_0927_ _0750_/X _0927_/X _0926_/X _1537_/Q _0949_/A _0925_/X vssd1 vccd1 vccd1 vssd1
+ sky130_fd_sc_hd__a2111o_1$1
X_0858_ _1622_/Q _1147_/A _0858_/X _1654_/Q _1213_/A vccd1 vssd1 vccd1 vssd1 sky130_fd_sc_hd__a22o_1$1
XFILLER_127_490 vssd1 vccd1 vccd1 vssd1 sky130_ef_sc_hd__decap_40_12$1
XFILLER_115_641 vccd1 vssd1 vccd1 vssd1 sky130_fd_sc_hd__fill_1$1
X_0789_ _0880_/A2 _1482_/D _0785_/X _1441_/C1 _1482_/Q _0788_/X vssd1 vccd1 vccd1
+ vssd1 sky130_fd_sc_hd__o221a_1$1
XTAP_TAPCELL_ROW_58_1171 vccd1 vssd1 sky130_fd_sc_hd__tapvpwrvgnd_1$1
XFILLER_115_685 vssd1 vccd1 vccd1 vssd1 sky130_ef_sc_hd__decap_40_12$1
XFILLER_114_195 vccd1 vssd1 vccd1 vssd1 sky130_fd_sc_hd__fill_1$1
XFILLER_29_15 vssd1 vccd1 vccd1 vssd1 sky130_ef_sc_hd__decap_40_12$1
Xhold15 hold15/A hold15/X vssd1 vccd1 vccd1 vssd1 sky130_fd_sc_hd__dlygate4sd3_1$1
Xhold26 hold26/A hold26/X vssd1 vccd1 vccd1 vssd1 sky130_fd_sc_hd__dlygate4sd3_1$1
Xhold37 hold37/A hold37/X vssd1 vccd1 vccd1 vssd1 sky130_fd_sc_hd__dlygate4sd3_1$1
XFILLER_102_357 vssd1 vccd1 vccd1 vssd1 sky130_fd_sc_hd__fill_4$1
XTAP_TAPCELL_ROW_71_1371 vccd1 vssd1 sky130_fd_sc_hd__tapvpwrvgnd_1$1
XTAP_TAPCELL_ROW_71_1360 vccd1 vssd1 sky130_fd_sc_hd__tapvpwrvgnd_1$1
Xhold48 wbs_dat_i[28] hold48/X vssd1 vccd1 vccd1 vssd1 sky130_fd_sc_hd__dlygate4sd3_1$1
Xhold59 hold59/A hold59/X vssd1 vccd1 vccd1 vssd1 sky130_fd_sc_hd__dlygate4sd3_1$1
XFILLER_56_411 vssd1 vccd1 vccd1 vssd1 sky130_fd_sc_hd__fill_8$1
XFILLER_84_753 vssd1 vccd1 vccd1 vssd1 sky130_fd_sc_hd__fill_2$1
XFILLER_56_433 vssd1 vccd1 vccd1 vssd1 sky130_ef_sc_hd__decap_40_12$1
XFILLER_17_809 vssd1 vccd1 vccd1 vssd1 sky130_ef_sc_hd__decap_40_12$1
XFILLER_29_669 vssd1 vccd1 vccd1 vssd1 sky130_fd_sc_hd__fill_2$1
XFILLER_71_425 vssd1 vccd1 vccd1 vssd1 sky130_ef_sc_hd__decap_40_12$1
XFILLER_56_477 vssd1 vccd1 vccd1 vssd1 sky130_ef_sc_hd__decap_40_12$1
XFILLER_43_105 vssd1 vccd1 vccd1 vssd1 sky130_fd_sc_hd__fill_4$1
XFILLER_43_149 vssd1 vccd1 vccd1 vssd1 sky130_ef_sc_hd__decap_40_12$1
XFILLER_45_69 vssd1 vccd1 vccd1 vssd1 sky130_ef_sc_hd__decap_40_12$1
XFILLER_71_469 vssd1 vccd1 vccd1 vssd1 sky130_fd_sc_hd__fill_2$1
XTAP_TAPCELL_ROW_14_509 vccd1 vssd1 sky130_fd_sc_hd__tapvpwrvgnd_1$1
XFILLER_24_363 vccd1 vssd1 vccd1 vssd1 sky130_fd_sc_hd__fill_1$1
XFILLER_40_801 vssd1 vccd1 vccd1 vssd1 sky130_fd_sc_hd__fill_2$1
XFILLER_12_525 vssd1 vccd1 vccd1 vssd1 sky130_fd_sc_hd__fill_4$1
XFILLER_61_57 vssd1 vccd1 vccd1 vssd1 sky130_ef_sc_hd__decap_40_12$1
XFILLER_51_193 vssd1 vccd1 vccd1 vssd1 sky130_ef_sc_hd__decap_40_12$1
XFILLER_12_569 vssd1 vccd1 vccd1 vssd1 sky130_ef_sc_hd__decap_40_12$1
XFILLER_138_755 vccd1 vssd1 vccd1 vssd1 sky130_fd_sc_hd__fill_1$1
XFILLER_8_529 vssd1 vccd1 vccd1 vssd1 sky130_fd_sc_hd__fill_2$1
XFILLER_137_265 vssd1 vccd1 vccd1 vssd1 sky130_ef_sc_hd__decap_40_12$1
XFILLER_125_405 vssd1 vccd1 vccd1 vssd1 sky130_ef_sc_hd__decap_40_12$1
XFILLER_124_3 vssd1 vccd1 vccd1 vssd1 sky130_ef_sc_hd__decap_40_12$1
XFILLER_4_713 vssd1 vccd1 vccd1 vssd1 sky130_ef_sc_hd__decap_40_12$1
XFILLER_125_449 vssd1 vccd1 vccd1 vssd1 sky130_fd_sc_hd__fill_8$1
XFILLER_4_757 vssd1 vccd1 vccd1 vssd1 sky130_ef_sc_hd__decap_40_12$1
XFILLER_3_223 vccd1 vssd1 vccd1 vssd1 sky130_fd_sc_hd__fill_1$1
XFILLER_79_503 vccd1 vssd1 vccd1 vssd1 sky130_fd_sc_hd__fill_1$1
XFILLER_120_121 vssd1 vccd1 vccd1 vssd1 sky130_ef_sc_hd__decap_40_12$1
XFILLER_10_83 vccd1 vssd1 vccd1 vssd1 sky130_fd_sc_hd__fill_1$1
XFILLER_126_83 vccd1 vssd1 vccd1 vssd1 sky130_fd_sc_hd__fill_1$1
XFILLER_94_517 vssd1 vccd1 vccd1 vssd1 sky130_fd_sc_hd__fill_4$1
XFILLER_86_65 vssd1 vccd1 vccd1 vssd1 sky130_ef_sc_hd__decap_40_12$1
XFILLER_120_165 vssd1 vccd1 vccd1 vssd1 sky130_ef_sc_hd__decap_40_12$1
XTAP_TAPCELL_ROW_89_1632 vccd1 vssd1 sky130_fd_sc_hd__tapvpwrvgnd_1$1
XFILLER_19_113 vssd1 vccd1 vccd1 vssd1 sky130_ef_sc_hd__decap_40_12$1
XFILLER_59_293 vssd1 vccd1 vccd1 vssd1 sky130_ef_sc_hd__decap_40_12$1
XFILLER_19_81 vssd1 vccd1 vccd1 vssd1 sky130_ef_sc_hd__decap_40_12$1
XFILLER_47_433 vssd1 vccd1 vccd1 vssd1 sky130_fd_sc_hd__fill_2$1
XFILLER_90_701 vssd1 vccd1 vccd1 vssd1 sky130_ef_sc_hd__decap_40_12$1
XFILLER_75_797 vssd1 vccd1 vccd1 vssd1 sky130_ef_sc_hd__decap_40_12$1
XFILLER_62_469 vssd1 vccd1 vccd1 vssd1 sky130_fd_sc_hd__fill_4$1
XFILLER_15_385 vssd1 vccd1 vccd1 vssd1 sky130_fd_sc_hd__fill_4$1
XFILLER_43_694 vssd1 vccd1 vccd1 vssd1 sky130_ef_sc_hd__decap_40_12$1
X_1830_ vccd1 vssd1 _1830_/X _1830_/A vccd1 vssd1 sky130_fd_sc_hd__buf_1$1
XFILLER_30_333 vssd1 vccd1 vccd1 vssd1 sky130_ef_sc_hd__decap_40_12$1
XFILLER_42_193 vssd1 vccd1 vccd1 vssd1 sky130_fd_sc_hd__fill_2$1
XFILLER_128_221 vssd1 vccd1 vccd1 vssd1 sky130_ef_sc_hd__decap_40_12$1
XFILLER_30_377 vssd1 vccd1 vccd1 vssd1 sky130_ef_sc_hd__decap_40_12$1
XFILLER_129_777 vssd1 vccd1 vccd1 vssd1 sky130_fd_sc_hd__fill_4$1
XTAP_TAPCELL_ROW_116_2039 vccd1 vssd1 sky130_fd_sc_hd__tapvpwrvgnd_1$1
X_1761_ _1761_/Q _1761_/CLK hold50/X vccd1 vssd1 vccd1 vssd1 sky130_fd_sc_hd__dfxtp_1$1
XFILLER_128_265 vssd1 vccd1 vccd1 vssd1 sky130_ef_sc_hd__decap_40_12$1
X_1692_ hold35/A _1749_/CLK _1692_/D vccd1 vssd1 vccd1 vssd1 sky130_fd_sc_hd__dfxtp_1$1
XFILLER_7_573 vssd1 vccd1 vccd1 vssd1 sky130_ef_sc_hd__decap_40_12$1
Xmax_cap248 vccd1 vssd1 _0826_/B1 _0784_/B1 vccd1 vssd1 sky130_fd_sc_hd__buf_2$1
XFILLER_131_408 vssd1 vccd1 vccd1 vssd1 sky130_ef_sc_hd__decap_40_12$1
XFILLER_97_333 vssd1 vccd1 vccd1 vssd1 sky130_fd_sc_hd__fill_2$1
XTAP_TAPCELL_ROW_111_1972 vccd1 vssd1 sky130_fd_sc_hd__tapvpwrvgnd_1$1
XTAP_TAPCELL_ROW_111_1961 vccd1 vssd1 sky130_fd_sc_hd__tapvpwrvgnd_1$1
XFILLER_85_517 vssd1 vccd1 vccd1 vssd1 sky130_ef_sc_hd__decap_40_12$1
XFILLER_58_709 vssd1 vccd1 vccd1 vssd1 sky130_ef_sc_hd__decap_40_12$1
XFILLER_112_699 vccd1 vssd1 vccd1 vssd1 sky130_fd_sc_hd__fill_1$1
XFILLER_111_165 vssd1 vccd1 vccd1 vssd1 sky130_fd_sc_hd__fill_2$1
XTAP_TAPCELL_ROW_53_1090 vccd1 vssd1 sky130_fd_sc_hd__tapvpwrvgnd_1$1
Xclkbuf_leaf_10_wb_clk_i _1759_/CLK clkbuf_leaf_9_wb_clk_i/A vssd1 vccd1 vccd1 vssd1
+ sky130_fd_sc_hd__clkbuf_8$1
XFILLER_66_742 vssd1 vccd1 vccd1 vssd1 sky130_ef_sc_hd__decap_40_12$1
XFILLER_38_433 vssd1 vccd1 vccd1 vssd1 sky130_ef_sc_hd__decap_40_12$1
X_1126_ _1126_/A _1126_/X _1144_/B vssd1 vccd1 vccd1 vssd1 sky130_fd_sc_hd__or2_1$1
XFILLER_93_561 vssd1 vccd1 vccd1 vssd1 sky130_ef_sc_hd__decap_40_12$1
XFILLER_25_105 vssd1 vccd1 vccd1 vssd1 sky130_fd_sc_hd__fill_4$1
XFILLER_38_477 vssd1 vccd1 vccd1 vssd1 sky130_ef_sc_hd__decap_40_12$1
XFILLER_80_233 vssd1 vccd1 vccd1 vssd1 sky130_ef_sc_hd__decap_40_12$1
XFILLER_53_447 vccd1 vssd1 vccd1 vssd1 sky130_fd_sc_hd__fill_1$1
XFILLER_25_149 vssd1 vccd1 vccd1 vssd1 sky130_ef_sc_hd__decap_40_12$1
X_1057_ _1455_/C1 _1056_/X _1079_/A2 hold125/X _1561_/D vssd1 vccd1 vccd1 vssd1 sky130_fd_sc_hd__o211a_1$1
XFILLER_15_39 vssd1 vccd1 vccd1 vssd1 sky130_ef_sc_hd__decap_40_12$1
XFILLER_80_277 vssd1 vccd1 vccd1 vssd1 sky130_ef_sc_hd__decap_40_12$1
XFILLER_21_333 vssd1 vccd1 vccd1 vssd1 sky130_fd_sc_hd__fill_2$1
XFILLER_33_193 vssd1 vccd1 vccd1 vssd1 sky130_ef_sc_hd__decap_40_12$1
XFILLER_119_221 vssd1 vccd1 vccd1 vssd1 sky130_fd_sc_hd__fill_2$1
XFILLER_31_27 vssd1 vccd1 vccd1 vssd1 sky130_ef_sc_hd__decap_40_12$1
XFILLER_107_405 vssd1 vccd1 vccd1 vssd1 sky130_ef_sc_hd__decap_40_12$1
XFILLER_107_449 vssd1 vccd1 vccd1 vssd1 sky130_fd_sc_hd__fill_4$1
XTAP_TAPCELL_ROW_73_1400 vccd1 vssd1 sky130_fd_sc_hd__tapvpwrvgnd_1$1
XFILLER_122_419 vccd1 vssd1 vccd1 vssd1 sky130_fd_sc_hd__fill_1$1
XFILLER_1_727 vccd1 vssd1 vccd1 vssd1 sky130_fd_sc_hd__fill_1$1
XFILLER_88_333 vssd1 vccd1 vccd1 vssd1 sky130_ef_sc_hd__decap_40_12$1
XFILLER_130_463 vssd1 vccd1 vccd1 vssd1 sky130_ef_sc_hd__decap_40_12$1
XFILLER_102_121 vssd1 vccd1 vccd1 vssd1 sky130_ef_sc_hd__decap_40_12$1
XFILLER_102_165 vssd1 vccd1 vccd1 vssd1 sky130_ef_sc_hd__decap_40_12$1
XFILLER_84_572 vssd1 vccd1 vccd1 vssd1 sky130_ef_sc_hd__decap_40_12$1
XFILLER_72_701 vssd1 vccd1 vccd1 vssd1 sky130_ef_sc_hd__decap_40_12$1
XFILLER_17_617 vssd1 vccd1 vccd1 vssd1 sky130_ef_sc_hd__decap_40_12$1
XFILLER_112_41 vssd1 vccd1 vccd1 vssd1 sky130_ef_sc_hd__decap_40_12$1
XFILLER_112_85 vssd1 vccd1 vccd1 vssd1 sky130_ef_sc_hd__decap_40_12$1
XTAP_TAPCELL_ROW_84_1562 vccd1 vssd1 sky130_fd_sc_hd__tapvpwrvgnd_1$1
XFILLER_71_277 vssd1 vccd1 vccd1 vssd1 sky130_fd_sc_hd__fill_2$1
XFILLER_12_333 vssd1 vccd1 vccd1 vssd1 sky130_ef_sc_hd__decap_40_12$1
XFILLER_24_193 vssd1 vccd1 vccd1 vssd1 sky130_fd_sc_hd__fill_2$1
XFILLER_40_642 vssd1 vccd1 vccd1 vssd1 sky130_fd_sc_hd__fill_2$1
XFILLER_12_377 vssd1 vccd1 vccd1 vssd1 sky130_ef_sc_hd__decap_40_12$1
XFILLER_40_686 vssd1 vccd1 vccd1 vssd1 sky130_ef_sc_hd__decap_40_12$1
XFILLER_138_585 vssd1 vccd1 vccd1 vssd1 sky130_fd_sc_hd__fill_2$1
XFILLER_137_82 vssd1 vccd1 vccd1 vssd1 sky130_fd_sc_hd__fill_8$1
XFILLER_125_279 vccd1 vssd1 vccd1 vssd1 sky130_fd_sc_hd__fill_1$1
XFILLER_21_93 vssd1 vccd1 vccd1 vssd1 sky130_ef_sc_hd__decap_40_12$1
XFILLER_79_333 vssd1 vccd1 vccd1 vssd1 sky130_fd_sc_hd__fill_2$1
XFILLER_4_587 vccd1 vssd1 vccd1 vssd1 sky130_fd_sc_hd__fill_1$1
XFILLER_75_561 vssd1 vccd1 vccd1 vssd1 sky130_ef_sc_hd__decap_40_12$1
XFILLER_48_786 vssd1 vccd1 vccd1 vssd1 sky130_ef_sc_hd__decap_40_12$1
XTAP_TAPCELL_ROW_126_2190 vccd1 vssd1 sky130_fd_sc_hd__tapvpwrvgnd_1$1
XFILLER_62_233 vssd1 vccd1 vccd1 vssd1 sky130_ef_sc_hd__decap_40_12$1
XFILLER_35_447 vccd1 vssd1 vccd1 vssd1 sky130_fd_sc_hd__fill_1$1
XFILLER_63_767 vccd1 vssd1 vccd1 vssd1 sky130_fd_sc_hd__fill_1$1
XFILLER_23_609 vssd1 vccd1 vccd1 vssd1 sky130_fd_sc_hd__fill_4$1
XFILLER_62_277 vssd1 vccd1 vccd1 vssd1 sky130_ef_sc_hd__decap_40_12$1
XFILLER_50_417 vssd1 vccd1 vccd1 vssd1 sky130_fd_sc_hd__fill_2$1
XTAP_TAPCELL_ROW_46_987 vccd1 vssd1 sky130_fd_sc_hd__tapvpwrvgnd_1$1
XFILLER_15_193 vssd1 vccd1 vccd1 vssd1 sky130_ef_sc_hd__decap_40_12$1
XFILLER_31_653 vssd1 vccd1 vccd1 vssd1 sky130_ef_sc_hd__decap_40_12$1
XFILLER_87_3 vssd1 vccd1 vccd1 vssd1 sky130_ef_sc_hd__decap_40_12$1
XFILLER_30_141 vssd1 vccd1 vccd1 vssd1 sky130_ef_sc_hd__decap_40_12$1
XFILLER_31_697 vssd1 vccd1 vccd1 vssd1 sky130_ef_sc_hd__decap_40_12$1
X_1813_ vccd1 vssd1 _1813_/X _1813_/A vccd1 vssd1 sky130_fd_sc_hd__buf_1$1
XFILLER_117_714 vssd1 vccd1 vccd1 vssd1 sky130_ef_sc_hd__decap_40_12$1
X_1744_ _1852_/A clkload3/A _1744_/D vccd1 vssd1 vccd1 vssd1 sky130_fd_sc_hd__dfxtp_1$1
XFILLER_7_51 vssd1 vccd1 vccd1 vssd1 sky130_fd_sc_hd__fill_4$1
XFILLER_131_205 vssd1 vccd1 vccd1 vssd1 sky130_ef_sc_hd__decap_40_12$1
X_1675_ _1675_/Q clkload9/A _1675_/D vccd1 vssd1 vccd1 vssd1 sky130_fd_sc_hd__dfxtp_1$1
XFILLER_98_620 vssd1 vccd1 vccd1 vssd1 sky130_ef_sc_hd__decap_40_12$1
XTAP_TAPCELL_ROW_55_1130 vccd1 vssd1 sky130_fd_sc_hd__tapvpwrvgnd_1$1
XPHY_EDGE_ROW_15_Right_15 vccd1 vssd1 vccd1 vssd1 sky130_fd_sc_hd__decap_3$1
XFILLER_131_249 vssd1 vccd1 vccd1 vssd1 sky130_ef_sc_hd__decap_40_12$1
XFILLER_112_485 vssd1 vccd1 vccd1 vssd1 sky130_ef_sc_hd__decap_40_12$1
XFILLER_100_625 vssd1 vccd1 vccd1 vssd1 sky130_fd_sc_hd__fill_2$1
XFILLER_54_701 vssd1 vccd1 vccd1 vssd1 sky130_fd_sc_hd__fill_2$1
XFILLER_39_797 vssd1 vccd1 vccd1 vssd1 sky130_fd_sc_hd__fill_8$1
XFILLER_93_391 vccd1 vssd1 vccd1 vssd1 sky130_fd_sc_hd__fill_1$1
XFILLER_54_745 vssd1 vccd1 vccd1 vssd1 sky130_fd_sc_hd__fill_8$1
XFILLER_26_27 vccd1 vssd1 vccd1 vssd1 sky130_fd_sc_hd__fill_1$1
X_1109_ _1447_/C1 _1108_/X _1123_/A2 hold21/X _1586_/D vssd1 vccd1 vccd1 vssd1 sky130_fd_sc_hd__o211a_1$1
XPHY_EDGE_ROW_24_Right_24 vccd1 vssd1 vccd1 vssd1 sky130_fd_sc_hd__decap_3$1
XFILLER_26_469 vssd1 vccd1 vccd1 vssd1 sky130_fd_sc_hd__fill_4$1
XFILLER_53_277 vssd1 vccd1 vccd1 vssd1 sky130_fd_sc_hd__fill_2$1
XFILLER_41_417 vssd1 vccd1 vccd1 vssd1 sky130_ef_sc_hd__decap_40_12$1
XTAP_TAPCELL_ROW_66_1292 vccd1 vssd1 sky130_fd_sc_hd__tapvpwrvgnd_1$1
XTAP_TAPCELL_ROW_24_659 vccd1 vssd1 sky130_fd_sc_hd__tapvpwrvgnd_1$1
XFILLER_42_15 vssd1 vccd1 vccd1 vssd1 sky130_ef_sc_hd__decap_40_12$1
XFILLER_22_697 vssd1 vccd1 vccd1 vssd1 sky130_fd_sc_hd__fill_2$1
XFILLER_108_725 vssd1 vccd1 vccd1 vssd1 sky130_ef_sc_hd__decap_40_12$1
XFILLER_5_329 vssd1 vccd1 vccd1 vssd1 sky130_fd_sc_hd__fill_4$1
XFILLER_107_279 vccd1 vssd1 vccd1 vssd1 sky130_fd_sc_hd__fill_1$1
XPHY_EDGE_ROW_33_Right_33 vccd1 vssd1 vccd1 vssd1 sky130_fd_sc_hd__decap_3$1
XFILLER_122_249 vssd1 vccd1 vccd1 vssd1 sky130_fd_sc_hd__fill_2$1
XFILLER_88_141 vssd1 vccd1 vccd1 vssd1 sky130_ef_sc_hd__decap_40_12$1
XFILLER_1_557 vssd1 vccd1 vccd1 vssd1 sky130_fd_sc_hd__fill_2$1
XFILLER_131_783 vccd1 vssd1 vccd1 vssd1 sky130_fd_sc_hd__fill_1$1
XFILLER_89_697 vssd1 vccd1 vccd1 vssd1 sky130_ef_sc_hd__decap_40_12$1
XFILLER_49_517 vssd1 vccd1 vccd1 vssd1 sky130_fd_sc_hd__fill_4$1
XFILLER_123_51 vssd1 vccd1 vccd1 vssd1 sky130_fd_sc_hd__fill_4$1
XFILLER_91_317 vssd1 vccd1 vccd1 vssd1 sky130_ef_sc_hd__decap_40_12$1
XFILLER_57_561 vssd1 vccd1 vccd1 vssd1 sky130_ef_sc_hd__decap_40_12$1
XTAP_TAPCELL_ROW_4_362 vccd1 vssd1 sky130_fd_sc_hd__tapvpwrvgnd_1$1
XPHY_EDGE_ROW_42_Right_42 vccd1 vssd1 vccd1 vssd1 sky130_fd_sc_hd__decap_3$1
XFILLER_83_55 vccd1 vssd1 vccd1 vssd1 sky130_fd_sc_hd__fill_1$1
XFILLER_72_553 vssd1 vccd1 vccd1 vssd1 sky130_fd_sc_hd__fill_2$1
XFILLER_17_447 vccd1 vssd1 vccd1 vssd1 sky130_fd_sc_hd__fill_1$1
XFILLER_44_233 vssd1 vccd1 vccd1 vssd1 sky130_ef_sc_hd__decap_40_12$1
XFILLER_32_417 vssd1 vccd1 vccd1 vssd1 sky130_fd_sc_hd__fill_2$1
XFILLER_44_277 vssd1 vccd1 vccd1 vssd1 sky130_ef_sc_hd__decap_40_12$1
XFILLER_13_653 vssd1 vccd1 vccd1 vssd1 sky130_ef_sc_hd__decap_40_12$1
XTAP_TAPCELL_ROW_43_946 vccd1 vssd1 sky130_fd_sc_hd__tapvpwrvgnd_1$1
XFILLER_12_141 vssd1 vccd1 vccd1 vssd1 sky130_ef_sc_hd__decap_40_12$1
XFILLER_9_613 vssd1 vccd1 vccd1 vssd1 sky130_fd_sc_hd__fill_2$1
XFILLER_13_697 vssd1 vccd1 vccd1 vssd1 sky130_ef_sc_hd__decap_40_12$1
XPHY_EDGE_ROW_51_Right_51 vccd1 vssd1 vccd1 vssd1 sky130_fd_sc_hd__decap_3$1
XFILLER_32_81 vssd1 vccd1 vccd1 vssd1 sky130_fd_sc_hd__fill_2$1
XFILLER_126_533 vssd1 vccd1 vccd1 vssd1 sky130_ef_sc_hd__decap_40_12$1
XTAP_TAPCELL_ROW_97_1753 vccd1 vssd1 sky130_fd_sc_hd__tapvpwrvgnd_1$1
XFILLER_8_189 vssd1 vccd1 vccd1 vssd1 sky130_fd_sc_hd__fill_4$1
XFILLER_5_841 vccd1 vssd1 vccd1 vssd1 sky130_fd_sc_hd__fill_1$1
XPHY_EDGE_ROW_136_Right_136 vccd1 vssd1 vccd1 vssd1 sky130_fd_sc_hd__decap_3$1
XFILLER_113_205 vssd1 vccd1 vccd1 vssd1 sky130_ef_sc_hd__decap_40_12$1
X_1460_ _1460_/A _1460_/X _1464_/B vssd1 vccd1 vccd1 vssd1 sky130_fd_sc_hd__or2_1$1
X_1391_ _1461_/C1 _1390_/X _1399_/A2 hold59/X _1723_/D vssd1 vccd1 vccd1 vssd1 sky130_fd_sc_hd__o211a_1$1
XFILLER_113_249 vssd1 vccd1 vccd1 vssd1 sky130_ef_sc_hd__decap_40_12$1
XFILLER_121_293 vssd1 vccd1 vccd1 vssd1 sky130_ef_sc_hd__decap_40_12$1
XFILLER_95_645 vssd1 vccd1 vccd1 vssd1 sky130_ef_sc_hd__decap_40_12$1
XFILLER_94_133 vssd1 vccd1 vccd1 vssd1 sky130_fd_sc_hd__fill_4$1
XFILLER_94_177 vssd1 vccd1 vccd1 vssd1 sky130_ef_sc_hd__decap_40_12$1
XPHY_EDGE_ROW_60_Right_60 vccd1 vssd1 vccd1 vssd1 sky130_fd_sc_hd__decap_3$1
XFILLER_36_701 vssd1 vccd1 vccd1 vssd1 sky130_ef_sc_hd__decap_40_12$1
XFILLER_75_391 vccd1 vssd1 vccd1 vssd1 sky130_fd_sc_hd__fill_1$1
XFILLER_90_361 vssd1 vccd1 vccd1 vssd1 sky130_fd_sc_hd__fill_2$1
XFILLER_63_586 vccd1 vssd1 vccd1 vssd1 sky130_fd_sc_hd__fill_1$1
XFILLER_23_417 vssd1 vccd1 vccd1 vssd1 sky130_ef_sc_hd__decap_40_12$1
XFILLER_35_277 vssd1 vccd1 vccd1 vssd1 sky130_fd_sc_hd__fill_2$1
XTAP_TAPCELL_ROW_106_1893 vccd1 vssd1 sky130_fd_sc_hd__tapvpwrvgnd_1$1
XTAP_TAPCELL_ROW_21_618 vccd1 vssd1 sky130_fd_sc_hd__tapvpwrvgnd_1$1
XFILLER_31_461 vssd1 vccd1 vccd1 vssd1 sky130_ef_sc_hd__decap_40_12$1
XFILLER_129_371 vccd1 vssd1 vccd1 vssd1 sky130_fd_sc_hd__fill_1$1
XFILLER_12_29 vssd1 vccd1 vccd1 vssd1 sky130_ef_sc_hd__decap_40_12$1
XFILLER_129_393 vssd1 vccd1 vccd1 vssd1 sky130_ef_sc_hd__decap_40_12$1
XFILLER_128_29 vssd1 vccd1 vccd1 vssd1 sky130_ef_sc_hd__decap_40_12$1
Xhold101 _1595_/Q _1126_/A vssd1 vccd1 vccd1 vssd1 sky130_fd_sc_hd__dlygate4sd3_1$1
X_1727_ _1727_/Q _1759_/CLK _1727_/D vccd1 vssd1 vccd1 vssd1 sky130_fd_sc_hd__dfxtp_1$1
Xhold112 _1694_/Q _1330_/A vssd1 vccd1 vccd1 vssd1 sky130_fd_sc_hd__dlygate4sd3_1$1
Xhold123 _1695_/Q _1332_/A vssd1 vccd1 vccd1 vssd1 sky130_fd_sc_hd__dlygate4sd3_1$1
XPHY_EDGE_ROW_103_Right_103 vccd1 vssd1 vccd1 vssd1 sky130_fd_sc_hd__decap_3$1
Xhold134 _1530_/Q _0992_/A vssd1 vccd1 vccd1 vssd1 sky130_fd_sc_hd__dlygate4sd3_1$1
Xhold145 wbs_dat_i[27] input39/A vssd1 vccd1 vccd1 vssd1 sky130_fd_sc_hd__dlygate4sd3_1$1
Xhold156 _1600_/Q _1136_/A vssd1 vccd1 vccd1 vssd1 sky130_fd_sc_hd__dlygate4sd3_1$1
XFILLER_132_525 vssd1 vccd1 vccd1 vssd1 sky130_fd_sc_hd__fill_4$1
Xhold167 _1730_/Q _1404_/A vssd1 vccd1 vccd1 vssd1 sky130_fd_sc_hd__dlygate4sd3_1$1
X_1658_ _1658_/Q _1729_/CLK _1658_/D vccd1 vssd1 vccd1 vssd1 sky130_fd_sc_hd__dfxtp_1$1
XFILLER_132_569 vssd1 vccd1 vccd1 vssd1 sky130_ef_sc_hd__decap_40_12$1
XFILLER_104_249 vssd1 vccd1 vccd1 vssd1 sky130_fd_sc_hd__fill_2$1
Xhold178 _1750_/Q _1446_/A vssd1 vccd1 vccd1 vssd1 sky130_fd_sc_hd__dlygate4sd3_1$1
Xhold189 _1678_/Q _1298_/A vssd1 vccd1 vccd1 vssd1 sky130_fd_sc_hd__dlygate4sd3_1$1
XFILLER_113_783 vccd1 vssd1 vccd1 vssd1 sky130_fd_sc_hd__fill_1$1
X_1589_ _1807_/A _1720_/CLK _1589_/D vccd1 vssd1 vccd1 vssd1 sky130_fd_sc_hd__dfxtp_1$1
XFILLER_86_601 vssd1 vccd1 vccd1 vssd1 sky130_ef_sc_hd__decap_40_12$1
XFILLER_100_433 vssd1 vccd1 vccd1 vssd1 sky130_ef_sc_hd__decap_40_12$1
XFILLER_86_645 vccd1 vssd1 vccd1 vssd1 sky130_fd_sc_hd__fill_1$1
XFILLER_85_111 vccd1 vssd1 vccd1 vssd1 sky130_fd_sc_hd__fill_1$1
XPHY_EDGE_ROW_13_Left_152 vccd1 vssd1 vccd1 vssd1 sky130_fd_sc_hd__decap_3$1
XFILLER_37_15 vssd1 vccd1 vccd1 vssd1 sky130_ef_sc_hd__decap_40_12$1
XFILLER_100_477 vssd1 vccd1 vccd1 vssd1 sky130_fd_sc_hd__fill_2$1
XFILLER_73_317 vssd1 vccd1 vccd1 vssd1 sky130_ef_sc_hd__decap_40_12$1
XTAP_TAPCELL_ROW_68_1321 vccd1 vssd1 sky130_fd_sc_hd__tapvpwrvgnd_1$1
XFILLER_54_531 vccd1 vssd1 vccd1 vssd1 sky130_fd_sc_hd__fill_1$1
XTAP_TAPCELL_ROW_1_310 vccd1 vssd1 sky130_fd_sc_hd__tapvpwrvgnd_1$1
XTAP_TAPCELL_ROW_1_321 vccd1 vssd1 sky130_fd_sc_hd__tapvpwrvgnd_1$1
XTAP_TAPCELL_ROW_29_729 vccd1 vssd1 sky130_fd_sc_hd__tapvpwrvgnd_1$1
XFILLER_26_233 vssd1 vccd1 vccd1 vssd1 sky130_ef_sc_hd__decap_40_12$1
XFILLER_81_361 vssd1 vccd1 vccd1 vssd1 sky130_fd_sc_hd__fill_8$1
XTAP_TAPCELL_ROW_81_1510 vccd1 vssd1 sky130_fd_sc_hd__tapvpwrvgnd_1$1
XFILLER_54_586 vssd1 vccd1 vccd1 vssd1 sky130_fd_sc_hd__fill_2$1
XFILLER_14_417 vssd1 vccd1 vccd1 vssd1 sky130_fd_sc_hd__fill_2$1
XFILLER_26_277 vssd1 vccd1 vccd1 vssd1 sky130_ef_sc_hd__decap_40_12$1
XTAP_TAPCELL_ROW_81_1521 vccd1 vssd1 sky130_fd_sc_hd__tapvpwrvgnd_1$1
XFILLER_53_69 vssd1 vccd1 vccd1 vssd1 sky130_ef_sc_hd__decap_40_12$1
XFILLER_41_225 vssd1 vccd1 vccd1 vssd1 sky130_ef_sc_hd__decap_40_12$1
XFILLER_10_601 vssd1 vccd1 vccd1 vssd1 sky130_ef_sc_hd__decap_40_12$1
XPHY_EDGE_ROW_22_Left_161 vccd1 vssd1 vccd1 vssd1 sky130_fd_sc_hd__decap_3$1
XTAP_TAPCELL_ROW_40_905 vccd1 vssd1 sky130_fd_sc_hd__tapvpwrvgnd_1$1
XFILLER_10_645 vssd1 vccd1 vccd1 vssd1 sky130_ef_sc_hd__decap_40_12$1
XFILLER_5_137 vssd1 vccd1 vccd1 vssd1 sky130_ef_sc_hd__decap_40_12$1
XFILLER_123_503 vccd1 vssd1 vccd1 vssd1 sky130_fd_sc_hd__fill_1$1
XTAP_TAPCELL_ROW_79_1483 vccd1 vssd1 sky130_fd_sc_hd__tapvpwrvgnd_1$1
XTAP_TAPCELL_ROW_9_432 vccd1 vssd1 sky130_fd_sc_hd__tapvpwrvgnd_1$1
XFILLER_2_811 vccd1 vssd1 vccd1 vssd1 sky130_fd_sc_hd__fill_1$1
XFILLER_96_409 vssd1 vccd1 vccd1 vssd1 sky130_fd_sc_hd__fill_8$1
XTAP_TAPCELL_ROW_92_1683 vccd1 vssd1 sky130_fd_sc_hd__tapvpwrvgnd_1$1
XFILLER_89_461 vssd1 vccd1 vccd1 vssd1 sky130_ef_sc_hd__decap_40_12$1
XFILLER_78_77 vssd1 vccd1 vccd1 vssd1 sky130_fd_sc_hd__fill_4$1
XFILLER_77_601 vccd1 vssd1 vccd1 vssd1 sky130_fd_sc_hd__fill_1$1
XPHY_EDGE_ROW_31_Left_170 vccd1 vssd1 vccd1 vssd1 sky130_fd_sc_hd__decap_3$1
XFILLER_103_293 vssd1 vccd1 vccd1 vssd1 sky130_ef_sc_hd__decap_40_12$1
XFILLER_76_133 vssd1 vccd1 vccd1 vssd1 sky130_fd_sc_hd__fill_4$1
XFILLER_134_83 vccd1 vssd1 vccd1 vssd1 sky130_fd_sc_hd__fill_1$1
XFILLER_18_701 vssd1 vccd1 vccd1 vssd1 sky130_ef_sc_hd__decap_40_12$1
XFILLER_94_65 vssd1 vccd1 vccd1 vssd1 sky130_ef_sc_hd__decap_40_12$1
XFILLER_91_125 vssd1 vccd1 vccd1 vssd1 sky130_ef_sc_hd__decap_40_12$1
XFILLER_76_177 vssd1 vccd1 vccd1 vssd1 sky130_ef_sc_hd__decap_40_12$1
XFILLER_91_169 vssd1 vccd1 vccd1 vssd1 sky130_ef_sc_hd__decap_40_12$1
XFILLER_27_81 vssd1 vccd1 vccd1 vssd1 sky130_ef_sc_hd__decap_40_12$1
XFILLER_45_553 vssd1 vccd1 vccd1 vssd1 sky130_fd_sc_hd__fill_4$1
XFILLER_72_361 vssd1 vccd1 vccd1 vssd1 sky130_fd_sc_hd__fill_2$1
XFILLER_17_277 vssd1 vccd1 vccd1 vssd1 sky130_fd_sc_hd__fill_2$1
XFILLER_33_737 vccd1 vssd1 vccd1 vssd1 sky130_fd_sc_hd__fill_1$1
XFILLER_45_597 vssd1 vccd1 vccd1 vssd1 sky130_fd_sc_hd__fill_2$1
XFILLER_60_589 vssd1 vccd1 vccd1 vssd1 sky130_ef_sc_hd__decap_40_12$1
XFILLER_13_461 vssd1 vccd1 vccd1 vssd1 sky130_ef_sc_hd__decap_40_12$1
X_0960_ _1784_/A _0960_/X _0990_/B vssd1 vccd1 vccd1 vssd1 sky130_fd_sc_hd__or2_1$1
XFILLER_119_809 vssd1 vccd1 vccd1 vssd1 sky130_ef_sc_hd__decap_40_12$1
XFILLER_41_781 vssd1 vccd1 vccd1 vssd1 sky130_fd_sc_hd__fill_2$1
X_0891_ _0945_/A _0891_/X _0891_/B _0891_/C vccd1 vssd1 vccd1 vssd1 sky130_fd_sc_hd__or3_1$1
XFILLER_126_363 vccd1 vssd1 vccd1 vssd1 sky130_fd_sc_hd__fill_1$1
XFILLER_126_396 vssd1 vccd1 vccd1 vssd1 sky130_fd_sc_hd__fill_4$1
XFILLER_99_225 vssd1 vccd1 vccd1 vssd1 sky130_ef_sc_hd__decap_40_12$1
XFILLER_5_671 vccd1 vssd1 vccd1 vssd1 sky130_fd_sc_hd__fill_1$1
X_1512_ _1780_/A _1608_/CLK _1512_/D vccd1 vssd1 vccd1 vssd1 sky130_fd_sc_hd__dfxtp_1$1
X_1443_ _1443_/C1 _1442_/X _1465_/A2 hold90/X _1748_/D vssd1 vccd1 vccd1 vssd1 sky130_fd_sc_hd__o211a_1$1
XFILLER_4_41 vssd1 vccd1 vccd1 vssd1 sky130_ef_sc_hd__decap_40_12$1
XFILLER_68_601 vssd1 vccd1 vccd1 vssd1 sky130_ef_sc_hd__decap_40_12$1
XFILLER_4_85 vssd1 vccd1 vccd1 vssd1 sky130_ef_sc_hd__decap_40_12$1
X_1374_ _1715_/Q _1374_/X _1398_/B vssd1 vccd1 vccd1 vssd1 sky130_fd_sc_hd__or2_1$1
XFILLER_68_645 vssd1 vccd1 vccd1 vssd1 sky130_fd_sc_hd__fill_4$1
XFILLER_67_111 vccd1 vssd1 vccd1 vssd1 sky130_fd_sc_hd__fill_1$1
XFILLER_83_615 vccd1 vssd1 vccd1 vssd1 sky130_fd_sc_hd__fill_1$1
XTAP_TAPCELL_ROW_108_1922 vccd1 vssd1 sky130_fd_sc_hd__tapvpwrvgnd_1$1
XFILLER_55_317 vssd1 vccd1 vccd1 vssd1 sky130_ef_sc_hd__decap_40_12$1
XFILLER_70_309 vssd1 vccd1 vccd1 vssd1 sky130_ef_sc_hd__decap_40_12$1
XFILLER_36_531 vccd1 vssd1 vccd1 vssd1 sky130_fd_sc_hd__fill_1$1
XFILLER_63_361 vssd1 vccd1 vccd1 vssd1 sky130_ef_sc_hd__decap_40_12$1
XFILLER_23_225 vssd1 vccd1 vccd1 vssd1 sky130_ef_sc_hd__decap_40_12$1
XTAP_TAPCELL_ROW_63_1251 vccd1 vssd1 sky130_fd_sc_hd__tapvpwrvgnd_1$1
XTAP_TAPCELL_ROW_63_1240 vccd1 vssd1 sky130_fd_sc_hd__tapvpwrvgnd_1$1
XFILLER_23_39 vssd1 vccd1 vccd1 vssd1 sky130_ef_sc_hd__decap_40_12$1
XFILLER_32_781 vssd1 vccd1 vccd1 vssd1 sky130_ef_sc_hd__decap_40_12$1
XFILLER_137_617 vssd1 vccd1 vccd1 vssd1 sky130_fd_sc_hd__fill_2$1
XFILLER_133_823 vccd1 vssd1 vccd1 vssd1 sky130_fd_sc_hd__fill_1$1
XFILLER_120_528 vssd1 vccd1 vccd1 vssd1 sky130_fd_sc_hd__fill_4$1
XFILLER_99_781 vssd1 vccd1 vccd1 vssd1 sky130_fd_sc_hd__fill_2$1
XFILLER_58_133 vssd1 vccd1 vccd1 vssd1 sky130_fd_sc_hd__fill_4$1
XFILLER_101_753 vssd1 vccd1 vccd1 vssd1 sky130_ef_sc_hd__decap_40_12$1
XFILLER_86_475 vccd1 vssd1 vccd1 vssd1 sky130_fd_sc_hd__fill_1$1
XFILLER_86_453 vssd1 vccd1 vccd1 vssd1 sky130_ef_sc_hd__decap_40_12$1
XFILLER_59_667 vssd1 vccd1 vccd1 vssd1 sky130_fd_sc_hd__fill_4$1
XFILLER_47_807 vccd1 vssd1 vccd1 vssd1 sky130_fd_sc_hd__fill_1$1
XFILLER_104_53 vssd1 vccd1 vccd1 vssd1 sky130_ef_sc_hd__decap_40_12$1
XFILLER_101_797 vssd1 vccd1 vccd1 vssd1 sky130_fd_sc_hd__fill_8$1
XFILLER_73_125 vssd1 vccd1 vccd1 vssd1 sky130_ef_sc_hd__decap_40_12$1
XFILLER_58_177 vssd1 vccd1 vccd1 vssd1 sky130_ef_sc_hd__decap_40_12$1
XFILLER_104_97 vssd1 vccd1 vccd1 vssd1 sky130_ef_sc_hd__decap_40_12$1
XFILLER_27_553 vssd1 vccd1 vccd1 vssd1 sky130_fd_sc_hd__fill_4$1
XFILLER_39_391 vccd1 vssd1 vccd1 vssd1 sky130_fd_sc_hd__fill_1$1
XFILLER_82_670 vssd1 vccd1 vccd1 vssd1 sky130_fd_sc_hd__fill_2$1
XFILLER_73_169 vssd1 vccd1 vccd1 vssd1 sky130_ef_sc_hd__decap_40_12$1
XFILLER_70_821 vccd1 vssd1 vccd1 vssd1 sky130_fd_sc_hd__fill_1$1
XFILLER_54_361 vssd1 vccd1 vccd1 vssd1 sky130_fd_sc_hd__fill_2$1
XFILLER_42_501 vssd1 vccd1 vccd1 vssd1 sky130_ef_sc_hd__decap_40_12$1
XFILLER_120_41 vssd1 vccd1 vccd1 vssd1 sky130_ef_sc_hd__decap_40_12$1
XFILLER_82_692 vssd1 vccd1 vccd1 vssd1 sky130_fd_sc_hd__fill_8$1
XFILLER_27_597 vssd1 vccd1 vccd1 vssd1 sky130_ef_sc_hd__decap_40_12$1
XFILLER_42_589 vssd1 vccd1 vccd1 vssd1 sky130_ef_sc_hd__decap_40_12$1
XFILLER_120_85 vssd1 vccd1 vccd1 vssd1 sky130_ef_sc_hd__decap_40_12$1
XFILLER_127_105 vssd1 vccd1 vccd1 vssd1 sky130_fd_sc_hd__fill_4$1
XFILLER_109_820 vssd1 vccd1 vccd1 vssd1 sky130_ef_sc_hd__decap_40_12$1
XFILLER_10_475 vccd1 vssd1 vccd1 vssd1 sky130_fd_sc_hd__fill_1$1
XFILLER_6_413 vssd1 vccd1 vccd1 vssd1 sky130_fd_sc_hd__fill_4$1
XFILLER_127_149 vssd1 vccd1 vccd1 vssd1 sky130_ef_sc_hd__decap_40_12$1
XTAP_TAPCELL_ROW_94_1712 vccd1 vssd1 sky130_fd_sc_hd__tapvpwrvgnd_1$1
XFILLER_6_457 vssd1 vccd1 vccd1 vssd1 sky130_ef_sc_hd__decap_40_12$1
XFILLER_108_363 vccd1 vssd1 vccd1 vssd1 sky130_fd_sc_hd__fill_1$1
XFILLER_135_193 vssd1 vccd1 vccd1 vssd1 sky130_ef_sc_hd__decap_40_12$1
XFILLER_123_333 vssd1 vccd1 vccd1 vssd1 sky130_fd_sc_hd__fill_2$1
XFILLER_2_641 vssd1 vccd1 vccd1 vssd1 sky130_fd_sc_hd__fill_2$1
XFILLER_97_729 vssd1 vccd1 vccd1 vssd1 sky130_ef_sc_hd__decap_40_12$1
XFILLER_49_111 vccd1 vssd1 vccd1 vssd1 sky130_fd_sc_hd__fill_1$1
XFILLER_65_604 vssd1 vccd1 vccd1 vssd1 sky130_ef_sc_hd__decap_40_12$1
XFILLER_38_807 vssd1 vccd1 vccd1 vssd1 sky130_fd_sc_hd__fill_4$1
XFILLER_92_401 vssd1 vccd1 vccd1 vssd1 sky130_ef_sc_hd__decap_40_12$1
XFILLER_37_317 vssd1 vccd1 vccd1 vssd1 sky130_ef_sc_hd__decap_40_12$1
XTAP_TAPCELL_ROW_121_2108 vccd1 vssd1 sky130_fd_sc_hd__tapvpwrvgnd_1$1
XFILLER_92_445 vssd1 vccd1 vccd1 vssd1 sky130_ef_sc_hd__decap_40_12$1
XFILLER_18_531 vccd1 vssd1 vccd1 vssd1 sky130_fd_sc_hd__fill_1$1
X_1090_ _1791_/A _1090_/X _1122_/B vssd1 vccd1 vccd1 vssd1 sky130_fd_sc_hd__or2_1$1
XTAP_TAPCELL_ROW_121_2119 vccd1 vssd1 sky130_fd_sc_hd__tapvpwrvgnd_1$1
XFILLER_61_821 vssd1 vccd1 vccd1 vssd1 sky130_fd_sc_hd__fill_2$1
XFILLER_52_309 vssd1 vccd1 vccd1 vssd1 sky130_ef_sc_hd__decap_40_12$1
XFILLER_33_501 vssd1 vccd1 vccd1 vssd1 sky130_fd_sc_hd__fill_2$1
XFILLER_45_361 vssd1 vccd1 vccd1 vssd1 sky130_ef_sc_hd__decap_40_12$1
XTAP_TAPCELL_ROW_103_1852 vccd1 vssd1 sky130_fd_sc_hd__tapvpwrvgnd_1$1
XTAP_TAPCELL_ROW_103_1841 vccd1 vssd1 sky130_fd_sc_hd__tapvpwrvgnd_1$1
XFILLER_21_729 vssd1 vccd1 vccd1 vssd1 sky130_ef_sc_hd__decap_40_12$1
XFILLER_14_781 vssd1 vccd1 vccd1 vssd1 sky130_ef_sc_hd__decap_40_12$1
X_0943_ hold12/A _1411_/A _0945_/B _1700_/Q _1279_/A vccd1 vssd1 vccd1 vssd1 sky130_fd_sc_hd__a22o_1$1
XFILLER_119_617 vssd1 vccd1 vccd1 vssd1 sky130_ef_sc_hd__decap_40_12$1
XTAP_TAPCELL_ROW_31_768 vccd1 vssd1 sky130_fd_sc_hd__tapvpwrvgnd_1$1
Xclkbuf_leaf_35_wb_clk_i _1580_/CLK clkload1/A vssd1 vccd1 vccd1 vssd1 sky130_fd_sc_hd__clkbuf_8$1
XTAP_TAPCELL_ROW_136_2340 vccd1 vssd1 sky130_fd_sc_hd__tapvpwrvgnd_1$1
X_0874_ _0752_/A _1496_/D _0870_/X _1319_/C1 _1496_/Q _0873_/X vssd1 vccd1 vccd1 vssd1
+ sky130_fd_sc_hd__o221a_1$1
Xclkload10 _1704_/CLK clkload10/Y vssd1 vccd1 vccd1 vssd1 sky130_fd_sc_hd__bufinv_16$1
XFILLER_9_273 vssd1 vccd1 vccd1 vssd1 sky130_fd_sc_hd__fill_4$1
Xclkload32 _1762_/CLK clkload32/Y vccd1 vssd1 vccd1 vssd1 sky130_fd_sc_hd__clkinv_4$1
Xclkload21 clkload21/Y _1748_/CLK vccd1 vssd1 vccd1 vssd1 sky130_fd_sc_hd__clkinv_2$1
XTAP_TAPCELL_ROW_11_470 vccd1 vssd1 sky130_fd_sc_hd__tapvpwrvgnd_1$1
XFILLER_126_193 vssd1 vccd1 vccd1 vssd1 sky130_fd_sc_hd__fill_2$1
XFILLER_114_333 vssd1 vccd1 vccd1 vssd1 sky130_ef_sc_hd__decap_40_12$1
XFILLER_102_517 vssd1 vccd1 vccd1 vssd1 sky130_ef_sc_hd__decap_40_12$1
XFILLER_87_217 vssd1 vccd1 vccd1 vssd1 sky130_fd_sc_hd__fill_4$1
X_1426_ _1848_/A _1426_/X _1474_/B vssd1 vccd1 vccd1 vssd1 sky130_fd_sc_hd__or2_1$1
XFILLER_96_773 vssd1 vccd1 vccd1 vssd1 sky130_ef_sc_hd__decap_40_12$1
X_1357_ _1441_/C1 _1356_/X _1409_/A2 hold30/X _1706_/D vssd1 vccd1 vccd1 vssd1 sky130_fd_sc_hd__o211a_1$1
XFILLER_95_261 vssd1 vccd1 vccd1 vssd1 sky130_ef_sc_hd__decap_40_12$1
XFILLER_55_125 vssd1 vccd1 vccd1 vssd1 sky130_ef_sc_hd__decap_40_12$1
XFILLER_83_445 vssd1 vccd1 vccd1 vssd1 sky130_fd_sc_hd__fill_2$1
X_1288_ _1835_/A _1288_/X _1342_/B vssd1 vccd1 vccd1 vssd1 sky130_fd_sc_hd__or2_1$1
XFILLER_64_670 vssd1 vccd1 vccd1 vssd1 sky130_ef_sc_hd__decap_40_12$1
XFILLER_55_169 vssd1 vccd1 vccd1 vssd1 sky130_ef_sc_hd__decap_40_12$1
XFILLER_24_501 vssd1 vccd1 vccd1 vssd1 sky130_ef_sc_hd__decap_40_12$1
XFILLER_36_361 vssd1 vccd1 vccd1 vssd1 sky130_fd_sc_hd__fill_2$1
XTAP_TAPCELL_ROW_39_879 vccd1 vssd1 sky130_fd_sc_hd__tapvpwrvgnd_1$1
XFILLER_70_139 vccd1 vssd1 vccd1 vssd1 sky130_fd_sc_hd__fill_1$1
XTAP_TAPCELL_ROW_19_581 vccd1 vssd1 sky130_fd_sc_hd__tapvpwrvgnd_1$1
XTAP_TAPCELL_ROW_19_592 vccd1 vssd1 sky130_fd_sc_hd__tapvpwrvgnd_1$1
XFILLER_24_545 vssd1 vccd1 vccd1 vssd1 sky130_ef_sc_hd__decap_40_12$1
XFILLER_34_27 vccd1 vssd1 vccd1 vssd1 sky130_fd_sc_hd__fill_1$1
XFILLER_11_217 vssd1 vccd1 vccd1 vssd1 sky130_fd_sc_hd__fill_4$1
XFILLER_24_589 vssd1 vccd1 vccd1 vssd1 sky130_ef_sc_hd__decap_40_12$1
XFILLER_137_403 vssd1 vccd1 vccd1 vssd1 sky130_fd_sc_hd__fill_2$1
XFILLER_109_105 vssd1 vccd1 vccd1 vssd1 sky130_fd_sc_hd__fill_4$1
XFILLER_50_15 vssd1 vccd1 vccd1 vssd1 sky130_ef_sc_hd__decap_40_12$1
Xclkload4 clkload4/A clkload4/Y vccd1 vssd1 vccd1 vssd1 sky130_fd_sc_hd__clkinv_4$1
XFILLER_137_447 vccd1 vssd1 vccd1 vssd1 sky130_fd_sc_hd__fill_1$1
XFILLER_109_149 vssd1 vccd1 vccd1 vssd1 sky130_ef_sc_hd__decap_40_12$1
XTAP_TAPCELL_ROW_76_1442 vccd1 vssd1 sky130_fd_sc_hd__tapvpwrvgnd_1$1
XFILLER_3_405 vssd1 vccd1 vccd1 vssd1 sky130_ef_sc_hd__decap_40_12$1
XFILLER_117_193 vssd1 vccd1 vccd1 vssd1 sky130_ef_sc_hd__decap_40_12$1
XFILLER_105_333 vssd1 vccd1 vccd1 vssd1 sky130_fd_sc_hd__fill_2$1
XFILLER_3_449 vssd1 vccd1 vccd1 vssd1 sky130_ef_sc_hd__decap_40_12$1
XFILLER_132_141 vssd1 vccd1 vccd1 vssd1 sky130_ef_sc_hd__decap_40_12$1
XFILLER_121_837 vssd1 vccd1 vccd1 vssd1 sky130_fd_sc_hd__fill_2$1
XFILLER_79_729 vssd1 vccd1 vccd1 vssd1 sky130_fd_sc_hd__fill_8$1
XFILLER_59_57 vssd1 vccd1 vccd1 vssd1 sky130_ef_sc_hd__decap_40_12$1
Xfanout230 _1052_/B _1066_/B vssd1 vccd1 vccd1 vssd1 sky130_fd_sc_hd__clkbuf_8$1
Xfanout241 _0753_/X _0866_/B1 vssd1 vccd1 vccd1 vssd1 sky130_fd_sc_hd__buf_8$1
XFILLER_59_431 vssd1 vccd1 vccd1 vssd1 sky130_fd_sc_hd__fill_8$1
XFILLER_120_369 vccd1 vssd1 vccd1 vssd1 sky130_fd_sc_hd__fill_1$1
Xfanout274 _1417_/C1 _1319_/C1 vssd1 vccd1 vccd1 vssd1 sky130_fd_sc_hd__clkbuf_4$1
Xfanout263 _1305_/C1 vccd1 vssd1 _1319_/C1 vccd1 vssd1 sky130_fd_sc_hd__buf_4$1
XFILLER_101_561 vssd1 vccd1 vccd1 vssd1 sky130_ef_sc_hd__decap_40_12$1
XFILLER_87_795 vccd1 vssd1 vccd1 vssd1 sky130_fd_sc_hd__fill_1$1
XFILLER_19_317 vssd1 vccd1 vccd1 vssd1 sky130_ef_sc_hd__decap_40_12$1
XFILLER_131_51 vssd1 vccd1 vccd1 vssd1 sky130_fd_sc_hd__fill_4$1
XFILLER_74_489 vssd1 vccd1 vccd1 vssd1 sky130_ef_sc_hd__decap_40_12$1
XFILLER_15_501 vssd1 vccd1 vccd1 vssd1 sky130_fd_sc_hd__fill_2$1
XFILLER_27_361 vssd1 vccd1 vccd1 vssd1 sky130_ef_sc_hd__decap_40_12$1
XFILLER_34_309 vssd1 vccd1 vccd1 vssd1 sky130_ef_sc_hd__decap_40_12$1
XFILLER_43_821 vssd1 vccd1 vccd1 vssd1 sky130_fd_sc_hd__fill_2$1
XFILLER_91_55 vccd1 vssd1 vccd1 vssd1 sky130_fd_sc_hd__fill_1$1
XFILLER_70_673 vssd1 vccd1 vccd1 vssd1 sky130_fd_sc_hd__fill_2$1
XTAP_TAPCELL_ROW_118_2070 vccd1 vssd1 sky130_fd_sc_hd__tapvpwrvgnd_1$1
XFILLER_7_777 vssd1 vccd1 vccd1 vssd1 sky130_fd_sc_hd__fill_4$1
XFILLER_6_221 vssd1 vccd1 vccd1 vssd1 sky130_ef_sc_hd__decap_40_12$1
XFILLER_124_620 vssd1 vccd1 vccd1 vssd1 sky130_ef_sc_hd__decap_40_12$1
XFILLER_6_265 vssd1 vccd1 vccd1 vssd1 sky130_ef_sc_hd__decap_40_12$1
XFILLER_40_81 vssd1 vccd1 vccd1 vssd1 sky130_fd_sc_hd__fill_2$1
XFILLER_108_193 vssd1 vccd1 vccd1 vssd1 sky130_fd_sc_hd__fill_2$1
XTAP_TAPCELL_ROW_131_2270 vccd1 vssd1 sky130_fd_sc_hd__tapvpwrvgnd_1$1
XFILLER_69_217 vssd1 vccd1 vccd1 vssd1 sky130_fd_sc_hd__fill_4$1
XFILLER_124_697 vssd1 vccd1 vccd1 vssd1 sky130_fd_sc_hd__fill_2$1
XFILLER_97_559 vccd1 vssd1 vccd1 vssd1 sky130_fd_sc_hd__fill_1$1
X_1211_ _1409_/C1 _1210_/X _1211_/A2 hold2/X hold25/A vssd1 vccd1 vccd1 vssd1 sky130_fd_sc_hd__o211a_1$1
XFILLER_84_209 vssd1 vccd1 vccd1 vssd1 sky130_ef_sc_hd__decap_40_12$1
XFILLER_93_721 vssd1 vccd1 vccd1 vssd1 sky130_fd_sc_hd__fill_4$1
XFILLER_77_261 vssd1 vccd1 vccd1 vssd1 sky130_ef_sc_hd__decap_40_12$1
XFILLER_65_423 vssd1 vccd1 vccd1 vssd1 sky130_ef_sc_hd__decap_40_12$1
XFILLER_38_637 vssd1 vccd1 vccd1 vssd1 sky130_fd_sc_hd__fill_4$1
X_1142_ hold93/X _1142_/X _1144_/B vssd1 vccd1 vccd1 vssd1 sky130_fd_sc_hd__or2_1$1
XFILLER_93_765 vssd1 vccd1 vccd1 vssd1 sky130_ef_sc_hd__decap_40_12$1
XFILLER_37_125 vssd1 vccd1 vccd1 vssd1 sky130_ef_sc_hd__decap_40_12$1
X_1073_ _1471_/C1 _1072_/X _1079_/A2 hold49/X _1569_/D vssd1 vccd1 vccd1 vssd1 sky130_fd_sc_hd__o211a_1$1
XFILLER_92_253 vssd1 vccd1 vccd1 vssd1 sky130_ef_sc_hd__decap_40_12$1
XFILLER_53_629 vssd1 vccd1 vccd1 vssd1 sky130_ef_sc_hd__decap_40_12$1
XFILLER_18_361 vssd1 vccd1 vccd1 vssd1 sky130_fd_sc_hd__fill_2$1
XFILLER_34_810 vssd1 vccd1 vccd1 vssd1 sky130_fd_sc_hd__fill_2$1
XFILLER_37_169 vssd1 vccd1 vccd1 vssd1 sky130_ef_sc_hd__decap_40_12$1
XFILLER_80_448 vssd1 vccd1 vccd1 vssd1 sky130_ef_sc_hd__decap_40_12$1
XFILLER_52_139 vccd1 vssd1 vccd1 vssd1 sky130_fd_sc_hd__fill_1$1
XTAP_TAPCELL_ROW_36_838 vccd1 vssd1 sky130_fd_sc_hd__tapvpwrvgnd_1$1
XFILLER_46_681 vssd1 vccd1 vccd1 vssd1 sky130_ef_sc_hd__decap_40_12$1
XTAP_TAPCELL_ROW_47_1010 vccd1 vssd1 sky130_fd_sc_hd__tapvpwrvgnd_1$1
XFILLER_61_673 vssd1 vccd1 vccd1 vssd1 sky130_ef_sc_hd__decap_40_12$1
XTAP_TAPCELL_ROW_16_540 vccd1 vssd1 sky130_fd_sc_hd__tapvpwrvgnd_1$1
XFILLER_21_559 vccd1 vssd1 vccd1 vssd1 sky130_fd_sc_hd__fill_1$1
X_0926_ hold57/A _1344_/A _0926_/X hold52/A _1279_/A vccd1 vssd1 vccd1 vssd1 sky130_fd_sc_hd__a22o_1$1
X_0857_ _1808_/A _0879_/A2 _0857_/X _1686_/Q _0875_/B1 vccd1 vssd1 vccd1 vssd1 sky130_fd_sc_hd__a22o_1$1
XFILLER_20_29 vssd1 vccd1 vccd1 vssd1 sky130_ef_sc_hd__decap_40_12$1
XFILLER_136_29 vssd1 vccd1 vccd1 vssd1 sky130_ef_sc_hd__decap_40_12$1
X_0788_ _0750_/X _0788_/X _0787_/X _1846_/A _0747_/X _0786_/X vssd1 vccd1 vccd1 vssd1
+ sky130_fd_sc_hd__a2111o_1$1
XFILLER_114_141 vssd1 vccd1 vccd1 vssd1 sky130_ef_sc_hd__decap_40_12$1
XTAP_TAPCELL_ROW_58_1172 vccd1 vssd1 sky130_fd_sc_hd__tapvpwrvgnd_1$1
XFILLER_0_419 vccd1 vssd1 vccd1 vssd1 sky130_fd_sc_hd__fill_1$1
XFILLER_130_645 vssd1 vccd1 vccd1 vssd1 sky130_ef_sc_hd__decap_40_12$1
XFILLER_115_697 vssd1 vccd1 vccd1 vssd1 sky130_fd_sc_hd__fill_4$1
Xhold16 wbs_adr_i[2] hold16/X vssd1 vccd1 vccd1 vssd1 sky130_fd_sc_hd__dlygate4sd3_1$1
Xhold27 hold27/A hold27/X vssd1 vccd1 vccd1 vssd1 sky130_fd_sc_hd__dlygate4sd3_1$1
X_1409_ _1409_/C1 _1408_/X _1409_/A2 hold2/X hold3/A vssd1 vccd1 vccd1 vssd1 sky130_fd_sc_hd__o211a_1$1
Xhold38 hold38/A hold38/X vssd1 vccd1 vccd1 vssd1 sky130_fd_sc_hd__dlygate4sd3_1$1
XPHY_EDGE_ROW_89_Right_89 vccd1 vssd1 vccd1 vssd1 sky130_fd_sc_hd__decap_3$1
XTAP_TAPCELL_ROW_71_1372 vccd1 vssd1 sky130_fd_sc_hd__tapvpwrvgnd_1$1
XTAP_TAPCELL_ROW_71_1361 vccd1 vssd1 sky130_fd_sc_hd__tapvpwrvgnd_1$1
XFILLER_69_751 vssd1 vccd1 vccd1 vssd1 sky130_ef_sc_hd__decap_40_12$1
XFILLER_29_27 vssd1 vccd1 vccd1 vssd1 sky130_ef_sc_hd__decap_40_12$1
Xhold49 hold49/A hold49/X vssd1 vccd1 vccd1 vssd1 sky130_fd_sc_hd__dlygate4sd3_1$1
XFILLER_29_615 vccd1 vssd1 vccd1 vssd1 sky130_fd_sc_hd__fill_1$1
XFILLER_56_445 vssd1 vccd1 vccd1 vssd1 sky130_ef_sc_hd__decap_40_12$1
XFILLER_56_489 vssd1 vccd1 vccd1 vssd1 sky130_ef_sc_hd__decap_40_12$1
XFILLER_16_309 vssd1 vccd1 vccd1 vssd1 sky130_ef_sc_hd__decap_40_12$1
XFILLER_45_15 vssd1 vccd1 vccd1 vssd1 sky130_ef_sc_hd__decap_40_12$1
XPHY_EDGE_ROW_98_Right_98 vccd1 vssd1 vccd1 vssd1 sky130_fd_sc_hd__decap_3$1
XFILLER_51_161 vssd1 vccd1 vccd1 vssd1 sky130_fd_sc_hd__fill_4$1
XFILLER_137_211 vccd1 vssd1 vccd1 vssd1 sky130_fd_sc_hd__fill_1$1
XFILLER_61_69 vssd1 vccd1 vccd1 vssd1 sky130_ef_sc_hd__decap_40_12$1
XFILLER_20_581 vssd1 vccd1 vccd1 vssd1 sky130_fd_sc_hd__fill_4$1
XFILLER_137_277 vssd1 vccd1 vccd1 vssd1 sky130_fd_sc_hd__fill_2$1
XFILLER_125_417 vssd1 vccd1 vccd1 vssd1 sky130_ef_sc_hd__decap_40_12$1
XFILLER_117_3 vssd1 vccd1 vccd1 vssd1 sky130_ef_sc_hd__decap_40_12$1
XFILLER_4_725 vssd1 vccd1 vccd1 vssd1 sky130_ef_sc_hd__decap_40_12$1
XFILLER_106_642 vssd1 vccd1 vccd1 vssd1 sky130_fd_sc_hd__fill_2$1
XFILLER_133_461 vssd1 vccd1 vccd1 vssd1 sky130_fd_sc_hd__fill_2$1
XFILLER_106_653 vssd1 vccd1 vccd1 vssd1 sky130_fd_sc_hd__fill_2$1
XPHY_EDGE_ROW_5_Left_144 vccd1 vssd1 vccd1 vssd1 sky130_fd_sc_hd__decap_3$1
XFILLER_4_769 vssd1 vccd1 vccd1 vssd1 sky130_ef_sc_hd__decap_40_12$1
XFILLER_121_645 vssd1 vccd1 vccd1 vssd1 sky130_fd_sc_hd__fill_2$1
XFILLER_79_559 vccd1 vssd1 vccd1 vssd1 sky130_fd_sc_hd__fill_1$1
XFILLER_3_279 vccd1 vssd1 vccd1 vssd1 sky130_fd_sc_hd__fill_1$1
XFILLER_120_133 vssd1 vccd1 vccd1 vssd1 sky130_fd_sc_hd__fill_4$1
XFILLER_66_209 vssd1 vccd1 vccd1 vssd1 sky130_ef_sc_hd__decap_40_12$1
XFILLER_120_177 vssd1 vccd1 vccd1 vssd1 sky130_ef_sc_hd__decap_40_12$1
XFILLER_86_77 vssd1 vccd1 vccd1 vssd1 sky130_fd_sc_hd__fill_4$1
XFILLER_59_261 vssd1 vccd1 vccd1 vssd1 sky130_ef_sc_hd__decap_40_12$1
XTAP_TAPCELL_ROW_89_1633 vccd1 vssd1 sky130_fd_sc_hd__tapvpwrvgnd_1$1
XFILLER_75_754 vssd1 vccd1 vccd1 vssd1 sky130_ef_sc_hd__decap_40_12$1
XFILLER_19_125 vssd1 vccd1 vccd1 vssd1 sky130_ef_sc_hd__decap_40_12$1
XFILLER_90_713 vssd1 vccd1 vccd1 vssd1 sky130_ef_sc_hd__decap_40_12$1
XFILLER_74_253 vssd1 vccd1 vccd1 vssd1 sky130_ef_sc_hd__decap_40_12$1
XFILLER_19_93 vssd1 vccd1 vccd1 vssd1 sky130_ef_sc_hd__decap_40_12$1
XFILLER_19_169 vssd1 vccd1 vccd1 vssd1 sky130_ef_sc_hd__decap_40_12$1
XFILLER_90_757 vssd1 vccd1 vccd1 vssd1 sky130_ef_sc_hd__decap_40_12$1
XFILLER_28_681 vssd1 vccd1 vccd1 vssd1 sky130_ef_sc_hd__decap_40_12$1
XFILLER_34_139 vccd1 vssd1 vccd1 vssd1 sky130_fd_sc_hd__fill_1$1
XTAP_TAPCELL_ROW_100_1800 vccd1 vssd1 sky130_fd_sc_hd__tapvpwrvgnd_1$1
XFILLER_30_301 vssd1 vccd1 vccd1 vssd1 sky130_fd_sc_hd__fill_4$1
XFILLER_31_813 vccd1 vssd1 vccd1 vssd1 sky130_fd_sc_hd__fill_1$1
XFILLER_35_81 vssd1 vccd1 vccd1 vssd1 sky130_ef_sc_hd__decap_40_12$1
XFILLER_43_673 vssd1 vccd1 vccd1 vssd1 sky130_fd_sc_hd__fill_4$1
XFILLER_30_345 vssd1 vccd1 vccd1 vssd1 sky130_ef_sc_hd__decap_40_12$1
X_1760_ _1760_/Q _1760_/CLK _1760_/D vccd1 vssd1 vccd1 vssd1 sky130_fd_sc_hd__dfxtp_1$1
XFILLER_30_389 vssd1 vccd1 vccd1 vssd1 sky130_ef_sc_hd__decap_40_12$1
XFILLER_128_233 vssd1 vccd1 vccd1 vssd1 sky130_ef_sc_hd__decap_40_12$1
XFILLER_7_541 vssd1 vccd1 vccd1 vssd1 sky130_ef_sc_hd__decap_40_12$1
XFILLER_128_277 vssd1 vccd1 vccd1 vssd1 sky130_ef_sc_hd__decap_40_12$1
X_1691_ _1691_/Q _1755_/CLK _1691_/D vccd1 vssd1 vccd1 vssd1 sky130_fd_sc_hd__dfxtp_1$1
XFILLER_116_406 vssd1 vccd1 vccd1 vssd1 sky130_ef_sc_hd__decap_40_12$1
XFILLER_7_585 vssd1 vccd1 vccd1 vssd1 sky130_ef_sc_hd__decap_40_12$1
Xmax_cap249 vccd1 vssd1 _0784_/B1 _0744_/Y vccd1 vssd1 sky130_fd_sc_hd__buf_2$1
XFILLER_124_461 vccd1 vssd1 vccd1 vssd1 sky130_fd_sc_hd__fill_1$1
XFILLER_112_601 vssd1 vccd1 vccd1 vssd1 sky130_ef_sc_hd__decap_40_12$1
XFILLER_98_813 vssd1 vccd1 vccd1 vssd1 sky130_fd_sc_hd__fill_8$1
XFILLER_111_111 vccd1 vssd1 vccd1 vssd1 sky130_fd_sc_hd__fill_1$1
XFILLER_32_3 vssd1 vccd1 vccd1 vssd1 sky130_ef_sc_hd__decap_40_12$1
XFILLER_112_645 vssd1 vccd1 vccd1 vssd1 sky130_ef_sc_hd__decap_40_12$1
XTAP_TAPCELL_ROW_111_1962 vccd1 vssd1 sky130_fd_sc_hd__tapvpwrvgnd_1$1
XFILLER_100_829 vssd1 vccd1 vccd1 vssd1 sky130_ef_sc_hd__decap_40_12$1
XFILLER_85_529 vssd1 vccd1 vccd1 vssd1 sky130_ef_sc_hd__decap_40_12$1
XFILLER_78_581 vssd1 vccd1 vccd1 vssd1 sky130_fd_sc_hd__fill_4$1
XTAP_TAPCELL_ROW_53_1091 vccd1 vssd1 sky130_fd_sc_hd__tapvpwrvgnd_1$1
XFILLER_38_401 vssd1 vccd1 vccd1 vssd1 sky130_ef_sc_hd__decap_40_12$1
XFILLER_66_754 vssd1 vccd1 vccd1 vssd1 sky130_fd_sc_hd__fill_2$1
XFILLER_38_445 vssd1 vccd1 vccd1 vssd1 sky130_ef_sc_hd__decap_40_12$1
XFILLER_93_573 vssd1 vccd1 vccd1 vssd1 sky130_ef_sc_hd__decap_40_12$1
X_1125_ _1437_/C1 _1124_/X _1145_/A2 hold107/X _1594_/D vssd1 vccd1 vccd1 vssd1 sky130_fd_sc_hd__o211a_1$1
XFILLER_81_724 vssd1 vccd1 vccd1 vssd1 sky130_fd_sc_hd__fill_4$1
XFILLER_38_489 vssd1 vccd1 vccd1 vssd1 sky130_ef_sc_hd__decap_40_12$1
X_1056_ _1056_/A _1056_/X _1078_/B vssd1 vccd1 vccd1 vssd1 sky130_fd_sc_hd__or2_1$1
XFILLER_80_245 vssd1 vccd1 vccd1 vssd1 sky130_fd_sc_hd__fill_4$1
XFILLER_80_289 vssd1 vccd1 vccd1 vssd1 sky130_ef_sc_hd__decap_40_12$1
XFILLER_33_161 vssd1 vccd1 vccd1 vssd1 sky130_fd_sc_hd__fill_4$1
XFILLER_40_109 vssd1 vccd1 vccd1 vssd1 sky130_ef_sc_hd__decap_40_12$1
XFILLER_21_389 vssd1 vccd1 vccd1 vssd1 sky130_fd_sc_hd__fill_2$1
XFILLER_31_39 vssd1 vccd1 vccd1 vssd1 sky130_ef_sc_hd__decap_40_12$1
XFILLER_135_726 vssd1 vccd1 vccd1 vssd1 sky130_fd_sc_hd__fill_2$1
X_0909_ _0945_/A _0909_/X _0909_/B _0909_/C vccd1 vssd1 vccd1 vssd1 sky130_fd_sc_hd__or3_1$1
XFILLER_119_277 vssd1 vccd1 vccd1 vssd1 sky130_fd_sc_hd__fill_2$1
XFILLER_107_417 vssd1 vccd1 vccd1 vssd1 sky130_ef_sc_hd__decap_40_12$1
XTAP_TAPCELL_ROW_73_1401 vccd1 vssd1 sky130_fd_sc_hd__tapvpwrvgnd_1$1
XFILLER_88_301 vssd1 vccd1 vccd1 vssd1 sky130_fd_sc_hd__fill_4$1
XFILLER_130_442 vssd1 vccd1 vccd1 vssd1 sky130_fd_sc_hd__fill_2$1
XFILLER_102_133 vssd1 vccd1 vccd1 vssd1 sky130_fd_sc_hd__fill_4$1
XFILLER_88_367 vccd1 vssd1 vccd1 vssd1 sky130_fd_sc_hd__fill_1$1
XFILLER_88_345 vssd1 vccd1 vccd1 vssd1 sky130_ef_sc_hd__decap_40_12$1
XFILLER_0_249 vssd1 vccd1 vccd1 vssd1 sky130_fd_sc_hd__fill_2$1
XFILLER_130_475 vccd1 vssd1 vccd1 vssd1 sky130_fd_sc_hd__fill_1$1
XFILLER_102_177 vssd1 vccd1 vccd1 vssd1 sky130_ef_sc_hd__decap_40_12$1
XFILLER_57_721 vssd1 vccd1 vccd1 vssd1 sky130_fd_sc_hd__fill_4$1
XFILLER_48_209 vssd1 vccd1 vccd1 vssd1 sky130_ef_sc_hd__decap_40_12$1
XFILLER_29_445 vssd1 vccd1 vccd1 vssd1 sky130_fd_sc_hd__fill_2$1
XFILLER_72_713 vssd1 vccd1 vccd1 vssd1 sky130_ef_sc_hd__decap_40_12$1
XFILLER_56_253 vssd1 vccd1 vccd1 vssd1 sky130_ef_sc_hd__decap_40_12$1
XFILLER_17_629 vssd1 vccd1 vccd1 vssd1 sky130_ef_sc_hd__decap_40_12$1
XFILLER_84_584 vssd1 vccd1 vccd1 vssd1 sky130_fd_sc_hd__fill_4$1
XFILLER_72_757 vssd1 vccd1 vccd1 vssd1 sky130_ef_sc_hd__decap_40_12$1
XFILLER_72_735 vccd1 vssd1 vccd1 vssd1 sky130_fd_sc_hd__fill_1$1
XFILLER_71_223 vccd1 vssd1 vccd1 vssd1 sky130_fd_sc_hd__fill_1$1
XFILLER_16_139 vccd1 vssd1 vccd1 vssd1 sky130_fd_sc_hd__fill_1$1
XFILLER_112_53 vssd1 vccd1 vccd1 vssd1 sky130_ef_sc_hd__decap_40_12$1
XFILLER_112_97 vssd1 vccd1 vccd1 vssd1 sky130_ef_sc_hd__decap_40_12$1
XTAP_TAPCELL_ROW_84_1563 vccd1 vssd1 sky130_fd_sc_hd__tapvpwrvgnd_1$1
XFILLER_52_470 vssd1 vccd1 vccd1 vssd1 sky130_fd_sc_hd__fill_4$1
XFILLER_12_301 vssd1 vccd1 vccd1 vssd1 sky130_fd_sc_hd__fill_4$1
XFILLER_25_673 vssd1 vccd1 vccd1 vssd1 sky130_ef_sc_hd__decap_40_12$1
XFILLER_31_109 vssd1 vccd1 vccd1 vssd1 sky130_fd_sc_hd__fill_2$1
XFILLER_40_610 vssd1 vccd1 vccd1 vssd1 sky130_ef_sc_hd__decap_40_12$1
XFILLER_12_345 vssd1 vccd1 vccd1 vssd1 sky130_ef_sc_hd__decap_40_12$1
XPHY_EDGE_ROW_117_Right_117 vccd1 vssd1 vccd1 vssd1 sky130_fd_sc_hd__decap_3$1
XFILLER_8_305 vssd1 vccd1 vccd1 vssd1 sky130_fd_sc_hd__fill_2$1
XFILLER_138_531 vccd1 vssd1 vccd1 vssd1 sky130_fd_sc_hd__fill_1$1
XFILLER_12_389 vssd1 vccd1 vccd1 vssd1 sky130_ef_sc_hd__decap_40_12$1
XFILLER_40_698 vssd1 vccd1 vccd1 vssd1 sky130_fd_sc_hd__fill_2$1
XFILLER_125_225 vssd1 vccd1 vccd1 vssd1 sky130_ef_sc_hd__decap_40_12$1
XFILLER_4_533 vssd1 vccd1 vccd1 vssd1 sky130_ef_sc_hd__decap_40_12$1
XFILLER_106_450 vssd1 vccd1 vccd1 vssd1 sky130_ef_sc_hd__decap_40_12$1
XFILLER_98_109 vssd1 vccd1 vccd1 vssd1 sky130_ef_sc_hd__decap_40_12$1
XFILLER_0_783 vccd1 vssd1 vccd1 vssd1 sky130_fd_sc_hd__fill_1$1
XFILLER_75_573 vssd1 vccd1 vccd1 vssd1 sky130_ef_sc_hd__decap_40_12$1
XTAP_TAPCELL_ROW_126_2191 vccd1 vssd1 sky130_fd_sc_hd__tapvpwrvgnd_1$1
XFILLER_48_798 vccd1 vssd1 vccd1 vssd1 sky130_fd_sc_hd__fill_1$1
XFILLER_62_245 vssd1 vccd1 vccd1 vssd1 sky130_fd_sc_hd__fill_4$1
XFILLER_62_289 vssd1 vccd1 vccd1 vssd1 sky130_ef_sc_hd__decap_40_12$1
XFILLER_15_161 vssd1 vccd1 vccd1 vssd1 sky130_fd_sc_hd__fill_4$1
XFILLER_22_109 vssd1 vccd1 vccd1 vssd1 sky130_ef_sc_hd__decap_40_12$1
XFILLER_43_470 vssd1 vccd1 vccd1 vssd1 sky130_ef_sc_hd__decap_40_12$1
XTAP_TAPCELL_ROW_46_988 vccd1 vssd1 sky130_fd_sc_hd__tapvpwrvgnd_1$1
XTAP_TAPCELL_ROW_26_690 vccd1 vssd1 sky130_fd_sc_hd__tapvpwrvgnd_1$1
XFILLER_30_153 vssd1 vccd1 vccd1 vssd1 sky130_ef_sc_hd__decap_40_12$1
XFILLER_31_665 vssd1 vccd1 vccd1 vssd1 sky130_fd_sc_hd__fill_4$1
XFILLER_129_531 vssd1 vccd1 vccd1 vssd1 sky130_ef_sc_hd__decap_40_12$1
X_1812_ _1812_/A _1812_/X vssd1 vccd1 vccd1 vssd1 sky130_fd_sc_hd__clkbuf_2$1
XFILLER_30_197 vssd1 vccd1 vccd1 vssd1 sky130_ef_sc_hd__decap_40_12$1
XFILLER_117_726 vssd1 vccd1 vccd1 vssd1 sky130_fd_sc_hd__fill_2$1
XFILLER_117_704 vssd1 vccd1 vccd1 vssd1 sky130_fd_sc_hd__fill_2$1
XPHY_EDGE_ROW_68_Left_207 vccd1 vssd1 vccd1 vssd1 sky130_fd_sc_hd__decap_3$1
X_1743_ _1851_/A clkload8/A _1743_/D vccd1 vssd1 vccd1 vssd1 sky130_fd_sc_hd__dfxtp_1$1
X_1674_ _1836_/A _1738_/CLK _1674_/D vccd1 vssd1 vccd1 vssd1 sky130_fd_sc_hd__dfxtp_1$1
XFILLER_7_393 vssd1 vccd1 vccd1 vssd1 sky130_ef_sc_hd__decap_40_12$1
XFILLER_89_109 vssd1 vccd1 vccd1 vssd1 sky130_fd_sc_hd__fill_2$1
XFILLER_131_217 vssd1 vccd1 vccd1 vssd1 sky130_fd_sc_hd__fill_4$1
XFILLER_125_781 vssd1 vccd1 vccd1 vssd1 sky130_fd_sc_hd__fill_2$1
XFILLER_98_632 vssd1 vccd1 vccd1 vssd1 sky130_ef_sc_hd__decap_40_12$1
XTAP_TAPCELL_ROW_55_1131 vccd1 vssd1 sky130_fd_sc_hd__tapvpwrvgnd_1$1
XTAP_TAPCELL_ROW_55_1120 vccd1 vssd1 sky130_fd_sc_hd__tapvpwrvgnd_1$1
XFILLER_58_529 vssd1 vccd1 vccd1 vssd1 sky130_fd_sc_hd__fill_2$1
XFILLER_112_497 vssd1 vccd1 vccd1 vssd1 sky130_ef_sc_hd__decap_40_12$1
XFILLER_85_337 vssd1 vccd1 vccd1 vssd1 sky130_ef_sc_hd__decap_40_12$1
XPHY_EDGE_ROW_77_Left_216 vccd1 vssd1 vccd1 vssd1 sky130_fd_sc_hd__decap_3$1
XFILLER_38_253 vssd1 vccd1 vccd1 vssd1 sky130_ef_sc_hd__decap_40_12$1
XFILLER_53_223 vccd1 vssd1 vccd1 vssd1 sky130_fd_sc_hd__fill_1$1
XFILLER_81_543 vccd1 vssd1 vccd1 vssd1 sky130_fd_sc_hd__fill_1$1
X_1108_ _1804_/A _1108_/X _1122_/B vssd1 vccd1 vccd1 vssd1 sky130_fd_sc_hd__or2_1$1
XFILLER_54_757 vssd1 vccd1 vccd1 vssd1 sky130_ef_sc_hd__decap_40_12$1
X_1039_ _1449_/C1 _1038_/X _1053_/A2 hold210/X _1552_/D vssd1 vccd1 vccd1 vssd1 sky130_fd_sc_hd__o211a_1$1
XFILLER_13_109 vssd1 vccd1 vccd1 vssd1 sky130_fd_sc_hd__fill_2$1
XFILLER_41_429 vssd1 vccd1 vccd1 vssd1 sky130_ef_sc_hd__decap_40_12$1
XTAP_TAPCELL_ROW_66_1293 vccd1 vssd1 sky130_fd_sc_hd__tapvpwrvgnd_1$1
XFILLER_22_643 vccd1 vssd1 vccd1 vssd1 sky130_fd_sc_hd__fill_1$1
XFILLER_42_27 vccd1 vssd1 vccd1 vssd1 sky130_fd_sc_hd__fill_1$1
XPHY_EDGE_ROW_86_Left_225 vccd1 vssd1 vccd1 vssd1 sky130_fd_sc_hd__decap_3$1
XFILLER_6_809 vssd1 vccd1 vccd1 vssd1 sky130_fd_sc_hd__fill_2$1
XFILLER_108_737 vssd1 vccd1 vccd1 vssd1 sky130_ef_sc_hd__decap_40_12$1
XFILLER_107_225 vssd1 vccd1 vccd1 vssd1 sky130_ef_sc_hd__decap_40_12$1
XFILLER_116_781 vssd1 vccd1 vccd1 vssd1 sky130_fd_sc_hd__fill_8$1
XFILLER_1_503 vccd1 vssd1 vccd1 vssd1 sky130_fd_sc_hd__fill_1$1
XFILLER_77_805 vssd1 vccd1 vccd1 vssd1 sky130_ef_sc_hd__decap_40_12$1
XFILLER_103_486 vssd1 vccd1 vccd1 vssd1 sky130_fd_sc_hd__fill_4$1
XFILLER_88_153 vssd1 vccd1 vccd1 vssd1 sky130_ef_sc_hd__decap_40_12$1
XFILLER_67_57 vssd1 vccd1 vccd1 vssd1 sky130_ef_sc_hd__decap_40_12$1
XPHY_EDGE_ROW_95_Left_234 vccd1 vssd1 vccd1 vssd1 sky130_fd_sc_hd__decap_3$1
XFILLER_88_197 vssd1 vccd1 vccd1 vssd1 sky130_ef_sc_hd__decap_40_12$1
XFILLER_57_573 vssd1 vccd1 vccd1 vssd1 sky130_fd_sc_hd__fill_8$1
XTAP_TAPCELL_ROW_4_363 vccd1 vssd1 sky130_fd_sc_hd__tapvpwrvgnd_1$1
XFILLER_91_329 vssd1 vccd1 vccd1 vssd1 sky130_fd_sc_hd__fill_4$1
XFILLER_44_245 vssd1 vccd1 vccd1 vssd1 sky130_fd_sc_hd__fill_4$1
XFILLER_44_289 vssd1 vccd1 vccd1 vssd1 sky130_ef_sc_hd__decap_40_12$1
XFILLER_16_83 vccd1 vssd1 vccd1 vssd1 sky130_fd_sc_hd__fill_1$1
XTAP_TAPCELL_ROW_43_947 vccd1 vssd1 sky130_fd_sc_hd__tapvpwrvgnd_1$1
XFILLER_12_153 vssd1 vccd1 vccd1 vssd1 sky130_ef_sc_hd__decap_40_12$1
XFILLER_13_665 vssd1 vccd1 vccd1 vssd1 sky130_fd_sc_hd__fill_4$1
XFILLER_9_669 vssd1 vccd1 vccd1 vssd1 sky130_fd_sc_hd__fill_2$1
XFILLER_40_473 vssd1 vccd1 vccd1 vssd1 sky130_fd_sc_hd__fill_2$1
XFILLER_126_501 vssd1 vccd1 vccd1 vssd1 sky130_ef_sc_hd__decap_40_12$1
XFILLER_12_197 vssd1 vccd1 vccd1 vssd1 sky130_ef_sc_hd__decap_40_12$1
XFILLER_126_545 vssd1 vccd1 vccd1 vssd1 sky130_ef_sc_hd__decap_40_12$1
XTAP_TAPCELL_ROW_97_1754 vccd1 vssd1 sky130_fd_sc_hd__tapvpwrvgnd_1$1
XFILLER_126_589 vssd1 vccd1 vccd1 vssd1 sky130_ef_sc_hd__decap_40_12$1
XFILLER_113_217 vssd1 vccd1 vccd1 vssd1 sky130_fd_sc_hd__fill_4$1
XFILLER_107_781 vssd1 vccd1 vccd1 vssd1 sky130_fd_sc_hd__fill_2$1
XFILLER_4_363 vccd1 vssd1 vccd1 vssd1 sky130_fd_sc_hd__fill_1$1
X_1390_ hold96/X _1390_/X _1398_/B vssd1 vccd1 vccd1 vssd1 sky130_fd_sc_hd__or2_1$1
XTAP_TAPCELL_ROW_128_2220 vccd1 vssd1 sky130_fd_sc_hd__tapvpwrvgnd_1$1
XFILLER_121_261 vssd1 vccd1 vccd1 vssd1 sky130_ef_sc_hd__decap_40_12$1
XFILLER_95_613 vssd1 vccd1 vccd1 vssd1 sky130_fd_sc_hd__fill_2$1
XFILLER_95_657 vssd1 vccd1 vccd1 vssd1 sky130_ef_sc_hd__decap_40_12$1
XFILLER_67_337 vssd1 vccd1 vccd1 vssd1 sky130_ef_sc_hd__decap_40_12$1
XFILLER_82_307 vccd1 vssd1 vccd1 vssd1 sky130_fd_sc_hd__fill_1$1
XTAP_TAPCELL_ROW_50_1050 vccd1 vssd1 sky130_fd_sc_hd__tapvpwrvgnd_1$1
XFILLER_94_189 vssd1 vccd1 vccd1 vssd1 sky130_fd_sc_hd__fill_4$1
XFILLER_36_713 vssd1 vccd1 vccd1 vssd1 sky130_ef_sc_hd__decap_40_12$1
XFILLER_36_746 vssd1 vccd1 vccd1 vssd1 sky130_fd_sc_hd__fill_2$1
XFILLER_91_841 vccd1 vssd1 vccd1 vssd1 sky130_fd_sc_hd__fill_1$1
XFILLER_35_223 vccd1 vssd1 vccd1 vssd1 sky130_fd_sc_hd__fill_1$1
XFILLER_36_757 vssd1 vccd1 vccd1 vssd1 sky130_ef_sc_hd__decap_40_12$1
XFILLER_23_429 vssd1 vccd1 vccd1 vssd1 sky130_ef_sc_hd__decap_40_12$1
XTAP_TAPCELL_ROW_106_1894 vccd1 vssd1 sky130_fd_sc_hd__tapvpwrvgnd_1$1
XTAP_TAPCELL_ROW_106_1883 vccd1 vssd1 sky130_fd_sc_hd__tapvpwrvgnd_1$1
XTAP_TAPCELL_ROW_21_608 vccd1 vssd1 sky130_fd_sc_hd__tapvpwrvgnd_1$1
XTAP_TAPCELL_ROW_21_619 vccd1 vssd1 sky130_fd_sc_hd__tapvpwrvgnd_1$1
XFILLER_31_473 vssd1 vccd1 vccd1 vssd1 sky130_ef_sc_hd__decap_40_12$1
XFILLER_136_309 vssd1 vccd1 vccd1 vssd1 sky130_ef_sc_hd__decap_40_12$1
XFILLER_129_361 vssd1 vccd1 vccd1 vssd1 sky130_fd_sc_hd__fill_8$1
Xhold124 wbs_dat_i[20] input32/A vssd1 vccd1 vccd1 vssd1 sky130_fd_sc_hd__dlygate4sd3_1$1
Xhold102 _1569_/Q _1072_/A vssd1 vccd1 vccd1 vssd1 sky130_fd_sc_hd__dlygate4sd3_1$1
XFILLER_117_578 vssd1 vccd1 vccd1 vssd1 sky130_ef_sc_hd__decap_40_12$1
Xhold113 _1566_/Q _1066_/A vssd1 vccd1 vccd1 vssd1 sky130_fd_sc_hd__dlygate4sd3_1$1
X_1726_ _1726_/Q _1726_/CLK _1726_/D vccd1 vssd1 vccd1 vssd1 sky130_fd_sc_hd__dfxtp_1$1
XFILLER_105_707 vccd1 vssd1 vccd1 vssd1 sky130_fd_sc_hd__fill_1$1
Xhold135 _1698_/Q _1338_/A vssd1 vccd1 vccd1 vssd1 sky130_fd_sc_hd__dlygate4sd3_1$1
Xhold157 _1568_/Q _1070_/A vssd1 vccd1 vccd1 vssd1 sky130_fd_sc_hd__dlygate4sd3_1$1
Xhold146 input39/X hold146/X vssd1 vccd1 vccd1 vssd1 sky130_fd_sc_hd__dlygate4sd3_1$1
Xhold168 _1688_/Q _1318_/A vssd1 vccd1 vccd1 vssd1 sky130_fd_sc_hd__dlygate4sd3_1$1
X_1657_ _1657_/Q _1754_/CLK _1657_/D vccd1 vssd1 vccd1 vssd1 sky130_fd_sc_hd__dfxtp_2$1
Xhold179 _1626_/Q _1190_/A vssd1 vccd1 vccd1 vssd1 sky130_fd_sc_hd__dlygate4sd3_1$1
XFILLER_59_805 vssd1 vccd1 vccd1 vssd1 sky130_fd_sc_hd__fill_2$1
X_1588_ _1806_/A clkload7/A _1588_/D vccd1 vssd1 vccd1 vssd1 sky130_fd_sc_hd__dfxtp_1$1
XFILLER_100_401 vssd1 vccd1 vccd1 vssd1 sky130_ef_sc_hd__decap_40_12$1
XFILLER_98_473 vssd1 vccd1 vccd1 vssd1 sky130_fd_sc_hd__fill_2$1
XFILLER_86_613 vssd1 vccd1 vccd1 vssd1 sky130_ef_sc_hd__decap_40_12$1
XFILLER_100_445 vssd1 vccd1 vccd1 vssd1 sky130_ef_sc_hd__decap_40_12$1
XFILLER_85_167 vccd1 vssd1 vccd1 vssd1 sky130_fd_sc_hd__fill_1$1
XFILLER_37_27 vssd1 vccd1 vccd1 vssd1 sky130_ef_sc_hd__decap_40_12$1
XFILLER_100_489 vssd1 vccd1 vccd1 vssd1 sky130_ef_sc_hd__decap_40_12$1
XFILLER_73_329 vssd1 vccd1 vccd1 vssd1 sky130_fd_sc_hd__fill_4$1
XTAP_TAPCELL_ROW_68_1322 vccd1 vssd1 sky130_fd_sc_hd__tapvpwrvgnd_1$1
XTAP_TAPCELL_ROW_1_311 vccd1 vssd1 sky130_fd_sc_hd__tapvpwrvgnd_1$1
XTAP_TAPCELL_ROW_1_322 vccd1 vssd1 sky130_fd_sc_hd__tapvpwrvgnd_1$1
XFILLER_26_245 vssd1 vccd1 vccd1 vssd1 sky130_fd_sc_hd__fill_4$1
XFILLER_53_15 vssd1 vccd1 vccd1 vssd1 sky130_ef_sc_hd__decap_40_12$1
XFILLER_26_289 vssd1 vccd1 vccd1 vssd1 sky130_ef_sc_hd__decap_40_12$1
XTAP_TAPCELL_ROW_81_1522 vccd1 vssd1 sky130_fd_sc_hd__tapvpwrvgnd_1$1
XTAP_TAPCELL_ROW_81_1511 vccd1 vssd1 sky130_fd_sc_hd__tapvpwrvgnd_1$1
XFILLER_41_237 vssd1 vccd1 vccd1 vssd1 sky130_ef_sc_hd__decap_40_12$1
XTAP_TAPCELL_ROW_40_906 vccd1 vssd1 sky130_fd_sc_hd__tapvpwrvgnd_1$1
XFILLER_10_613 vssd1 vccd1 vccd1 vssd1 sky130_ef_sc_hd__decap_40_12$1
XFILLER_22_473 vssd1 vccd1 vccd1 vssd1 sky130_fd_sc_hd__fill_2$1
XFILLER_108_501 vssd1 vccd1 vccd1 vssd1 sky130_ef_sc_hd__decap_40_12$1
XFILLER_10_657 vssd1 vccd1 vccd1 vssd1 sky130_ef_sc_hd__decap_40_12$1
XFILLER_5_105 vssd1 vccd1 vccd1 vssd1 sky130_fd_sc_hd__fill_4$1
XFILLER_118_41 vssd1 vccd1 vccd1 vssd1 sky130_ef_sc_hd__decap_40_12$1
XTAP_TAPCELL_ROW_79_1484 vccd1 vssd1 sky130_fd_sc_hd__tapvpwrvgnd_1$1
XFILLER_5_149 vssd1 vccd1 vccd1 vssd1 sky130_ef_sc_hd__decap_40_12$1
XFILLER_108_589 vssd1 vccd1 vccd1 vssd1 sky130_fd_sc_hd__fill_2$1
XTAP_TAPCELL_ROW_9_433 vccd1 vssd1 sky130_fd_sc_hd__tapvpwrvgnd_1$1
XFILLER_118_85 vssd1 vccd1 vccd1 vssd1 sky130_ef_sc_hd__decap_40_12$1
XTAP_TAPCELL_ROW_92_1673 vccd1 vssd1 sky130_fd_sc_hd__tapvpwrvgnd_1$1
XFILLER_1_333 vssd1 vccd1 vccd1 vssd1 sky130_fd_sc_hd__fill_2$1
XFILLER_110_209 vssd1 vccd1 vccd1 vssd1 sky130_ef_sc_hd__decap_40_12$1
XFILLER_103_261 vssd1 vccd1 vccd1 vssd1 sky130_ef_sc_hd__decap_40_12$1
XTAP_TAPCELL_ROW_92_1684 vccd1 vssd1 sky130_fd_sc_hd__tapvpwrvgnd_1$1
XFILLER_89_473 vssd1 vccd1 vccd1 vssd1 sky130_fd_sc_hd__fill_4$1
XFILLER_49_337 vssd1 vccd1 vccd1 vssd1 sky130_ef_sc_hd__decap_40_12$1
XFILLER_64_307 vccd1 vssd1 vccd1 vssd1 sky130_fd_sc_hd__fill_1$1
XFILLER_94_77 vssd1 vccd1 vccd1 vssd1 sky130_fd_sc_hd__fill_4$1
XFILLER_76_189 vssd1 vccd1 vccd1 vssd1 sky130_fd_sc_hd__fill_4$1
XFILLER_18_713 vssd1 vccd1 vccd1 vssd1 sky130_ef_sc_hd__decap_40_12$1
XTAP_TAPCELL_ROW_123_2150 vccd1 vssd1 sky130_fd_sc_hd__tapvpwrvgnd_1$1
XFILLER_91_137 vssd1 vccd1 vccd1 vssd1 sky130_ef_sc_hd__decap_40_12$1
XFILLER_73_841 vccd1 vssd1 vccd1 vssd1 sky130_fd_sc_hd__fill_1$1
XFILLER_17_223 vccd1 vssd1 vccd1 vssd1 sky130_fd_sc_hd__fill_1$1
XFILLER_18_757 vssd1 vccd1 vccd1 vssd1 sky130_ef_sc_hd__decap_40_12$1
XFILLER_27_93 vssd1 vccd1 vccd1 vssd1 sky130_ef_sc_hd__decap_40_12$1
XFILLER_33_727 vccd1 vssd1 vccd1 vssd1 sky130_fd_sc_hd__fill_1$1
XFILLER_60_546 vssd1 vccd1 vccd1 vssd1 sky130_ef_sc_hd__decap_40_12$1
XFILLER_26_790 vccd1 vssd1 vccd1 vssd1 sky130_fd_sc_hd__fill_1$1
XFILLER_41_760 vssd1 vccd1 vccd1 vssd1 sky130_fd_sc_hd__fill_8$1
X_0890_ hold96/A _1344_/A _0891_/C hold92/A _1411_/A vccd1 vssd1 vccd1 vssd1 sky130_fd_sc_hd__a22o_1$1
XFILLER_13_473 vssd1 vccd1 vccd1 vssd1 sky130_ef_sc_hd__decap_40_12$1
XFILLER_43_81 vssd1 vccd1 vccd1 vssd1 sky130_ef_sc_hd__decap_40_12$1
XFILLER_118_309 vssd1 vccd1 vccd1 vssd1 sky130_ef_sc_hd__decap_40_12$1
X_1511_ _1779_/A _1608_/CLK _1511_/D vccd1 vssd1 vccd1 vssd1 sky130_fd_sc_hd__dfxtp_1$1
X_1442_ _1442_/A _1442_/X _1464_/B vssd1 vccd1 vccd1 vssd1 sky130_fd_sc_hd__or2_1$1
XFILLER_99_237 vssd1 vccd1 vccd1 vssd1 sky130_ef_sc_hd__decap_40_12$1
XFILLER_4_193 vssd1 vccd1 vccd1 vssd1 sky130_fd_sc_hd__fill_2$1
XFILLER_68_613 vssd1 vccd1 vccd1 vssd1 sky130_ef_sc_hd__decap_40_12$1
XFILLER_4_53 vssd1 vccd1 vccd1 vssd1 sky130_ef_sc_hd__decap_40_12$1
X_1373_ _1449_/C1 _1372_/X _1399_/A2 hold21/X hold22/A vssd1 vccd1 vccd1 vssd1 sky130_fd_sc_hd__o211a_1$1
XFILLER_68_657 vssd1 vccd1 vccd1 vssd1 sky130_ef_sc_hd__decap_40_12$1
XFILLER_4_97 vssd1 vccd1 vccd1 vssd1 sky130_ef_sc_hd__decap_40_12$1
XFILLER_110_754 vssd1 vccd1 vccd1 vssd1 sky130_fd_sc_hd__fill_2$1
XFILLER_95_465 vssd1 vccd1 vccd1 vssd1 sky130_fd_sc_hd__fill_4$1
XFILLER_67_167 vccd1 vssd1 vccd1 vssd1 sky130_fd_sc_hd__fill_1$1
XTAP_TAPCELL_ROW_108_1923 vccd1 vssd1 sky130_fd_sc_hd__tapvpwrvgnd_1$1
XFILLER_55_329 vssd1 vccd1 vccd1 vssd1 sky130_fd_sc_hd__fill_4$1
XFILLER_82_137 vssd1 vccd1 vccd1 vssd1 sky130_fd_sc_hd__fill_2$1
XFILLER_91_671 vccd1 vssd1 vccd1 vssd1 sky130_fd_sc_hd__fill_1$1
XFILLER_63_373 vssd1 vccd1 vccd1 vssd1 sky130_fd_sc_hd__fill_8$1
XFILLER_51_502 vssd1 vccd1 vccd1 vssd1 sky130_fd_sc_hd__fill_2$1
XFILLER_36_587 vccd1 vssd1 vccd1 vssd1 sky130_fd_sc_hd__fill_1$1
XFILLER_23_237 vssd1 vccd1 vccd1 vssd1 sky130_ef_sc_hd__decap_40_12$1
XTAP_TAPCELL_ROW_63_1252 vccd1 vssd1 sky130_fd_sc_hd__tapvpwrvgnd_1$1
XTAP_TAPCELL_ROW_63_1241 vccd1 vssd1 sky130_fd_sc_hd__tapvpwrvgnd_1$1
XFILLER_51_557 vssd1 vccd1 vccd1 vssd1 sky130_fd_sc_hd__fill_2$1
XFILLER_32_793 vssd1 vccd1 vccd1 vssd1 sky130_fd_sc_hd__fill_2$1
XFILLER_118_810 vssd1 vccd1 vccd1 vssd1 sky130_fd_sc_hd__fill_2$1
XFILLER_31_281 vssd1 vccd1 vccd1 vssd1 sky130_ef_sc_hd__decap_40_12$1
XFILLER_136_139 vccd1 vssd1 vccd1 vssd1 sky130_fd_sc_hd__fill_1$1
XFILLER_118_821 vssd1 vccd1 vccd1 vssd1 sky130_fd_sc_hd__fill_2$1
XFILLER_3_609 vssd1 vccd1 vccd1 vssd1 sky130_fd_sc_hd__fill_4$1
XFILLER_132_301 vssd1 vccd1 vccd1 vssd1 sky130_fd_sc_hd__fill_4$1
X_1709_ _1832_/A clkload2/A _1709_/D vccd1 vssd1 vccd1 vssd1 sky130_fd_sc_hd__dfxtp_1$1
XFILLER_105_559 vccd1 vssd1 vccd1 vssd1 sky130_fd_sc_hd__fill_1$1
XFILLER_120_507 vccd1 vssd1 vccd1 vssd1 sky130_fd_sc_hd__fill_1$1
XFILLER_59_613 vssd1 vccd1 vccd1 vssd1 sky130_fd_sc_hd__fill_2$1
XFILLER_48_15 vssd1 vccd1 vccd1 vssd1 sky130_ef_sc_hd__decap_40_12$1
XFILLER_113_581 vssd1 vccd1 vccd1 vssd1 sky130_ef_sc_hd__decap_40_12$1
XFILLER_86_421 vccd1 vssd1 vccd1 vssd1 sky130_fd_sc_hd__fill_1$1
XFILLER_101_765 vssd1 vccd1 vccd1 vssd1 sky130_ef_sc_hd__decap_40_12$1
XFILLER_100_253 vssd1 vccd1 vccd1 vssd1 sky130_ef_sc_hd__decap_40_12$1
XFILLER_86_465 vssd1 vccd1 vccd1 vssd1 sky130_fd_sc_hd__fill_8$1
XFILLER_74_605 vssd1 vccd1 vccd1 vssd1 sky130_ef_sc_hd__decap_40_12$1
XFILLER_46_307 vccd1 vssd1 vccd1 vssd1 sky130_fd_sc_hd__fill_1$1
Xclkbuf_leaf_5_wb_clk_i _1749_/CLK clkbuf_leaf_9_wb_clk_i/A vssd1 vccd1 vccd1 vssd1
+ sky130_fd_sc_hd__clkbuf_8$1
XFILLER_58_189 vssd1 vccd1 vccd1 vssd1 sky130_fd_sc_hd__fill_4$1
XFILLER_104_65 vssd1 vccd1 vccd1 vssd1 sky130_ef_sc_hd__decap_40_12$1
XFILLER_73_137 vssd1 vccd1 vccd1 vssd1 sky130_ef_sc_hd__decap_40_12$1
XFILLER_55_841 vccd1 vssd1 vccd1 vssd1 sky130_fd_sc_hd__fill_1$1
XFILLER_70_811 vccd1 vssd1 vccd1 vssd1 sky130_fd_sc_hd__fill_1$1
XFILLER_15_727 vccd1 vssd1 vccd1 vssd1 sky130_fd_sc_hd__fill_1$1
XFILLER_42_513 vssd1 vccd1 vccd1 vssd1 sky130_ef_sc_hd__decap_40_12$1
XFILLER_81_181 vssd1 vccd1 vccd1 vssd1 sky130_ef_sc_hd__decap_40_12$1
XFILLER_54_395 vssd1 vccd1 vccd1 vssd1 sky130_ef_sc_hd__decap_40_12$1
XFILLER_120_53 vssd1 vccd1 vccd1 vssd1 sky130_ef_sc_hd__decap_40_12$1
XFILLER_120_97 vssd1 vccd1 vccd1 vssd1 sky130_ef_sc_hd__decap_40_12$1
XFILLER_10_421 vssd1 vccd1 vccd1 vssd1 sky130_ef_sc_hd__decap_40_12$1
XFILLER_13_51 vssd1 vccd1 vccd1 vssd1 sky130_fd_sc_hd__fill_4$1
XFILLER_129_51 vssd1 vccd1 vccd1 vssd1 sky130_fd_sc_hd__fill_4$1
XFILLER_109_832 vssd1 vccd1 vccd1 vssd1 sky130_fd_sc_hd__fill_4$1
XTAP_TAPCELL_ROW_94_1713 vccd1 vssd1 sky130_fd_sc_hd__tapvpwrvgnd_1$1
XFILLER_6_469 vssd1 vccd1 vccd1 vssd1 sky130_fd_sc_hd__fill_4$1
XFILLER_135_161 vssd1 vccd1 vccd1 vssd1 sky130_fd_sc_hd__fill_4$1
XFILLER_89_55 vccd1 vssd1 vccd1 vssd1 sky130_fd_sc_hd__fill_1$1
XFILLER_104_581 vssd1 vccd1 vccd1 vssd1 sky130_fd_sc_hd__fill_4$1
XFILLER_89_281 vssd1 vccd1 vccd1 vssd1 sky130_ef_sc_hd__decap_40_12$1
XFILLER_2_697 vssd1 vccd1 vccd1 vssd1 sky130_fd_sc_hd__fill_2$1
XFILLER_92_413 vssd1 vccd1 vccd1 vssd1 sky130_fd_sc_hd__fill_4$1
XFILLER_37_329 vssd1 vccd1 vccd1 vssd1 sky130_fd_sc_hd__fill_4$1
XFILLER_38_81 vssd1 vccd1 vccd1 vssd1 sky130_fd_sc_hd__fill_2$1
XFILLER_49_167 vccd1 vssd1 vccd1 vssd1 sky130_fd_sc_hd__fill_1$1
XTAP_TAPCELL_ROW_121_2109 vccd1 vssd1 sky130_fd_sc_hd__tapvpwrvgnd_1$1
XFILLER_92_457 vssd1 vccd1 vccd1 vssd1 sky130_fd_sc_hd__fill_8$1
XFILLER_64_137 vssd1 vccd1 vccd1 vssd1 sky130_fd_sc_hd__fill_2$1
XFILLER_73_671 vccd1 vssd1 vccd1 vssd1 sky130_fd_sc_hd__fill_1$1
XFILLER_18_587 vccd1 vssd1 vccd1 vssd1 sky130_fd_sc_hd__fill_1$1
XFILLER_60_321 vssd1 vccd1 vccd1 vssd1 sky130_ef_sc_hd__decap_40_12$1
XFILLER_45_373 vssd1 vccd1 vccd1 vssd1 sky130_ef_sc_hd__decap_40_12$1
XTAP_TAPCELL_ROW_103_1842 vccd1 vssd1 sky130_fd_sc_hd__tapvpwrvgnd_1$1
XFILLER_60_365 vssd1 vccd1 vccd1 vssd1 sky130_ef_sc_hd__decap_40_12$1
XFILLER_33_557 vssd1 vccd1 vccd1 vssd1 sky130_fd_sc_hd__fill_2$1
XFILLER_14_793 vssd1 vccd1 vccd1 vssd1 sky130_ef_sc_hd__decap_40_12$1
X_0942_ _0942_/X _1015_/A hold26/A hold15/A _0949_/A vssd1 vccd1 _0941_/X vccd1 vssd1
+ sky130_fd_sc_hd__a221o_1$1
XFILLER_119_629 vssd1 vccd1 vccd1 vssd1 sky130_ef_sc_hd__decap_40_12$1
XFILLER_13_281 vssd1 vccd1 vccd1 vssd1 sky130_ef_sc_hd__decap_40_12$1
XTAP_TAPCELL_ROW_31_758 vccd1 vssd1 sky130_fd_sc_hd__tapvpwrvgnd_1$1
XTAP_TAPCELL_ROW_31_769 vccd1 vssd1 sky130_fd_sc_hd__tapvpwrvgnd_1$1
XTAP_TAPCELL_ROW_136_2341 vccd1 vssd1 sky130_fd_sc_hd__tapvpwrvgnd_1$1
XFILLER_118_139 vccd1 vssd1 vccd1 vssd1 sky130_fd_sc_hd__fill_1$1
X_0873_ _0750_/X _0873_/X _0872_/X _1752_/Q _1411_/A _0871_/X vssd1 vccd1 vccd1 vssd1
+ sky130_fd_sc_hd__a2111o_1$1
Xclkload33 _1633_/CLK clkload33/Y vccd1 vssd1 vccd1 vssd1 sky130_fd_sc_hd__clkinv_4$1
Xclkload22 _1749_/CLK clkload22/Y vccd1 vssd1 vccd1 vssd1 sky130_fd_sc_hd__clkinvlp_4$1
XFILLER_62_3 vssd1 vccd1 vccd1 vssd1 sky130_ef_sc_hd__decap_40_12$1
XTAP_TAPCELL_ROW_11_471 vccd1 vssd1 sky130_fd_sc_hd__tapvpwrvgnd_1$1
XTAP_TAPCELL_ROW_11_460 vccd1 vssd1 sky130_fd_sc_hd__tapvpwrvgnd_1$1
Xclkload11 _1671_/CLK clkload11/Y vssd1 vccd1 vccd1 vssd1 sky130_fd_sc_hd__bufinv_16$1
XFILLER_133_109 vssd1 vccd1 vccd1 vssd1 sky130_fd_sc_hd__fill_2$1
XFILLER_127_673 vssd1 vccd1 vccd1 vssd1 sky130_ef_sc_hd__decap_40_12$1
XFILLER_127_662 vssd1 vccd1 vccd1 vssd1 sky130_fd_sc_hd__fill_8$1
XFILLER_114_301 vssd1 vccd1 vccd1 vssd1 sky130_fd_sc_hd__fill_4$1
XFILLER_114_345 vssd1 vccd1 vccd1 vssd1 sky130_ef_sc_hd__decap_40_12$1
XFILLER_102_529 vssd1 vccd1 vccd1 vssd1 sky130_fd_sc_hd__fill_2$1
X_1425_ _1441_/C1 _1424_/X _1475_/A2 hold197/X _1739_/D vssd1 vccd1 vccd1 vssd1 sky130_fd_sc_hd__o211a_1$1
XFILLER_68_421 vssd1 vccd1 vccd1 vssd1 sky130_fd_sc_hd__fill_8$1
X_1356_ _1829_/A _1356_/X _1356_/B vssd1 vccd1 vccd1 vssd1 sky130_fd_sc_hd__or2_1$1
XFILLER_96_785 vssd1 vccd1 vccd1 vssd1 sky130_ef_sc_hd__decap_40_12$1
XFILLER_95_273 vssd1 vccd1 vccd1 vssd1 sky130_fd_sc_hd__fill_4$1
XFILLER_18_29 vssd1 vccd1 vccd1 vssd1 sky130_ef_sc_hd__decap_40_12$1
XFILLER_28_307 vccd1 vssd1 vccd1 vssd1 sky130_fd_sc_hd__fill_1$1
X_1287_ _1417_/C1 _1286_/X _1343_/A2 hold67/X _1672_/D vssd1 vccd1 vccd1 vssd1 sky130_fd_sc_hd__o211a_1$1
XFILLER_55_137 vssd1 vccd1 vccd1 vssd1 sky130_ef_sc_hd__decap_40_12$1
XPHY_EDGE_ROW_50_Left_189 vccd1 vssd1 vccd1 vssd1 sky130_fd_sc_hd__decap_3$1
XFILLER_37_841 vccd1 vssd1 vccd1 vssd1 sky130_fd_sc_hd__fill_1$1
XFILLER_52_811 vccd1 vssd1 vccd1 vssd1 sky130_fd_sc_hd__fill_1$1
XFILLER_64_682 vssd1 vccd1 vccd1 vssd1 sky130_ef_sc_hd__decap_40_12$1
XFILLER_63_181 vssd1 vccd1 vccd1 vssd1 sky130_ef_sc_hd__decap_40_12$1
XTAP_TAPCELL_ROW_19_582 vccd1 vssd1 sky130_fd_sc_hd__tapvpwrvgnd_1$1
XFILLER_24_513 vssd1 vccd1 vccd1 vssd1 sky130_ef_sc_hd__decap_40_12$1
XFILLER_24_557 vssd1 vccd1 vccd1 vssd1 sky130_ef_sc_hd__decap_40_12$1
Xclkload5 clkload5/A clkload5/Y vccd1 vssd1 vccd1 vssd1 sky130_fd_sc_hd__clkinv_4$1
XFILLER_50_27 vccd1 vssd1 vccd1 vssd1 sky130_fd_sc_hd__fill_1$1
XFILLER_20_785 vssd1 vccd1 vccd1 vssd1 sky130_fd_sc_hd__fill_2$1
XFILLER_124_109 vssd1 vccd1 vccd1 vssd1 sky130_ef_sc_hd__decap_40_12$1
XFILLER_117_161 vssd1 vccd1 vccd1 vssd1 sky130_fd_sc_hd__fill_4$1
XFILLER_106_813 vssd1 vccd1 vccd1 vssd1 sky130_fd_sc_hd__fill_8$1
XTAP_TAPCELL_ROW_76_1443 vccd1 vssd1 sky130_fd_sc_hd__tapvpwrvgnd_1$1
XFILLER_3_417 vssd1 vccd1 vccd1 vssd1 sky130_ef_sc_hd__decap_40_12$1
XFILLER_132_153 vssd1 vccd1 vccd1 vssd1 sky130_ef_sc_hd__decap_40_12$1
XFILLER_132_197 vssd1 vccd1 vccd1 vssd1 sky130_ef_sc_hd__decap_40_12$1
Xfanout220 _1211_/A2 vccd1 vssd1 _1147_/Y vccd1 vssd1 sky130_fd_sc_hd__buf_6$1
Xfanout231 _0991_/A2 _0949_/Y vssd1 vccd1 vccd1 vssd1 sky130_fd_sc_hd__clkbuf_8$1
XFILLER_59_421 vssd1 vccd1 vccd1 vssd1 sky130_fd_sc_hd__fill_2$1
XFILLER_59_69 vssd1 vccd1 vccd1 vssd1 sky130_ef_sc_hd__decap_40_12$1
Xfanout242 _1279_/A vccd1 vssd1 _0875_/B1 vccd1 vssd1 sky130_fd_sc_hd__buf_6$1
Xfanout253 _0879_/A2 hold10/A vssd1 vccd1 vccd1 vssd1 sky130_fd_sc_hd__clkbuf_8$1
Xfanout264 _1431_/C1 vccd1 vssd1 _1435_/C1 vccd1 vssd1 sky130_fd_sc_hd__buf_4$1
XFILLER_59_465 vssd1 vccd1 vccd1 vssd1 sky130_fd_sc_hd__fill_4$1
Xfanout275 _1471_/C1 vccd1 vssd1 _1465_/C1 vccd1 vssd1 sky130_fd_sc_hd__buf_4$1
XFILLER_101_573 vssd1 vccd1 vccd1 vssd1 sky130_ef_sc_hd__decap_40_12$1
XFILLER_87_785 vssd1 vccd1 vccd1 vssd1 sky130_fd_sc_hd__fill_8$1
XFILLER_86_251 vccd1 vssd1 vccd1 vssd1 sky130_fd_sc_hd__fill_1$1
XFILLER_19_329 vssd1 vccd1 vccd1 vssd1 sky130_fd_sc_hd__fill_4$1
XFILLER_75_57 vssd1 vccd1 vccd1 vssd1 sky130_ef_sc_hd__decap_40_12$1
XFILLER_46_137 vssd1 vccd1 vccd1 vssd1 sky130_fd_sc_hd__fill_2$1
XFILLER_55_671 vccd1 vssd1 vccd1 vssd1 sky130_fd_sc_hd__fill_1$1
XFILLER_27_373 vssd1 vccd1 vccd1 vssd1 sky130_ef_sc_hd__decap_40_12$1
XFILLER_42_321 vssd1 vccd1 vccd1 vssd1 sky130_ef_sc_hd__decap_40_12$1
XFILLER_70_641 vssd1 vccd1 vccd1 vssd1 sky130_fd_sc_hd__fill_2$1
XFILLER_15_557 vssd1 vccd1 vccd1 vssd1 sky130_fd_sc_hd__fill_2$1
XFILLER_70_696 vssd1 vccd1 vccd1 vssd1 sky130_fd_sc_hd__fill_4$1
XFILLER_42_365 vssd1 vccd1 vccd1 vssd1 sky130_ef_sc_hd__decap_40_12$1
XFILLER_11_741 vssd1 vccd1 vccd1 vssd1 sky130_ef_sc_hd__decap_40_12$1
XFILLER_24_83 vccd1 vssd1 vccd1 vssd1 sky130_fd_sc_hd__fill_1$1
XFILLER_11_785 vssd1 vccd1 vccd1 vssd1 sky130_ef_sc_hd__decap_40_12$1
XFILLER_10_251 vccd1 vssd1 vccd1 vssd1 sky130_fd_sc_hd__fill_1$1
XTAP_TAPCELL_ROW_118_2071 vccd1 vssd1 sky130_fd_sc_hd__tapvpwrvgnd_1$1
XFILLER_6_233 vssd1 vccd1 vccd1 vssd1 sky130_ef_sc_hd__decap_40_12$1
XFILLER_115_109 vssd1 vccd1 vccd1 vssd1 sky130_fd_sc_hd__fill_2$1
XFILLER_109_673 vssd1 vccd1 vccd1 vssd1 sky130_fd_sc_hd__fill_4$1
XFILLER_6_277 vssd1 vccd1 vccd1 vssd1 sky130_ef_sc_hd__decap_40_12$1
XTAP_TAPCELL_ROW_131_2260 vccd1 vssd1 sky130_fd_sc_hd__tapvpwrvgnd_1$1
XFILLER_124_632 vssd1 vccd1 vccd1 vssd1 sky130_ef_sc_hd__decap_40_12$1
XFILLER_109_695 vssd1 vccd1 vccd1 vssd1 sky130_fd_sc_hd__fill_4$1
XTAP_TAPCELL_ROW_131_2271 vccd1 vssd1 sky130_fd_sc_hd__tapvpwrvgnd_1$1
XFILLER_97_505 vssd1 vccd1 vccd1 vssd1 sky130_ef_sc_hd__decap_40_12$1
XFILLER_111_337 vssd1 vccd1 vccd1 vssd1 sky130_ef_sc_hd__decap_40_12$1
XFILLER_78_730 vssd1 vccd1 vccd1 vssd1 sky130_ef_sc_hd__decap_40_12$1
X_1210_ _1636_/Q _1210_/X _1210_/B vssd1 vccd1 vccd1 vssd1 sky130_fd_sc_hd__or2_1$1
X_1141_ _1409_/C1 _1140_/X _1145_/A2 hold109/X _1602_/D vssd1 vccd1 vccd1 vssd1 sky130_fd_sc_hd__o211a_1$1
XFILLER_77_273 vssd1 vccd1 vccd1 vssd1 sky130_fd_sc_hd__fill_4$1
XFILLER_92_221 vssd1 vccd1 vccd1 vssd1 sky130_ef_sc_hd__decap_40_12$1
XFILLER_65_435 vssd1 vccd1 vccd1 vssd1 sky130_fd_sc_hd__fill_2$1
XFILLER_65_446 vssd1 vccd1 vccd1 vssd1 sky130_fd_sc_hd__fill_2$1
XFILLER_19_841 vccd1 vssd1 vccd1 vssd1 sky130_fd_sc_hd__fill_1$1
XFILLER_37_137 vssd1 vccd1 vccd1 vssd1 sky130_ef_sc_hd__decap_40_12$1
X_1072_ _1072_/A _1072_/X _1078_/B vssd1 vccd1 vccd1 vssd1 sky130_fd_sc_hd__or2_1$1
XFILLER_93_777 vssd1 vccd1 vccd1 vssd1 sky130_fd_sc_hd__fill_4$1
XFILLER_92_265 vssd1 vccd1 vccd1 vssd1 sky130_ef_sc_hd__decap_40_12$1
XTAP_TAPCELL_ROW_36_839 vccd1 vssd1 sky130_fd_sc_hd__tapvpwrvgnd_1$1
XFILLER_45_181 vssd1 vccd1 vccd1 vssd1 sky130_ef_sc_hd__decap_40_12$1
XTAP_TAPCELL_ROW_47_1000 vccd1 vssd1 sky130_fd_sc_hd__tapvpwrvgnd_1$1
XFILLER_46_693 vssd1 vccd1 vccd1 vssd1 sky130_fd_sc_hd__fill_4$1
XTAP_TAPCELL_ROW_47_1011 vccd1 vssd1 sky130_fd_sc_hd__tapvpwrvgnd_1$1
XFILLER_61_641 vccd1 vssd1 vccd1 vssd1 sky130_fd_sc_hd__fill_1$1
XTAP_TAPCELL_ROW_16_541 vccd1 vssd1 sky130_fd_sc_hd__tapvpwrvgnd_1$1
XFILLER_61_685 vssd1 vccd1 vccd1 vssd1 sky130_ef_sc_hd__decap_40_12$1
XTAP_TAPCELL_ROW_60_1200 vccd1 vssd1 sky130_fd_sc_hd__tapvpwrvgnd_1$1
XFILLER_21_505 vssd1 vccd1 vccd1 vssd1 sky130_ef_sc_hd__decap_40_12$1
XFILLER_60_195 vccd1 vssd1 vccd1 vssd1 sky130_fd_sc_hd__fill_1$1
X_0925_ _1633_/Q _1147_/A _0925_/X _1569_/Q _1015_/A vccd1 vssd1 vccd1 vssd1 sky130_fd_sc_hd__a22o_1$1
X_0856_ _1493_/D _0852_/X _0855_/X _0850_/X _0854_/X vssd1 vccd1 vccd1 vssd1 sky130_fd_sc_hd__o31a_1$1
XFILLER_106_109 vssd1 vccd1 vccd1 vssd1 sky130_ef_sc_hd__decap_40_12$1
X_0787_ _1814_/A _0878_/A2 _0787_/X _1784_/A _0875_/A2 vccd1 vssd1 vccd1 vssd1 sky130_fd_sc_hd__a22o_1$1
XFILLER_115_665 vssd1 vccd1 vccd1 vssd1 sky130_fd_sc_hd__fill_4$1
XFILLER_114_153 vssd1 vccd1 vccd1 vssd1 sky130_ef_sc_hd__decap_40_12$1
XFILLER_103_805 vssd1 vccd1 vccd1 vssd1 sky130_fd_sc_hd__fill_2$1
XTAP_TAPCELL_ROW_58_1173 vccd1 vssd1 sky130_fd_sc_hd__tapvpwrvgnd_1$1
XFILLER_130_657 vssd1 vccd1 vccd1 vssd1 sky130_ef_sc_hd__decap_40_12$1
Xhold17 hold17/A hold17/X vssd1 vccd1 vccd1 vssd1 sky130_fd_sc_hd__dlygate4sd3_1$1
X_1408_ _1732_/Q _1408_/X _1408_/B vssd1 vccd1 vccd1 vssd1 sky130_fd_sc_hd__or2_1$1
XFILLER_114_197 vssd1 vccd1 vccd1 vssd1 sky130_ef_sc_hd__decap_40_12$1
Xhold28 hold28/A hold28/X vssd1 vccd1 vccd1 vssd1 sky130_fd_sc_hd__dlygate4sd3_1$1
XTAP_TAPCELL_ROW_71_1362 vccd1 vssd1 sky130_fd_sc_hd__tapvpwrvgnd_1$1
XFILLER_69_763 vssd1 vccd1 vccd1 vssd1 sky130_ef_sc_hd__decap_40_12$1
XFILLER_29_39 vssd1 vccd1 vccd1 vssd1 sky130_ef_sc_hd__decap_40_12$1
Xhold39 hold39/A hold39/X vssd1 vccd1 vccd1 vssd1 sky130_fd_sc_hd__dlygate4sd3_1$1
XFILLER_68_251 vccd1 vssd1 vccd1 vssd1 sky130_fd_sc_hd__fill_1$1
X_1339_ _1441_/C1 _1338_/X _1343_/A2 hold109/X _1698_/D vssd1 vccd1 vccd1 vssd1 sky130_fd_sc_hd__o211a_1$1
XFILLER_84_755 vccd1 vssd1 vccd1 vssd1 sky130_fd_sc_hd__fill_1$1
XFILLER_83_221 vssd1 vccd1 vccd1 vssd1 sky130_fd_sc_hd__fill_2$1
XFILLER_56_457 vssd1 vccd1 vccd1 vssd1 sky130_ef_sc_hd__decap_40_12$1
XFILLER_28_137 vssd1 vccd1 vccd1 vssd1 sky130_fd_sc_hd__fill_2$1
XFILLER_45_27 vssd1 vccd1 vccd1 vssd1 sky130_ef_sc_hd__decap_40_12$1
XFILLER_71_449 vssd1 vccd1 vccd1 vssd1 sky130_ef_sc_hd__decap_40_12$1
XFILLER_37_671 vccd1 vssd1 vccd1 vssd1 sky130_fd_sc_hd__fill_1$1
XFILLER_24_321 vssd1 vccd1 vccd1 vssd1 sky130_ef_sc_hd__decap_40_12$1
XFILLER_101_55 vccd1 vssd1 vccd1 vssd1 sky130_fd_sc_hd__fill_1$1
XFILLER_61_15 vssd1 vccd1 vccd1 vssd1 sky130_ef_sc_hd__decap_40_12$1
XFILLER_24_365 vssd1 vccd1 vccd1 vssd1 sky130_ef_sc_hd__decap_40_12$1
XFILLER_138_757 vssd1 vccd1 vccd1 vssd1 sky130_fd_sc_hd__fill_2$1
XFILLER_137_289 vssd1 vccd1 vccd1 vssd1 sky130_ef_sc_hd__decap_40_12$1
XFILLER_125_429 vssd1 vccd1 vccd1 vssd1 sky130_ef_sc_hd__decap_40_12$1
XFILLER_4_737 vssd1 vccd1 vccd1 vssd1 sky130_ef_sc_hd__decap_40_12$1
XFILLER_3_225 vssd1 vccd1 vccd1 vssd1 sky130_ef_sc_hd__decap_40_12$1
XFILLER_79_505 vssd1 vccd1 vccd1 vssd1 sky130_ef_sc_hd__decap_40_12$1
XFILLER_10_41 vssd1 vccd1 vccd1 vssd1 sky130_ef_sc_hd__decap_40_12$1
XFILLER_126_41 vssd1 vccd1 vccd1 vssd1 sky130_ef_sc_hd__decap_40_12$1
XFILLER_10_85 vssd1 vccd1 vccd1 vssd1 sky130_ef_sc_hd__decap_40_12$1
XFILLER_126_85 vssd1 vccd1 vccd1 vssd1 sky130_ef_sc_hd__decap_40_12$1
XFILLER_120_189 vssd1 vccd1 vccd1 vssd1 sky130_fd_sc_hd__fill_4$1
XFILLER_59_273 vssd1 vccd1 vccd1 vssd1 sky130_fd_sc_hd__fill_4$1
XTAP_TAPCELL_ROW_89_1634 vccd1 vssd1 sky130_fd_sc_hd__tapvpwrvgnd_1$1
XFILLER_74_221 vssd1 vccd1 vccd1 vssd1 sky130_ef_sc_hd__decap_40_12$1
XFILLER_19_137 vssd1 vccd1 vccd1 vssd1 sky130_ef_sc_hd__decap_40_12$1
XFILLER_47_435 vccd1 vssd1 vccd1 vssd1 sky130_fd_sc_hd__fill_1$1
XFILLER_75_766 vssd1 vccd1 vccd1 vssd1 sky130_fd_sc_hd__fill_8$1
XFILLER_74_265 vssd1 vccd1 vccd1 vssd1 sky130_ef_sc_hd__decap_40_12$1
XFILLER_16_811 vccd1 vssd1 vccd1 vssd1 sky130_fd_sc_hd__fill_1$1
XFILLER_28_693 vssd1 vccd1 vccd1 vssd1 sky130_fd_sc_hd__fill_4$1
XFILLER_90_769 vssd1 vccd1 vccd1 vssd1 sky130_ef_sc_hd__decap_40_12$1
XFILLER_27_181 vssd1 vccd1 vccd1 vssd1 sky130_ef_sc_hd__decap_40_12$1
XFILLER_43_663 vssd1 vccd1 vccd1 vssd1 sky130_fd_sc_hd__fill_8$1
XPHY_EDGE_ROW_106_Left_245 vccd1 vssd1 vccd1 vssd1 sky130_fd_sc_hd__decap_3$1
XTAP_TAPCELL_ROW_100_1801 vccd1 vssd1 sky130_fd_sc_hd__tapvpwrvgnd_1$1
XTAP_TAPCELL_ROW_13_500 vccd1 vssd1 sky130_fd_sc_hd__tapvpwrvgnd_1$1
XFILLER_31_836 vssd1 vccd1 vccd1 vssd1 sky130_fd_sc_hd__fill_4$1
XFILLER_35_93 vssd1 vccd1 vccd1 vssd1 sky130_ef_sc_hd__decap_40_12$1
XFILLER_42_195 vccd1 vssd1 vccd1 vssd1 sky130_fd_sc_hd__fill_1$1
XFILLER_30_357 vssd1 vccd1 vccd1 vssd1 sky130_fd_sc_hd__fill_4$1
XTAP_TAPCELL_ROW_133_2300 vccd1 vssd1 sky130_fd_sc_hd__tapvpwrvgnd_1$1
XFILLER_128_245 vssd1 vccd1 vccd1 vssd1 sky130_fd_sc_hd__fill_4$1
XFILLER_51_81 vssd1 vccd1 vccd1 vssd1 sky130_ef_sc_hd__decap_40_12$1
XFILLER_128_289 vssd1 vccd1 vccd1 vssd1 sky130_ef_sc_hd__decap_40_12$1
XFILLER_116_418 vssd1 vccd1 vccd1 vssd1 sky130_fd_sc_hd__fill_2$1
X_1690_ _1690_/Q _1690_/CLK _1690_/D vccd1 vssd1 vccd1 vssd1 sky130_fd_sc_hd__dfxtp_1$1
XFILLER_7_553 vssd1 vccd1 vccd1 vssd1 sky130_fd_sc_hd__fill_4$1
XFILLER_7_597 vssd1 vccd1 vccd1 vssd1 sky130_ef_sc_hd__decap_40_12$1
XPHY_EDGE_ROW_115_Left_254 vccd1 vssd1 vccd1 vssd1 sky130_fd_sc_hd__decap_3$1
XFILLER_124_484 vssd1 vccd1 vccd1 vssd1 sky130_ef_sc_hd__decap_40_12$1
XFILLER_112_613 vssd1 vccd1 vccd1 vssd1 sky130_ef_sc_hd__decap_40_12$1
XFILLER_3_781 vssd1 vccd1 vccd1 vssd1 sky130_fd_sc_hd__fill_2$1
XFILLER_112_657 vssd1 vccd1 vccd1 vssd1 sky130_ef_sc_hd__decap_40_12$1
XTAP_TAPCELL_ROW_111_1963 vccd1 vssd1 sky130_fd_sc_hd__tapvpwrvgnd_1$1
XFILLER_97_335 vccd1 vssd1 vccd1 vssd1 sky130_fd_sc_hd__fill_1$1
XFILLER_111_167 vccd1 vssd1 vccd1 vssd1 sky130_fd_sc_hd__fill_1$1
XTAP_TAPCELL_ROW_53_1092 vccd1 vssd1 sky130_fd_sc_hd__tapvpwrvgnd_1$1
XFILLER_25_3 vssd1 vccd1 vccd1 vssd1 sky130_ef_sc_hd__decap_40_12$1
XFILLER_38_413 vssd1 vccd1 vccd1 vssd1 sky130_fd_sc_hd__fill_4$1
XFILLER_93_541 vssd1 vccd1 vccd1 vssd1 sky130_ef_sc_hd__decap_40_12$1
XFILLER_65_221 vssd1 vccd1 vccd1 vssd1 sky130_fd_sc_hd__fill_2$1
X_1124_ _1812_/A _1124_/X _1144_/B vssd1 vccd1 vccd1 vssd1 sky130_fd_sc_hd__or2_1$1
XFILLER_53_405 vssd1 vccd1 vccd1 vssd1 sky130_ef_sc_hd__decap_40_12$1
XFILLER_38_457 vssd1 vccd1 vccd1 vssd1 sky130_ef_sc_hd__decap_40_12$1
X_1055_ _1455_/C1 _1054_/X _1079_/A2 hold120/X _1055_/X vssd1 vccd1 vccd1 vssd1 sky130_fd_sc_hd__o211a_1$1
XFILLER_93_585 vssd1 vccd1 vccd1 vssd1 sky130_ef_sc_hd__decap_40_12$1
XFILLER_19_671 vccd1 vssd1 vccd1 vssd1 sky130_fd_sc_hd__fill_1$1
XPHY_EDGE_ROW_124_Left_263 vccd1 vssd1 vccd1 vssd1 sky130_fd_sc_hd__decap_3$1
XFILLER_53_449 vssd1 vccd1 vccd1 vssd1 sky130_ef_sc_hd__decap_40_12$1
XFILLER_21_335 vccd1 vssd1 vccd1 vssd1 sky130_fd_sc_hd__fill_1$1
XFILLER_119_223 vccd1 vssd1 vccd1 vssd1 sky130_fd_sc_hd__fill_1$1
X_0908_ _1758_/Q _1411_/A _0909_/C _1694_/Q _1279_/A vccd1 vssd1 vccd1 vssd1 sky130_fd_sc_hd__a22o_1$1
XFILLER_107_429 vssd1 vccd1 vccd1 vssd1 sky130_ef_sc_hd__decap_40_12$1
XPHY_EDGE_ROW_133_Left_272 vccd1 vssd1 vccd1 vssd1 sky130_fd_sc_hd__decap_3$1
XFILLER_128_790 vssd1 vccd1 vccd1 vssd1 sky130_ef_sc_hd__decap_40_12$1
X_0839_ _1279_/A _1683_/Q _0838_/X _0839_/X vccd1 vssd1 vccd1 vssd1 sky130_fd_sc_hd__a21o_1$1
XTAP_TAPCELL_ROW_73_1402 vccd1 vssd1 sky130_fd_sc_hd__tapvpwrvgnd_1$1
XFILLER_103_613 vssd1 vccd1 vccd1 vssd1 sky130_fd_sc_hd__fill_2$1
XFILLER_1_729 vssd1 vccd1 vccd1 vssd1 sky130_ef_sc_hd__decap_40_12$1
XFILLER_130_421 vssd1 vccd1 vccd1 vssd1 sky130_fd_sc_hd__fill_8$1
XFILLER_88_357 vssd1 vccd1 vccd1 vssd1 sky130_fd_sc_hd__fill_4$1
XFILLER_102_189 vssd1 vccd1 vccd1 vssd1 sky130_fd_sc_hd__fill_4$1
XFILLER_56_221 vssd1 vccd1 vccd1 vssd1 sky130_ef_sc_hd__decap_40_12$1
XFILLER_56_15 vssd1 vccd1 vccd1 vssd1 sky130_ef_sc_hd__decap_40_12$1
XFILLER_56_265 vssd1 vccd1 vccd1 vssd1 sky130_ef_sc_hd__decap_40_12$1
XFILLER_72_725 vssd1 vccd1 vccd1 vssd1 sky130_fd_sc_hd__fill_8$1
XFILLER_112_65 vssd1 vccd1 vccd1 vssd1 sky130_ef_sc_hd__decap_40_12$1
XTAP_TAPCELL_ROW_84_1553 vccd1 vssd1 sky130_fd_sc_hd__tapvpwrvgnd_1$1
XFILLER_72_769 vssd1 vccd1 vccd1 vssd1 sky130_fd_sc_hd__fill_8$1
XFILLER_25_641 vssd1 vccd1 vccd1 vssd1 sky130_ef_sc_hd__decap_40_12$1
XTAP_TAPCELL_ROW_84_1564 vccd1 vssd1 sky130_fd_sc_hd__tapvpwrvgnd_1$1
XFILLER_71_279 vccd1 vssd1 vccd1 vssd1 sky130_fd_sc_hd__fill_1$1
XFILLER_25_685 vssd1 vccd1 vccd1 vssd1 sky130_ef_sc_hd__decap_40_12$1
XFILLER_24_195 vccd1 vssd1 vccd1 vssd1 sky130_fd_sc_hd__fill_1$1
XFILLER_40_622 vssd1 vccd1 vccd1 vssd1 sky130_ef_sc_hd__decap_40_12$1
XFILLER_12_357 vssd1 vccd1 vccd1 vssd1 sky130_fd_sc_hd__fill_4$1
XFILLER_138_587 vccd1 vssd1 vccd1 vssd1 sky130_fd_sc_hd__fill_1$1
XTAP_TAPCELL_ROW_115_2030 vccd1 vssd1 sky130_fd_sc_hd__tapvpwrvgnd_1$1
XFILLER_4_501 vssd1 vccd1 vccd1 vssd1 sky130_ef_sc_hd__decap_40_12$1
XFILLER_125_237 vssd1 vccd1 vccd1 vssd1 sky130_ef_sc_hd__decap_40_12$1
XFILLER_21_51 vssd1 vccd1 vccd1 vssd1 sky130_fd_sc_hd__fill_4$1
XFILLER_4_545 vssd1 vccd1 vccd1 vssd1 sky130_ef_sc_hd__decap_40_12$1
XFILLER_134_793 vccd1 vssd1 vccd1 vssd1 sky130_fd_sc_hd__fill_1$1
XFILLER_106_462 vssd1 vccd1 vccd1 vssd1 sky130_ef_sc_hd__decap_40_12$1
XFILLER_97_55 vccd1 vssd1 vccd1 vssd1 sky130_fd_sc_hd__fill_1$1
XFILLER_4_589 vssd1 vccd1 vccd1 vssd1 sky130_ef_sc_hd__decap_40_12$1
XFILLER_133_281 vssd1 vccd1 vccd1 vssd1 sky130_ef_sc_hd__decap_40_12$1
XFILLER_79_335 vccd1 vssd1 vccd1 vssd1 sky130_fd_sc_hd__fill_1$1
XFILLER_121_476 vssd1 vccd1 vccd1 vssd1 sky130_ef_sc_hd__decap_40_12$1
XFILLER_94_305 vssd1 vccd1 vccd1 vssd1 sky130_fd_sc_hd__fill_2$1
XFILLER_67_519 vssd1 vccd1 vccd1 vssd1 sky130_fd_sc_hd__fill_8$1
XFILLER_47_221 vssd1 vccd1 vccd1 vssd1 sky130_fd_sc_hd__fill_2$1
XFILLER_75_541 vssd1 vccd1 vccd1 vssd1 sky130_ef_sc_hd__decap_40_12$1
XFILLER_35_405 vssd1 vccd1 vccd1 vssd1 sky130_ef_sc_hd__decap_40_12$1
XTAP_TAPCELL_ROW_126_2192 vccd1 vssd1 sky130_fd_sc_hd__tapvpwrvgnd_1$1
XFILLER_90_533 vssd1 vccd1 vccd1 vssd1 sky130_ef_sc_hd__decap_40_12$1
XFILLER_90_511 vccd1 vssd1 vccd1 vssd1 sky130_fd_sc_hd__fill_1$1
XFILLER_75_585 vssd1 vccd1 vccd1 vssd1 sky130_fd_sc_hd__fill_8$1
XFILLER_16_641 vssd1 vccd1 vccd1 vssd1 sky130_fd_sc_hd__fill_2$1
XFILLER_35_449 vssd1 vccd1 vccd1 vssd1 sky130_ef_sc_hd__decap_40_12$1
XFILLER_46_81 vssd1 vccd1 vccd1 vssd1 sky130_fd_sc_hd__fill_2$1
XFILLER_50_419 vccd1 vssd1 vccd1 vssd1 sky130_fd_sc_hd__fill_1$1
XTAP_TAPCELL_ROW_46_989 vccd1 vssd1 sky130_fd_sc_hd__tapvpwrvgnd_1$1
XTAP_TAPCELL_ROW_26_691 vccd1 vssd1 sky130_fd_sc_hd__tapvpwrvgnd_1$1
XFILLER_30_121 vssd1 vccd1 vccd1 vssd1 sky130_ef_sc_hd__decap_40_12$1
XFILLER_43_482 vssd1 vccd1 vccd1 vssd1 sky130_ef_sc_hd__decap_40_12$1
X_1811_ _1811_/A _1811_/X vssd1 vccd1 vccd1 vssd1 sky130_fd_sc_hd__clkbuf_2$1
XFILLER_129_543 vssd1 vccd1 vccd1 vssd1 sky130_ef_sc_hd__decap_40_12$1
XFILLER_30_165 vssd1 vccd1 vccd1 vssd1 sky130_ef_sc_hd__decap_40_12$1
X_1742_ _1850_/A _1742_/CLK _1742_/D vccd1 vssd1 vccd1 vssd1 sky130_fd_sc_hd__dfxtp_1$1
X_1673_ _1835_/A _1704_/CLK _1673_/D vccd1 vssd1 vccd1 vssd1 sky130_fd_sc_hd__dfxtp_1$1
XFILLER_7_361 vssd1 vccd1 vccd1 vssd1 sky130_ef_sc_hd__decap_40_12$1
XFILLER_112_410 vssd1 vccd1 vccd1 vssd1 sky130_fd_sc_hd__fill_2$1
XTAP_TAPCELL_ROW_55_1132 vccd1 vssd1 sky130_fd_sc_hd__tapvpwrvgnd_1$1
XTAP_TAPCELL_ROW_55_1121 vccd1 vssd1 sky130_fd_sc_hd__tapvpwrvgnd_1$1
XFILLER_100_627 vccd1 vssd1 vccd1 vssd1 sky130_fd_sc_hd__fill_1$1
XFILLER_97_165 vssd1 vccd1 vccd1 vssd1 sky130_fd_sc_hd__fill_2$1
XFILLER_85_305 vssd1 vccd1 vccd1 vssd1 sky130_ef_sc_hd__decap_40_12$1
XFILLER_85_349 vssd1 vccd1 vccd1 vssd1 sky130_ef_sc_hd__decap_40_12$1
XFILLER_38_221 vssd1 vccd1 vccd1 vssd1 sky130_ef_sc_hd__decap_40_12$1
XFILLER_54_703 vccd1 vssd1 vccd1 vssd1 sky130_fd_sc_hd__fill_1$1
XFILLER_66_585 vssd1 vccd1 vccd1 vssd1 sky130_fd_sc_hd__fill_2$1
XFILLER_26_29 vssd1 vccd1 vccd1 vssd1 sky130_ef_sc_hd__decap_40_12$1
XFILLER_38_265 vssd1 vccd1 vccd1 vssd1 sky130_ef_sc_hd__decap_40_12$1
XFILLER_54_769 vssd1 vccd1 vccd1 vssd1 sky130_ef_sc_hd__decap_40_12$1
XPHY_EDGE_ROW_5_Right_5 vccd1 vssd1 vccd1 vssd1 sky130_fd_sc_hd__decap_3$1
X_1107_ _1305_/C1 _1106_/X _1145_/A2 hold55/X _1585_/D vssd1 vccd1 vccd1 vssd1 sky130_fd_sc_hd__o211a_1$1
X_1038_ _1038_/A _1038_/X _1052_/B vssd1 vccd1 vccd1 vssd1 sky130_fd_sc_hd__or2_1$1
XFILLER_53_279 vccd1 vssd1 vccd1 vssd1 sky130_fd_sc_hd__fill_1$1
XTAP_TAPCELL_ROW_66_1294 vccd1 vssd1 sky130_fd_sc_hd__tapvpwrvgnd_1$1
XTAP_TAPCELL_ROW_66_1283 vccd1 vssd1 sky130_fd_sc_hd__tapvpwrvgnd_1$1
XFILLER_21_165 vssd1 vccd1 vccd1 vssd1 sky130_fd_sc_hd__fill_2$1
XFILLER_22_699 vccd1 vssd1 vccd1 vssd1 sky130_fd_sc_hd__fill_1$1
XFILLER_108_749 vssd1 vccd1 vccd1 vssd1 sky130_fd_sc_hd__fill_2$1
XFILLER_107_237 vssd1 vccd1 vccd1 vssd1 sky130_ef_sc_hd__decap_40_12$1
XFILLER_135_579 vssd1 vccd1 vccd1 vssd1 sky130_fd_sc_hd__fill_8$1
XFILLER_115_281 vssd1 vccd1 vccd1 vssd1 sky130_ef_sc_hd__decap_40_12$1
XFILLER_103_432 vssd1 vccd1 vccd1 vssd1 sky130_ef_sc_hd__decap_40_12$1
XFILLER_88_121 vssd1 vccd1 vccd1 vssd1 sky130_ef_sc_hd__decap_40_12$1
XFILLER_1_559 vccd1 vssd1 vccd1 vssd1 sky130_fd_sc_hd__fill_1$1
XFILLER_131_785 vssd1 vccd1 vccd1 vssd1 sky130_fd_sc_hd__fill_4$1
XFILLER_131_763 vssd1 vccd1 vccd1 vssd1 sky130_ef_sc_hd__decap_40_12$1
XFILLER_130_251 vccd1 vssd1 vccd1 vssd1 sky130_fd_sc_hd__fill_1$1
XFILLER_88_165 vssd1 vccd1 vccd1 vssd1 sky130_ef_sc_hd__decap_40_12$1
XFILLER_77_817 vssd1 vccd1 vccd1 vssd1 sky130_fd_sc_hd__fill_4$1
XFILLER_76_305 vssd1 vccd1 vccd1 vssd1 sky130_fd_sc_hd__fill_2$1
XFILLER_67_69 vssd1 vccd1 vccd1 vssd1 sky130_ef_sc_hd__decap_40_12$1
XFILLER_29_221 vssd1 vccd1 vccd1 vssd1 sky130_fd_sc_hd__fill_2$1
XFILLER_92_809 vssd1 vccd1 vccd1 vssd1 sky130_fd_sc_hd__fill_2$1
XFILLER_57_541 vssd1 vccd1 vccd1 vssd1 sky130_ef_sc_hd__decap_40_12$1
XTAP_TAPCELL_ROW_4_364 vccd1 vssd1 sky130_fd_sc_hd__tapvpwrvgnd_1$1
XTAP_TAPCELL_ROW_4_353 vccd1 vssd1 sky130_fd_sc_hd__tapvpwrvgnd_1$1
XFILLER_72_522 vssd1 vccd1 vccd1 vssd1 sky130_fd_sc_hd__fill_8$1
XFILLER_72_500 vccd1 vssd1 vccd1 vssd1 sky130_fd_sc_hd__fill_1$1
XFILLER_17_405 vssd1 vccd1 vccd1 vssd1 sky130_ef_sc_hd__decap_40_12$1
XFILLER_83_57 vssd1 vccd1 vccd1 vssd1 sky130_ef_sc_hd__decap_40_12$1
XFILLER_72_555 vccd1 vssd1 vccd1 vssd1 sky130_fd_sc_hd__fill_1$1
XFILLER_72_533 vssd1 vccd1 vccd1 vssd1 sky130_ef_sc_hd__decap_40_12$1
XFILLER_17_449 vssd1 vccd1 vccd1 vssd1 sky130_ef_sc_hd__decap_40_12$1
XFILLER_60_739 vssd1 vccd1 vccd1 vssd1 sky130_ef_sc_hd__decap_40_12$1
XFILLER_32_419 vccd1 vssd1 vccd1 vssd1 sky130_fd_sc_hd__fill_1$1
XTAP_TAPCELL_ROW_43_948 vccd1 vssd1 sky130_fd_sc_hd__tapvpwrvgnd_1$1
XFILLER_12_121 vssd1 vccd1 vccd1 vssd1 sky130_ef_sc_hd__decap_40_12$1
XFILLER_9_615 vccd1 vssd1 vccd1 vssd1 sky130_fd_sc_hd__fill_1$1
XTAP_TAPCELL_ROW_23_650 vccd1 vssd1 sky130_fd_sc_hd__tapvpwrvgnd_1$1
XFILLER_12_165 vssd1 vccd1 vccd1 vssd1 sky130_ef_sc_hd__decap_40_12$1
XFILLER_32_83 vccd1 vssd1 vccd1 vssd1 sky130_fd_sc_hd__fill_1$1
XFILLER_126_513 vssd1 vccd1 vccd1 vssd1 sky130_ef_sc_hd__decap_40_12$1
XTAP_TAPCELL_ROW_97_1755 vccd1 vssd1 sky130_fd_sc_hd__tapvpwrvgnd_1$1
XFILLER_5_821 vssd1 vccd1 vccd1 vssd1 sky130_ef_sc_hd__decap_40_12$1
XFILLER_126_557 vssd1 vccd1 vccd1 vssd1 sky130_ef_sc_hd__decap_40_12$1
XFILLER_95_625 vccd1 vssd1 vccd1 vssd1 sky130_fd_sc_hd__fill_1$1
XFILLER_79_165 vssd1 vccd1 vccd1 vssd1 sky130_fd_sc_hd__fill_2$1
XFILLER_67_305 vssd1 vccd1 vccd1 vssd1 sky130_ef_sc_hd__decap_40_12$1
XTAP_TAPCELL_ROW_128_2221 vccd1 vssd1 sky130_fd_sc_hd__tapvpwrvgnd_1$1
XFILLER_121_273 vssd1 vccd1 vccd1 vssd1 sky130_fd_sc_hd__fill_4$1
XFILLER_67_349 vssd1 vccd1 vccd1 vssd1 sky130_ef_sc_hd__decap_40_12$1
XFILLER_95_669 vssd1 vccd1 vccd1 vssd1 sky130_fd_sc_hd__fill_2$1
XTAP_TAPCELL_ROW_50_1051 vccd1 vssd1 sky130_fd_sc_hd__tapvpwrvgnd_1$1
Xclkbuf_leaf_29_wb_clk_i _1736_/CLK clkload1/A vssd1 vccd1 vccd1 vssd1 sky130_fd_sc_hd__clkbuf_8$1
XFILLER_36_725 vssd1 vccd1 vccd1 vssd1 sky130_ef_sc_hd__decap_40_12$1
XFILLER_75_393 vssd1 vccd1 vccd1 vssd1 sky130_ef_sc_hd__decap_40_12$1
XFILLER_36_769 vssd1 vccd1 vccd1 vssd1 sky130_ef_sc_hd__decap_40_12$1
XFILLER_90_363 vccd1 vssd1 vccd1 vssd1 sky130_fd_sc_hd__fill_1$1
XFILLER_35_279 vccd1 vssd1 vccd1 vssd1 sky130_fd_sc_hd__fill_1$1
XTAP_TAPCELL_ROW_106_1895 vccd1 vssd1 sky130_fd_sc_hd__tapvpwrvgnd_1$1
XTAP_TAPCELL_ROW_106_1884 vccd1 vssd1 sky130_fd_sc_hd__tapvpwrvgnd_1$1
XFILLER_90_385 vssd1 vccd1 vccd1 vssd1 sky130_fd_sc_hd__fill_2$1
XFILLER_50_249 vssd1 vccd1 vccd1 vssd1 sky130_fd_sc_hd__fill_2$1
XFILLER_92_3 vssd1 vccd1 vccd1 vssd1 sky130_ef_sc_hd__decap_40_12$1
XTAP_TAPCELL_ROW_21_609 vccd1 vssd1 sky130_fd_sc_hd__tapvpwrvgnd_1$1
XFILLER_31_441 vssd1 vccd1 vccd1 vssd1 sky130_fd_sc_hd__fill_4$1
XFILLER_31_485 vssd1 vccd1 vccd1 vssd1 sky130_ef_sc_hd__decap_40_12$1
XFILLER_117_502 vssd1 vccd1 vccd1 vssd1 sky130_fd_sc_hd__fill_2$1
XFILLER_117_524 vssd1 vccd1 vccd1 vssd1 sky130_ef_sc_hd__decap_40_12$1
X_1725_ _1725_/Q _1752_/CLK _1725_/D vccd1 vssd1 vccd1 vssd1 sky130_fd_sc_hd__dfxtp_1$1
XFILLER_8_681 vssd1 vccd1 vccd1 vssd1 sky130_ef_sc_hd__decap_40_12$1
Xhold125 input32/X hold125/X vssd1 vccd1 vccd1 vssd1 sky130_fd_sc_hd__dlygate4sd3_1$1
Xhold114 _1754_/Q _1454_/A vssd1 vccd1 vccd1 vssd1 sky130_fd_sc_hd__dlygate4sd3_1$1
Xhold103 _1719_/Q _1382_/A vssd1 vccd1 vccd1 vssd1 sky130_fd_sc_hd__dlygate4sd3_1$1
Xhold147 _1467_/X _1760_/D vssd1 vccd1 vccd1 vssd1 sky130_fd_sc_hd__dlygate4sd3_1$1
Xhold136 _1758_/Q _1462_/A vssd1 vccd1 vccd1 vssd1 sky130_fd_sc_hd__dlygate4sd3_1$1
Xhold158 _1528_/Q _0988_/A vssd1 vccd1 vccd1 vssd1 sky130_fd_sc_hd__dlygate4sd3_1$1
X_1656_ _1656_/Q _1690_/CLK _1656_/D vccd1 vssd1 vccd1 vssd1 sky130_fd_sc_hd__dfxtp_2$1
XFILLER_113_741 vssd1 vccd1 vccd1 vssd1 sky130_ef_sc_hd__decap_40_12$1
Xhold169 _1690_/Q _1322_/A vssd1 vccd1 vccd1 vssd1 sky130_fd_sc_hd__dlygate4sd3_1$1
X_1587_ _1805_/A _1739_/CLK _1587_/D vccd1 vssd1 vccd1 vssd1 sky130_fd_sc_hd__dfxtp_1$1
XFILLER_113_785 vssd1 vccd1 vccd1 vssd1 sky130_ef_sc_hd__decap_40_12$1
XFILLER_112_251 vccd1 vssd1 vccd1 vssd1 sky130_fd_sc_hd__fill_1$1
XFILLER_58_305 vssd1 vccd1 vccd1 vssd1 sky130_fd_sc_hd__fill_2$1
XFILLER_100_413 vssd1 vccd1 vccd1 vssd1 sky130_fd_sc_hd__fill_4$1
XFILLER_86_625 vssd1 vccd1 vccd1 vssd1 sky130_ef_sc_hd__decap_40_12$1
XFILLER_85_113 vssd1 vccd1 vccd1 vssd1 sky130_ef_sc_hd__decap_40_12$1
XFILLER_100_457 vssd1 vccd1 vccd1 vssd1 sky130_ef_sc_hd__decap_40_12$1
XFILLER_74_809 vssd1 vccd1 vccd1 vssd1 sky130_fd_sc_hd__fill_2$1
XFILLER_37_39 vssd1 vccd1 vccd1 vssd1 sky130_ef_sc_hd__decap_40_12$1
XFILLER_39_541 vssd1 vccd1 vccd1 vssd1 sky130_ef_sc_hd__decap_40_12$1
XTAP_TAPCELL_ROW_68_1323 vccd1 vssd1 sky130_fd_sc_hd__tapvpwrvgnd_1$1
XTAP_TAPCELL_ROW_1_312 vccd1 vssd1 sky130_fd_sc_hd__tapvpwrvgnd_1$1
XFILLER_27_769 vssd1 vccd1 vccd1 vssd1 sky130_ef_sc_hd__decap_40_12$1
XFILLER_53_27 vssd1 vccd1 vccd1 vssd1 sky130_ef_sc_hd__decap_40_12$1
XFILLER_14_419 vccd1 vssd1 vccd1 vssd1 sky130_fd_sc_hd__fill_1$1
XFILLER_41_205 vssd1 vccd1 vccd1 vssd1 sky130_ef_sc_hd__decap_40_12$1
XTAP_TAPCELL_ROW_81_1512 vccd1 vssd1 sky130_fd_sc_hd__tapvpwrvgnd_1$1
XTAP_TAPCELL_ROW_40_907 vccd1 vssd1 sky130_fd_sc_hd__tapvpwrvgnd_1$1
XFILLER_41_249 vssd1 vccd1 vccd1 vssd1 sky130_ef_sc_hd__decap_40_12$1
XFILLER_10_625 vssd1 vccd1 vccd1 vssd1 sky130_ef_sc_hd__decap_40_12$1
XFILLER_136_811 vccd1 vssd1 vccd1 vssd1 sky130_fd_sc_hd__fill_1$1
XFILLER_10_669 vssd1 vccd1 vccd1 vssd1 sky130_ef_sc_hd__decap_40_12$1
XFILLER_136_833 vccd1 vssd1 vccd1 vssd1 sky130_fd_sc_hd__fill_1$1
XFILLER_108_513 vssd1 vccd1 vccd1 vssd1 sky130_fd_sc_hd__fill_2$1
XTAP_TAPCELL_ROW_79_1485 vccd1 vssd1 sky130_fd_sc_hd__tapvpwrvgnd_1$1
XFILLER_123_505 vssd1 vccd1 vccd1 vssd1 sky130_fd_sc_hd__fill_4$1
XFILLER_118_53 vssd1 vccd1 vccd1 vssd1 sky130_ef_sc_hd__decap_40_12$1
XFILLER_108_579 vssd1 vccd1 vccd1 vssd1 sky130_fd_sc_hd__fill_8$1
XTAP_TAPCELL_ROW_9_434 vccd1 vssd1 sky130_fd_sc_hd__tapvpwrvgnd_1$1
XFILLER_2_813 vssd1 vccd1 vccd1 vssd1 sky130_ef_sc_hd__decap_40_12$1
XFILLER_135_398 vccd1 vssd1 vccd1 vssd1 sky130_fd_sc_hd__fill_1$1
XFILLER_118_97 vssd1 vccd1 vccd1 vssd1 sky130_ef_sc_hd__decap_40_12$1
XTAP_TAPCELL_ROW_92_1685 vccd1 vssd1 sky130_fd_sc_hd__tapvpwrvgnd_1$1
XTAP_TAPCELL_ROW_92_1674 vccd1 vssd1 sky130_fd_sc_hd__tapvpwrvgnd_1$1
XFILLER_49_305 vssd1 vccd1 vccd1 vssd1 sky130_ef_sc_hd__decap_40_12$1
XFILLER_134_41 vssd1 vccd1 vccd1 vssd1 sky130_ef_sc_hd__decap_40_12$1
XFILLER_103_273 vssd1 vccd1 vccd1 vssd1 sky130_fd_sc_hd__fill_4$1
XFILLER_89_485 vssd1 vccd1 vccd1 vssd1 sky130_ef_sc_hd__decap_40_12$1
XFILLER_1_389 vssd1 vccd1 vccd1 vssd1 sky130_fd_sc_hd__fill_2$1
XFILLER_134_85 vssd1 vccd1 vccd1 vssd1 sky130_ef_sc_hd__decap_40_12$1
XFILLER_77_669 vssd1 vccd1 vccd1 vssd1 sky130_fd_sc_hd__fill_2$1
XFILLER_65_809 vssd1 vccd1 vccd1 vssd1 sky130_ef_sc_hd__decap_40_12$1
XFILLER_49_349 vssd1 vccd1 vccd1 vssd1 sky130_ef_sc_hd__decap_40_12$1
XFILLER_91_105 vssd1 vccd1 vccd1 vssd1 sky130_fd_sc_hd__fill_4$1
XFILLER_18_725 vssd1 vccd1 vccd1 vssd1 sky130_ef_sc_hd__decap_40_12$1
XTAP_TAPCELL_ROW_123_2140 vccd1 vssd1 sky130_fd_sc_hd__tapvpwrvgnd_1$1
XFILLER_91_149 vssd1 vccd1 vccd1 vssd1 sky130_ef_sc_hd__decap_40_12$1
XFILLER_18_769 vssd1 vccd1 vccd1 vssd1 sky130_ef_sc_hd__decap_40_12$1
XTAP_TAPCELL_ROW_28_720 vccd1 vssd1 sky130_fd_sc_hd__tapvpwrvgnd_1$1
XTAP_TAPCELL_ROW_123_2151 vccd1 vssd1 sky130_fd_sc_hd__tapvpwrvgnd_1$1
XFILLER_72_363 vccd1 vssd1 vccd1 vssd1 sky130_fd_sc_hd__fill_1$1
XFILLER_17_279 vccd1 vssd1 vccd1 vssd1 sky130_fd_sc_hd__fill_1$1
XFILLER_33_717 vssd1 vccd1 vccd1 vssd1 sky130_fd_sc_hd__fill_8$1
XFILLER_72_385 vssd1 vccd1 vccd1 vssd1 sky130_fd_sc_hd__fill_4$1
XFILLER_45_599 vccd1 vssd1 vccd1 vssd1 sky130_fd_sc_hd__fill_1$1
XFILLER_60_558 vssd1 vccd1 vccd1 vssd1 sky130_ef_sc_hd__decap_40_12$1
XFILLER_13_441 vssd1 vccd1 vccd1 vssd1 sky130_fd_sc_hd__fill_4$1
XFILLER_32_249 vssd1 vccd1 vccd1 vssd1 sky130_fd_sc_hd__fill_2$1
XFILLER_13_485 vssd1 vccd1 vccd1 vssd1 sky130_ef_sc_hd__decap_40_12$1
XFILLER_41_783 vccd1 vssd1 vccd1 vssd1 sky130_fd_sc_hd__fill_1$1
XFILLER_43_93 vssd1 vccd1 vccd1 vssd1 sky130_ef_sc_hd__decap_40_12$1
XFILLER_9_445 vssd1 vccd1 vccd1 vssd1 sky130_fd_sc_hd__fill_2$1
XFILLER_126_321 vssd1 vccd1 vccd1 vssd1 sky130_ef_sc_hd__decap_40_12$1
XFILLER_114_527 vssd1 vccd1 vccd1 vssd1 sky130_fd_sc_hd__fill_4$1
XFILLER_99_205 vssd1 vccd1 vccd1 vssd1 sky130_ef_sc_hd__decap_40_12$1
XFILLER_5_673 vssd1 vccd1 vccd1 vssd1 sky130_ef_sc_hd__decap_40_12$1
X_1510_ _1782_/A _1608_/CLK _1510_/D vccd1 vssd1 vccd1 vssd1 sky130_fd_sc_hd__dfxtp_1$1
XFILLER_99_249 vssd1 vccd1 vccd1 vssd1 sky130_ef_sc_hd__decap_40_12$1
X_1441_ _1441_/C1 _1440_/X _1475_/A2 hold172/X _1747_/D vssd1 vccd1 vccd1 vssd1 sky130_fd_sc_hd__o211a_1$1
XFILLER_4_65 vssd1 vccd1 vccd1 vssd1 sky130_ef_sc_hd__decap_40_12$1
X_1372_ _1714_/Q _1372_/X _1398_/B vssd1 vccd1 vccd1 vssd1 sky130_fd_sc_hd__or2_1$1
XFILLER_68_625 vssd1 vccd1 vccd1 vssd1 sky130_ef_sc_hd__decap_40_12$1
XFILLER_67_113 vssd1 vccd1 vccd1 vssd1 sky130_ef_sc_hd__decap_40_12$1
XFILLER_68_669 vssd1 vccd1 vccd1 vssd1 sky130_fd_sc_hd__fill_8$1
XTAP_TAPCELL_ROW_108_1924 vccd1 vssd1 sky130_fd_sc_hd__tapvpwrvgnd_1$1
XTAP_TAPCELL_ROW_108_1913 vccd1 vssd1 sky130_fd_sc_hd__tapvpwrvgnd_1$1
XFILLER_83_617 vssd1 vccd1 vccd1 vssd1 sky130_ef_sc_hd__decap_40_12$1
XFILLER_36_533 vssd1 vccd1 vccd1 vssd1 sky130_ef_sc_hd__decap_40_12$1
XFILLER_23_205 vssd1 vccd1 vccd1 vssd1 sky130_ef_sc_hd__decap_40_12$1
XFILLER_24_717 vssd1 vccd1 vccd1 vssd1 sky130_fd_sc_hd__fill_2$1
XFILLER_24_739 vssd1 vccd1 vccd1 vssd1 sky130_fd_sc_hd__fill_2$1
XFILLER_90_193 vssd1 vccd1 vccd1 vssd1 sky130_fd_sc_hd__fill_2$1
XTAP_TAPCELL_ROW_63_1242 vccd1 vssd1 sky130_fd_sc_hd__tapvpwrvgnd_1$1
XFILLER_23_249 vssd1 vccd1 vccd1 vssd1 sky130_ef_sc_hd__decap_40_12$1
XFILLER_31_293 vssd1 vccd1 vccd1 vssd1 sky130_ef_sc_hd__decap_40_12$1
XFILLER_129_181 vssd1 vccd1 vccd1 vssd1 sky130_ef_sc_hd__decap_40_12$1
XFILLER_105_505 vssd1 vccd1 vccd1 vssd1 sky130_ef_sc_hd__decap_40_12$1
X_1708_ _1831_/A clkload9/A _1708_/D vccd1 vssd1 vccd1 vssd1 sky130_fd_sc_hd__dfxtp_1$1
XFILLER_2_109 vssd1 vccd1 vccd1 vssd1 sky130_ef_sc_hd__decap_40_12$1
X_1639_ _1639_/Q _1736_/CLK _1639_/D vccd1 vssd1 vccd1 vssd1 sky130_fd_sc_hd__dfxtp_1$1
XFILLER_113_593 vssd1 vccd1 vccd1 vssd1 sky130_ef_sc_hd__decap_40_12$1
XFILLER_99_783 vccd1 vssd1 vccd1 vssd1 sky130_fd_sc_hd__fill_1$1
XFILLER_48_27 vccd1 vssd1 vccd1 vssd1 sky130_fd_sc_hd__fill_1$1
XFILLER_100_221 vssd1 vccd1 vccd1 vssd1 sky130_ef_sc_hd__decap_40_12$1
XFILLER_101_777 vssd1 vccd1 vccd1 vssd1 sky130_fd_sc_hd__fill_4$1
XFILLER_100_265 vssd1 vccd1 vccd1 vssd1 sky130_ef_sc_hd__decap_40_12$1
XFILLER_74_617 vssd1 vccd1 vccd1 vssd1 sky130_ef_sc_hd__decap_40_12$1
XFILLER_73_105 vssd1 vccd1 vccd1 vssd1 sky130_fd_sc_hd__fill_4$1
XFILLER_104_77 vssd1 vccd1 vccd1 vssd1 sky130_fd_sc_hd__fill_4$1
XFILLER_73_149 vssd1 vccd1 vccd1 vssd1 sky130_ef_sc_hd__decap_40_12$1
XFILLER_64_15 vssd1 vccd1 vccd1 vssd1 sky130_ef_sc_hd__decap_40_12$1
XFILLER_39_393 vssd1 vccd1 vccd1 vssd1 sky130_ef_sc_hd__decap_40_12$1
XFILLER_82_672 vccd1 vssd1 vccd1 vssd1 sky130_fd_sc_hd__fill_1$1
XFILLER_82_661 vssd1 vccd1 vccd1 vssd1 sky130_fd_sc_hd__fill_2$1
XFILLER_54_363 vccd1 vssd1 vccd1 vssd1 sky130_fd_sc_hd__fill_1$1
XFILLER_42_525 vssd1 vccd1 vccd1 vssd1 sky130_fd_sc_hd__fill_4$1
XFILLER_120_65 vssd1 vccd1 vccd1 vssd1 sky130_ef_sc_hd__decap_40_12$1
XFILLER_81_193 vssd1 vccd1 vccd1 vssd1 sky130_ef_sc_hd__decap_40_12$1
XFILLER_14_249 vssd1 vccd1 vccd1 vssd1 sky130_fd_sc_hd__fill_2$1
XFILLER_42_558 vssd1 vccd1 vccd1 vssd1 sky130_ef_sc_hd__decap_40_12$1
XFILLER_23_783 vccd1 vssd1 vccd1 vssd1 sky130_fd_sc_hd__fill_1$1
XFILLER_23_794 vssd1 vccd1 vccd1 vssd1 sky130_ef_sc_hd__decap_40_12$1
XFILLER_10_433 vssd1 vccd1 vccd1 vssd1 sky130_ef_sc_hd__decap_40_12$1
XFILLER_10_477 vssd1 vccd1 vccd1 vssd1 sky130_ef_sc_hd__decap_40_12$1
XFILLER_108_321 vssd1 vccd1 vccd1 vssd1 sky130_ef_sc_hd__decap_40_12$1
XTAP_TAPCELL_ROW_94_1714 vccd1 vssd1 sky130_fd_sc_hd__tapvpwrvgnd_1$1
XTAP_TAPCELL_ROW_94_1703 vccd1 vssd1 sky130_fd_sc_hd__tapvpwrvgnd_1$1
XFILLER_124_825 vccd1 vssd1 vccd1 vssd1 sky130_fd_sc_hd__fill_1$1
XFILLER_108_365 vssd1 vccd1 vccd1 vssd1 sky130_ef_sc_hd__decap_40_12$1
XFILLER_123_335 vccd1 vssd1 vccd1 vssd1 sky130_fd_sc_hd__fill_1$1
XFILLER_2_643 vccd1 vssd1 vccd1 vssd1 sky130_fd_sc_hd__fill_1$1
XFILLER_49_113 vssd1 vccd1 vccd1 vssd1 sky130_ef_sc_hd__decap_40_12$1
XFILLER_89_293 vssd1 vccd1 vccd1 vssd1 sky130_ef_sc_hd__decap_40_12$1
XFILLER_77_466 vssd1 vccd1 vccd1 vssd1 sky130_ef_sc_hd__decap_40_12$1
XFILLER_65_617 vssd1 vccd1 vccd1 vssd1 sky130_ef_sc_hd__decap_40_12$1
XFILLER_18_533 vssd1 vccd1 vccd1 vssd1 sky130_ef_sc_hd__decap_40_12$1
XFILLER_73_661 vssd1 vccd1 vccd1 vssd1 sky130_fd_sc_hd__fill_8$1
XFILLER_33_503 vccd1 vssd1 vccd1 vssd1 sky130_fd_sc_hd__fill_1$1
XFILLER_61_823 vccd1 vssd1 vccd1 vssd1 sky130_fd_sc_hd__fill_1$1
XFILLER_45_385 vssd1 vccd1 vccd1 vssd1 sky130_fd_sc_hd__fill_4$1
XTAP_TAPCELL_ROW_103_1843 vccd1 vssd1 sky130_fd_sc_hd__tapvpwrvgnd_1$1
XFILLER_72_193 vssd1 vccd1 vccd1 vssd1 sky130_fd_sc_hd__fill_2$1
XFILLER_60_333 vssd1 vccd1 vccd1 vssd1 sky130_ef_sc_hd__decap_40_12$1
XFILLER_54_81 vssd1 vccd1 vccd1 vssd1 sky130_fd_sc_hd__fill_2$1
XFILLER_21_709 vssd1 vccd1 vccd1 vssd1 sky130_ef_sc_hd__decap_40_12$1
X_0941_ _1636_/Q _0740_/X _0941_/X _1732_/Q _1344_/A vccd1 vssd1 vccd1 vssd1 sky130_fd_sc_hd__a22o_1$1
XFILLER_60_377 vssd1 vccd1 vccd1 vssd1 sky130_ef_sc_hd__decap_40_12$1
XFILLER_13_293 vssd1 vccd1 vccd1 vssd1 sky130_ef_sc_hd__decap_40_12$1
XTAP_TAPCELL_ROW_31_759 vccd1 vssd1 sky130_fd_sc_hd__tapvpwrvgnd_1$1
XTAP_TAPCELL_ROW_136_2342 vccd1 vssd1 sky130_fd_sc_hd__tapvpwrvgnd_1$1
X_0872_ _1528_/Q _0949_/A _0872_/X _1720_/Q _1344_/A vccd1 vssd1 vccd1 vssd1 sky130_fd_sc_hd__a22o_1$1
Xclkload23 _1717_/CLK clkload23/Y vccd1 vssd1 vccd1 vssd1 sky130_fd_sc_hd__clkinv_4$1
Xclkload34 clkload34/X _1761_/CLK vssd1 vccd1 vccd1 vssd1 sky130_fd_sc_hd__clkbuf_4$1
XTAP_TAPCELL_ROW_11_472 vccd1 vssd1 sky130_fd_sc_hd__tapvpwrvgnd_1$1
XTAP_TAPCELL_ROW_11_461 vccd1 vssd1 sky130_fd_sc_hd__tapvpwrvgnd_1$1
Xclkload12 clkload12/Y _1608_/CLK vccd1 vssd1 vccd1 vssd1 sky130_fd_sc_hd__clkinv_2$1
XFILLER_127_685 vssd1 vccd1 vccd1 vssd1 sky130_fd_sc_hd__fill_2$1
XFILLER_55_3 vssd1 vccd1 vccd1 vssd1 sky130_ef_sc_hd__decap_40_12$1
XFILLER_126_195 vccd1 vssd1 vccd1 vssd1 sky130_fd_sc_hd__fill_1$1
XFILLER_114_357 vssd1 vccd1 vccd1 vssd1 sky130_fd_sc_hd__fill_4$1
XFILLER_96_731 vssd1 vccd1 vccd1 vssd1 sky130_ef_sc_hd__decap_40_12$1
X_1424_ _1847_/A _1424_/X _1474_/B vssd1 vccd1 vccd1 vssd1 sky130_fd_sc_hd__or2_1$1
Xclkbuf_leaf_44_wb_clk_i _1716_/CLK clkload0/A vssd1 vccd1 vccd1 vssd1 sky130_fd_sc_hd__clkbuf_8$1
XFILLER_110_530 vssd1 vccd1 vccd1 vssd1 sky130_fd_sc_hd__fill_2$1
X_1355_ _1421_/C1 _1354_/X _1409_/A2 hold61/X _1705_/D vssd1 vccd1 vccd1 vssd1 sky130_fd_sc_hd__o211a_1$1
XFILLER_56_606 vssd1 vccd1 vccd1 vssd1 sky130_ef_sc_hd__decap_40_12$1
XFILLER_110_585 vssd1 vccd1 vccd1 vssd1 sky130_fd_sc_hd__fill_2$1
XFILLER_96_797 vssd1 vccd1 vccd1 vssd1 sky130_ef_sc_hd__decap_40_12$1
XFILLER_68_477 vssd1 vccd1 vccd1 vssd1 sky130_ef_sc_hd__decap_40_12$1
XFILLER_55_105 vssd1 vccd1 vccd1 vssd1 sky130_fd_sc_hd__fill_4$1
X_1286_ _1840_/A _1286_/X _1342_/B vssd1 vccd1 vccd1 vssd1 sky130_fd_sc_hd__or2_1$1
XFILLER_83_447 vccd1 vssd1 vccd1 vssd1 sky130_fd_sc_hd__fill_1$1
XFILLER_55_149 vssd1 vccd1 vccd1 vssd1 sky130_ef_sc_hd__decap_40_12$1
XFILLER_36_363 vccd1 vssd1 vccd1 vssd1 sky130_fd_sc_hd__fill_1$1
XFILLER_64_694 vssd1 vccd1 vccd1 vssd1 sky130_fd_sc_hd__fill_4$1
XTAP_TAPCELL_ROW_19_583 vccd1 vssd1 sky130_fd_sc_hd__tapvpwrvgnd_1$1
XFILLER_24_525 vssd1 vccd1 vccd1 vssd1 sky130_fd_sc_hd__fill_4$1
XFILLER_63_193 vssd1 vccd1 vccd1 vssd1 sky130_ef_sc_hd__decap_40_12$1
XFILLER_51_333 vssd1 vccd1 vccd1 vssd1 sky130_fd_sc_hd__fill_2$1
XFILLER_24_569 vssd1 vccd1 vccd1 vssd1 sky130_ef_sc_hd__decap_40_12$1
XFILLER_34_29 vssd1 vccd1 vccd1 vssd1 sky130_ef_sc_hd__decap_40_12$1
Xclkload6 clkload6/X clkload6/A vssd1 vccd1 vccd1 vssd1 sky130_fd_sc_hd__clkbuf_8$1
XFILLER_20_753 vssd1 vccd1 vccd1 vssd1 sky130_fd_sc_hd__fill_2$1
XFILLER_137_449 vssd1 vccd1 vccd1 vssd1 sky130_fd_sc_hd__fill_2$1
XFILLER_118_630 vccd1 vssd1 vccd1 vssd1 sky130_fd_sc_hd__fill_1$1
XTAP_TAPCELL_ROW_76_1433 vccd1 vssd1 sky130_fd_sc_hd__tapvpwrvgnd_1$1
XFILLER_133_633 vssd1 vccd1 vccd1 vssd1 sky130_fd_sc_hd__fill_2$1
XFILLER_132_121 vssd1 vccd1 vccd1 vssd1 sky130_ef_sc_hd__decap_40_12$1
XFILLER_105_335 vccd1 vssd1 vccd1 vssd1 sky130_fd_sc_hd__fill_1$1
XTAP_TAPCELL_ROW_76_1444 vccd1 vssd1 sky130_fd_sc_hd__tapvpwrvgnd_1$1
XFILLER_59_15 vssd1 vccd1 vccd1 vssd1 sky130_ef_sc_hd__decap_40_12$1
XFILLER_3_429 vssd1 vccd1 vccd1 vssd1 sky130_ef_sc_hd__decap_40_12$1
XFILLER_132_165 vssd1 vccd1 vccd1 vssd1 sky130_ef_sc_hd__decap_40_12$1
Xfanout210 _1398_/B _1356_/B vssd1 vccd1 vccd1 vssd1 sky130_fd_sc_hd__clkbuf_8$1
XFILLER_121_839 vccd1 vssd1 vccd1 vssd1 sky130_fd_sc_hd__fill_1$1
XFILLER_120_305 vssd1 vccd1 vccd1 vssd1 sky130_fd_sc_hd__fill_2$1
Xfanout232 _1013_/A2 vccd1 vssd1 _0949_/Y vccd1 vssd1 sky130_fd_sc_hd__buf_6$1
Xfanout221 _1188_/B vccd1 vssd1 _1146_/X vccd1 vssd1 sky130_fd_sc_hd__buf_4$1
Xfanout254 hold9/X hold10/A vssd1 vccd1 vccd1 vssd1 sky130_fd_sc_hd__buf_8$1
Xfanout243 _0875_/B1 vccd1 vssd1 hold18/X vccd1 vssd1 sky130_fd_sc_hd__buf_6$1
Xfanout265 _1421_/C1 vccd1 vssd1 _1435_/C1 vccd1 vssd1 sky130_fd_sc_hd__buf_4$1
Xfanout276 _1475_/C1 vccd1 vssd1 _1465_/C1 vccd1 vssd1 sky130_fd_sc_hd__buf_4$1
XFILLER_101_585 vssd1 vccd1 vccd1 vssd1 sky130_ef_sc_hd__decap_40_12$1
XFILLER_47_606 vssd1 vccd1 vccd1 vssd1 sky130_fd_sc_hd__fill_8$1
XFILLER_47_617 vssd1 vccd1 vccd1 vssd1 sky130_ef_sc_hd__decap_40_12$1
XFILLER_75_69 vssd1 vccd1 vccd1 vssd1 sky130_ef_sc_hd__decap_40_12$1
XFILLER_15_503 vccd1 vssd1 vccd1 vssd1 sky130_fd_sc_hd__fill_1$1
XFILLER_27_385 vssd1 vccd1 vccd1 vssd1 sky130_fd_sc_hd__fill_4$1
XTAP_TAPCELL_ROW_38_870 vccd1 vssd1 sky130_fd_sc_hd__tapvpwrvgnd_1$1
XFILLER_43_823 vccd1 vssd1 vccd1 vssd1 sky130_fd_sc_hd__fill_1$1
XFILLER_91_57 vssd1 vccd1 vccd1 vssd1 sky130_ef_sc_hd__decap_40_12$1
XFILLER_54_193 vssd1 vccd1 vccd1 vssd1 sky130_fd_sc_hd__fill_2$1
XFILLER_42_333 vssd1 vccd1 vccd1 vssd1 sky130_ef_sc_hd__decap_40_12$1
XFILLER_42_377 vssd1 vccd1 vccd1 vssd1 sky130_ef_sc_hd__decap_40_12$1
XFILLER_11_753 vssd1 vccd1 vccd1 vssd1 sky130_ef_sc_hd__decap_40_12$1
XTAP_TAPCELL_ROW_118_2072 vccd1 vssd1 sky130_fd_sc_hd__tapvpwrvgnd_1$1
XFILLER_109_630 vssd1 vccd1 vccd1 vssd1 sky130_fd_sc_hd__fill_2$1
XFILLER_11_797 vssd1 vccd1 vccd1 vssd1 sky130_ef_sc_hd__decap_40_12$1
XFILLER_6_245 vssd1 vccd1 vccd1 vssd1 sky130_fd_sc_hd__fill_4$1
XFILLER_108_195 vccd1 vssd1 vccd1 vssd1 sky130_fd_sc_hd__fill_1$1
XFILLER_6_289 vssd1 vccd1 vccd1 vssd1 sky130_ef_sc_hd__decap_40_12$1
XFILLER_40_83 vccd1 vssd1 vccd1 vssd1 sky130_fd_sc_hd__fill_1$1
XTAP_TAPCELL_ROW_131_2272 vccd1 vssd1 sky130_fd_sc_hd__tapvpwrvgnd_1$1
XTAP_TAPCELL_ROW_131_2261 vccd1 vssd1 sky130_fd_sc_hd__tapvpwrvgnd_1$1
XFILLER_97_517 vssd1 vccd1 vccd1 vssd1 sky130_ef_sc_hd__decap_40_12$1
XFILLER_124_699 vccd1 vssd1 vccd1 vssd1 sky130_fd_sc_hd__fill_1$1
XFILLER_123_165 vssd1 vccd1 vccd1 vssd1 sky130_fd_sc_hd__fill_2$1
XFILLER_111_305 vssd1 vccd1 vccd1 vssd1 sky130_ef_sc_hd__decap_40_12$1
XFILLER_2_473 vssd1 vccd1 vccd1 vssd1 sky130_fd_sc_hd__fill_2$1
XFILLER_111_349 vssd1 vccd1 vccd1 vssd1 sky130_ef_sc_hd__decap_40_12$1
XFILLER_78_753 vssd1 vccd1 vccd1 vssd1 sky130_fd_sc_hd__fill_2$1
XFILLER_78_742 vssd1 vccd1 vccd1 vssd1 sky130_fd_sc_hd__fill_2$1
XFILLER_49_81 vssd1 vccd1 vccd1 vssd1 sky130_ef_sc_hd__decap_40_12$1
X_1140_ _1140_/A _1140_/X _1140_/B vssd1 vccd1 vccd1 vssd1 sky130_fd_sc_hd__or2_1$1
XFILLER_37_105 vssd1 vccd1 vccd1 vssd1 sky130_fd_sc_hd__fill_4$1
XFILLER_92_233 vssd1 vccd1 vccd1 vssd1 sky130_ef_sc_hd__decap_40_12$1
XFILLER_1_55 vccd1 vssd1 vccd1 vssd1 sky130_fd_sc_hd__fill_1$1
XFILLER_19_820 vssd1 vccd1 vccd1 vssd1 sky130_fd_sc_hd__fill_4$1
X_1071_ _1465_/C1 _1070_/X _1079_/A2 hold146/X _1568_/D vssd1 vccd1 vccd1 vssd1 sky130_fd_sc_hd__o211a_1$1
XFILLER_37_149 vssd1 vccd1 vccd1 vssd1 sky130_ef_sc_hd__decap_40_12$1
XFILLER_92_277 vssd1 vccd1 vccd1 vssd1 sky130_ef_sc_hd__decap_40_12$1
XFILLER_18_363 vccd1 vssd1 vccd1 vssd1 sky130_fd_sc_hd__fill_1$1
XTAP_TAPCELL_ROW_47_1001 vccd1 vssd1 sky130_fd_sc_hd__tapvpwrvgnd_1$1
XTAP_TAPCELL_ROW_47_1012 vccd1 vssd1 sky130_fd_sc_hd__tapvpwrvgnd_1$1
XTAP_TAPCELL_ROW_16_542 vccd1 vssd1 sky130_fd_sc_hd__tapvpwrvgnd_1$1
XFILLER_33_333 vssd1 vccd1 vccd1 vssd1 sky130_fd_sc_hd__fill_2$1
XFILLER_45_193 vssd1 vccd1 vccd1 vssd1 sky130_ef_sc_hd__decap_40_12$1
XFILLER_61_697 vssd1 vccd1 vccd1 vssd1 sky130_ef_sc_hd__decap_40_12$1
XTAP_TAPCELL_ROW_60_1201 vccd1 vssd1 sky130_fd_sc_hd__tapvpwrvgnd_1$1
XFILLER_60_141 vssd1 vccd1 vccd1 vssd1 sky130_ef_sc_hd__decap_40_12$1
XFILLER_21_517 vssd1 vccd1 vccd1 vssd1 sky130_ef_sc_hd__decap_40_12$1
XFILLER_119_405 vssd1 vccd1 vccd1 vssd1 sky130_ef_sc_hd__decap_40_12$1
X_0924_ _1411_/A _1761_/Q _0923_/X _0924_/X vccd1 vssd1 vccd1 vssd1 sky130_fd_sc_hd__a21o_1$1
X_0855_ _0855_/X _1493_/Q _0739_/D _0752_/A vssd1 vccd1 vccd1 vssd1 sky130_fd_sc_hd__o21a_1$1
XFILLER_119_449 vssd1 vccd1 vccd1 vssd1 sky130_ef_sc_hd__decap_40_12$1
XFILLER_119_438 vssd1 vccd1 vccd1 vssd1 sky130_fd_sc_hd__fill_8$1
XFILLER_134_419 vccd1 vssd1 vccd1 vssd1 sky130_fd_sc_hd__fill_1$1
XFILLER_134_408 vccd1 vssd1 vccd1 vssd1 sky130_fd_sc_hd__fill_1$1
X_0786_ _1829_/A _1344_/A _0786_/X _1836_/A hold18/X vccd1 vssd1 vccd1 vssd1 sky130_fd_sc_hd__a22o_1$1
XFILLER_114_121 vssd1 vccd1 vccd1 vssd1 sky130_ef_sc_hd__decap_40_12$1
XTAP_TAPCELL_ROW_58_1174 vccd1 vssd1 sky130_fd_sc_hd__tapvpwrvgnd_1$1
XTAP_TAPCELL_ROW_58_1163 vccd1 vssd1 sky130_fd_sc_hd__tapvpwrvgnd_1$1
XFILLER_114_165 vssd1 vccd1 vccd1 vssd1 sky130_ef_sc_hd__decap_40_12$1
XFILLER_102_305 vssd1 vccd1 vccd1 vssd1 sky130_fd_sc_hd__fill_2$1
Xhold29 wbs_dat_i[5] hold29/X vssd1 vccd1 vccd1 vssd1 sky130_fd_sc_hd__dlygate4sd3_1$1
XFILLER_130_669 vssd1 vccd1 vccd1 vssd1 sky130_ef_sc_hd__decap_40_12$1
X_1407_ _1475_/C1 _1406_/X _1409_/A2 hold64/X _1731_/D vssd1 vccd1 vccd1 vssd1 sky130_fd_sc_hd__o211a_1$1
Xhold18 hold18/A hold18/X vssd1 vccd1 vccd1 vssd1 sky130_fd_sc_hd__dlygate4sd3_1$1
XTAP_TAPCELL_ROW_71_1363 vccd1 vssd1 sky130_fd_sc_hd__tapvpwrvgnd_1$1
XFILLER_84_701 vssd1 vccd1 vccd1 vssd1 sky130_ef_sc_hd__decap_40_12$1
XFILLER_69_775 vssd1 vccd1 vccd1 vssd1 sky130_fd_sc_hd__fill_2$1
XFILLER_29_617 vssd1 vccd1 vccd1 vssd1 sky130_ef_sc_hd__decap_40_12$1
X_1338_ _1338_/A _1338_/X _1342_/B vssd1 vccd1 vccd1 vssd1 sky130_fd_sc_hd__or2_1$1
X_1269_ _1417_/C1 _1268_/X _1273_/A2 hold146/X _1664_/D vssd1 vccd1 vccd1 vssd1 sky130_fd_sc_hd__o211a_1$1
XFILLER_56_469 vssd1 vccd1 vccd1 vssd1 sky130_fd_sc_hd__fill_4$1
XFILLER_83_277 vssd1 vccd1 vccd1 vssd1 sky130_fd_sc_hd__fill_2$1
XFILLER_45_39 vssd1 vccd1 vccd1 vssd1 sky130_ef_sc_hd__decap_40_12$1
XFILLER_24_333 vssd1 vccd1 vccd1 vssd1 sky130_ef_sc_hd__decap_40_12$1
XFILLER_36_193 vssd1 vccd1 vccd1 vssd1 sky130_fd_sc_hd__fill_2$1
XFILLER_24_377 vssd1 vccd1 vccd1 vssd1 sky130_ef_sc_hd__decap_40_12$1
XFILLER_61_27 vssd1 vccd1 vccd1 vssd1 sky130_ef_sc_hd__decap_40_12$1
XFILLER_138_725 vssd1 vccd1 vccd1 vssd1 sky130_fd_sc_hd__fill_2$1
XFILLER_137_202 vccd1 vssd1 vccd1 vssd1 sky130_fd_sc_hd__fill_1$1
XFILLER_137_279 vccd1 vssd1 vccd1 vssd1 sky130_fd_sc_hd__fill_1$1
XFILLER_106_622 vssd1 vccd1 vccd1 vssd1 sky130_ef_sc_hd__decap_40_12$1
XFILLER_4_749 vssd1 vccd1 vccd1 vssd1 sky130_fd_sc_hd__fill_4$1
XFILLER_106_655 vccd1 vssd1 vccd1 vssd1 sky130_fd_sc_hd__fill_1$1
XFILLER_10_53 vssd1 vccd1 vccd1 vssd1 sky130_ef_sc_hd__decap_40_12$1
XFILLER_3_237 vssd1 vccd1 vccd1 vssd1 sky130_ef_sc_hd__decap_40_12$1
XFILLER_126_53 vssd1 vccd1 vccd1 vssd1 sky130_ef_sc_hd__decap_40_12$1
XFILLER_106_699 vccd1 vssd1 vccd1 vssd1 sky130_fd_sc_hd__fill_1$1
XFILLER_105_165 vssd1 vccd1 vccd1 vssd1 sky130_fd_sc_hd__fill_2$1
XFILLER_79_517 vssd1 vccd1 vccd1 vssd1 sky130_ef_sc_hd__decap_40_12$1
XFILLER_10_97 vssd1 vccd1 vccd1 vssd1 sky130_ef_sc_hd__decap_40_12$1
XFILLER_126_97 vssd1 vccd1 vccd1 vssd1 sky130_ef_sc_hd__decap_40_12$1
XFILLER_121_647 vccd1 vssd1 vccd1 vssd1 sky130_fd_sc_hd__fill_1$1
XFILLER_87_561 vssd1 vccd1 vccd1 vssd1 sky130_ef_sc_hd__decap_40_12$1
XFILLER_75_701 vccd1 vssd1 vccd1 vssd1 sky130_fd_sc_hd__fill_1$1
XFILLER_19_105 vssd1 vccd1 vccd1 vssd1 sky130_fd_sc_hd__fill_4$1
XTAP_TAPCELL_ROW_89_1635 vccd1 vssd1 sky130_fd_sc_hd__tapvpwrvgnd_1$1
XFILLER_19_51 vssd1 vccd1 vccd1 vssd1 sky130_fd_sc_hd__fill_4$1
XFILLER_47_447 vccd1 vssd1 vccd1 vssd1 sky130_fd_sc_hd__fill_1$1
XFILLER_74_233 vssd1 vccd1 vccd1 vssd1 sky130_ef_sc_hd__decap_40_12$1
XFILLER_19_149 vssd1 vccd1 vccd1 vssd1 sky130_ef_sc_hd__decap_40_12$1
XFILLER_35_609 vssd1 vccd1 vccd1 vssd1 sky130_fd_sc_hd__fill_2$1
XFILLER_74_277 vssd1 vccd1 vccd1 vssd1 sky130_ef_sc_hd__decap_40_12$1
XFILLER_62_417 vssd1 vccd1 vccd1 vssd1 sky130_fd_sc_hd__fill_2$1
XFILLER_15_333 vssd1 vccd1 vccd1 vssd1 sky130_fd_sc_hd__fill_2$1
XFILLER_27_193 vssd1 vccd1 vccd1 vssd1 sky130_ef_sc_hd__decap_40_12$1
XFILLER_43_642 vssd1 vccd1 vccd1 vssd1 sky130_ef_sc_hd__decap_40_12$1
XTAP_TAPCELL_ROW_100_1802 vccd1 vssd1 sky130_fd_sc_hd__tapvpwrvgnd_1$1
XFILLER_42_141 vssd1 vccd1 vccd1 vssd1 sky130_ef_sc_hd__decap_40_12$1
XFILLER_70_494 vssd1 vccd1 vccd1 vssd1 sky130_ef_sc_hd__decap_40_12$1
XTAP_TAPCELL_ROW_13_501 vccd1 vssd1 sky130_fd_sc_hd__tapvpwrvgnd_1$1
XFILLER_129_725 vssd1 vccd1 vccd1 vssd1 sky130_fd_sc_hd__fill_2$1
XTAP_TAPCELL_ROW_133_2301 vccd1 vssd1 sky130_fd_sc_hd__tapvpwrvgnd_1$1
XFILLER_11_561 vssd1 vccd1 vccd1 vssd1 sky130_ef_sc_hd__decap_40_12$1
XFILLER_51_93 vssd1 vccd1 vccd1 vssd1 sky130_ef_sc_hd__decap_40_12$1
XFILLER_137_791 vssd1 vccd1 vccd1 vssd1 sky130_ef_sc_hd__decap_40_12$1
XFILLER_112_625 vssd1 vccd1 vccd1 vssd1 sky130_ef_sc_hd__decap_40_12$1
XFILLER_124_496 vssd1 vccd1 vccd1 vssd1 sky130_fd_sc_hd__fill_8$1
XFILLER_112_669 vssd1 vccd1 vccd1 vssd1 sky130_ef_sc_hd__decap_40_12$1
XTAP_TAPCELL_ROW_111_1964 vccd1 vssd1 sky130_fd_sc_hd__tapvpwrvgnd_1$1
XFILLER_111_113 vssd1 vccd1 vccd1 vssd1 sky130_ef_sc_hd__decap_40_12$1
XFILLER_97_369 vssd1 vccd1 vccd1 vssd1 sky130_fd_sc_hd__fill_2$1
XTAP_TAPCELL_ROW_53_1093 vccd1 vssd1 sky130_fd_sc_hd__tapvpwrvgnd_1$1
XFILLER_18_3 vssd1 vccd1 vccd1 vssd1 sky130_ef_sc_hd__decap_40_12$1
XFILLER_93_553 vssd1 vccd1 vccd1 vssd1 sky130_fd_sc_hd__fill_4$1
XFILLER_38_469 vssd1 vccd1 vccd1 vssd1 sky130_fd_sc_hd__fill_4$1
X_1123_ _1387_/C1 _1122_/X _1123_/A2 hold125/X _1593_/D vssd1 vccd1 vccd1 vssd1 sky130_fd_sc_hd__o211a_1$1
X_1054_ _1560_/Q _1054_/X _1078_/B vssd1 vccd1 vccd1 vssd1 sky130_fd_sc_hd__or2_1$1
XFILLER_93_597 vssd1 vccd1 vccd1 vssd1 sky130_ef_sc_hd__decap_40_12$1
XFILLER_65_277 vssd1 vccd1 vccd1 vssd1 sky130_fd_sc_hd__fill_2$1
XFILLER_53_417 vssd1 vccd1 vccd1 vssd1 sky130_fd_sc_hd__fill_4$1
XFILLER_18_193 vssd1 vccd1 vccd1 vssd1 sky130_fd_sc_hd__fill_2$1
XFILLER_34_642 vssd1 vccd1 vccd1 vssd1 sky130_fd_sc_hd__fill_2$1
XFILLER_61_461 vssd1 vccd1 vccd1 vssd1 sky130_ef_sc_hd__decap_40_12$1
X_0907_ _1630_/Q _1147_/A _0909_/B _1598_/Q hold10/A vccd1 vssd1 vccd1 vssd1 sky130_fd_sc_hd__a22o_1$1
XFILLER_119_279 vccd1 vssd1 vccd1 vssd1 sky130_fd_sc_hd__fill_1$1
X_0838_ _1715_/Q _0878_/B1 _0838_/X _1555_/Q _1015_/A vccd1 vssd1 vccd1 vssd1 sky130_fd_sc_hd__a22o_1$1
XFILLER_134_249 vssd1 vccd1 vccd1 vssd1 sky130_fd_sc_hd__fill_2$1
XPHY_EDGE_ROW_131_Right_131 vccd1 vssd1 vccd1 vssd1 sky130_fd_sc_hd__decap_3$1
X_0769_ input5/X _0784_/B1 _0769_/X _1839_/A _0875_/B1 vccd1 vssd1 vccd1 vssd1 sky130_fd_sc_hd__a22o_1$1
XFILLER_103_669 vssd1 vccd1 vccd1 vssd1 sky130_fd_sc_hd__fill_2$1
XFILLER_0_229 vssd1 vccd1 vccd1 vssd1 sky130_ef_sc_hd__decap_40_12$1
XFILLER_130_477 vssd1 vccd1 vccd1 vssd1 sky130_ef_sc_hd__decap_40_12$1
XFILLER_69_561 vssd1 vccd1 vccd1 vssd1 sky130_ef_sc_hd__decap_40_12$1
XFILLER_84_531 vccd1 vssd1 vccd1 vssd1 sky130_fd_sc_hd__fill_1$1
XFILLER_56_27 vccd1 vssd1 vccd1 vssd1 sky130_fd_sc_hd__fill_1$1
XFILLER_56_233 vssd1 vccd1 vccd1 vssd1 sky130_ef_sc_hd__decap_40_12$1
XFILLER_17_609 vssd1 vccd1 vccd1 vssd1 sky130_fd_sc_hd__fill_4$1
XFILLER_29_447 vccd1 vssd1 vccd1 vssd1 sky130_fd_sc_hd__fill_1$1
XFILLER_56_277 vssd1 vccd1 vccd1 vssd1 sky130_ef_sc_hd__decap_40_12$1
XFILLER_44_417 vssd1 vccd1 vccd1 vssd1 sky130_fd_sc_hd__fill_2$1
XFILLER_112_77 vssd1 vccd1 vccd1 vssd1 sky130_fd_sc_hd__fill_4$1
XFILLER_72_15 vssd1 vccd1 vccd1 vssd1 sky130_ef_sc_hd__decap_40_12$1
XFILLER_71_225 vssd1 vccd1 vccd1 vssd1 sky130_ef_sc_hd__decap_40_12$1
XFILLER_25_653 vssd1 vccd1 vccd1 vssd1 sky130_ef_sc_hd__decap_40_12$1
XTAP_TAPCELL_ROW_84_1565 vccd1 vssd1 sky130_fd_sc_hd__tapvpwrvgnd_1$1
XTAP_TAPCELL_ROW_84_1554 vccd1 vssd1 sky130_fd_sc_hd__tapvpwrvgnd_1$1
XFILLER_24_141 vssd1 vccd1 vccd1 vssd1 sky130_ef_sc_hd__decap_40_12$1
XFILLER_80_781 vssd1 vccd1 vccd1 vssd1 sky130_fd_sc_hd__fill_8$1
XFILLER_40_634 vssd1 vccd1 vccd1 vssd1 sky130_fd_sc_hd__fill_8$1
XFILLER_40_645 vssd1 vccd1 vccd1 vssd1 sky130_ef_sc_hd__decap_40_12$1
XFILLER_8_307 vccd1 vssd1 vccd1 vssd1 sky130_fd_sc_hd__fill_1$1
XFILLER_126_717 vssd1 vccd1 vccd1 vssd1 sky130_ef_sc_hd__decap_40_12$1
XFILLER_122_3 vssd1 vccd1 vccd1 vssd1 sky130_ef_sc_hd__decap_40_12$1
XTAP_TAPCELL_ROW_115_2020 vccd1 vssd1 sky130_fd_sc_hd__tapvpwrvgnd_1$1
XFILLER_125_205 vssd1 vccd1 vccd1 vssd1 sky130_ef_sc_hd__decap_40_12$1
XFILLER_119_780 vssd1 vccd1 vccd1 vssd1 sky130_fd_sc_hd__fill_4$1
XTAP_TAPCELL_ROW_115_2031 vccd1 vssd1 sky130_fd_sc_hd__tapvpwrvgnd_1$1
XFILLER_4_513 vssd1 vccd1 vccd1 vssd1 sky130_ef_sc_hd__decap_40_12$1
XFILLER_125_249 vssd1 vccd1 vccd1 vssd1 sky130_ef_sc_hd__decap_40_12$1
XFILLER_4_557 vssd1 vccd1 vccd1 vssd1 sky130_ef_sc_hd__decap_40_12$1
XFILLER_106_474 vssd1 vccd1 vccd1 vssd1 sky130_fd_sc_hd__fill_2$1
XFILLER_133_293 vssd1 vccd1 vccd1 vssd1 sky130_ef_sc_hd__decap_40_12$1
XFILLER_0_741 vssd1 vccd1 vccd1 vssd1 sky130_ef_sc_hd__decap_40_12$1
XFILLER_67_509 vssd1 vccd1 vccd1 vssd1 sky130_fd_sc_hd__fill_2$1
XFILLER_48_701 vssd1 vccd1 vccd1 vssd1 sky130_fd_sc_hd__fill_4$1
XFILLER_121_488 vssd1 vccd1 vccd1 vssd1 sky130_ef_sc_hd__decap_40_12$1
XFILLER_0_785 vssd1 vccd1 vccd1 vssd1 sky130_ef_sc_hd__decap_40_12$1
XFILLER_75_553 vssd1 vccd1 vccd1 vssd1 sky130_fd_sc_hd__fill_4$1
XTAP_TAPCELL_ROW_126_2193 vccd1 vssd1 sky130_fd_sc_hd__tapvpwrvgnd_1$1
XFILLER_90_501 vssd1 vccd1 vccd1 vssd1 sky130_fd_sc_hd__fill_8$1
XFILLER_35_417 vssd1 vccd1 vccd1 vssd1 sky130_ef_sc_hd__decap_40_12$1
XFILLER_47_277 vssd1 vccd1 vccd1 vssd1 sky130_fd_sc_hd__fill_2$1
XFILLER_90_545 vssd1 vccd1 vccd1 vssd1 sky130_ef_sc_hd__decap_40_12$1
XFILLER_90_589 vssd1 vccd1 vccd1 vssd1 sky130_fd_sc_hd__fill_4$1
XFILLER_16_697 vssd1 vccd1 vccd1 vssd1 sky130_fd_sc_hd__fill_2$1
XTAP_TAPCELL_ROW_26_692 vccd1 vssd1 sky130_fd_sc_hd__tapvpwrvgnd_1$1
XFILLER_43_494 vssd1 vccd1 vccd1 vssd1 sky130_fd_sc_hd__fill_8$1
X_1810_ vccd1 vssd1 _1810_/X _1810_/A vccd1 vssd1 sky130_fd_sc_hd__buf_2$1
XFILLER_62_81 vssd1 vccd1 vccd1 vssd1 sky130_fd_sc_hd__fill_2$1
XFILLER_30_133 vssd1 vccd1 vccd1 vssd1 sky130_fd_sc_hd__fill_4$1
XFILLER_129_522 vccd1 vssd1 vccd1 vssd1 sky130_fd_sc_hd__fill_1$1
XFILLER_30_177 vssd1 vccd1 vccd1 vssd1 sky130_ef_sc_hd__decap_40_12$1
XFILLER_129_577 vccd1 vssd1 vccd1 vssd1 sky130_fd_sc_hd__fill_1$1
XFILLER_129_555 vssd1 vccd1 vccd1 vssd1 sky130_fd_sc_hd__fill_4$1
X_1741_ _1849_/A clkload3/A _1741_/D vccd1 vssd1 vccd1 vssd1 sky130_fd_sc_hd__dfxtp_1$1
XFILLER_11_391 vccd1 vssd1 vccd1 vssd1 sky130_fd_sc_hd__fill_1$1
X_1672_ _1840_/A _1738_/CLK _1672_/D vccd1 vssd1 vccd1 vssd1 sky130_fd_sc_hd__dfxtp_1$1
XFILLER_7_373 vssd1 vccd1 vccd1 vssd1 sky130_ef_sc_hd__decap_40_12$1
XFILLER_116_249 vssd1 vccd1 vccd1 vssd1 sky130_fd_sc_hd__fill_2$1
XFILLER_125_783 vccd1 vssd1 vccd1 vssd1 sky130_fd_sc_hd__fill_1$1
XTAP_TAPCELL_ROW_55_1122 vccd1 vssd1 sky130_fd_sc_hd__tapvpwrvgnd_1$1
XFILLER_112_444 vssd1 vccd1 vccd1 vssd1 sky130_ef_sc_hd__decap_40_12$1
XFILLER_98_645 vssd1 vccd1 vccd1 vssd1 sky130_ef_sc_hd__decap_40_12$1
XFILLER_97_111 vccd1 vssd1 vccd1 vssd1 sky130_fd_sc_hd__fill_1$1
XFILLER_85_317 vssd1 vccd1 vccd1 vssd1 sky130_ef_sc_hd__decap_40_12$1
XFILLER_39_745 vssd1 vccd1 vccd1 vssd1 sky130_fd_sc_hd__fill_2$1
XFILLER_38_233 vssd1 vccd1 vccd1 vssd1 sky130_ef_sc_hd__decap_40_12$1
XFILLER_39_756 vssd1 vccd1 vccd1 vssd1 sky130_ef_sc_hd__decap_40_12$1
XFILLER_93_361 vssd1 vccd1 vccd1 vssd1 sky130_ef_sc_hd__decap_40_12$1
XFILLER_81_501 vssd1 vccd1 vccd1 vssd1 sky130_fd_sc_hd__fill_2$1
XFILLER_26_417 vssd1 vccd1 vccd1 vssd1 sky130_fd_sc_hd__fill_2$1
XFILLER_38_277 vssd1 vccd1 vccd1 vssd1 sky130_ef_sc_hd__decap_40_12$1
X_1106_ _1803_/A _1106_/X _1144_/B vssd1 vccd1 vccd1 vssd1 sky130_fd_sc_hd__or2_1$1
XFILLER_53_225 vssd1 vccd1 vccd1 vssd1 sky130_ef_sc_hd__decap_40_12$1
X_1037_ _1431_/C1 _1036_/X _1053_/A2 hold142/X _1551_/D vssd1 vccd1 vccd1 vssd1 sky130_fd_sc_hd__o211a_1$1
XFILLER_22_601 vssd1 vccd1 vccd1 vssd1 sky130_ef_sc_hd__decap_40_12$1
XTAP_TAPCELL_ROW_66_1295 vccd1 vssd1 sky130_fd_sc_hd__tapvpwrvgnd_1$1
XTAP_TAPCELL_ROW_66_1284 vccd1 vssd1 sky130_fd_sc_hd__tapvpwrvgnd_1$1
XFILLER_62_781 vssd1 vccd1 vccd1 vssd1 sky130_ef_sc_hd__decap_40_12$1
XFILLER_21_111 vccd1 vssd1 vccd1 vssd1 sky130_fd_sc_hd__fill_1$1
XFILLER_22_645 vssd1 vccd1 vccd1 vssd1 sky130_ef_sc_hd__decap_40_12$1
XFILLER_42_29 vssd1 vccd1 vccd1 vssd1 sky130_ef_sc_hd__decap_40_12$1
XFILLER_135_503 vccd1 vssd1 vccd1 vssd1 sky130_fd_sc_hd__fill_1$1
XFILLER_107_205 vssd1 vccd1 vccd1 vssd1 sky130_ef_sc_hd__decap_40_12$1
XFILLER_123_709 vssd1 vccd1 vccd1 vssd1 sky130_ef_sc_hd__decap_40_12$1
XFILLER_107_249 vssd1 vccd1 vccd1 vssd1 sky130_ef_sc_hd__decap_40_12$1
XFILLER_1_505 vssd1 vccd1 vccd1 vssd1 sky130_ef_sc_hd__decap_40_12$1
XFILLER_115_293 vssd1 vccd1 vccd1 vssd1 sky130_ef_sc_hd__decap_40_12$1
XFILLER_107_55 vccd1 vssd1 vccd1 vssd1 sky130_fd_sc_hd__fill_1$1
XFILLER_88_133 vssd1 vccd1 vccd1 vssd1 sky130_fd_sc_hd__fill_4$1
XFILLER_131_775 vssd1 vccd1 vccd1 vssd1 sky130_fd_sc_hd__fill_8$1
XFILLER_103_444 vssd1 vccd1 vccd1 vssd1 sky130_fd_sc_hd__fill_4$1
XFILLER_67_15 vssd1 vccd1 vccd1 vssd1 sky130_ef_sc_hd__decap_40_12$1
XFILLER_88_177 vssd1 vccd1 vccd1 vssd1 sky130_ef_sc_hd__decap_40_12$1
XFILLER_69_391 vccd1 vssd1 vccd1 vssd1 sky130_fd_sc_hd__fill_1$1
XFILLER_57_553 vssd1 vccd1 vccd1 vssd1 sky130_fd_sc_hd__fill_4$1
XTAP_TAPCELL_ROW_4_365 vccd1 vssd1 sky130_fd_sc_hd__tapvpwrvgnd_1$1
XTAP_TAPCELL_ROW_4_354 vccd1 vssd1 sky130_fd_sc_hd__tapvpwrvgnd_1$1
XFILLER_84_361 vssd1 vccd1 vccd1 vssd1 sky130_fd_sc_hd__fill_2$1
XFILLER_57_597 vssd1 vccd1 vccd1 vssd1 sky130_ef_sc_hd__decap_40_12$1
XFILLER_17_417 vssd1 vccd1 vccd1 vssd1 sky130_ef_sc_hd__decap_40_12$1
XFILLER_29_277 vssd1 vccd1 vccd1 vssd1 sky130_fd_sc_hd__fill_2$1
XFILLER_45_726 vssd1 vccd1 vccd1 vssd1 sky130_fd_sc_hd__fill_2$1
XFILLER_83_69 vssd1 vccd1 vccd1 vssd1 sky130_ef_sc_hd__decap_40_12$1
XFILLER_72_545 vssd1 vccd1 vccd1 vssd1 sky130_fd_sc_hd__fill_8$1
XFILLER_16_41 vssd1 vccd1 vccd1 vssd1 sky130_ef_sc_hd__decap_40_12$1
XFILLER_25_461 vssd1 vccd1 vccd1 vssd1 sky130_ef_sc_hd__decap_40_12$1
XFILLER_53_781 vssd1 vccd1 vccd1 vssd1 sky130_fd_sc_hd__fill_2$1
XPHY_EDGE_ROW_11_Right_11 vccd1 vssd1 vccd1 vssd1 sky130_fd_sc_hd__decap_3$1
XFILLER_16_85 vssd1 vccd1 vccd1 vssd1 sky130_ef_sc_hd__decap_40_12$1
XTAP_TAPCELL_ROW_43_938 vccd1 vssd1 sky130_fd_sc_hd__tapvpwrvgnd_1$1
XTAP_TAPCELL_ROW_43_949 vccd1 vssd1 sky130_fd_sc_hd__tapvpwrvgnd_1$1
XFILLER_12_133 vssd1 vccd1 vccd1 vssd1 sky130_fd_sc_hd__fill_4$1
XTAP_TAPCELL_ROW_23_640 vccd1 vssd1 sky130_fd_sc_hd__tapvpwrvgnd_1$1
XFILLER_12_177 vssd1 vccd1 vccd1 vssd1 sky130_ef_sc_hd__decap_40_12$1
XTAP_TAPCELL_ROW_23_651 vccd1 vssd1 sky130_fd_sc_hd__tapvpwrvgnd_1$1
XFILLER_40_475 vccd1 vssd1 vccd1 vssd1 sky130_fd_sc_hd__fill_1$1
XFILLER_8_137 vssd1 vccd1 vccd1 vssd1 sky130_fd_sc_hd__fill_2$1
XFILLER_138_363 vccd1 vssd1 vccd1 vssd1 sky130_fd_sc_hd__fill_1$1
XFILLER_126_525 vssd1 vccd1 vccd1 vssd1 sky130_fd_sc_hd__fill_4$1
XTAP_TAPCELL_ROW_97_1756 vccd1 vssd1 sky130_fd_sc_hd__tapvpwrvgnd_1$1
XFILLER_5_833 vssd1 vccd1 vccd1 vssd1 sky130_fd_sc_hd__fill_4$1
XFILLER_126_569 vssd1 vccd1 vccd1 vssd1 sky130_ef_sc_hd__decap_40_12$1
XFILLER_4_321 vssd1 vccd1 vccd1 vssd1 sky130_ef_sc_hd__decap_40_12$1
XFILLER_107_783 vccd1 vssd1 vccd1 vssd1 sky130_fd_sc_hd__fill_1$1
XFILLER_4_365 vssd1 vccd1 vccd1 vssd1 sky130_ef_sc_hd__decap_40_12$1
XFILLER_79_111 vccd1 vssd1 vccd1 vssd1 sky130_fd_sc_hd__fill_1$1
XPHY_EDGE_ROW_20_Right_20 vccd1 vssd1 vccd1 vssd1 sky130_fd_sc_hd__decap_3$1
XFILLER_122_753 vssd1 vccd1 vccd1 vssd1 sky130_fd_sc_hd__fill_2$1
XFILLER_95_615 vccd1 vssd1 vccd1 vssd1 sky130_fd_sc_hd__fill_1$1
XTAP_TAPCELL_ROW_128_2222 vccd1 vssd1 sky130_fd_sc_hd__tapvpwrvgnd_1$1
XFILLER_67_317 vssd1 vccd1 vccd1 vssd1 sky130_ef_sc_hd__decap_40_12$1
XFILLER_82_309 vssd1 vccd1 vccd1 vssd1 sky130_ef_sc_hd__decap_40_12$1
XTAP_TAPCELL_ROW_50_1052 vccd1 vssd1 sky130_fd_sc_hd__tapvpwrvgnd_1$1
XFILLER_91_821 vssd1 vccd1 vccd1 vssd1 sky130_fd_sc_hd__fill_2$1
XFILLER_75_361 vssd1 vccd1 vccd1 vssd1 sky130_ef_sc_hd__decap_40_12$1
XFILLER_63_501 vssd1 vccd1 vccd1 vssd1 sky130_fd_sc_hd__fill_2$1
XFILLER_57_81 vssd1 vccd1 vccd1 vssd1 sky130_ef_sc_hd__decap_40_12$1
XFILLER_36_737 vccd1 vssd1 vccd1 vssd1 sky130_fd_sc_hd__fill_1$1
XFILLER_48_586 vssd1 vccd1 vccd1 vssd1 sky130_fd_sc_hd__fill_2$1
XFILLER_35_225 vssd1 vccd1 vccd1 vssd1 sky130_ef_sc_hd__decap_40_12$1
XFILLER_36_748 vccd1 vssd1 vccd1 vssd1 sky130_fd_sc_hd__fill_1$1
XFILLER_51_718 vssd1 vccd1 vccd1 vssd1 sky130_fd_sc_hd__fill_2$1
XTAP_TAPCELL_ROW_106_1896 vccd1 vssd1 sky130_fd_sc_hd__tapvpwrvgnd_1$1
XTAP_TAPCELL_ROW_106_1885 vccd1 vssd1 sky130_fd_sc_hd__tapvpwrvgnd_1$1
XFILLER_44_781 vssd1 vccd1 vccd1 vssd1 sky130_ef_sc_hd__decap_40_12$1
XFILLER_85_3 vssd1 vccd1 vccd1 vssd1 sky130_ef_sc_hd__decap_40_12$1
XFILLER_31_497 vssd1 vccd1 vccd1 vssd1 sky130_fd_sc_hd__fill_4$1
XFILLER_129_385 vssd1 vccd1 vccd1 vssd1 sky130_fd_sc_hd__fill_4$1
XFILLER_117_536 vssd1 vccd1 vccd1 vssd1 sky130_ef_sc_hd__decap_40_12$1
X_1724_ hold41/A _1749_/CLK _1724_/D vccd1 vssd1 vccd1 vssd1 sky130_fd_sc_hd__dfxtp_1$1
Xhold115 _1567_/Q _1068_/A vssd1 vccd1 vccd1 vssd1 sky130_fd_sc_hd__dlygate4sd3_1$1
Xhold126 _1631_/Q _1200_/A vssd1 vccd1 vccd1 vssd1 sky130_fd_sc_hd__dlygate4sd3_1$1
Xhold104 _1598_/Q _1132_/A vssd1 vccd1 vccd1 vssd1 sky130_fd_sc_hd__dlygate4sd3_1$1
XFILLER_117_569 vssd1 vccd1 vccd1 vssd1 sky130_fd_sc_hd__fill_2$1
XFILLER_8_693 vssd1 vccd1 vccd1 vssd1 sky130_fd_sc_hd__fill_4$1
XFILLER_7_181 vssd1 vccd1 vccd1 vssd1 sky130_ef_sc_hd__decap_40_12$1
Xhold148 _1757_/Q _1460_/A vssd1 vccd1 vccd1 vssd1 sky130_fd_sc_hd__dlygate4sd3_1$1
Xhold159 _1728_/Q _1400_/A vssd1 vccd1 vccd1 vssd1 sky130_fd_sc_hd__dlygate4sd3_1$1
Xhold137 _1726_/Q _1396_/A vssd1 vccd1 vccd1 vssd1 sky130_fd_sc_hd__dlygate4sd3_1$1
X_1655_ _1655_/Q _1720_/CLK _1655_/D vccd1 vssd1 vccd1 vssd1 sky130_fd_sc_hd__dfxtp_2$1
X_1586_ _1804_/A _1716_/CLK _1586_/D vccd1 vssd1 vccd1 vssd1 sky130_fd_sc_hd__dfxtp_1$1
XFILLER_113_753 vssd1 vccd1 vccd1 vssd1 sky130_ef_sc_hd__decap_40_12$1
XFILLER_98_475 vccd1 vssd1 vccd1 vssd1 sky130_fd_sc_hd__fill_1$1
XFILLER_59_807 vccd1 vssd1 vccd1 vssd1 sky130_fd_sc_hd__fill_1$1
XFILLER_113_797 vssd1 vccd1 vccd1 vssd1 sky130_ef_sc_hd__decap_40_12$1
XFILLER_86_637 vssd1 vccd1 vccd1 vssd1 sky130_fd_sc_hd__fill_4$1
XFILLER_85_125 vssd1 vccd1 vccd1 vssd1 sky130_ef_sc_hd__decap_40_12$1
XFILLER_100_469 vssd1 vccd1 vccd1 vssd1 sky130_fd_sc_hd__fill_4$1
XFILLER_39_553 vssd1 vccd1 vccd1 vssd1 sky130_fd_sc_hd__fill_4$1
XFILLER_94_681 vssd1 vccd1 vccd1 vssd1 sky130_ef_sc_hd__decap_40_12$1
XFILLER_85_169 vssd1 vccd1 vccd1 vssd1 sky130_ef_sc_hd__decap_40_12$1
XFILLER_82_821 vccd1 vssd1 vccd1 vssd1 sky130_fd_sc_hd__fill_1$1
XTAP_TAPCELL_ROW_68_1313 vccd1 vssd1 sky130_fd_sc_hd__tapvpwrvgnd_1$1
XFILLER_66_361 vssd1 vccd1 vccd1 vssd1 sky130_fd_sc_hd__fill_2$1
XFILLER_54_501 vssd1 vccd1 vccd1 vssd1 sky130_ef_sc_hd__decap_40_12$1
XTAP_TAPCELL_ROW_1_313 vccd1 vssd1 sky130_fd_sc_hd__tapvpwrvgnd_1$1
XFILLER_27_715 vssd1 vccd1 vccd1 vssd1 sky130_ef_sc_hd__decap_40_12$1
XTAP_TAPCELL_ROW_68_1324 vccd1 vssd1 sky130_fd_sc_hd__tapvpwrvgnd_1$1
XFILLER_54_578 vssd1 vccd1 vccd1 vssd1 sky130_fd_sc_hd__fill_8$1
XFILLER_42_729 vssd1 vccd1 vccd1 vssd1 sky130_ef_sc_hd__decap_40_12$1
XTAP_TAPCELL_ROW_81_1513 vccd1 vssd1 sky130_fd_sc_hd__tapvpwrvgnd_1$1
XFILLER_53_39 vssd1 vccd1 vccd1 vssd1 sky130_ef_sc_hd__decap_40_12$1
XFILLER_41_217 vssd1 vccd1 vccd1 vssd1 sky130_fd_sc_hd__fill_4$1
XFILLER_50_795 vssd1 vccd1 vccd1 vssd1 sky130_fd_sc_hd__fill_2$1
XFILLER_22_475 vccd1 vssd1 vccd1 vssd1 sky130_fd_sc_hd__fill_1$1
XFILLER_10_637 vssd1 vccd1 vccd1 vssd1 sky130_fd_sc_hd__fill_4$1
XTAP_TAPCELL_ROW_79_1486 vccd1 vssd1 sky130_fd_sc_hd__tapvpwrvgnd_1$1
XFILLER_123_517 vssd1 vccd1 vccd1 vssd1 sky130_fd_sc_hd__fill_4$1
XFILLER_118_65 vssd1 vccd1 vccd1 vssd1 sky130_ef_sc_hd__decap_40_12$1
XFILLER_2_825 vssd1 vccd1 vccd1 vssd1 sky130_ef_sc_hd__decap_40_12$1
XTAP_TAPCELL_ROW_9_435 vccd1 vssd1 sky130_fd_sc_hd__tapvpwrvgnd_1$1
XFILLER_131_561 vssd1 vccd1 vccd1 vssd1 sky130_ef_sc_hd__decap_40_12$1
XFILLER_104_764 vssd1 vccd1 vccd1 vssd1 sky130_ef_sc_hd__decap_40_12$1
XTAP_TAPCELL_ROW_92_1686 vccd1 vssd1 sky130_fd_sc_hd__tapvpwrvgnd_1$1
XTAP_TAPCELL_ROW_92_1675 vccd1 vssd1 sky130_fd_sc_hd__tapvpwrvgnd_1$1
XFILLER_1_335 vccd1 vssd1 vccd1 vssd1 sky130_fd_sc_hd__fill_1$1
XFILLER_134_53 vssd1 vccd1 vccd1 vssd1 sky130_ef_sc_hd__decap_40_12$1
XFILLER_89_497 vssd1 vccd1 vccd1 vssd1 sky130_fd_sc_hd__fill_4$1
XFILLER_49_317 vssd1 vccd1 vccd1 vssd1 sky130_ef_sc_hd__decap_40_12$1
XFILLER_134_97 vssd1 vccd1 vccd1 vssd1 sky130_ef_sc_hd__decap_40_12$1
XFILLER_85_681 vssd1 vccd1 vccd1 vssd1 sky130_ef_sc_hd__decap_40_12$1
XFILLER_73_821 vssd1 vccd1 vccd1 vssd1 sky130_fd_sc_hd__fill_2$1
XFILLER_64_309 vssd1 vccd1 vccd1 vssd1 sky130_ef_sc_hd__decap_40_12$1
XFILLER_57_361 vssd1 vccd1 vccd1 vssd1 sky130_ef_sc_hd__decap_40_12$1
XFILLER_45_501 vssd1 vccd1 vccd1 vssd1 sky130_fd_sc_hd__fill_2$1
XTAP_TAPCELL_ROW_123_2141 vccd1 vssd1 sky130_fd_sc_hd__tapvpwrvgnd_1$1
XFILLER_17_225 vssd1 vccd1 vccd1 vssd1 sky130_ef_sc_hd__decap_40_12$1
XFILLER_18_737 vssd1 vccd1 vccd1 vssd1 sky130_ef_sc_hd__decap_40_12$1
XFILLER_27_51 vssd1 vccd1 vccd1 vssd1 sky130_fd_sc_hd__fill_4$1
XTAP_TAPCELL_ROW_28_721 vccd1 vssd1 sky130_fd_sc_hd__tapvpwrvgnd_1$1
XTAP_TAPCELL_ROW_123_2152 vccd1 vssd1 sky130_fd_sc_hd__tapvpwrvgnd_1$1
XFILLER_60_504 vssd1 vccd1 vccd1 vssd1 sky130_ef_sc_hd__decap_40_12$1
XFILLER_33_729 vssd1 vccd1 vccd1 vssd1 sky130_fd_sc_hd__fill_8$1
XFILLER_13_497 vssd1 vccd1 vccd1 vssd1 sky130_fd_sc_hd__fill_4$1
XFILLER_127_823 vccd1 vssd1 vccd1 vssd1 sky130_fd_sc_hd__fill_1$1
XFILLER_126_333 vssd1 vccd1 vccd1 vssd1 sky130_ef_sc_hd__decap_40_12$1
XFILLER_5_641 vssd1 vccd1 vccd1 vssd1 sky130_ef_sc_hd__decap_40_12$1
XFILLER_99_217 vssd1 vccd1 vccd1 vssd1 sky130_fd_sc_hd__fill_4$1
XFILLER_107_591 vssd1 vccd1 vccd1 vssd1 sky130_fd_sc_hd__fill_2$1
X_1440_ _1855_/A _1440_/X _1474_/B vssd1 vccd1 vccd1 vssd1 sky130_fd_sc_hd__or2_1$1
XFILLER_5_685 vssd1 vccd1 vccd1 vssd1 sky130_ef_sc_hd__decap_40_12$1
X_1371_ _1437_/C1 _1370_/X _1409_/A2 hold55/X _1713_/D vssd1 vccd1 vccd1 vssd1 sky130_fd_sc_hd__o211a_1$1
XFILLER_4_195 vccd1 vssd1 vccd1 vssd1 sky130_fd_sc_hd__fill_1$1
XFILLER_4_77 vssd1 vccd1 vccd1 vssd1 sky130_fd_sc_hd__fill_4$1
XFILLER_122_583 vssd1 vccd1 vccd1 vssd1 sky130_fd_sc_hd__fill_4$1
XFILLER_68_637 vssd1 vccd1 vccd1 vssd1 sky130_fd_sc_hd__fill_4$1
XFILLER_67_125 vssd1 vccd1 vccd1 vssd1 sky130_ef_sc_hd__decap_40_12$1
XTAP_TAPCELL_ROW_108_1914 vccd1 vssd1 sky130_fd_sc_hd__tapvpwrvgnd_1$1
XFILLER_83_629 vssd1 vccd1 vccd1 vssd1 sky130_fd_sc_hd__fill_4$1
XFILLER_67_169 vssd1 vccd1 vccd1 vssd1 sky130_ef_sc_hd__decap_40_12$1
XFILLER_36_501 vssd1 vccd1 vccd1 vssd1 sky130_ef_sc_hd__decap_40_12$1
XFILLER_48_361 vssd1 vccd1 vccd1 vssd1 sky130_fd_sc_hd__fill_2$1
XTAP_TAPCELL_ROW_108_1925 vccd1 vssd1 sky130_fd_sc_hd__tapvpwrvgnd_1$1
XFILLER_82_139 vccd1 vssd1 vccd1 vssd1 sky130_fd_sc_hd__fill_1$1
XFILLER_36_545 vssd1 vccd1 vccd1 vssd1 sky130_ef_sc_hd__decap_40_12$1
XFILLER_17_781 vssd1 vccd1 vccd1 vssd1 sky130_fd_sc_hd__fill_2$1
XFILLER_23_217 vssd1 vccd1 vccd1 vssd1 sky130_fd_sc_hd__fill_4$1
XTAP_TAPCELL_ROW_63_1243 vccd1 vssd1 sky130_fd_sc_hd__tapvpwrvgnd_1$1
XFILLER_51_559 vccd1 vssd1 vccd1 vssd1 sky130_fd_sc_hd__fill_1$1
XFILLER_31_261 vssd1 vccd1 vccd1 vssd1 sky130_ef_sc_hd__decap_40_12$1
XFILLER_129_193 vssd1 vccd1 vccd1 vssd1 sky130_ef_sc_hd__decap_40_12$1
XFILLER_117_333 vssd1 vccd1 vccd1 vssd1 sky130_fd_sc_hd__fill_2$1
XFILLER_105_517 vssd1 vccd1 vccd1 vssd1 sky130_ef_sc_hd__decap_40_12$1
X_1707_ _1830_/A clkload9/A _1707_/D vccd1 vssd1 vccd1 vssd1 sky130_fd_sc_hd__dfxtp_1$1
X_1638_ _1638_/Q _1737_/CLK _1638_/D vccd1 vssd1 vccd1 vssd1 sky130_fd_sc_hd__dfxtp_1$1
X_1569_ _1569_/Q _1633_/CLK _1569_/D vccd1 vssd1 vccd1 vssd1 sky130_fd_sc_hd__dfxtp_1$1
XFILLER_86_401 vssd1 vccd1 vccd1 vssd1 sky130_ef_sc_hd__decap_40_12$1
XFILLER_59_615 vccd1 vssd1 vccd1 vssd1 sky130_fd_sc_hd__fill_1$1
XFILLER_100_233 vssd1 vccd1 vccd1 vssd1 sky130_ef_sc_hd__decap_40_12$1
XFILLER_100_277 vssd1 vccd1 vccd1 vssd1 sky130_ef_sc_hd__decap_40_12$1
XFILLER_74_629 vssd1 vccd1 vccd1 vssd1 sky130_fd_sc_hd__fill_2$1
XFILLER_27_501 vssd1 vccd1 vccd1 vssd1 sky130_fd_sc_hd__fill_2$1
XFILLER_39_361 vssd1 vccd1 vccd1 vssd1 sky130_ef_sc_hd__decap_40_12$1
XFILLER_46_309 vssd1 vccd1 vccd1 vssd1 sky130_ef_sc_hd__decap_40_12$1
XFILLER_64_27 vccd1 vssd1 vccd1 vssd1 sky130_fd_sc_hd__fill_1$1
XFILLER_70_813 vssd1 vccd1 vccd1 vssd1 sky130_fd_sc_hd__fill_8$1
XFILLER_81_161 vssd1 vccd1 vccd1 vssd1 sky130_fd_sc_hd__fill_4$1
XFILLER_15_729 vssd1 vccd1 vccd1 vssd1 sky130_ef_sc_hd__decap_40_12$1
XFILLER_120_77 vssd1 vccd1 vccd1 vssd1 sky130_fd_sc_hd__fill_4$1
XFILLER_80_15 vssd1 vccd1 vccd1 vssd1 sky130_ef_sc_hd__decap_40_12$1
XFILLER_10_401 vssd1 vccd1 vccd1 vssd1 sky130_ef_sc_hd__decap_40_12$1
XFILLER_50_581 vssd1 vccd1 vccd1 vssd1 sky130_fd_sc_hd__fill_4$1
XTAP_TAPCELL_ROW_33_790 vccd1 vssd1 sky130_fd_sc_hd__tapvpwrvgnd_1$1
XFILLER_10_445 vssd1 vccd1 vccd1 vssd1 sky130_ef_sc_hd__decap_40_12$1
XFILLER_136_620 vssd1 vccd1 vccd1 vssd1 sky130_ef_sc_hd__decap_40_12$1
XFILLER_108_333 vssd1 vccd1 vccd1 vssd1 sky130_ef_sc_hd__decap_40_12$1
XTAP_TAPCELL_ROW_94_1715 vccd1 vssd1 sky130_fd_sc_hd__tapvpwrvgnd_1$1
XTAP_TAPCELL_ROW_94_1704 vccd1 vssd1 sky130_fd_sc_hd__tapvpwrvgnd_1$1
XFILLER_10_489 vssd1 vccd1 vccd1 vssd1 sky130_ef_sc_hd__decap_40_12$1
XFILLER_108_377 vssd1 vccd1 vccd1 vssd1 sky130_ef_sc_hd__decap_40_12$1
XFILLER_89_57 vssd1 vccd1 vccd1 vssd1 sky130_ef_sc_hd__decap_40_12$1
XFILLER_96_209 vssd1 vccd1 vccd1 vssd1 sky130_ef_sc_hd__decap_40_12$1
XFILLER_89_261 vssd1 vccd1 vccd1 vssd1 sky130_ef_sc_hd__decap_40_12$1
XFILLER_2_699 vccd1 vssd1 vccd1 vssd1 sky130_fd_sc_hd__fill_1$1
XFILLER_1_165 vssd1 vccd1 vccd1 vssd1 sky130_fd_sc_hd__fill_2$1
XFILLER_131_391 vccd1 vssd1 vccd1 vssd1 sky130_fd_sc_hd__fill_1$1
XFILLER_77_445 vssd1 vccd1 vccd1 vssd1 sky130_fd_sc_hd__fill_2$1
XFILLER_49_125 vssd1 vccd1 vccd1 vssd1 sky130_ef_sc_hd__decap_40_12$1
XFILLER_77_478 vssd1 vccd1 vccd1 vssd1 sky130_fd_sc_hd__fill_4$1
XFILLER_65_629 vssd1 vccd1 vccd1 vssd1 sky130_ef_sc_hd__decap_40_12$1
XFILLER_18_501 vssd1 vccd1 vccd1 vssd1 sky130_ef_sc_hd__decap_40_12$1
XFILLER_49_169 vssd1 vccd1 vccd1 vssd1 sky130_ef_sc_hd__decap_40_12$1
XFILLER_64_139 vccd1 vssd1 vccd1 vssd1 sky130_fd_sc_hd__fill_1$1
XFILLER_58_681 vssd1 vccd1 vccd1 vssd1 sky130_fd_sc_hd__fill_2$1
XFILLER_38_83 vccd1 vssd1 vccd1 vssd1 sky130_fd_sc_hd__fill_1$1
XFILLER_18_545 vssd1 vccd1 vccd1 vssd1 sky130_ef_sc_hd__decap_40_12$1
XFILLER_73_673 vssd1 vccd1 vccd1 vssd1 sky130_ef_sc_hd__decap_40_12$1
XFILLER_60_301 vssd1 vccd1 vccd1 vssd1 sky130_fd_sc_hd__fill_4$1
XFILLER_18_589 vssd1 vccd1 vccd1 vssd1 sky130_ef_sc_hd__decap_40_12$1
XTAP_TAPCELL_ROW_103_1844 vccd1 vssd1 sky130_fd_sc_hd__tapvpwrvgnd_1$1
XFILLER_60_345 vssd1 vccd1 vccd1 vssd1 sky130_ef_sc_hd__decap_40_12$1
XFILLER_33_559 vccd1 vssd1 vccd1 vssd1 sky130_fd_sc_hd__fill_1$1
X_0940_ _0749_/X _1507_/D _0936_/X _1409_/C1 _1507_/Q _0939_/X vssd1 vccd1 vccd1 vssd1
+ sky130_fd_sc_hd__o221a_1$1
XFILLER_60_389 vssd1 vccd1 vccd1 vssd1 sky130_ef_sc_hd__decap_40_12$1
XFILLER_13_261 vssd1 vccd1 vccd1 vssd1 sky130_ef_sc_hd__decap_40_12$1
XFILLER_20_209 vssd1 vccd1 vccd1 vssd1 sky130_ef_sc_hd__decap_40_12$1
XFILLER_119_609 vssd1 vccd1 vccd1 vssd1 sky130_fd_sc_hd__fill_4$1
XFILLER_9_221 vssd1 vccd1 vccd1 vssd1 sky130_fd_sc_hd__fill_2$1
XTAP_TAPCELL_ROW_136_2343 vccd1 vssd1 sky130_fd_sc_hd__tapvpwrvgnd_1$1
X_0871_ _1810_/A hold10/A _0871_/X _1688_/Q _1279_/A vccd1 vssd1 vccd1 vssd1 sky130_fd_sc_hd__a22o_1$1
Xclkload35 clkload35/Y _1764_/CLK vccd1 vssd1 vccd1 vssd1 sky130_fd_sc_hd__clkinv_2$1
Xclkload24 _1756_/CLK clkload24/Y vccd1 vssd1 vccd1 vssd1 sky130_fd_sc_hd__clkinv_4$1
XFILLER_70_81 vssd1 vccd1 vccd1 vssd1 sky130_fd_sc_hd__fill_2$1
XTAP_TAPCELL_ROW_11_462 vccd1 vssd1 sky130_fd_sc_hd__tapvpwrvgnd_1$1
Xclkload13 clkload13/Y _1575_/CLK vccd1 vssd1 vccd1 vssd1 sky130_fd_sc_hd__inv_4$1
XFILLER_126_141 vssd1 vccd1 vccd1 vssd1 sky130_ef_sc_hd__decap_40_12$1
XFILLER_130_807 vssd1 vccd1 vccd1 vssd1 sky130_fd_sc_hd__fill_4$1
X_1423_ _1441_/C1 _1422_/X _1411_/Y hold30/X _1738_/D vssd1 vccd1 vccd1 vssd1 sky130_fd_sc_hd__o211a_1$1
XFILLER_48_3 vssd1 vccd1 vccd1 vssd1 sky130_ef_sc_hd__decap_40_12$1
XFILLER_68_401 vssd1 vccd1 vccd1 vssd1 sky130_ef_sc_hd__decap_40_12$1
XFILLER_122_391 vccd1 vssd1 vccd1 vssd1 sky130_fd_sc_hd__fill_1$1
XFILLER_96_743 vssd1 vccd1 vccd1 vssd1 sky130_fd_sc_hd__fill_4$1
X_1354_ _1828_/A _1354_/X _1408_/B vssd1 vccd1 vccd1 vssd1 sky130_fd_sc_hd__or2_1$1
XFILLER_68_489 vssd1 vccd1 vccd1 vssd1 sky130_ef_sc_hd__decap_40_12$1
XFILLER_56_618 vssd1 vccd1 vccd1 vssd1 sky130_ef_sc_hd__decap_40_12$1
X_1285_ _1289_/C1 _1284_/X _1343_/A2 hold71/X _1671_/D vssd1 vccd1 vccd1 vssd1 sky130_fd_sc_hd__o211a_1$1
XFILLER_49_670 vssd1 vccd1 vccd1 vssd1 sky130_fd_sc_hd__fill_2$1
XFILLER_28_309 vssd1 vccd1 vccd1 vssd1 sky130_ef_sc_hd__decap_40_12$1
Xclkbuf_leaf_13_wb_clk_i _1754_/CLK clkbuf_leaf_9_wb_clk_i/A vssd1 vccd1 vccd1 vssd1
+ sky130_fd_sc_hd__clkbuf_8$1
XFILLER_70_109 vssd1 vccd1 vccd1 vssd1 sky130_ef_sc_hd__decap_40_12$1
XFILLER_63_161 vssd1 vccd1 vccd1 vssd1 sky130_fd_sc_hd__fill_4$1
XFILLER_52_813 vssd1 vccd1 vccd1 vssd1 sky130_ef_sc_hd__decap_40_12$1
XTAP_TAPCELL_ROW_19_584 vccd1 vssd1 sky130_fd_sc_hd__tapvpwrvgnd_1$1
XFILLER_51_389 vssd1 vccd1 vccd1 vssd1 sky130_fd_sc_hd__fill_2$1
XFILLER_32_581 vssd1 vccd1 vccd1 vssd1 sky130_fd_sc_hd__fill_4$1
Xclkload7 clkload7/Y clkload7/A vccd1 vssd1 vccd1 vssd1 sky130_fd_sc_hd__clkinv_2$1
XFILLER_50_29 vssd1 vccd1 vccd1 vssd1 sky130_ef_sc_hd__decap_40_12$1
XFILLER_20_787 vccd1 vssd1 vccd1 vssd1 sky130_fd_sc_hd__fill_1$1
XTAP_TAPCELL_ROW_76_1434 vccd1 vssd1 sky130_fd_sc_hd__tapvpwrvgnd_1$1
XTAP_TAPCELL_ROW_76_1445 vccd1 vssd1 sky130_fd_sc_hd__tapvpwrvgnd_1$1
XFILLER_132_133 vssd1 vccd1 vccd1 vssd1 sky130_fd_sc_hd__fill_4$1
XFILLER_78_209 vssd1 vccd1 vccd1 vssd1 sky130_ef_sc_hd__decap_40_12$1
XFILLER_59_27 vssd1 vccd1 vccd1 vssd1 sky130_ef_sc_hd__decap_40_12$1
XFILLER_133_689 vccd1 vssd1 vccd1 vssd1 sky130_fd_sc_hd__fill_1$1
XFILLER_132_177 vssd1 vccd1 vccd1 vssd1 sky130_ef_sc_hd__decap_40_12$1
Xfanout222 _1210_/B _1146_/X vssd1 vccd1 vccd1 vssd1 sky130_fd_sc_hd__clkbuf_8$1
Xfanout211 _1331_/A2 vccd1 vssd1 _1279_/Y vccd1 vssd1 sky130_fd_sc_hd__buf_6$1
XFILLER_87_721 vssd1 vccd1 vccd1 vssd1 sky130_fd_sc_hd__fill_4$1
XFILLER_59_401 vssd1 vccd1 vccd1 vssd1 sky130_ef_sc_hd__decap_40_12$1
XFILLER_115_55 vccd1 vssd1 vccd1 vssd1 sky130_fd_sc_hd__fill_1$1
Xfanout233 _0990_/B vccd1 vssd1 _0948_/X vccd1 vssd1 sky130_fd_sc_hd__buf_4$1
Xfanout244 _0881_/B1 vccd1 vssd1 _0747_/X vccd1 vssd1 sky130_fd_sc_hd__buf_6$1
Xfanout277 vccd1 vssd1 _1409_/C1 _1465_/C1 vccd1 vssd1 sky130_fd_sc_hd__buf_2$1
XFILLER_86_253 vssd1 vccd1 vccd1 vssd1 sky130_ef_sc_hd__decap_40_12$1
Xfanout266 _1435_/C1 _1319_/C1 vssd1 vccd1 vccd1 vssd1 sky130_fd_sc_hd__clkbuf_4$1
XFILLER_75_15 vssd1 vccd1 vccd1 vssd1 sky130_ef_sc_hd__decap_40_12$1
XFILLER_47_629 vssd1 vccd1 vccd1 vssd1 sky130_ef_sc_hd__decap_40_12$1
XFILLER_101_597 vssd1 vccd1 vccd1 vssd1 sky130_ef_sc_hd__decap_40_12$1
XFILLER_74_437 vccd1 vssd1 vccd1 vssd1 sky130_fd_sc_hd__fill_1$1
XFILLER_46_139 vccd1 vssd1 vccd1 vssd1 sky130_fd_sc_hd__fill_1$1
XTAP_TAPCELL_ROW_120_2100 vccd1 vssd1 sky130_fd_sc_hd__tapvpwrvgnd_1$1
XFILLER_61_109 vssd1 vccd1 vccd1 vssd1 sky130_fd_sc_hd__fill_2$1
XFILLER_55_673 vssd1 vccd1 vccd1 vssd1 sky130_ef_sc_hd__decap_40_12$1
XTAP_TAPCELL_ROW_38_871 vccd1 vssd1 sky130_fd_sc_hd__tapvpwrvgnd_1$1
XFILLER_42_301 vssd1 vccd1 vccd1 vssd1 sky130_fd_sc_hd__fill_4$1
XFILLER_70_643 vccd1 vssd1 vccd1 vssd1 sky130_fd_sc_hd__fill_1$1
XFILLER_15_559 vccd1 vssd1 vccd1 vssd1 sky130_fd_sc_hd__fill_1$1
XFILLER_42_345 vssd1 vccd1 vccd1 vssd1 sky130_ef_sc_hd__decap_40_12$1
XFILLER_91_69 vssd1 vccd1 vccd1 vssd1 sky130_ef_sc_hd__decap_40_12$1
XFILLER_70_687 vccd1 vssd1 vccd1 vssd1 sky130_fd_sc_hd__fill_1$1
XFILLER_24_41 vssd1 vccd1 vccd1 vssd1 sky130_ef_sc_hd__decap_40_12$1
XFILLER_30_529 vssd1 vccd1 vccd1 vssd1 sky130_fd_sc_hd__fill_2$1
XFILLER_42_389 vssd1 vccd1 vccd1 vssd1 sky130_ef_sc_hd__decap_40_12$1
XFILLER_11_721 vssd1 vccd1 vccd1 vssd1 sky130_fd_sc_hd__fill_4$1
XFILLER_24_85 vssd1 vccd1 vccd1 vssd1 sky130_ef_sc_hd__decap_40_12$1
XFILLER_11_765 vssd1 vccd1 vccd1 vssd1 sky130_ef_sc_hd__decap_40_12$1
XFILLER_10_253 vssd1 vccd1 vccd1 vssd1 sky130_ef_sc_hd__decap_40_12$1
XFILLER_7_725 vssd1 vccd1 vccd1 vssd1 sky130_fd_sc_hd__fill_2$1
XTAP_TAPCELL_ROW_118_2073 vccd1 vssd1 sky130_fd_sc_hd__tapvpwrvgnd_1$1
XFILLER_136_461 vccd1 vssd1 vccd1 vssd1 sky130_fd_sc_hd__fill_1$1
XFILLER_108_141 vssd1 vccd1 vccd1 vssd1 sky130_ef_sc_hd__decap_40_12$1
XFILLER_123_111 vccd1 vssd1 vccd1 vssd1 sky130_fd_sc_hd__fill_1$1
XTAP_TAPCELL_ROW_131_2262 vccd1 vssd1 sky130_fd_sc_hd__tapvpwrvgnd_1$1
XFILLER_124_645 vssd1 vccd1 vccd1 vssd1 sky130_ef_sc_hd__decap_40_12$1
XFILLER_112_807 vssd1 vccd1 vccd1 vssd1 sky130_fd_sc_hd__fill_4$1
XFILLER_111_317 vssd1 vccd1 vccd1 vssd1 sky130_ef_sc_hd__decap_40_12$1
XFILLER_97_529 vssd1 vccd1 vccd1 vssd1 sky130_ef_sc_hd__decap_40_12$1
XFILLER_49_93 vssd1 vccd1 vccd1 vssd1 sky130_ef_sc_hd__decap_40_12$1
XFILLER_65_437 vccd1 vssd1 vccd1 vssd1 sky130_fd_sc_hd__fill_1$1
X_1070_ _1070_/A _1070_/X _1078_/B vssd1 vccd1 vccd1 vssd1 sky130_fd_sc_hd__or2_1$1
XFILLER_92_245 vssd1 vccd1 vccd1 vssd1 sky130_fd_sc_hd__fill_4$1
XFILLER_92_289 vssd1 vccd1 vccd1 vssd1 sky130_ef_sc_hd__decap_40_12$1
XFILLER_80_418 vssd1 vccd1 vccd1 vssd1 sky130_fd_sc_hd__fill_2$1
XFILLER_65_81 vssd1 vccd1 vccd1 vssd1 sky130_ef_sc_hd__decap_40_12$1
XFILLER_52_109 vssd1 vccd1 vccd1 vssd1 sky130_ef_sc_hd__decap_40_12$1
XFILLER_34_813 vssd1 vccd1 vccd1 vssd1 sky130_fd_sc_hd__fill_8$1
XFILLER_34_824 vssd1 vccd1 vccd1 vssd1 sky130_fd_sc_hd__fill_2$1
XFILLER_45_161 vssd1 vccd1 vccd1 vssd1 sky130_fd_sc_hd__fill_4$1
XTAP_TAPCELL_ROW_47_1002 vccd1 vssd1 sky130_fd_sc_hd__tapvpwrvgnd_1$1
XFILLER_60_153 vssd1 vccd1 vccd1 vssd1 sky130_ef_sc_hd__decap_40_12$1
XTAP_TAPCELL_ROW_16_543 vccd1 vssd1 sky130_fd_sc_hd__tapvpwrvgnd_1$1
XTAP_TAPCELL_ROW_60_1202 vccd1 vssd1 sky130_fd_sc_hd__tapvpwrvgnd_1$1
XFILLER_60_197 vssd1 vccd1 vccd1 vssd1 sky130_ef_sc_hd__decap_40_12$1
XFILLER_14_581 vssd1 vccd1 vccd1 vssd1 sky130_fd_sc_hd__fill_4$1
XFILLER_21_529 vssd1 vccd1 vccd1 vssd1 sky130_ef_sc_hd__decap_40_12$1
XFILLER_33_389 vssd1 vccd1 vccd1 vssd1 sky130_fd_sc_hd__fill_2$1
XFILLER_119_417 vssd1 vccd1 vccd1 vssd1 sky130_ef_sc_hd__decap_40_12$1
XPHY_EDGE_ROW_112_Right_112 vccd1 vssd1 vccd1 vssd1 sky130_fd_sc_hd__decap_3$1
X_0923_ hold53/A hold10/A _0923_/X _1665_/Q hold6/X vccd1 vssd1 vccd1 vssd1 sky130_fd_sc_hd__a22o_1$1
X_0854_ _0854_/X _1279_/A hold43/A hold34/A _0949_/A vssd1 vccd1 _0853_/X vccd1 vssd1
+ sky130_fd_sc_hd__a221o_1$1
XFILLER_127_461 vssd1 vccd1 vccd1 vssd1 sky130_fd_sc_hd__fill_4$1
XPHY_EDGE_ROW_49_Right_49 vccd1 vssd1 vccd1 vssd1 sky130_fd_sc_hd__decap_3$1
X_0785_ _0785_/X _0906_/B1 _1777_/A _1642_/Q _0866_/B1 vssd1 vccd1 _0784_/X vccd1
+ vssd1 sky130_fd_sc_hd__a221o_1$1
XFILLER_114_133 vssd1 vccd1 vccd1 vssd1 sky130_fd_sc_hd__fill_4$1
XFILLER_103_807 vccd1 vssd1 vccd1 vssd1 sky130_fd_sc_hd__fill_1$1
XTAP_TAPCELL_ROW_58_1175 vccd1 vssd1 sky130_fd_sc_hd__tapvpwrvgnd_1$1
XTAP_TAPCELL_ROW_58_1164 vccd1 vssd1 sky130_fd_sc_hd__tapvpwrvgnd_1$1
XFILLER_130_604 vssd1 vccd1 vccd1 vssd1 sky130_ef_sc_hd__decap_40_12$1
XFILLER_114_177 vssd1 vccd1 vccd1 vssd1 sky130_ef_sc_hd__decap_40_12$1
X_1406_ hold75/X _1406_/X _1408_/B vssd1 vccd1 vccd1 vssd1 sky130_fd_sc_hd__or2_1$1
Xhold19 hold19/A hold19/X vssd1 vccd1 vccd1 vssd1 sky130_fd_sc_hd__dlygate4sd3_1$1
XTAP_TAPCELL_ROW_71_1364 vccd1 vssd1 sky130_fd_sc_hd__tapvpwrvgnd_1$1
X_1337_ _1471_/C1 _1336_/X _1343_/A2 hold49/X _1697_/D vssd1 vccd1 vccd1 vssd1 sky130_fd_sc_hd__o211a_1$1
XFILLER_84_713 vssd1 vccd1 vccd1 vssd1 sky130_ef_sc_hd__decap_40_12$1
XFILLER_68_253 vssd1 vccd1 vccd1 vssd1 sky130_ef_sc_hd__decap_40_12$1
XFILLER_29_629 vssd1 vccd1 vccd1 vssd1 sky130_ef_sc_hd__decap_40_12$1
XFILLER_110_361 vssd1 vccd1 vccd1 vssd1 sky130_fd_sc_hd__fill_2$1
XFILLER_84_757 vssd1 vccd1 vccd1 vssd1 sky130_ef_sc_hd__decap_40_12$1
XFILLER_83_223 vccd1 vssd1 vccd1 vssd1 sky130_fd_sc_hd__fill_1$1
XFILLER_28_139 vccd1 vssd1 vccd1 vssd1 sky130_fd_sc_hd__fill_1$1
X_1268_ _1664_/Q _1268_/X _1270_/B vssd1 vccd1 vccd1 vssd1 sky130_fd_sc_hd__or2_1$1
XPHY_EDGE_ROW_58_Right_58 vccd1 vssd1 vccd1 vssd1 sky130_fd_sc_hd__decap_3$1
XFILLER_25_802 vssd1 vccd1 vccd1 vssd1 sky130_fd_sc_hd__fill_2$1
X_1199_ _1461_/C1 _1198_/X _1211_/A2 hold81/X _1630_/D vssd1 vccd1 vccd1 vssd1 sky130_fd_sc_hd__o211a_1$1
XFILLER_24_301 vssd1 vccd1 vccd1 vssd1 sky130_fd_sc_hd__fill_4$1
XFILLER_37_673 vssd1 vccd1 vccd1 vssd1 sky130_ef_sc_hd__decap_40_12$1
XFILLER_43_109 vssd1 vccd1 vccd1 vssd1 sky130_fd_sc_hd__fill_2$1
XFILLER_52_643 vccd1 vssd1 vccd1 vssd1 sky130_fd_sc_hd__fill_1$1
XFILLER_24_345 vssd1 vccd1 vccd1 vssd1 sky130_ef_sc_hd__decap_40_12$1
XTAP_TAPCELL_ROW_35_830 vccd1 vssd1 sky130_fd_sc_hd__tapvpwrvgnd_1$1
XFILLER_101_57 vssd1 vccd1 vccd1 vssd1 sky130_ef_sc_hd__decap_40_12$1
XFILLER_61_39 vssd1 vccd1 vccd1 vssd1 sky130_ef_sc_hd__decap_40_12$1
XFILLER_12_529 vssd1 vccd1 vccd1 vssd1 sky130_fd_sc_hd__fill_2$1
XFILLER_24_389 vssd1 vccd1 vccd1 vssd1 sky130_ef_sc_hd__decap_40_12$1
XFILLER_138_759 vccd1 vssd1 vccd1 vssd1 sky130_fd_sc_hd__fill_1$1
XFILLER_137_225 vssd1 vccd1 vccd1 vssd1 sky130_ef_sc_hd__decap_40_12$1
XFILLER_106_601 vssd1 vccd1 vccd1 vssd1 sky130_fd_sc_hd__fill_4$1
XPHY_EDGE_ROW_67_Right_67 vccd1 vssd1 vccd1 vssd1 sky130_fd_sc_hd__decap_3$1
XFILLER_106_634 vssd1 vccd1 vccd1 vssd1 sky130_fd_sc_hd__fill_8$1
XFILLER_3_205 vssd1 vccd1 vccd1 vssd1 sky130_ef_sc_hd__decap_40_12$1
XFILLER_133_453 vssd1 vccd1 vccd1 vssd1 sky130_fd_sc_hd__fill_2$1
XFILLER_106_645 vssd1 vccd1 vccd1 vssd1 sky130_fd_sc_hd__fill_8$1
XFILLER_105_111 vccd1 vssd1 vccd1 vssd1 sky130_fd_sc_hd__fill_1$1
XFILLER_3_249 vssd1 vccd1 vccd1 vssd1 sky130_ef_sc_hd__decap_40_12$1
XFILLER_79_529 vssd1 vccd1 vccd1 vssd1 sky130_ef_sc_hd__decap_40_12$1
XFILLER_10_65 vssd1 vccd1 vccd1 vssd1 sky130_ef_sc_hd__decap_40_12$1
XFILLER_126_65 vssd1 vccd1 vccd1 vssd1 sky130_ef_sc_hd__decap_40_12$1
XFILLER_102_840 vssd1 vccd1 vccd1 vssd1 sky130_fd_sc_hd__fill_2$1
XFILLER_87_573 vssd1 vccd1 vccd1 vssd1 sky130_fd_sc_hd__fill_4$1
XFILLER_101_361 vssd1 vccd1 vccd1 vssd1 sky130_ef_sc_hd__decap_40_12$1
XTAP_TAPCELL_ROW_89_1636 vccd1 vssd1 sky130_fd_sc_hd__tapvpwrvgnd_1$1
XPHY_EDGE_ROW_76_Right_76 vccd1 vssd1 vccd1 vssd1 sky130_fd_sc_hd__decap_3$1
XFILLER_74_245 vssd1 vccd1 vccd1 vssd1 sky130_fd_sc_hd__fill_4$1
XFILLER_90_738 vssd1 vccd1 vccd1 vssd1 sky130_ef_sc_hd__decap_40_12$1
XFILLER_74_289 vssd1 vccd1 vccd1 vssd1 sky130_ef_sc_hd__decap_40_12$1
XFILLER_16_813 vssd1 vccd1 vccd1 vssd1 sky130_ef_sc_hd__decap_40_12$1
XFILLER_27_161 vssd1 vccd1 vccd1 vssd1 sky130_fd_sc_hd__fill_4$1
XFILLER_34_109 vssd1 vccd1 vccd1 vssd1 sky130_ef_sc_hd__decap_40_12$1
XFILLER_35_51 vssd1 vccd1 vccd1 vssd1 sky130_fd_sc_hd__fill_4$1
XFILLER_43_654 vccd1 vssd1 vccd1 vssd1 sky130_fd_sc_hd__fill_1$1
XFILLER_42_153 vssd1 vccd1 vccd1 vssd1 sky130_ef_sc_hd__decap_40_12$1
XTAP_TAPCELL_ROW_100_1803 vccd1 vssd1 sky130_fd_sc_hd__tapvpwrvgnd_1$1
XFILLER_70_473 vssd1 vccd1 vccd1 vssd1 sky130_fd_sc_hd__fill_2$1
XTAP_TAPCELL_ROW_13_502 vccd1 vssd1 sky130_fd_sc_hd__tapvpwrvgnd_1$1
XFILLER_15_389 vssd1 vccd1 vccd1 vssd1 sky130_fd_sc_hd__fill_2$1
XFILLER_42_197 vssd1 vccd1 vccd1 vssd1 sky130_ef_sc_hd__decap_40_12$1
XTAP_TAPCELL_ROW_133_2302 vccd1 vssd1 sky130_fd_sc_hd__tapvpwrvgnd_1$1
XPHY_EDGE_ROW_85_Right_85 vccd1 vssd1 vccd1 vssd1 sky130_fd_sc_hd__decap_3$1
XFILLER_11_573 vssd1 vccd1 vccd1 vssd1 sky130_ef_sc_hd__decap_40_12$1
XFILLER_124_475 vccd1 vssd1 vccd1 vssd1 sky130_fd_sc_hd__fill_1$1
XFILLER_112_637 vssd1 vccd1 vccd1 vssd1 sky130_fd_sc_hd__fill_4$1
XTAP_TAPCELL_ROW_111_1965 vccd1 vssd1 sky130_fd_sc_hd__tapvpwrvgnd_1$1
XFILLER_111_125 vssd1 vccd1 vccd1 vssd1 sky130_ef_sc_hd__decap_40_12$1
XFILLER_97_337 vssd1 vccd1 vccd1 vssd1 sky130_ef_sc_hd__decap_40_12$1
XFILLER_3_783 vccd1 vssd1 vccd1 vssd1 sky130_fd_sc_hd__fill_1$1
XFILLER_111_169 vssd1 vccd1 vccd1 vssd1 sky130_ef_sc_hd__decap_40_12$1
XPHY_EDGE_ROW_94_Right_94 vccd1 vssd1 vccd1 vssd1 sky130_fd_sc_hd__decap_3$1
XPHY_EDGE_ROW_29_Left_168 vccd1 vssd1 vccd1 vssd1 sky130_fd_sc_hd__decap_3$1
XFILLER_65_223 vccd1 vssd1 vccd1 vssd1 sky130_fd_sc_hd__fill_1$1
XTAP_TAPCELL_ROW_53_1094 vccd1 vssd1 sky130_fd_sc_hd__tapvpwrvgnd_1$1
XFILLER_66_757 vssd1 vccd1 vccd1 vssd1 sky130_ef_sc_hd__decap_40_12$1
X_1122_ _1811_/A _1122_/X _1122_/B vssd1 vccd1 vccd1 vssd1 sky130_fd_sc_hd__or2_1$1
X_1053_ _1449_/C1 _1052_/X _1053_/A2 hold98/X _1559_/D vssd1 vccd1 vccd1 vssd1 sky130_fd_sc_hd__o211a_1$1
XFILLER_19_673 vssd1 vccd1 vccd1 vssd1 sky130_ef_sc_hd__decap_40_12$1
XFILLER_25_109 vssd1 vccd1 vccd1 vssd1 sky130_fd_sc_hd__fill_2$1
XFILLER_22_805 vssd1 vccd1 vccd1 vssd1 sky130_fd_sc_hd__fill_4$1
XFILLER_61_473 vssd1 vccd1 vccd1 vssd1 sky130_ef_sc_hd__decap_40_12$1
XPHY_EDGE_ROW_1_Left_140 vccd1 vssd1 vccd1 vssd1 sky130_fd_sc_hd__decap_3$1
XFILLER_21_337 vssd1 vccd1 vccd1 vssd1 sky130_ef_sc_hd__decap_40_12$1
XPHY_EDGE_ROW_38_Left_177 vccd1 vssd1 vccd1 vssd1 sky130_fd_sc_hd__decap_3$1
X_0906_ _0906_/X _0906_/B1 _1534_/Q _1662_/Q _0949_/A vssd1 vccd1 _0905_/X vccd1 vssd1
+ sky130_fd_sc_hd__a221o_1$1
XFILLER_119_225 vssd1 vccd1 vccd1 vssd1 sky130_ef_sc_hd__decap_40_12$1
XFILLER_135_718 vssd1 vccd1 vccd1 vssd1 sky130_fd_sc_hd__fill_8$1
XFILLER_135_729 vssd1 vccd1 vccd1 vssd1 sky130_fd_sc_hd__fill_4$1
X_0837_ _0880_/A2 _1490_/D _0833_/X _1443_/C1 _1490_/Q _0836_/X vssd1 vccd1 vccd1
+ vssd1 sky130_fd_sc_hd__o221a_1$1
XFILLER_89_805 vssd1 vccd1 vccd1 vssd1 sky130_fd_sc_hd__fill_2$1
X_0768_ _1779_/A _0875_/A2 _0768_/X _1639_/Q _0906_/B1 vccd1 vssd1 vccd1 vssd1 sky130_fd_sc_hd__a22o_1$1
XFILLER_1_709 vssd1 vccd1 vccd1 vssd1 sky130_ef_sc_hd__decap_40_12$1
XFILLER_130_401 vssd1 vccd1 vccd1 vssd1 sky130_ef_sc_hd__decap_40_12$1
XFILLER_103_615 vccd1 vssd1 vccd1 vssd1 sky130_fd_sc_hd__fill_1$1
XPHY_EDGE_ROW_47_Left_186 vccd1 vssd1 vccd1 vssd1 sky130_fd_sc_hd__decap_3$1
XFILLER_130_489 vssd1 vccd1 vccd1 vssd1 sky130_ef_sc_hd__decap_40_12$1
XFILLER_84_521 vssd1 vccd1 vccd1 vssd1 sky130_fd_sc_hd__fill_8$1
XFILLER_69_573 vssd1 vccd1 vccd1 vssd1 sky130_ef_sc_hd__decap_40_12$1
XFILLER_56_245 vssd1 vccd1 vccd1 vssd1 sky130_fd_sc_hd__fill_4$1
XFILLER_56_289 vssd1 vccd1 vccd1 vssd1 sky130_ef_sc_hd__decap_40_12$1
XFILLER_16_109 vssd1 vccd1 vccd1 vssd1 sky130_ef_sc_hd__decap_40_12$1
XFILLER_71_237 vssd1 vccd1 vccd1 vssd1 sky130_ef_sc_hd__decap_40_12$1
XTAP_TAPCELL_ROW_84_1566 vccd1 vssd1 sky130_fd_sc_hd__tapvpwrvgnd_1$1
XTAP_TAPCELL_ROW_84_1555 vccd1 vssd1 sky130_fd_sc_hd__tapvpwrvgnd_1$1
XFILLER_72_27 vccd1 vssd1 vccd1 vssd1 sky130_fd_sc_hd__fill_1$1
XPHY_EDGE_ROW_56_Left_195 vccd1 vssd1 vccd1 vssd1 sky130_fd_sc_hd__decap_3$1
XFILLER_24_153 vssd1 vccd1 vccd1 vssd1 sky130_ef_sc_hd__decap_40_12$1
XFILLER_25_665 vssd1 vccd1 vccd1 vssd1 sky130_fd_sc_hd__fill_4$1
XFILLER_9_809 vssd1 vccd1 vccd1 vssd1 sky130_ef_sc_hd__decap_40_12$1
XFILLER_24_197 vssd1 vccd1 vccd1 vssd1 sky130_ef_sc_hd__decap_40_12$1
XFILLER_40_657 vccd1 vssd1 vccd1 vssd1 sky130_fd_sc_hd__fill_1$1
XTAP_TAPCELL_ROW_115_2021 vccd1 vssd1 sky130_fd_sc_hd__tapvpwrvgnd_1$1
XFILLER_138_589 vssd1 vccd1 vccd1 vssd1 sky130_fd_sc_hd__fill_2$1
XFILLER_126_729 vssd1 vccd1 vccd1 vssd1 sky130_fd_sc_hd__fill_2$1
XFILLER_125_217 vssd1 vccd1 vccd1 vssd1 sky130_fd_sc_hd__fill_4$1
XTAP_TAPCELL_ROW_115_2032 vccd1 vssd1 sky130_fd_sc_hd__tapvpwrvgnd_1$1
XFILLER_115_3 vssd1 vccd1 vccd1 vssd1 sky130_ef_sc_hd__decap_40_12$1
XFILLER_4_525 vssd1 vccd1 vccd1 vssd1 sky130_fd_sc_hd__fill_4$1
XFILLER_133_261 vssd1 vccd1 vccd1 vssd1 sky130_ef_sc_hd__decap_40_12$1
XFILLER_4_569 vssd1 vccd1 vccd1 vssd1 sky130_ef_sc_hd__decap_40_12$1
XFILLER_97_57 vssd1 vccd1 vccd1 vssd1 sky130_ef_sc_hd__decap_40_12$1
XFILLER_79_337 vssd1 vccd1 vccd1 vssd1 sky130_ef_sc_hd__decap_40_12$1
XFILLER_94_307 vccd1 vssd1 vccd1 vssd1 sky130_fd_sc_hd__fill_1$1
XFILLER_0_753 vssd1 vccd1 vccd1 vssd1 sky130_fd_sc_hd__fill_2$1
XFILLER_102_681 vssd1 vccd1 vccd1 vssd1 sky130_ef_sc_hd__decap_40_12$1
XFILLER_0_797 vssd1 vccd1 vccd1 vssd1 sky130_ef_sc_hd__decap_40_12$1
XFILLER_47_223 vccd1 vssd1 vccd1 vssd1 sky130_fd_sc_hd__fill_1$1
XFILLER_48_757 vccd1 vssd1 vccd1 vssd1 sky130_fd_sc_hd__fill_1$1
XTAP_TAPCELL_ROW_126_2183 vccd1 vssd1 sky130_fd_sc_hd__tapvpwrvgnd_1$1
XFILLER_35_429 vssd1 vccd1 vccd1 vssd1 sky130_ef_sc_hd__decap_40_12$1
XTAP_TAPCELL_ROW_126_2194 vccd1 vssd1 sky130_fd_sc_hd__tapvpwrvgnd_1$1
XFILLER_90_557 vssd1 vccd1 vccd1 vssd1 sky130_fd_sc_hd__fill_2$1
XFILLER_16_643 vccd1 vssd1 vccd1 vssd1 sky130_fd_sc_hd__fill_1$1
XFILLER_46_83 vccd1 vssd1 vccd1 vssd1 sky130_fd_sc_hd__fill_1$1
XFILLER_31_613 vssd1 vccd1 vccd1 vssd1 sky130_fd_sc_hd__fill_2$1
XFILLER_129_501 vssd1 vccd1 vccd1 vssd1 sky130_fd_sc_hd__fill_2$1
XTAP_TAPCELL_ROW_26_693 vccd1 vssd1 sky130_fd_sc_hd__tapvpwrvgnd_1$1
X_1740_ _1848_/A _1740_/CLK _1740_/D vccd1 vssd1 vccd1 vssd1 sky130_fd_sc_hd__dfxtp_1$1
XFILLER_7_55 vccd1 vssd1 vccd1 vssd1 sky130_fd_sc_hd__fill_1$1
XFILLER_30_189 vssd1 vccd1 vccd1 vssd1 sky130_fd_sc_hd__fill_4$1
XFILLER_117_729 vssd1 vccd1 vccd1 vssd1 sky130_ef_sc_hd__decap_40_12$1
X_1671_ _1839_/A _1671_/CLK _1671_/D vccd1 vssd1 vccd1 vssd1 sky130_fd_sc_hd__dfxtp_1$1
XFILLER_7_385 vssd1 vccd1 vccd1 vssd1 sky130_fd_sc_hd__fill_4$1
XTAP_TAPCELL_ROW_55_1123 vccd1 vssd1 sky130_fd_sc_hd__tapvpwrvgnd_1$1
XFILLER_98_657 vssd1 vccd1 vccd1 vssd1 sky130_ef_sc_hd__decap_40_12$1
XFILLER_112_456 vssd1 vccd1 vccd1 vssd1 sky130_fd_sc_hd__fill_8$1
XFILLER_97_167 vccd1 vssd1 vccd1 vssd1 sky130_fd_sc_hd__fill_1$1
XFILLER_30_3 vssd1 vccd1 vccd1 vssd1 sky130_ef_sc_hd__decap_40_12$1
XFILLER_85_329 vssd1 vccd1 vccd1 vssd1 sky130_fd_sc_hd__fill_4$1
XFILLER_78_381 vssd1 vccd1 vccd1 vssd1 sky130_fd_sc_hd__fill_2$1
XFILLER_38_245 vssd1 vccd1 vccd1 vssd1 sky130_fd_sc_hd__fill_4$1
XFILLER_39_768 vssd1 vccd1 vccd1 vssd1 sky130_ef_sc_hd__decap_40_12$1
XFILLER_93_373 vssd1 vccd1 vccd1 vssd1 sky130_fd_sc_hd__fill_4$1
XFILLER_66_587 vccd1 vssd1 vccd1 vssd1 sky130_fd_sc_hd__fill_1$1
XFILLER_38_289 vssd1 vccd1 vccd1 vssd1 sky130_ef_sc_hd__decap_40_12$1
X_1105_ _1305_/C1 _1104_/X _1123_/A2 hold210/X _1584_/D vssd1 vccd1 vccd1 vssd1 sky130_fd_sc_hd__o211a_1$1
XFILLER_53_237 vssd1 vccd1 vccd1 vssd1 sky130_ef_sc_hd__decap_40_12$1
X_1036_ _1036_/A _1036_/X _1052_/B vssd1 vccd1 vccd1 vssd1 sky130_fd_sc_hd__or2_1$1
XTAP_TAPCELL_ROW_66_1296 vccd1 vssd1 sky130_fd_sc_hd__tapvpwrvgnd_1$1
XTAP_TAPCELL_ROW_66_1285 vccd1 vssd1 sky130_fd_sc_hd__tapvpwrvgnd_1$1
XFILLER_62_793 vssd1 vccd1 vccd1 vssd1 sky130_fd_sc_hd__fill_4$1
XFILLER_22_613 vssd1 vccd1 vccd1 vssd1 sky130_ef_sc_hd__decap_40_12$1
XFILLER_34_473 vssd1 vccd1 vccd1 vssd1 sky130_fd_sc_hd__fill_2$1
XTAP_TAPCELL_ROW_45_980 vccd1 vssd1 sky130_fd_sc_hd__tapvpwrvgnd_1$1
XFILLER_61_281 vssd1 vccd1 vccd1 vssd1 sky130_ef_sc_hd__decap_40_12$1
XFILLER_22_657 vssd1 vccd1 vccd1 vssd1 sky130_ef_sc_hd__decap_40_12$1
XFILLER_21_167 vccd1 vssd1 vccd1 vssd1 sky130_fd_sc_hd__fill_1$1
XFILLER_107_217 vssd1 vccd1 vccd1 vssd1 sky130_fd_sc_hd__fill_4$1
XFILLER_122_209 vssd1 vccd1 vccd1 vssd1 sky130_ef_sc_hd__decap_40_12$1
XFILLER_103_401 vssd1 vccd1 vccd1 vssd1 sky130_ef_sc_hd__decap_40_12$1
XFILLER_1_517 vssd1 vccd1 vccd1 vssd1 sky130_ef_sc_hd__decap_40_12$1
XFILLER_131_721 vssd1 vccd1 vccd1 vssd1 sky130_fd_sc_hd__fill_4$1
XFILLER_115_261 vssd1 vccd1 vccd1 vssd1 sky130_ef_sc_hd__decap_40_12$1
XFILLER_130_253 vssd1 vccd1 vccd1 vssd1 sky130_ef_sc_hd__decap_40_12$1
XFILLER_76_307 vccd1 vssd1 vccd1 vssd1 sky130_fd_sc_hd__fill_1$1
XFILLER_67_27 vssd1 vccd1 vccd1 vssd1 sky130_ef_sc_hd__decap_40_12$1
XFILLER_88_189 vssd1 vccd1 vccd1 vssd1 sky130_fd_sc_hd__fill_4$1
XFILLER_85_841 vccd1 vssd1 vccd1 vssd1 sky130_fd_sc_hd__fill_1$1
XTAP_TAPCELL_ROW_4_366 vccd1 vssd1 sky130_fd_sc_hd__tapvpwrvgnd_1$1
XTAP_TAPCELL_ROW_4_355 vccd1 vssd1 sky130_fd_sc_hd__tapvpwrvgnd_1$1
XFILLER_29_223 vccd1 vssd1 vccd1 vssd1 sky130_fd_sc_hd__fill_1$1
XFILLER_123_55 vccd1 vssd1 vccd1 vssd1 sky130_fd_sc_hd__fill_1$1
XFILLER_83_15 vssd1 vccd1 vccd1 vssd1 sky130_ef_sc_hd__decap_40_12$1
XPHY_EDGE_ROW_64_Left_203 vccd1 vssd1 vccd1 vssd1 sky130_fd_sc_hd__decap_3$1
XFILLER_17_429 vssd1 vccd1 vccd1 vssd1 sky130_ef_sc_hd__decap_40_12$1
XFILLER_16_53 vssd1 vccd1 vccd1 vssd1 sky130_ef_sc_hd__decap_40_12$1
XFILLER_13_613 vssd1 vccd1 vccd1 vssd1 sky130_fd_sc_hd__fill_2$1
XFILLER_25_473 vssd1 vccd1 vccd1 vssd1 sky130_ef_sc_hd__decap_40_12$1
XTAP_TAPCELL_ROW_43_939 vccd1 vssd1 sky130_fd_sc_hd__tapvpwrvgnd_1$1
XFILLER_9_617 vssd1 vccd1 vccd1 vssd1 sky130_ef_sc_hd__decap_40_12$1
XFILLER_16_97 vssd1 vccd1 vccd1 vssd1 sky130_ef_sc_hd__decap_40_12$1
XTAP_TAPCELL_ROW_23_641 vccd1 vssd1 sky130_fd_sc_hd__tapvpwrvgnd_1$1
XFILLER_40_421 vssd1 vccd1 vccd1 vssd1 sky130_ef_sc_hd__decap_40_12$1
XTAP_TAPCELL_ROW_23_652 vccd1 vssd1 sky130_fd_sc_hd__tapvpwrvgnd_1$1
XFILLER_138_331 vssd1 vccd1 vccd1 vssd1 sky130_fd_sc_hd__fill_4$1
XFILLER_12_189 vssd1 vccd1 vccd1 vssd1 sky130_fd_sc_hd__fill_4$1
XFILLER_32_41 vssd1 vccd1 vccd1 vssd1 sky130_ef_sc_hd__decap_40_12$1
XTAP_TAPCELL_ROW_97_1757 vccd1 vssd1 sky130_fd_sc_hd__tapvpwrvgnd_1$1
XPHY_EDGE_ROW_73_Left_212 vccd1 vssd1 vccd1 vssd1 sky130_fd_sc_hd__decap_3$1
XFILLER_32_85 vssd1 vccd1 vccd1 vssd1 sky130_ef_sc_hd__decap_40_12$1
XFILLER_4_333 vssd1 vccd1 vccd1 vssd1 sky130_ef_sc_hd__decap_40_12$1
XFILLER_4_377 vssd1 vccd1 vccd1 vssd1 sky130_ef_sc_hd__decap_40_12$1
XTAP_TAPCELL_ROW_128_2223 vccd1 vssd1 sky130_fd_sc_hd__tapvpwrvgnd_1$1
XFILLER_79_167 vccd1 vssd1 vccd1 vssd1 sky130_fd_sc_hd__fill_1$1
XFILLER_67_329 vssd1 vccd1 vccd1 vssd1 sky130_fd_sc_hd__fill_4$1
XFILLER_0_561 vssd1 vccd1 vccd1 vssd1 sky130_ef_sc_hd__decap_40_12$1
XFILLER_94_137 vssd1 vccd1 vccd1 vssd1 sky130_fd_sc_hd__fill_2$1
XTAP_TAPCELL_ROW_50_1053 vccd1 vssd1 sky130_fd_sc_hd__tapvpwrvgnd_1$1
XPHY_EDGE_ROW_82_Left_221 vccd1 vssd1 vccd1 vssd1 sky130_fd_sc_hd__decap_3$1
XFILLER_75_373 vssd1 vccd1 vccd1 vssd1 sky130_ef_sc_hd__decap_40_12$1
XFILLER_57_93 vssd1 vccd1 vccd1 vssd1 sky130_ef_sc_hd__decap_40_12$1
XFILLER_90_321 vssd1 vccd1 vccd1 vssd1 sky130_ef_sc_hd__decap_40_12$1
XFILLER_35_237 vssd1 vccd1 vccd1 vssd1 sky130_ef_sc_hd__decap_40_12$1
XFILLER_48_598 vssd1 vccd1 vccd1 vssd1 sky130_ef_sc_hd__decap_40_12$1
XFILLER_90_365 vssd1 vccd1 vccd1 vssd1 sky130_ef_sc_hd__decap_40_12$1
XTAP_TAPCELL_ROW_106_1897 vccd1 vssd1 sky130_fd_sc_hd__tapvpwrvgnd_1$1
XTAP_TAPCELL_ROW_106_1886 vccd1 vssd1 sky130_fd_sc_hd__tapvpwrvgnd_1$1
XFILLER_73_81 vssd1 vccd1 vccd1 vssd1 sky130_ef_sc_hd__decap_40_12$1
XFILLER_16_473 vssd1 vccd1 vccd1 vssd1 sky130_fd_sc_hd__fill_2$1
XFILLER_44_793 vssd1 vccd1 vccd1 vssd1 sky130_ef_sc_hd__decap_40_12$1
XFILLER_43_281 vssd1 vccd1 vccd1 vssd1 sky130_ef_sc_hd__decap_40_12$1
XPHY_EDGE_ROW_91_Left_230 vccd1 vssd1 vccd1 vssd1 sky130_fd_sc_hd__decap_3$1
XFILLER_78_3 vssd1 vccd1 vccd1 vssd1 sky130_ef_sc_hd__decap_40_12$1
X_1723_ hold96/A _1755_/CLK _1723_/D vccd1 vssd1 vccd1 vssd1 sky130_fd_sc_hd__dfxtp_1$1
XFILLER_117_515 vccd1 vssd1 vccd1 vssd1 sky130_fd_sc_hd__fill_1$1
Xclkbuf_leaf_38_wb_clk_i _1742_/CLK clkload0/A vssd1 vccd1 vccd1 vssd1 sky130_fd_sc_hd__clkbuf_8$1
Xhold105 _1534_/Q _1000_/A vssd1 vccd1 vccd1 vssd1 sky130_fd_sc_hd__dlygate4sd3_1$1
XFILLER_117_548 vssd1 vccd1 vccd1 vssd1 sky130_ef_sc_hd__decap_40_12$1
Xhold116 _1524_/Q _0980_/A vssd1 vccd1 vccd1 vssd1 sky130_fd_sc_hd__dlygate4sd3_1$1
XFILLER_7_193 vssd1 vccd1 vccd1 vssd1 sky130_ef_sc_hd__decap_40_12$1
XFILLER_132_529 vssd1 vccd1 vccd1 vssd1 sky130_fd_sc_hd__fill_2$1
Xhold138 _1727_/Q _1398_/A vssd1 vccd1 vccd1 vssd1 sky130_fd_sc_hd__dlygate4sd3_1$1
XFILLER_104_209 vssd1 vccd1 vccd1 vssd1 sky130_ef_sc_hd__decap_40_12$1
Xhold149 _1696_/Q _1334_/A vssd1 vccd1 vccd1 vssd1 sky130_fd_sc_hd__dlygate4sd3_1$1
Xhold127 _1521_/Q _0974_/A vssd1 vccd1 vccd1 vssd1 sky130_fd_sc_hd__dlygate4sd3_1$1
X_1654_ _1654_/Q _1753_/CLK _1654_/D vccd1 vssd1 vccd1 vssd1 sky130_fd_sc_hd__dfxtp_2$1
XFILLER_113_721 vssd1 vccd1 vccd1 vssd1 sky130_fd_sc_hd__fill_4$1
XFILLER_98_421 vssd1 vccd1 vccd1 vssd1 sky130_ef_sc_hd__decap_40_12$1
X_1585_ _1803_/A _1585_/CLK _1585_/D vccd1 vssd1 vccd1 vssd1 sky130_fd_sc_hd__dfxtp_1$1
XFILLER_113_765 vssd1 vccd1 vccd1 vssd1 sky130_ef_sc_hd__decap_40_12$1
XFILLER_112_253 vssd1 vccd1 vccd1 vssd1 sky130_ef_sc_hd__decap_40_12$1
XFILLER_58_307 vccd1 vssd1 vccd1 vssd1 sky130_fd_sc_hd__fill_1$1
XFILLER_85_137 vssd1 vccd1 vccd1 vssd1 sky130_ef_sc_hd__decap_40_12$1
XFILLER_67_841 vccd1 vssd1 vccd1 vssd1 sky130_fd_sc_hd__fill_1$1
XFILLER_82_800 vssd1 vccd1 vccd1 vssd1 sky130_ef_sc_hd__decap_40_12$1
XTAP_TAPCELL_ROW_68_1314 vccd1 vssd1 sky130_fd_sc_hd__tapvpwrvgnd_1$1
XFILLER_54_513 vssd1 vccd1 vccd1 vssd1 sky130_ef_sc_hd__decap_40_12$1
XTAP_TAPCELL_ROW_1_314 vccd1 vssd1 sky130_fd_sc_hd__tapvpwrvgnd_1$1
XFILLER_27_727 vccd1 vssd1 vccd1 vssd1 sky130_fd_sc_hd__fill_1$1
XFILLER_94_693 vssd1 vccd1 vccd1 vssd1 sky130_fd_sc_hd__fill_4$1
XFILLER_93_181 vssd1 vccd1 vccd1 vssd1 sky130_ef_sc_hd__decap_40_12$1
XTAP_TAPCELL_ROW_68_1325 vccd1 vssd1 sky130_fd_sc_hd__tapvpwrvgnd_1$1
XFILLER_35_760 vssd1 vccd1 vccd1 vssd1 sky130_ef_sc_hd__decap_40_12$1
XTAP_TAPCELL_ROW_81_1514 vccd1 vssd1 sky130_fd_sc_hd__tapvpwrvgnd_1$1
X_1019_ _1091_/C1 _1018_/X _1053_/A2 hold73/A _1542_/D vssd1 vccd1 vccd1 vssd1 sky130_fd_sc_hd__o211a_1$1
XFILLER_22_421 vssd1 vccd1 vccd1 vssd1 sky130_ef_sc_hd__decap_40_12$1
XTAP_TAPCELL_ROW_20_600 vccd1 vssd1 sky130_fd_sc_hd__tapvpwrvgnd_1$1
XFILLER_136_813 vssd1 vccd1 vccd1 vssd1 sky130_ef_sc_hd__decap_40_12$1
XFILLER_108_515 vccd1 vssd1 vccd1 vssd1 sky130_fd_sc_hd__fill_1$1
XTAP_TAPCELL_ROW_79_1487 vccd1 vssd1 sky130_fd_sc_hd__tapvpwrvgnd_1$1
XFILLER_78_15 vssd1 vccd1 vccd1 vssd1 sky130_ef_sc_hd__decap_40_12$1
XFILLER_118_77 vssd1 vccd1 vccd1 vssd1 sky130_fd_sc_hd__fill_4$1
XTAP_TAPCELL_ROW_9_436 vccd1 vssd1 sky130_fd_sc_hd__tapvpwrvgnd_1$1
XFILLER_2_837 vssd1 vccd1 vccd1 vssd1 sky130_fd_sc_hd__fill_4$1
XTAP_TAPCELL_ROW_92_1687 vccd1 vssd1 sky130_fd_sc_hd__tapvpwrvgnd_1$1
XTAP_TAPCELL_ROW_92_1676 vccd1 vssd1 sky130_fd_sc_hd__tapvpwrvgnd_1$1
XFILLER_131_573 vssd1 vccd1 vccd1 vssd1 sky130_ef_sc_hd__decap_40_12$1
XFILLER_104_776 vssd1 vccd1 vccd1 vssd1 sky130_ef_sc_hd__decap_40_12$1
XFILLER_49_329 vssd1 vccd1 vccd1 vssd1 sky130_fd_sc_hd__fill_4$1
XFILLER_134_65 vssd1 vccd1 vccd1 vssd1 sky130_ef_sc_hd__decap_40_12$1
XFILLER_76_137 vssd1 vccd1 vccd1 vssd1 sky130_fd_sc_hd__fill_2$1
XFILLER_85_693 vssd1 vccd1 vccd1 vssd1 sky130_ef_sc_hd__decap_40_12$1
XFILLER_72_321 vssd1 vccd1 vccd1 vssd1 sky130_ef_sc_hd__decap_40_12$1
XFILLER_57_373 vssd1 vccd1 vccd1 vssd1 sky130_fd_sc_hd__fill_2$1
XFILLER_17_237 vssd1 vccd1 vccd1 vssd1 sky130_ef_sc_hd__decap_40_12$1
XFILLER_18_749 vssd1 vccd1 vccd1 vssd1 sky130_fd_sc_hd__fill_4$1
XTAP_TAPCELL_ROW_28_722 vccd1 vssd1 sky130_fd_sc_hd__tapvpwrvgnd_1$1
XTAP_TAPCELL_ROW_123_2142 vccd1 vssd1 sky130_fd_sc_hd__tapvpwrvgnd_1$1
XFILLER_72_365 vssd1 vccd1 vccd1 vssd1 sky130_ef_sc_hd__decap_40_12$1
XFILLER_45_557 vssd1 vccd1 vccd1 vssd1 sky130_fd_sc_hd__fill_2$1
XFILLER_60_516 vssd1 vccd1 vccd1 vssd1 sky130_ef_sc_hd__decap_40_12$1
XFILLER_25_281 vssd1 vccd1 vccd1 vssd1 sky130_ef_sc_hd__decap_40_12$1
XFILLER_40_251 vccd1 vssd1 vccd1 vssd1 sky130_fd_sc_hd__fill_1$1
XFILLER_41_785 vssd1 vccd1 vccd1 vssd1 sky130_ef_sc_hd__decap_40_12$1
XFILLER_43_51 vssd1 vccd1 vccd1 vssd1 sky130_fd_sc_hd__fill_4$1
XFILLER_9_447 vccd1 vssd1 vccd1 vssd1 sky130_fd_sc_hd__fill_1$1
XFILLER_126_301 vssd1 vccd1 vccd1 vssd1 sky130_fd_sc_hd__fill_4$1
XFILLER_126_345 vssd1 vccd1 vccd1 vssd1 sky130_ef_sc_hd__decap_40_12$1
XFILLER_5_653 vssd1 vccd1 vccd1 vssd1 sky130_ef_sc_hd__decap_40_12$1
XFILLER_4_141 vssd1 vccd1 vccd1 vssd1 sky130_ef_sc_hd__decap_40_12$1
XFILLER_5_697 vssd1 vccd1 vccd1 vssd1 sky130_ef_sc_hd__decap_40_12$1
X_1370_ _1370_/A _1370_/X _1408_/B vssd1 vccd1 vccd1 vssd1 sky130_fd_sc_hd__or2_1$1
XFILLER_95_413 vccd1 vssd1 vccd1 vssd1 sky130_fd_sc_hd__fill_1$1
XFILLER_68_81 vssd1 vccd1 vccd1 vssd1 sky130_fd_sc_hd__fill_2$1
XFILLER_110_757 vssd1 vccd1 vccd1 vssd1 sky130_ef_sc_hd__decap_40_12$1
XFILLER_110_746 vssd1 vccd1 vccd1 vssd1 sky130_fd_sc_hd__fill_8$1
XFILLER_68_649 vssd1 vccd1 vccd1 vssd1 sky130_fd_sc_hd__fill_2$1
XFILLER_67_137 vssd1 vccd1 vccd1 vssd1 sky130_ef_sc_hd__decap_40_12$1
XFILLER_49_841 vccd1 vssd1 vccd1 vssd1 sky130_fd_sc_hd__fill_1$1
XFILLER_0_391 vccd1 vssd1 vccd1 vssd1 sky130_fd_sc_hd__fill_1$1
XTAP_TAPCELL_ROW_108_1915 vccd1 vssd1 sky130_fd_sc_hd__tapvpwrvgnd_1$1
XFILLER_64_811 vccd1 vssd1 vccd1 vssd1 sky130_fd_sc_hd__fill_1$1
XFILLER_64_800 vssd1 vccd1 vccd1 vssd1 sky130_fd_sc_hd__fill_2$1
XTAP_TAPCELL_ROW_108_1926 vccd1 vssd1 sky130_fd_sc_hd__tapvpwrvgnd_1$1
XFILLER_75_181 vssd1 vccd1 vccd1 vssd1 sky130_ef_sc_hd__decap_40_12$1
XFILLER_36_513 vssd1 vccd1 vccd1 vssd1 sky130_ef_sc_hd__decap_40_12$1
XFILLER_91_641 vssd1 vccd1 vccd1 vssd1 sky130_ef_sc_hd__decap_40_12$1
XFILLER_51_505 vssd1 vccd1 vccd1 vssd1 sky130_ef_sc_hd__decap_40_12$1
XFILLER_36_557 vssd1 vccd1 vccd1 vssd1 sky130_ef_sc_hd__decap_40_12$1
XFILLER_90_195 vccd1 vssd1 vccd1 vssd1 sky130_fd_sc_hd__fill_1$1
XTAP_TAPCELL_ROW_63_1244 vccd1 vssd1 sky130_fd_sc_hd__tapvpwrvgnd_1$1
XFILLER_32_752 vssd1 vccd1 vccd1 vssd1 sky130_fd_sc_hd__fill_4$1
XFILLER_31_273 vssd1 vccd1 vccd1 vssd1 sky130_fd_sc_hd__fill_4$1
XFILLER_129_161 vssd1 vccd1 vccd1 vssd1 sky130_fd_sc_hd__fill_4$1
XFILLER_118_813 vssd1 vccd1 vccd1 vssd1 sky130_fd_sc_hd__fill_8$1
X_1706_ _1829_/A _1738_/CLK _1706_/D vccd1 vssd1 vccd1 vssd1 sky130_fd_sc_hd__dfxtp_1$1
XFILLER_105_529 vssd1 vccd1 vccd1 vssd1 sky130_ef_sc_hd__decap_40_12$1
X_1637_ _1637_/Q _1736_/CLK _1637_/D vccd1 vssd1 vccd1 vssd1 sky130_fd_sc_hd__dfxtp_1$1
XFILLER_99_741 vssd1 vccd1 vccd1 vssd1 sky130_ef_sc_hd__decap_40_12$1
X_1568_ _1568_/Q _1760_/CLK _1568_/D vccd1 vssd1 vccd1 vssd1 sky130_fd_sc_hd__dfxtp_1$1
XFILLER_99_785 vccd1 vssd1 vccd1 vssd1 sky130_fd_sc_hd__fill_1$1
XFILLER_98_251 vccd1 vssd1 vccd1 vssd1 sky130_fd_sc_hd__fill_1$1
XFILLER_86_413 vssd1 vccd1 vccd1 vssd1 sky130_fd_sc_hd__fill_2$1
XFILLER_48_29 vssd1 vccd1 vccd1 vssd1 sky130_ef_sc_hd__decap_40_12$1
X_1499_ _1499_/Q _1759_/CLK _1499_/D vccd1 vssd1 vccd1 vssd1 sky130_fd_sc_hd__dfxtp_1$1
XFILLER_58_137 vssd1 vccd1 vccd1 vssd1 sky130_fd_sc_hd__fill_2$1
XFILLER_100_245 vssd1 vccd1 vccd1 vssd1 sky130_fd_sc_hd__fill_4$1
XFILLER_100_289 vssd1 vccd1 vccd1 vssd1 sky130_ef_sc_hd__decap_40_12$1
XFILLER_54_321 vssd1 vccd1 vccd1 vssd1 sky130_ef_sc_hd__decap_40_12$1
XFILLER_39_373 vssd1 vccd1 vccd1 vssd1 sky130_ef_sc_hd__decap_40_12$1
XPHY_EDGE_ROW_126_Right_126 vccd1 vssd1 vccd1 vssd1 sky130_fd_sc_hd__decap_3$1
XFILLER_82_663 vccd1 vssd1 vccd1 vssd1 sky130_fd_sc_hd__fill_1$1
XFILLER_82_641 vssd1 vccd1 vccd1 vssd1 sky130_fd_sc_hd__fill_2$1
XFILLER_27_557 vssd1 vccd1 vccd1 vssd1 sky130_fd_sc_hd__fill_2$1
XFILLER_54_365 vssd1 vccd1 vccd1 vssd1 sky130_ef_sc_hd__decap_40_12$1
XFILLER_23_741 vssd1 vccd1 vccd1 vssd1 sky130_ef_sc_hd__decap_40_12$1
XFILLER_42_549 vccd1 vssd1 vccd1 vssd1 sky130_fd_sc_hd__fill_1$1
XFILLER_80_27 vccd1 vssd1 vccd1 vssd1 sky130_fd_sc_hd__fill_1$1
XFILLER_22_251 vccd1 vssd1 vccd1 vssd1 sky130_fd_sc_hd__fill_1$1
XFILLER_23_785 vssd1 vccd1 vccd1 vssd1 sky130_fd_sc_hd__fill_4$1
XFILLER_10_413 vssd1 vccd1 vccd1 vssd1 sky130_fd_sc_hd__fill_4$1
XTAP_TAPCELL_ROW_33_791 vccd1 vssd1 sky130_fd_sc_hd__tapvpwrvgnd_1$1
XFILLER_127_109 vssd1 vccd1 vccd1 vssd1 sky130_fd_sc_hd__fill_2$1
XFILLER_108_301 vssd1 vccd1 vccd1 vssd1 sky130_fd_sc_hd__fill_4$1
XFILLER_10_457 vssd1 vccd1 vccd1 vssd1 sky130_ef_sc_hd__decap_40_12$1
XFILLER_6_417 vssd1 vccd1 vccd1 vssd1 sky130_fd_sc_hd__fill_2$1
XFILLER_136_632 vssd1 vccd1 vccd1 vssd1 sky130_ef_sc_hd__decap_40_12$1
XTAP_TAPCELL_ROW_94_1705 vccd1 vssd1 sky130_fd_sc_hd__tapvpwrvgnd_1$1
XFILLER_108_345 vssd1 vccd1 vccd1 vssd1 sky130_ef_sc_hd__decap_40_12$1
XTAP_TAPCELL_ROW_94_1716 vccd1 vssd1 sky130_fd_sc_hd__tapvpwrvgnd_1$1
XFILLER_123_337 vssd1 vccd1 vccd1 vssd1 sky130_ef_sc_hd__decap_40_12$1
XFILLER_108_389 vssd1 vccd1 vccd1 vssd1 sky130_ef_sc_hd__decap_40_12$1
XFILLER_89_69 vssd1 vccd1 vccd1 vssd1 sky130_ef_sc_hd__decap_40_12$1
XFILLER_2_601 vssd1 vccd1 vccd1 vssd1 sky130_ef_sc_hd__decap_40_12$1
XFILLER_8_3 vssd1 vccd1 vccd1 vssd1 sky130_ef_sc_hd__decap_40_12$1
XFILLER_1_111 vccd1 vssd1 vccd1 vssd1 sky130_fd_sc_hd__fill_1$1
XFILLER_2_645 vssd1 vccd1 vccd1 vssd1 sky130_ef_sc_hd__decap_40_12$1
XFILLER_89_273 vssd1 vccd1 vccd1 vssd1 sky130_fd_sc_hd__fill_4$1
XFILLER_49_137 vssd1 vccd1 vccd1 vssd1 sky130_ef_sc_hd__decap_40_12$1
XFILLER_46_811 vccd1 vssd1 vccd1 vssd1 sky130_fd_sc_hd__fill_1$1
XFILLER_18_513 vssd1 vccd1 vccd1 vssd1 sky130_ef_sc_hd__decap_40_12$1
XFILLER_57_181 vssd1 vccd1 vccd1 vssd1 sky130_ef_sc_hd__decap_40_12$1
XFILLER_18_557 vssd1 vccd1 vccd1 vssd1 sky130_ef_sc_hd__decap_40_12$1
XFILLER_73_685 vssd1 vccd1 vccd1 vssd1 sky130_ef_sc_hd__decap_40_12$1
XFILLER_33_505 vssd1 vccd1 vccd1 vssd1 sky130_ef_sc_hd__decap_40_12$1
XTAP_TAPCELL_ROW_103_1845 vccd1 vssd1 sky130_fd_sc_hd__tapvpwrvgnd_1$1
XFILLER_72_195 vccd1 vssd1 vccd1 vssd1 sky130_fd_sc_hd__fill_1$1
XFILLER_54_83 vccd1 vssd1 vccd1 vssd1 sky130_fd_sc_hd__fill_1$1
XFILLER_60_357 vssd1 vccd1 vccd1 vssd1 sky130_fd_sc_hd__fill_4$1
XFILLER_13_273 vssd1 vccd1 vccd1 vssd1 sky130_fd_sc_hd__fill_4$1
XTAP_TAPCELL_ROW_136_2344 vccd1 vssd1 sky130_fd_sc_hd__tapvpwrvgnd_1$1
XTAP_TAPCELL_ROW_136_2333 vccd1 vssd1 sky130_fd_sc_hd__tapvpwrvgnd_1$1
XFILLER_118_109 vssd1 vccd1 vccd1 vssd1 sky130_ef_sc_hd__decap_40_12$1
X_0870_ _1015_/A _1560_/Q _0869_/X _0870_/X vccd1 vssd1 vccd1 vssd1 sky130_fd_sc_hd__a21o_1$1
XFILLER_9_277 vssd1 vccd1 vccd1 vssd1 sky130_fd_sc_hd__fill_2$1
Xclkload25 _1755_/CLK clkload25/Y vssd1 vccd1 vccd1 vssd1 sky130_fd_sc_hd__bufinv_16$1
XTAP_TAPCELL_ROW_11_463 vccd1 vssd1 sky130_fd_sc_hd__tapvpwrvgnd_1$1
Xclkload14 clkload14/X _1579_/CLK vssd1 vccd1 vccd1 vssd1 sky130_fd_sc_hd__clkbuf_4$1
XFILLER_126_153 vssd1 vccd1 vccd1 vssd1 sky130_ef_sc_hd__decap_40_12$1
Xclkload36 clkload36/Y _1763_/CLK vccd1 vssd1 vccd1 vssd1 sky130_fd_sc_hd__clkinv_2$1
XFILLER_5_461 vssd1 vccd1 vccd1 vssd1 sky130_ef_sc_hd__decap_40_12$1
XFILLER_126_197 vssd1 vccd1 vccd1 vssd1 sky130_ef_sc_hd__decap_40_12$1
X_1422_ _1846_/A _1422_/X _1422_/B vssd1 vccd1 vccd1 vssd1 sky130_fd_sc_hd__or2_1$1
XFILLER_68_413 vssd1 vccd1 vccd1 vssd1 sky130_fd_sc_hd__fill_4$1
XPHY_EDGE_ROW_10_Left_149 vccd1 vssd1 vccd1 vssd1 sky130_fd_sc_hd__decap_3$1
XFILLER_95_221 vssd1 vccd1 vccd1 vssd1 sky130_fd_sc_hd__fill_2$1
X_1353_ _1421_/C1 _1352_/X _1409_/A2 hold67/X _1704_/D vssd1 vccd1 vccd1 vssd1 sky130_fd_sc_hd__o211a_1$1
XFILLER_83_405 vssd1 vccd1 vccd1 vssd1 sky130_ef_sc_hd__decap_40_12$1
X_1284_ _1839_/A _1284_/X _1342_/B vssd1 vccd1 vccd1 vssd1 sky130_fd_sc_hd__or2_1$1
XFILLER_110_587 vccd1 vssd1 vccd1 vssd1 sky130_fd_sc_hd__fill_1$1
XFILLER_83_449 vssd1 vccd1 vccd1 vssd1 sky130_ef_sc_hd__decap_40_12$1
XFILLER_76_490 vssd1 vccd1 vccd1 vssd1 sky130_ef_sc_hd__decap_40_12$1
XFILLER_64_641 vssd1 vccd1 vccd1 vssd1 sky130_fd_sc_hd__fill_2$1
XFILLER_36_321 vssd1 vccd1 vccd1 vssd1 sky130_ef_sc_hd__decap_40_12$1
XFILLER_52_825 vccd1 vssd1 vccd1 vssd1 sky130_fd_sc_hd__fill_1$1
XFILLER_36_365 vssd1 vccd1 vccd1 vssd1 sky130_ef_sc_hd__decap_40_12$1
XFILLER_51_335 vccd1 vssd1 vccd1 vssd1 sky130_fd_sc_hd__fill_1$1
XTAP_TAPCELL_ROW_19_585 vccd1 vssd1 sky130_fd_sc_hd__tapvpwrvgnd_1$1
XFILLER_109_109 vssd1 vccd1 vccd1 vssd1 sky130_fd_sc_hd__fill_2$1
Xclkload8 clkload8/Y clkload8/A vccd1 vssd1 vccd1 vssd1 sky130_fd_sc_hd__clkinv_2$1
XFILLER_20_755 vccd1 vssd1 vccd1 vssd1 sky130_fd_sc_hd__fill_1$1
X_0999_ _1463_/C1 _0998_/X _1013_/A2 hold86/X _1533_/D vssd1 vccd1 vccd1 vssd1 sky130_fd_sc_hd__o211a_1$1
XFILLER_118_643 vccd1 vssd1 vccd1 vssd1 sky130_fd_sc_hd__fill_1$1
XFILLER_118_610 vssd1 vccd1 vccd1 vssd1 sky130_ef_sc_hd__decap_40_12$1
XTAP_TAPCELL_ROW_30_750 vccd1 vssd1 sky130_fd_sc_hd__tapvpwrvgnd_1$1
XFILLER_106_805 vssd1 vccd1 vccd1 vssd1 sky130_fd_sc_hd__fill_4$1
XFILLER_133_613 vssd1 vccd1 vccd1 vssd1 sky130_fd_sc_hd__fill_2$1
XTAP_TAPCELL_ROW_76_1446 vccd1 vssd1 sky130_fd_sc_hd__tapvpwrvgnd_1$1
XTAP_TAPCELL_ROW_76_1435 vccd1 vssd1 sky130_fd_sc_hd__tapvpwrvgnd_1$1
XFILLER_105_337 vssd1 vccd1 vccd1 vssd1 sky130_ef_sc_hd__decap_40_12$1
XFILLER_59_39 vssd1 vccd1 vccd1 vssd1 sky130_ef_sc_hd__decap_40_12$1
XFILLER_120_307 vccd1 vssd1 vccd1 vssd1 sky130_fd_sc_hd__fill_1$1
Xfanout212 _1343_/A2 vccd1 vssd1 _1279_/Y vccd1 vssd1 sky130_fd_sc_hd__buf_6$1
Xfanout223 _1123_/A2 _1145_/A2 vssd1 vccd1 vccd1 vssd1 sky130_fd_sc_hd__clkbuf_8$1
XFILLER_59_413 vssd1 vccd1 vccd1 vssd1 sky130_fd_sc_hd__fill_8$1
XFILLER_132_189 vssd1 vccd1 vccd1 vssd1 sky130_fd_sc_hd__fill_4$1
Xfanout245 _1411_/A vccd1 vssd1 _0747_/X vccd1 vssd1 sky130_fd_sc_hd__buf_6$1
Xfanout256 _1147_/A vccd1 vssd1 _0740_/X vccd1 vssd1 sky130_fd_sc_hd__buf_6$1
Xfanout234 _1012_/B _0948_/X vssd1 vccd1 vccd1 vssd1 sky130_fd_sc_hd__clkbuf_8$1
XFILLER_87_744 vssd1 vccd1 vccd1 vssd1 sky130_ef_sc_hd__decap_40_12$1
XFILLER_86_221 vssd1 vccd1 vccd1 vssd1 sky130_ef_sc_hd__decap_40_12$1
Xfanout278 vccd1 vssd1 _1465_/C1 _1319_/C1 vccd1 vssd1 sky130_fd_sc_hd__buf_2$1
Xfanout267 _1455_/C1 vccd1 vssd1 _1319_/C1 vccd1 vssd1 sky130_fd_sc_hd__buf_4$1
XFILLER_86_265 vssd1 vccd1 vccd1 vssd1 sky130_ef_sc_hd__decap_40_12$1
XFILLER_75_27 vssd1 vccd1 vccd1 vssd1 sky130_ef_sc_hd__decap_40_12$1
XFILLER_74_449 vssd1 vccd1 vccd1 vssd1 sky130_ef_sc_hd__decap_40_12$1
XFILLER_28_811 vccd1 vssd1 vccd1 vssd1 sky130_fd_sc_hd__fill_1$1
XFILLER_39_181 vssd1 vccd1 vccd1 vssd1 sky130_ef_sc_hd__decap_40_12$1
XFILLER_131_55 vccd1 vssd1 vccd1 vssd1 sky130_fd_sc_hd__fill_1$1
XTAP_TAPCELL_ROW_120_2101 vccd1 vssd1 sky130_fd_sc_hd__tapvpwrvgnd_1$1
XFILLER_91_15 vssd1 vccd1 vccd1 vssd1 sky130_ef_sc_hd__decap_40_12$1
XFILLER_55_685 vssd1 vccd1 vccd1 vssd1 sky130_ef_sc_hd__decap_40_12$1
XFILLER_15_505 vssd1 vccd1 vccd1 vssd1 sky130_ef_sc_hd__decap_40_12$1
XTAP_TAPCELL_ROW_38_872 vccd1 vssd1 sky130_fd_sc_hd__tapvpwrvgnd_1$1
XFILLER_54_195 vccd1 vssd1 vccd1 vssd1 sky130_fd_sc_hd__fill_1$1
XFILLER_42_357 vssd1 vccd1 vccd1 vssd1 sky130_fd_sc_hd__fill_4$1
XFILLER_24_53 vssd1 vccd1 vccd1 vssd1 sky130_ef_sc_hd__decap_40_12$1
XFILLER_10_221 vssd1 vccd1 vccd1 vssd1 sky130_ef_sc_hd__decap_40_12$1
XFILLER_24_97 vssd1 vccd1 vccd1 vssd1 sky130_ef_sc_hd__decap_40_12$1
XTAP_TAPCELL_ROW_118_2074 vccd1 vssd1 sky130_fd_sc_hd__tapvpwrvgnd_1$1
XTAP_TAPCELL_ROW_118_2063 vccd1 vssd1 sky130_fd_sc_hd__tapvpwrvgnd_1$1
XFILLER_11_777 vssd1 vccd1 vccd1 vssd1 sky130_fd_sc_hd__fill_4$1
XFILLER_10_265 vssd1 vccd1 vccd1 vssd1 sky130_ef_sc_hd__decap_40_12$1
XFILLER_40_41 vssd1 vccd1 vccd1 vssd1 sky130_ef_sc_hd__decap_40_12$1
XFILLER_108_153 vssd1 vccd1 vccd1 vssd1 sky130_ef_sc_hd__decap_40_12$1
XFILLER_40_85 vssd1 vccd1 vccd1 vssd1 sky130_ef_sc_hd__decap_40_12$1
XTAP_TAPCELL_ROW_131_2263 vccd1 vssd1 sky130_fd_sc_hd__tapvpwrvgnd_1$1
XFILLER_124_657 vssd1 vccd1 vccd1 vssd1 sky130_ef_sc_hd__decap_40_12$1
XFILLER_108_197 vssd1 vccd1 vccd1 vssd1 sky130_ef_sc_hd__decap_40_12$1
XFILLER_123_167 vccd1 vssd1 vccd1 vssd1 sky130_fd_sc_hd__fill_1$1
XFILLER_2_475 vccd1 vssd1 vccd1 vssd1 sky130_fd_sc_hd__fill_1$1
XFILLER_111_329 vssd1 vccd1 vccd1 vssd1 sky130_fd_sc_hd__fill_4$1
XFILLER_78_755 vccd1 vssd1 vccd1 vssd1 sky130_fd_sc_hd__fill_1$1
XFILLER_77_221 vssd1 vccd1 vccd1 vssd1 sky130_fd_sc_hd__fill_2$1
XFILLER_93_725 vssd1 vccd1 vccd1 vssd1 sky130_fd_sc_hd__fill_2$1
XFILLER_65_449 vssd1 vccd1 vccd1 vssd1 sky130_ef_sc_hd__decap_40_12$1
XFILLER_1_57 vssd1 vccd1 vccd1 vssd1 sky130_ef_sc_hd__decap_40_12$1
XFILLER_18_321 vssd1 vccd1 vccd1 vssd1 sky130_ef_sc_hd__decap_40_12$1
XFILLER_46_641 vssd1 vccd1 vccd1 vssd1 sky130_fd_sc_hd__fill_2$1
XFILLER_65_93 vssd1 vccd1 vccd1 vssd1 sky130_ef_sc_hd__decap_40_12$1
XFILLER_18_365 vssd1 vccd1 vccd1 vssd1 sky130_ef_sc_hd__decap_40_12$1
XTAP_TAPCELL_ROW_47_1003 vccd1 vssd1 sky130_fd_sc_hd__tapvpwrvgnd_1$1
XFILLER_60_121 vssd1 vccd1 vccd1 vssd1 sky130_ef_sc_hd__decap_40_12$1
XTAP_TAPCELL_ROW_16_533 vccd1 vssd1 sky130_fd_sc_hd__tapvpwrvgnd_1$1
XFILLER_33_335 vccd1 vssd1 vccd1 vssd1 sky130_fd_sc_hd__fill_1$1
XFILLER_60_165 vssd1 vccd1 vccd1 vssd1 sky130_ef_sc_hd__decap_40_12$1
XTAP_TAPCELL_ROW_16_544 vccd1 vssd1 sky130_fd_sc_hd__tapvpwrvgnd_1$1
XFILLER_81_81 vssd1 vccd1 vccd1 vssd1 sky130_ef_sc_hd__decap_40_12$1
XTAP_TAPCELL_ROW_60_1203 vccd1 vssd1 sky130_fd_sc_hd__tapvpwrvgnd_1$1
X_0922_ _0752_/A _1504_/D _0919_/X _1465_/C1 _1504_/Q _0921_/X vssd1 vccd1 vccd1 vssd1
+ sky130_fd_sc_hd__o221a_1$1
XFILLER_119_429 vccd1 vssd1 vccd1 vssd1 sky130_fd_sc_hd__fill_1$1
X_0853_ _1807_/A hold10/A _0853_/X _1653_/Q _1213_/A vccd1 vssd1 vccd1 vssd1 sky130_fd_sc_hd__a22o_1$1
XFILLER_60_3 vssd1 vccd1 vccd1 vssd1 sky130_ef_sc_hd__decap_40_12$1
XFILLER_6_781 vssd1 vccd1 vccd1 vssd1 sky130_ef_sc_hd__decap_40_12$1
X_0784_ _1796_/A _0879_/A2 _0784_/X input8/X _0784_/B1 vccd1 vssd1 vccd1 vssd1 sky130_fd_sc_hd__a22o_1$1
XTAP_TAPCELL_ROW_58_1176 vccd1 vssd1 sky130_fd_sc_hd__tapvpwrvgnd_1$1
XTAP_TAPCELL_ROW_58_1165 vccd1 vssd1 sky130_fd_sc_hd__tapvpwrvgnd_1$1
XFILLER_130_616 vssd1 vccd1 vccd1 vssd1 sky130_ef_sc_hd__decap_40_12$1
XFILLER_102_307 vccd1 vssd1 vccd1 vssd1 sky130_fd_sc_hd__fill_1$1
XFILLER_69_711 vssd1 vccd1 vccd1 vssd1 sky130_ef_sc_hd__decap_40_12$1
X_1405_ _1471_/C1 _1404_/X _1409_/A2 hold109/X _1730_/D vssd1 vccd1 vccd1 vssd1 sky130_fd_sc_hd__o211a_1$1
XFILLER_114_189 vssd1 vccd1 vccd1 vssd1 sky130_fd_sc_hd__fill_4$1
XFILLER_111_841 vccd1 vssd1 vccd1 vssd1 sky130_fd_sc_hd__fill_1$1
XFILLER_96_530 vssd1 vccd1 vccd1 vssd1 sky130_fd_sc_hd__fill_2$1
XFILLER_68_221 vssd1 vccd1 vccd1 vssd1 sky130_ef_sc_hd__decap_40_12$1
X_1336_ hold52/X _1336_/X _1342_/B vssd1 vccd1 vccd1 vssd1 sky130_fd_sc_hd__or2_1$1
XFILLER_96_541 vssd1 vccd1 vccd1 vssd1 sky130_ef_sc_hd__decap_40_12$1
XTAP_TAPCELL_ROW_71_1365 vccd1 vssd1 sky130_fd_sc_hd__tapvpwrvgnd_1$1
XFILLER_69_777 vccd1 vssd1 vccd1 vssd1 sky130_fd_sc_hd__fill_1$1
XFILLER_68_265 vssd1 vccd1 vccd1 vssd1 sky130_ef_sc_hd__decap_40_12$1
XFILLER_96_585 vssd1 vccd1 vccd1 vssd1 sky130_fd_sc_hd__fill_2$1
XFILLER_84_725 vssd1 vccd1 vccd1 vssd1 sky130_ef_sc_hd__decap_40_12$1
Xinput1 input1/X adc_data[0] vssd1 vccd1 vccd1 vssd1 sky130_fd_sc_hd__clkbuf_4$1
X_1267_ _1437_/C1 _1266_/X _1273_/A2 hold83/X _1663_/D vssd1 vccd1 vccd1 vssd1 sky130_fd_sc_hd__o211a_1$1
XFILLER_84_769 vssd1 vccd1 vccd1 vssd1 sky130_ef_sc_hd__decap_40_12$1
XFILLER_37_641 vssd1 vccd1 vccd1 vssd1 sky130_ef_sc_hd__decap_40_12$1
X_1198_ _1198_/A _1198_/X _1210_/B vssd1 vccd1 vccd1 vssd1 sky130_fd_sc_hd__or2_1$1
XFILLER_83_279 vccd1 vssd1 vccd1 vssd1 sky130_fd_sc_hd__fill_1$1
XFILLER_64_460 vssd1 vccd1 vccd1 vssd1 sky130_ef_sc_hd__decap_40_12$1
XFILLER_37_685 vssd1 vccd1 vccd1 vssd1 sky130_fd_sc_hd__fill_8$1
XFILLER_52_633 vccd1 vssd1 vccd1 vssd1 sky130_fd_sc_hd__fill_1$1
XTAP_TAPCELL_ROW_35_820 vccd1 vssd1 sky130_fd_sc_hd__tapvpwrvgnd_1$1
XTAP_TAPCELL_ROW_35_831 vccd1 vssd1 sky130_fd_sc_hd__tapvpwrvgnd_1$1
XFILLER_36_195 vccd1 vssd1 vccd1 vssd1 sky130_fd_sc_hd__fill_1$1
XFILLER_24_357 vssd1 vccd1 vccd1 vssd1 sky130_fd_sc_hd__fill_4$1
XFILLER_101_69 vssd1 vccd1 vccd1 vssd1 sky130_ef_sc_hd__decap_40_12$1
XFILLER_51_165 vssd1 vccd1 vccd1 vssd1 sky130_fd_sc_hd__fill_2$1
XFILLER_138_727 vccd1 vssd1 vccd1 vssd1 sky130_fd_sc_hd__fill_1$1
XFILLER_20_585 vssd1 vccd1 vccd1 vssd1 sky130_fd_sc_hd__fill_2$1
XFILLER_118_451 vccd1 vssd1 vccd1 vssd1 sky130_fd_sc_hd__fill_1$1
XFILLER_3_217 vssd1 vccd1 vccd1 vssd1 sky130_fd_sc_hd__fill_4$1
XFILLER_133_432 vccd1 vssd1 vccd1 vssd1 sky130_fd_sc_hd__fill_1$1
XFILLER_121_605 vssd1 vccd1 vccd1 vssd1 sky130_fd_sc_hd__fill_2$1
XFILLER_106_679 vssd1 vccd1 vccd1 vssd1 sky130_ef_sc_hd__decap_40_12$1
XFILLER_105_167 vccd1 vssd1 vccd1 vssd1 sky130_fd_sc_hd__fill_1$1
XFILLER_10_77 vssd1 vccd1 vccd1 vssd1 sky130_fd_sc_hd__fill_4$1
XFILLER_126_77 vssd1 vccd1 vccd1 vssd1 sky130_fd_sc_hd__fill_4$1
XFILLER_120_137 vssd1 vccd1 vccd1 vssd1 sky130_fd_sc_hd__fill_2$1
XFILLER_114_690 vssd1 vccd1 vccd1 vssd1 sky130_fd_sc_hd__fill_8$1
XFILLER_86_15 vssd1 vccd1 vccd1 vssd1 sky130_ef_sc_hd__decap_40_12$1
XFILLER_59_221 vssd1 vccd1 vccd1 vssd1 sky130_fd_sc_hd__fill_2$1
XFILLER_101_373 vssd1 vccd1 vccd1 vssd1 sky130_ef_sc_hd__decap_40_12$1
XTAP_TAPCELL_ROW_89_1637 vccd1 vssd1 sky130_fd_sc_hd__tapvpwrvgnd_1$1
XFILLER_47_405 vssd1 vccd1 vccd1 vssd1 sky130_ef_sc_hd__decap_40_12$1
XFILLER_28_641 vssd1 vccd1 vccd1 vssd1 sky130_fd_sc_hd__fill_2$1
XFILLER_47_449 vssd1 vccd1 vccd1 vssd1 sky130_ef_sc_hd__decap_40_12$1
XFILLER_62_419 vccd1 vssd1 vccd1 vssd1 sky130_fd_sc_hd__fill_1$1
XFILLER_16_825 vccd1 vssd1 vccd1 vssd1 sky130_fd_sc_hd__fill_1$1
XFILLER_15_335 vccd1 vssd1 vccd1 vssd1 sky130_fd_sc_hd__fill_1$1
XFILLER_42_121 vssd1 vccd1 vccd1 vssd1 sky130_ef_sc_hd__decap_40_12$1
XTAP_TAPCELL_ROW_100_1804 vccd1 vssd1 sky130_fd_sc_hd__tapvpwrvgnd_1$1
XFILLER_30_305 vssd1 vccd1 vccd1 vssd1 sky130_fd_sc_hd__fill_2$1
XFILLER_42_165 vssd1 vccd1 vccd1 vssd1 sky130_ef_sc_hd__decap_40_12$1
XFILLER_129_727 vccd1 vssd1 vccd1 vssd1 sky130_fd_sc_hd__fill_1$1
XFILLER_11_541 vssd1 vccd1 vccd1 vssd1 sky130_ef_sc_hd__decap_40_12$1
XFILLER_51_51 vssd1 vccd1 vccd1 vssd1 sky130_fd_sc_hd__fill_4$1
XFILLER_11_585 vssd1 vccd1 vccd1 vssd1 sky130_ef_sc_hd__decap_40_12$1
XFILLER_7_501 vssd1 vccd1 vccd1 vssd1 sky130_fd_sc_hd__fill_2$1
XFILLER_124_421 vssd1 vccd1 vccd1 vssd1 sky130_ef_sc_hd__decap_40_12$1
XFILLER_97_305 vssd1 vccd1 vccd1 vssd1 sky130_ef_sc_hd__decap_40_12$1
XFILLER_97_349 vssd1 vccd1 vccd1 vssd1 sky130_ef_sc_hd__decap_40_12$1
XTAP_TAPCELL_ROW_111_1966 vccd1 vssd1 sky130_fd_sc_hd__tapvpwrvgnd_1$1
XFILLER_111_137 vssd1 vccd1 vccd1 vssd1 sky130_ef_sc_hd__decap_40_12$1
XFILLER_78_585 vssd1 vccd1 vccd1 vssd1 sky130_fd_sc_hd__fill_2$1
XTAP_TAPCELL_ROW_53_1095 vccd1 vssd1 sky130_fd_sc_hd__tapvpwrvgnd_1$1
X_1121_ _1455_/C1 _1120_/X _1145_/A2 hold120/X _1592_/D vssd1 vccd1 vccd1 vssd1 sky130_fd_sc_hd__o211a_1$1
XFILLER_76_81 vssd1 vccd1 vccd1 vssd1 sky130_fd_sc_hd__fill_2$1
XFILLER_66_769 vssd1 vccd1 vccd1 vssd1 sky130_ef_sc_hd__decap_40_12$1
XFILLER_19_641 vssd1 vccd1 vccd1 vssd1 sky130_ef_sc_hd__decap_40_12$1
XFILLER_81_717 vssd1 vccd1 vccd1 vssd1 sky130_fd_sc_hd__fill_2$1
XFILLER_65_279 vccd1 vssd1 vccd1 vssd1 sky130_fd_sc_hd__fill_1$1
X_1052_ _1052_/A _1052_/X _1052_/B vssd1 vccd1 vccd1 vssd1 sky130_fd_sc_hd__or2_1$1
XFILLER_19_685 vssd1 vccd1 vccd1 vssd1 sky130_ef_sc_hd__decap_40_12$1
XFILLER_80_249 vssd1 vccd1 vccd1 vssd1 sky130_fd_sc_hd__fill_2$1
XFILLER_18_195 vccd1 vssd1 vccd1 vssd1 sky130_fd_sc_hd__fill_1$1
XFILLER_34_622 vssd1 vccd1 vccd1 vssd1 sky130_ef_sc_hd__decap_40_12$1
XFILLER_61_485 vssd1 vccd1 vccd1 vssd1 sky130_ef_sc_hd__decap_40_12$1
XFILLER_21_305 vssd1 vccd1 vccd1 vssd1 sky130_ef_sc_hd__decap_40_12$1
XFILLER_33_165 vssd1 vccd1 vccd1 vssd1 sky130_fd_sc_hd__fill_2$1
XFILLER_21_349 vssd1 vccd1 vccd1 vssd1 sky130_ef_sc_hd__decap_40_12$1
XFILLER_119_237 vssd1 vccd1 vccd1 vssd1 sky130_ef_sc_hd__decap_40_12$1
X_0905_ _1726_/Q _1345_/A _0905_/X _1566_/Q _0753_/X vccd1 vssd1 vccd1 vssd1 sky130_fd_sc_hd__a22o_1$1
X_0836_ _0879_/B1 _0836_/X _0835_/X hold28/A _0875_/A2 _0834_/X vssd1 vccd1 vccd1
+ vssd1 sky130_fd_sc_hd__a2111o_1$1
XFILLER_127_281 vssd1 vccd1 vccd1 vssd1 sky130_ef_sc_hd__decap_40_12$1
X_0767_ _0767_/X _0881_/B1 _1794_/A _1843_/A _0878_/A2 vssd1 vccd1 _0766_/X vccd1
+ vssd1 sky130_fd_sc_hd__a221o_1$1
XFILLER_88_305 vssd1 vccd1 vccd1 vssd1 sky130_fd_sc_hd__fill_2$1
XFILLER_0_209 vssd1 vccd1 vccd1 vssd1 sky130_ef_sc_hd__decap_40_12$1
XFILLER_130_413 vssd1 vccd1 vccd1 vssd1 sky130_fd_sc_hd__fill_4$1
XPHY_EDGE_ROW_102_Left_241 vccd1 vssd1 vccd1 vssd1 sky130_fd_sc_hd__decap_3$1
XFILLER_102_137 vssd1 vccd1 vccd1 vssd1 sky130_fd_sc_hd__fill_2$1
XFILLER_111_682 vssd1 vccd1 vccd1 vssd1 sky130_fd_sc_hd__fill_4$1
XFILLER_111_671 vccd1 vssd1 vccd1 vssd1 sky130_fd_sc_hd__fill_1$1
XFILLER_69_585 vssd1 vccd1 vccd1 vssd1 sky130_ef_sc_hd__decap_40_12$1
XFILLER_57_725 vssd1 vccd1 vccd1 vssd1 sky130_fd_sc_hd__fill_2$1
XFILLER_56_29 vssd1 vccd1 vccd1 vssd1 sky130_ef_sc_hd__decap_40_12$1
XFILLER_29_405 vssd1 vccd1 vccd1 vssd1 sky130_ef_sc_hd__decap_40_12$1
X_1319_ _1319_/C1 _1318_/X _1331_/A2 hold120/X _1688_/D vssd1 vccd1 vccd1 vssd1 sky130_fd_sc_hd__o211a_1$1
XFILLER_84_533 vssd1 vccd1 vccd1 vssd1 sky130_fd_sc_hd__fill_8$1
XFILLER_57_769 vssd1 vccd1 vccd1 vssd1 sky130_ef_sc_hd__decap_40_12$1
XFILLER_29_449 vssd1 vccd1 vccd1 vssd1 sky130_ef_sc_hd__decap_40_12$1
XFILLER_71_205 vssd1 vccd1 vccd1 vssd1 sky130_ef_sc_hd__decap_40_12$1
XFILLER_44_419 vccd1 vssd1 vccd1 vssd1 sky130_fd_sc_hd__fill_1$1
XFILLER_71_249 vssd1 vccd1 vccd1 vssd1 sky130_ef_sc_hd__decap_40_12$1
XTAP_TAPCELL_ROW_84_1567 vccd1 vssd1 sky130_fd_sc_hd__tapvpwrvgnd_1$1
XTAP_TAPCELL_ROW_84_1556 vccd1 vssd1 sky130_fd_sc_hd__tapvpwrvgnd_1$1
XFILLER_24_121 vssd1 vccd1 vccd1 vssd1 sky130_ef_sc_hd__decap_40_12$1
XPHY_EDGE_ROW_111_Left_250 vccd1 vssd1 vccd1 vssd1 sky130_fd_sc_hd__decap_3$1
XFILLER_52_474 vssd1 vccd1 vccd1 vssd1 sky130_fd_sc_hd__fill_2$1
XFILLER_12_305 vssd1 vccd1 vccd1 vssd1 sky130_fd_sc_hd__fill_2$1
XFILLER_24_165 vssd1 vccd1 vccd1 vssd1 sky130_ef_sc_hd__decap_40_12$1
XFILLER_8_309 vssd1 vccd1 vccd1 vssd1 sky130_ef_sc_hd__decap_40_12$1
XFILLER_138_557 vssd1 vccd1 vccd1 vssd1 sky130_fd_sc_hd__fill_2$1
XTAP_TAPCELL_ROW_115_2022 vccd1 vssd1 sky130_fd_sc_hd__tapvpwrvgnd_1$1
XFILLER_108_3 vssd1 vccd1 vccd1 vssd1 sky130_ef_sc_hd__decap_40_12$1
XFILLER_106_410 vssd1 vccd1 vccd1 vssd1 sky130_fd_sc_hd__fill_8$1
XFILLER_134_752 vssd1 vccd1 vccd1 vssd1 sky130_fd_sc_hd__fill_4$1
XFILLER_79_305 vssd1 vccd1 vccd1 vssd1 sky130_ef_sc_hd__decap_40_12$1
XFILLER_133_273 vssd1 vccd1 vccd1 vssd1 sky130_fd_sc_hd__fill_4$1
XFILLER_121_435 vssd1 vccd1 vccd1 vssd1 sky130_fd_sc_hd__fill_4$1
XFILLER_97_69 vssd1 vccd1 vccd1 vssd1 sky130_ef_sc_hd__decap_40_12$1
XFILLER_79_349 vssd1 vccd1 vccd1 vssd1 sky130_ef_sc_hd__decap_40_12$1
Xoutput190 _1504_/Q wbs_dat_o[27] vssd1 vccd1 vccd1 vssd1 sky130_fd_sc_hd__buf_12$1
XFILLER_48_725 vssd1 vccd1 vccd1 vssd1 sky130_ef_sc_hd__decap_40_12$1
XFILLER_102_693 vssd1 vccd1 vccd1 vssd1 sky130_fd_sc_hd__fill_4$1
XFILLER_101_181 vssd1 vccd1 vccd1 vssd1 sky130_ef_sc_hd__decap_40_12$1
XFILLER_87_393 vssd1 vccd1 vccd1 vssd1 sky130_ef_sc_hd__decap_40_12$1
XTAP_TAPCELL_ROW_126_2184 vccd1 vssd1 sky130_fd_sc_hd__tapvpwrvgnd_1$1
XFILLER_47_279 vccd1 vssd1 vccd1 vssd1 sky130_fd_sc_hd__fill_1$1
XTAP_TAPCELL_ROW_126_2195 vccd1 vssd1 sky130_fd_sc_hd__tapvpwrvgnd_1$1
XFILLER_62_249 vssd1 vccd1 vccd1 vssd1 sky130_fd_sc_hd__fill_2$1
XFILLER_43_441 vssd1 vccd1 vccd1 vssd1 sky130_fd_sc_hd__fill_4$1
XFILLER_15_165 vssd1 vccd1 vccd1 vssd1 sky130_fd_sc_hd__fill_2$1
XFILLER_16_699 vccd1 vssd1 vccd1 vssd1 sky130_fd_sc_hd__fill_1$1
XTAP_TAPCELL_ROW_26_683 vccd1 vssd1 sky130_fd_sc_hd__tapvpwrvgnd_1$1
XTAP_TAPCELL_ROW_26_694 vccd1 vssd1 sky130_fd_sc_hd__tapvpwrvgnd_1$1
XFILLER_31_669 vssd1 vccd1 vccd1 vssd1 sky130_fd_sc_hd__fill_2$1
XFILLER_62_83 vccd1 vssd1 vccd1 vssd1 sky130_fd_sc_hd__fill_1$1
XFILLER_11_393 vssd1 vccd1 vccd1 vssd1 sky130_ef_sc_hd__decap_40_12$1
X_1670_ _1838_/A _1738_/CLK _1670_/D vccd1 vssd1 vccd1 vssd1 sky130_fd_sc_hd__dfxtp_1$1
XFILLER_109_281 vssd1 vccd1 vccd1 vssd1 sky130_ef_sc_hd__decap_40_12$1
XFILLER_125_785 vssd1 vccd1 vccd1 vssd1 sky130_fd_sc_hd__fill_4$1
XFILLER_124_251 vccd1 vssd1 vccd1 vssd1 sky130_fd_sc_hd__fill_1$1
XTAP_TAPCELL_ROW_55_1124 vccd1 vssd1 sky130_fd_sc_hd__tapvpwrvgnd_1$1
XFILLER_112_402 vssd1 vccd1 vccd1 vssd1 sky130_fd_sc_hd__fill_8$1
XFILLER_97_113 vssd1 vccd1 vccd1 vssd1 sky130_ef_sc_hd__decap_40_12$1
XFILLER_98_669 vssd1 vccd1 vccd1 vssd1 sky130_fd_sc_hd__fill_4$1
XFILLER_23_3 vssd1 vccd1 vccd1 vssd1 sky130_ef_sc_hd__decap_40_12$1
XFILLER_66_533 vssd1 vccd1 vccd1 vssd1 sky130_ef_sc_hd__decap_40_12$1
XFILLER_81_503 vccd1 vssd1 vccd1 vssd1 sky130_fd_sc_hd__fill_1$1
XFILLER_53_205 vssd1 vccd1 vccd1 vssd1 sky130_ef_sc_hd__decap_40_12$1
XFILLER_26_419 vccd1 vssd1 vccd1 vssd1 sky130_fd_sc_hd__fill_1$1
X_1104_ _1802_/A _1104_/X _1122_/B vssd1 vccd1 vccd1 vssd1 sky130_fd_sc_hd__or2_1$1
X_1035_ _1431_/C1 _1034_/X _1053_/A2 hold155/X _1550_/D vssd1 vccd1 vccd1 vssd1 sky130_fd_sc_hd__o211a_1$1
XFILLER_53_249 vssd1 vccd1 vccd1 vssd1 sky130_ef_sc_hd__decap_40_12$1
XTAP_TAPCELL_ROW_66_1297 vccd1 vssd1 sky130_fd_sc_hd__tapvpwrvgnd_1$1
XTAP_TAPCELL_ROW_66_1286 vccd1 vssd1 sky130_fd_sc_hd__tapvpwrvgnd_1$1
XFILLER_22_625 vssd1 vccd1 vccd1 vssd1 sky130_ef_sc_hd__decap_40_12$1
XTAP_TAPCELL_ROW_45_970 vccd1 vssd1 sky130_fd_sc_hd__tapvpwrvgnd_1$1
XTAP_TAPCELL_ROW_45_981 vccd1 vssd1 sky130_fd_sc_hd__tapvpwrvgnd_1$1
XFILLER_61_293 vssd1 vccd1 vccd1 vssd1 sky130_ef_sc_hd__decap_40_12$1
XFILLER_10_809 vssd1 vccd1 vccd1 vssd1 sky130_fd_sc_hd__fill_2$1
XFILLER_21_113 vssd1 vccd1 vccd1 vssd1 sky130_ef_sc_hd__decap_40_12$1
XFILLER_22_669 vssd1 vccd1 vccd1 vssd1 sky130_ef_sc_hd__decap_40_12$1
XFILLER_135_505 vssd1 vccd1 vccd1 vssd1 sky130_ef_sc_hd__decap_40_12$1
X_0819_ _0880_/A2 _1487_/D _0815_/X _1431_/C1 _1487_/Q _0818_/X vssd1 vccd1 vccd1
+ vssd1 sky130_fd_sc_hd__o221a_1$1
X_1799_ _1799_/A _1799_/X vssd1 vccd1 vccd1 vssd1 sky130_fd_sc_hd__clkbuf_2$1
XFILLER_116_796 vssd1 vccd1 vccd1 vssd1 sky130_fd_sc_hd__fill_8$1
XFILLER_115_273 vssd1 vccd1 vccd1 vssd1 sky130_fd_sc_hd__fill_4$1
XFILLER_107_57 vssd1 vccd1 vccd1 vssd1 sky130_ef_sc_hd__decap_40_12$1
XFILLER_103_413 vssd1 vccd1 vccd1 vssd1 sky130_fd_sc_hd__fill_2$1
XFILLER_1_529 vssd1 vccd1 vccd1 vssd1 sky130_ef_sc_hd__decap_40_12$1
XFILLER_130_221 vssd1 vccd1 vccd1 vssd1 sky130_ef_sc_hd__decap_40_12$1
XFILLER_103_457 vssd1 vccd1 vccd1 vssd1 sky130_fd_sc_hd__fill_2$1
XFILLER_67_39 vssd1 vccd1 vccd1 vssd1 sky130_ef_sc_hd__decap_40_12$1
XFILLER_130_265 vssd1 vccd1 vccd1 vssd1 sky130_ef_sc_hd__decap_40_12$1
XFILLER_69_393 vssd1 vccd1 vccd1 vssd1 sky130_ef_sc_hd__decap_40_12$1
XTAP_TAPCELL_ROW_4_367 vccd1 vssd1 sky130_fd_sc_hd__tapvpwrvgnd_1$1
XTAP_TAPCELL_ROW_4_356 vccd1 vssd1 sky130_fd_sc_hd__tapvpwrvgnd_1$1
XFILLER_84_363 vccd1 vssd1 vccd1 vssd1 sky130_fd_sc_hd__fill_1$1
XFILLER_57_588 vssd1 vccd1 vccd1 vssd1 sky130_fd_sc_hd__fill_4$1
XFILLER_29_279 vccd1 vssd1 vccd1 vssd1 sky130_fd_sc_hd__fill_1$1
XFILLER_45_706 vssd1 vccd1 vccd1 vssd1 sky130_ef_sc_hd__decap_40_12$1
Xclkbuf_leaf_8_wb_clk_i _1755_/CLK clkbuf_leaf_9_wb_clk_i/A vssd1 vccd1 vccd1 vssd1
+ sky130_fd_sc_hd__clkbuf_8$1
XFILLER_83_27 vssd1 vccd1 vccd1 vssd1 sky130_ef_sc_hd__decap_40_12$1
XFILLER_60_709 vssd1 vccd1 vccd1 vssd1 sky130_ef_sc_hd__decap_40_12$1
XFILLER_25_441 vssd1 vccd1 vccd1 vssd1 sky130_fd_sc_hd__fill_4$1
XFILLER_44_249 vssd1 vccd1 vccd1 vssd1 sky130_fd_sc_hd__fill_2$1
XFILLER_80_580 vssd1 vccd1 vccd1 vssd1 sky130_fd_sc_hd__fill_8$1
XFILLER_53_783 vccd1 vssd1 vccd1 vssd1 sky130_fd_sc_hd__fill_1$1
XFILLER_16_65 vssd1 vccd1 vccd1 vssd1 sky130_ef_sc_hd__decap_40_12$1
XFILLER_25_485 vssd1 vccd1 vccd1 vssd1 sky130_ef_sc_hd__decap_40_12$1
XFILLER_40_433 vssd1 vccd1 vccd1 vssd1 sky130_ef_sc_hd__decap_40_12$1
XFILLER_9_629 vssd1 vccd1 vccd1 vssd1 sky130_ef_sc_hd__decap_40_12$1
XFILLER_13_669 vssd1 vccd1 vccd1 vssd1 sky130_fd_sc_hd__fill_2$1
XTAP_TAPCELL_ROW_23_642 vccd1 vssd1 sky130_fd_sc_hd__tapvpwrvgnd_1$1
XFILLER_40_477 vssd1 vccd1 vccd1 vssd1 sky130_ef_sc_hd__decap_40_12$1
XFILLER_8_139 vccd1 vssd1 vccd1 vssd1 sky130_fd_sc_hd__fill_1$1
XFILLER_32_53 vssd1 vccd1 vccd1 vssd1 sky130_ef_sc_hd__decap_40_12$1
XTAP_TAPCELL_ROW_97_1758 vccd1 vssd1 sky130_fd_sc_hd__tapvpwrvgnd_1$1
XFILLER_32_97 vssd1 vccd1 vccd1 vssd1 sky130_ef_sc_hd__decap_40_12$1
XFILLER_107_741 vssd1 vccd1 vccd1 vssd1 sky130_ef_sc_hd__decap_40_12$1
XFILLER_4_301 vssd1 vccd1 vccd1 vssd1 sky130_fd_sc_hd__fill_4$1
XFILLER_106_251 vccd1 vssd1 vccd1 vssd1 sky130_fd_sc_hd__fill_1$1
XFILLER_4_345 vssd1 vccd1 vccd1 vssd1 sky130_ef_sc_hd__decap_40_12$1
XFILLER_107_785 vssd1 vccd1 vccd1 vssd1 sky130_ef_sc_hd__decap_40_12$1
XFILLER_79_113 vssd1 vccd1 vccd1 vssd1 sky130_ef_sc_hd__decap_40_12$1
XFILLER_4_389 vssd1 vccd1 vccd1 vssd1 sky130_ef_sc_hd__decap_40_12$1
XFILLER_122_755 vccd1 vssd1 vccd1 vssd1 sky130_fd_sc_hd__fill_1$1
XFILLER_121_221 vssd1 vccd1 vccd1 vssd1 sky130_fd_sc_hd__fill_2$1
XTAP_TAPCELL_ROW_128_2224 vccd1 vssd1 sky130_fd_sc_hd__tapvpwrvgnd_1$1
XTAP_TAPCELL_ROW_128_2213 vccd1 vssd1 sky130_fd_sc_hd__tapvpwrvgnd_1$1
XFILLER_95_617 vssd1 vccd1 vccd1 vssd1 sky130_fd_sc_hd__fill_8$1
XFILLER_0_573 vssd1 vccd1 vccd1 vssd1 sky130_ef_sc_hd__decap_40_12$1
XTAP_TAPCELL_ROW_50_1054 vccd1 vssd1 sky130_fd_sc_hd__tapvpwrvgnd_1$1
XTAP_TAPCELL_ROW_50_1043 vccd1 vssd1 sky130_fd_sc_hd__tapvpwrvgnd_1$1
XFILLER_63_503 vccd1 vssd1 vccd1 vssd1 sky130_fd_sc_hd__fill_1$1
XFILLER_91_823 vccd1 vssd1 vccd1 vssd1 sky130_fd_sc_hd__fill_1$1
XFILLER_75_385 vssd1 vccd1 vccd1 vssd1 sky130_fd_sc_hd__fill_4$1
XFILLER_35_205 vssd1 vccd1 vccd1 vssd1 sky130_ef_sc_hd__decap_40_12$1
XFILLER_90_333 vssd1 vccd1 vccd1 vssd1 sky130_ef_sc_hd__decap_40_12$1
XFILLER_63_558 vssd1 vccd1 vccd1 vssd1 sky130_fd_sc_hd__fill_2$1
XFILLER_35_249 vssd1 vccd1 vccd1 vssd1 sky130_ef_sc_hd__decap_40_12$1
XFILLER_44_750 vssd1 vccd1 vccd1 vssd1 sky130_fd_sc_hd__fill_4$1
XTAP_TAPCELL_ROW_106_1887 vccd1 vssd1 sky130_fd_sc_hd__tapvpwrvgnd_1$1
XFILLER_90_399 vssd1 vccd1 vccd1 vssd1 sky130_ef_sc_hd__decap_40_12$1
XFILLER_90_377 vssd1 vccd1 vccd1 vssd1 sky130_fd_sc_hd__fill_8$1
XFILLER_73_93 vssd1 vccd1 vccd1 vssd1 sky130_ef_sc_hd__decap_40_12$1
XFILLER_71_580 vssd1 vccd1 vccd1 vssd1 sky130_ef_sc_hd__decap_40_12$1
XFILLER_43_293 vssd1 vccd1 vccd1 vssd1 sky130_ef_sc_hd__decap_40_12$1
XFILLER_117_505 vssd1 vccd1 vccd1 vssd1 sky130_fd_sc_hd__fill_4$1
X_1722_ _1722_/Q _1729_/CLK _1722_/D vccd1 vssd1 vccd1 vssd1 sky130_fd_sc_hd__dfxtp_1$1
Xhold106 wbs_dat_i[21] input33/A vssd1 vccd1 vccd1 vssd1 sky130_fd_sc_hd__dlygate4sd3_1$1
Xhold117 _1633_/Q _1204_/A vssd1 vccd1 vccd1 vssd1 sky130_fd_sc_hd__dlygate4sd3_1$1
X_1653_ _1653_/Q _1720_/CLK _1653_/D vccd1 vssd1 vccd1 vssd1 sky130_fd_sc_hd__dfxtp_2$1
XFILLER_7_161 vssd1 vccd1 vccd1 vssd1 sky130_fd_sc_hd__fill_4$1
Xhold128 _1752_/Q _1450_/A vssd1 vccd1 vccd1 vssd1 sky130_fd_sc_hd__dlygate4sd3_1$1
Xhold139 _1561_/Q _1056_/A vssd1 vccd1 vccd1 vssd1 sky130_fd_sc_hd__dlygate4sd3_1$1
XPHY_EDGE_ROW_9_Right_9 vccd1 vssd1 vccd1 vssd1 sky130_fd_sc_hd__decap_3$1
XFILLER_125_571 vccd1 vssd1 vccd1 vssd1 sky130_fd_sc_hd__fill_1$1
X_1584_ _1802_/A _1585_/CLK _1584_/D vccd1 vssd1 vccd1 vssd1 sky130_fd_sc_hd__dfxtp_1$1
XFILLER_112_221 vssd1 vccd1 vccd1 vssd1 sky130_ef_sc_hd__decap_40_12$1
XFILLER_98_433 vssd1 vccd1 vccd1 vssd1 sky130_ef_sc_hd__decap_40_12$1
XFILLER_113_777 vssd1 vccd1 vccd1 vssd1 sky130_fd_sc_hd__fill_4$1
XFILLER_112_265 vssd1 vccd1 vccd1 vssd1 sky130_ef_sc_hd__decap_40_12$1
XPHY_EDGE_ROW_107_Right_107 vccd1 vssd1 vccd1 vssd1 sky130_fd_sc_hd__decap_3$1
XFILLER_98_477 vssd1 vccd1 vccd1 vssd1 sky130_ef_sc_hd__decap_40_12$1
XFILLER_85_105 vssd1 vccd1 vccd1 vssd1 sky130_fd_sc_hd__fill_4$1
XFILLER_85_149 vssd1 vccd1 vccd1 vssd1 sky130_ef_sc_hd__decap_40_12$1
XFILLER_66_363 vccd1 vssd1 vccd1 vssd1 sky130_fd_sc_hd__fill_1$1
XTAP_TAPCELL_ROW_1_315 vccd1 vssd1 sky130_fd_sc_hd__tapvpwrvgnd_1$1
XTAP_TAPCELL_ROW_68_1326 vccd1 vssd1 sky130_fd_sc_hd__tapvpwrvgnd_1$1
XTAP_TAPCELL_ROW_68_1315 vccd1 vssd1 sky130_fd_sc_hd__tapvpwrvgnd_1$1
XFILLER_66_385 vssd1 vccd1 vccd1 vssd1 sky130_fd_sc_hd__fill_2$1
XFILLER_54_525 vssd1 vccd1 vccd1 vssd1 sky130_fd_sc_hd__fill_4$1
XFILLER_93_193 vssd1 vccd1 vccd1 vssd1 sky130_ef_sc_hd__decap_40_12$1
XFILLER_81_333 vssd1 vccd1 vccd1 vssd1 sky130_fd_sc_hd__fill_2$1
XFILLER_54_569 vccd1 vssd1 vccd1 vssd1 sky130_fd_sc_hd__fill_1$1
XFILLER_26_249 vssd1 vccd1 vccd1 vssd1 sky130_fd_sc_hd__fill_2$1
XTAP_TAPCELL_ROW_81_1515 vccd1 vssd1 sky130_fd_sc_hd__tapvpwrvgnd_1$1
X_1018_ _1773_/A _1018_/X _1052_/B vssd1 vccd1 vccd1 vssd1 sky130_fd_sc_hd__or2_1$1
XFILLER_35_772 vssd1 vccd1 vccd1 vssd1 sky130_ef_sc_hd__decap_40_12$1
XFILLER_22_433 vssd1 vccd1 vccd1 vssd1 sky130_ef_sc_hd__decap_40_12$1
XFILLER_50_775 vssd1 vccd1 vccd1 vssd1 sky130_ef_sc_hd__decap_40_12$1
XFILLER_22_477 vssd1 vccd1 vccd1 vssd1 sky130_ef_sc_hd__decap_40_12$1
XTAP_TAPCELL_ROW_20_601 vccd1 vssd1 sky130_fd_sc_hd__tapvpwrvgnd_1$1
XFILLER_136_825 vssd1 vccd1 vccd1 vssd1 sky130_fd_sc_hd__fill_8$1
XFILLER_136_803 vssd1 vccd1 vccd1 vssd1 sky130_fd_sc_hd__fill_8$1
XFILLER_5_109 vssd1 vccd1 vccd1 vssd1 sky130_fd_sc_hd__fill_2$1
XFILLER_108_549 vccd1 vssd1 vccd1 vssd1 sky130_fd_sc_hd__fill_1$1
XTAP_TAPCELL_ROW_79_1488 vccd1 vssd1 sky130_fd_sc_hd__tapvpwrvgnd_1$1
XFILLER_2_805 vssd1 vccd1 vccd1 vssd1 sky130_fd_sc_hd__fill_4$1
XFILLER_104_722 vssd1 vccd1 vccd1 vssd1 sky130_fd_sc_hd__fill_4$1
XFILLER_89_400 vssd1 vccd1 vccd1 vssd1 sky130_ef_sc_hd__decap_40_12$1
XFILLER_78_27 vccd1 vssd1 vccd1 vssd1 sky130_fd_sc_hd__fill_1$1
XTAP_TAPCELL_ROW_9_437 vccd1 vssd1 sky130_fd_sc_hd__tapvpwrvgnd_1$1
XFILLER_131_541 vssd1 vccd1 vccd1 vssd1 sky130_ef_sc_hd__decap_40_12$1
XFILLER_103_221 vssd1 vccd1 vccd1 vssd1 sky130_fd_sc_hd__fill_2$1
XTAP_TAPCELL_ROW_92_1677 vccd1 vssd1 sky130_fd_sc_hd__tapvpwrvgnd_1$1
XFILLER_1_337 vssd1 vccd1 vccd1 vssd1 sky130_ef_sc_hd__decap_40_12$1
XFILLER_131_585 vssd1 vccd1 vccd1 vssd1 sky130_ef_sc_hd__decap_40_12$1
XFILLER_104_788 vssd1 vccd1 vccd1 vssd1 sky130_ef_sc_hd__decap_40_12$1
XFILLER_77_617 vssd1 vccd1 vccd1 vssd1 sky130_ef_sc_hd__decap_40_12$1
XFILLER_134_77 vssd1 vccd1 vccd1 vssd1 sky130_fd_sc_hd__fill_4$1
XFILLER_94_15 vssd1 vccd1 vccd1 vssd1 sky130_ef_sc_hd__decap_40_12$1
XFILLER_85_661 vssd1 vccd1 vccd1 vssd1 sky130_fd_sc_hd__fill_2$1
XFILLER_45_503 vccd1 vssd1 vccd1 vssd1 sky130_fd_sc_hd__fill_1$1
XFILLER_73_823 vccd1 vssd1 vccd1 vssd1 sky130_fd_sc_hd__fill_1$1
XFILLER_17_205 vssd1 vccd1 vccd1 vssd1 sky130_ef_sc_hd__decap_40_12$1
XTAP_TAPCELL_ROW_28_723 vccd1 vssd1 sky130_fd_sc_hd__tapvpwrvgnd_1$1
XTAP_TAPCELL_ROW_123_2143 vccd1 vssd1 sky130_fd_sc_hd__tapvpwrvgnd_1$1
XFILLER_84_193 vssd1 vccd1 vccd1 vssd1 sky130_fd_sc_hd__fill_2$1
XFILLER_72_333 vssd1 vccd1 vccd1 vssd1 sky130_ef_sc_hd__decap_40_12$1
XFILLER_17_249 vssd1 vccd1 vccd1 vssd1 sky130_ef_sc_hd__decap_40_12$1
XFILLER_60_528 vssd1 vccd1 vccd1 vssd1 sky130_fd_sc_hd__fill_4$1
XFILLER_25_293 vssd1 vccd1 vccd1 vssd1 sky130_ef_sc_hd__decap_40_12$1
XFILLER_41_797 vssd1 vccd1 vccd1 vssd1 sky130_fd_sc_hd__fill_2$1
XFILLER_126_357 vssd1 vccd1 vccd1 vssd1 sky130_fd_sc_hd__fill_4$1
XFILLER_5_665 vssd1 vccd1 vccd1 vssd1 sky130_fd_sc_hd__fill_4$1
XFILLER_4_153 vssd1 vccd1 vccd1 vssd1 sky130_ef_sc_hd__decap_40_12$1
XFILLER_107_593 vccd1 vssd1 vccd1 vssd1 sky130_fd_sc_hd__fill_1$1
XFILLER_4_197 vssd1 vccd1 vccd1 vssd1 sky130_ef_sc_hd__decap_40_12$1
XFILLER_110_714 vssd1 vccd1 vccd1 vssd1 sky130_ef_sc_hd__decap_40_12$1
XFILLER_67_105 vssd1 vccd1 vccd1 vssd1 sky130_fd_sc_hd__fill_4$1
XFILLER_67_149 vssd1 vccd1 vccd1 vssd1 sky130_ef_sc_hd__decap_40_12$1
XFILLER_110_769 vssd1 vccd1 vccd1 vssd1 sky130_ef_sc_hd__decap_40_12$1
XFILLER_95_469 vccd1 vssd1 vccd1 vssd1 sky130_fd_sc_hd__fill_1$1
XFILLER_83_609 vssd1 vccd1 vccd1 vssd1 sky130_fd_sc_hd__fill_4$1
XTAP_TAPCELL_ROW_108_1927 vccd1 vssd1 sky130_fd_sc_hd__tapvpwrvgnd_1$1
XTAP_TAPCELL_ROW_108_1916 vccd1 vssd1 sky130_fd_sc_hd__tapvpwrvgnd_1$1
XFILLER_36_525 vssd1 vccd1 vccd1 vssd1 sky130_fd_sc_hd__fill_4$1
XFILLER_48_363 vccd1 vssd1 vccd1 vssd1 sky130_fd_sc_hd__fill_1$1
XFILLER_91_653 vssd1 vccd1 vccd1 vssd1 sky130_ef_sc_hd__decap_40_12$1
XFILLER_90_141 vssd1 vccd1 vccd1 vssd1 sky130_ef_sc_hd__decap_40_12$1
XFILLER_84_81 vssd1 vccd1 vccd1 vssd1 sky130_fd_sc_hd__fill_2$1
XFILLER_75_193 vssd1 vccd1 vccd1 vssd1 sky130_ef_sc_hd__decap_40_12$1
XFILLER_63_333 vssd1 vccd1 vccd1 vssd1 sky130_fd_sc_hd__fill_2$1
XFILLER_36_569 vssd1 vccd1 vccd1 vssd1 sky130_ef_sc_hd__decap_40_12$1
XFILLER_51_517 vssd1 vccd1 vccd1 vssd1 sky130_ef_sc_hd__decap_40_12$1
XFILLER_17_783 vccd1 vssd1 vccd1 vssd1 sky130_fd_sc_hd__fill_1$1
XFILLER_90_3 vssd1 vccd1 vccd1 vssd1 sky130_ef_sc_hd__decap_40_12$1
XTAP_TAPCELL_ROW_63_1245 vccd1 vssd1 sky130_fd_sc_hd__tapvpwrvgnd_1$1
XFILLER_117_335 vccd1 vssd1 vccd1 vssd1 sky130_fd_sc_hd__fill_1$1
X_1705_ _1828_/A _1736_/CLK _1705_/D vccd1 vssd1 vccd1 vssd1 sky130_fd_sc_hd__dfxtp_1$1
XFILLER_132_305 vssd1 vccd1 vccd1 vssd1 sky130_fd_sc_hd__fill_2$1
X_1636_ _1636_/Q _1764_/CLK hold25/X vccd1 vssd1 vccd1 vssd1 sky130_fd_sc_hd__dfxtp_1$1
XFILLER_117_379 vssd1 vccd1 vccd1 vssd1 sky130_fd_sc_hd__fill_4$1
X_1567_ _1567_/Q _1760_/CLK _1567_/D vccd1 vssd1 vccd1 vssd1 sky130_fd_sc_hd__dfxtp_1$1
XFILLER_113_541 vssd1 vccd1 vccd1 vssd1 sky130_ef_sc_hd__decap_40_12$1
XFILLER_99_753 vssd1 vccd1 vccd1 vssd1 sky130_ef_sc_hd__decap_40_12$1
XFILLER_59_617 vssd1 vccd1 vccd1 vssd1 sky130_ef_sc_hd__decap_40_12$1
X_1498_ _1498_/Q _1754_/CLK _1498_/D vccd1 vssd1 vccd1 vssd1 sky130_fd_sc_hd__dfxtp_1$1
XFILLER_55_812 vssd1 vccd1 vccd1 vssd1 sky130_ef_sc_hd__decap_40_12$1
XFILLER_27_503 vccd1 vssd1 vccd1 vssd1 sky130_fd_sc_hd__fill_1$1
XFILLER_39_385 vssd1 vccd1 vccd1 vssd1 sky130_fd_sc_hd__fill_4$1
XFILLER_66_193 vssd1 vccd1 vccd1 vssd1 sky130_fd_sc_hd__fill_2$1
XFILLER_64_29 vssd1 vccd1 vccd1 vssd1 sky130_ef_sc_hd__decap_40_12$1
XFILLER_54_333 vssd1 vccd1 vccd1 vssd1 sky130_ef_sc_hd__decap_40_12$1
XFILLER_15_709 vssd1 vccd1 vccd1 vssd1 sky130_ef_sc_hd__decap_40_12$1
XFILLER_54_377 vssd1 vccd1 vccd1 vssd1 sky130_fd_sc_hd__fill_2$1
XFILLER_23_753 vssd1 vccd1 vccd1 vssd1 sky130_fd_sc_hd__fill_4$1
XFILLER_23_775 vssd1 vccd1 vccd1 vssd1 sky130_fd_sc_hd__fill_8$1
XFILLER_10_469 vssd1 vccd1 vccd1 vssd1 sky130_fd_sc_hd__fill_4$1
XFILLER_13_55 vccd1 vssd1 vccd1 vssd1 sky130_fd_sc_hd__fill_1$1
XTAP_TAPCELL_ROW_33_792 vccd1 vssd1 sky130_fd_sc_hd__tapvpwrvgnd_1$1
XFILLER_129_55 vccd1 vssd1 vccd1 vssd1 sky130_fd_sc_hd__fill_1$1
XFILLER_109_836 vccd1 vssd1 vccd1 vssd1 sky130_fd_sc_hd__fill_1$1
XTAP_TAPCELL_ROW_94_1706 vccd1 vssd1 sky130_fd_sc_hd__tapvpwrvgnd_1$1
XFILLER_89_15 vssd1 vccd1 vccd1 vssd1 sky130_ef_sc_hd__decap_40_12$1
XFILLER_136_655 vssd1 vccd1 vccd1 vssd1 sky130_ef_sc_hd__decap_40_12$1
XFILLER_124_806 vccd1 vssd1 vccd1 vssd1 sky130_fd_sc_hd__fill_1$1
XFILLER_108_357 vssd1 vccd1 vccd1 vssd1 sky130_fd_sc_hd__fill_4$1
XTAP_TAPCELL_ROW_94_1717 vccd1 vssd1 sky130_fd_sc_hd__tapvpwrvgnd_1$1
XFILLER_136_699 vccd1 vssd1 vccd1 vssd1 sky130_fd_sc_hd__fill_1$1
XFILLER_135_165 vssd1 vccd1 vccd1 vssd1 sky130_fd_sc_hd__fill_2$1
XFILLER_123_305 vssd1 vccd1 vccd1 vssd1 sky130_ef_sc_hd__decap_40_12$1
XFILLER_2_613 vssd1 vccd1 vccd1 vssd1 sky130_ef_sc_hd__decap_40_12$1
XFILLER_123_349 vssd1 vccd1 vccd1 vssd1 sky130_ef_sc_hd__decap_40_12$1
XFILLER_2_657 vssd1 vccd1 vccd1 vssd1 sky130_ef_sc_hd__decap_40_12$1
XFILLER_1_167 vccd1 vssd1 vccd1 vssd1 sky130_fd_sc_hd__fill_1$1
XFILLER_49_105 vssd1 vccd1 vccd1 vssd1 sky130_fd_sc_hd__fill_4$1
XFILLER_131_393 vssd1 vccd1 vccd1 vssd1 sky130_fd_sc_hd__fill_2$1
XFILLER_104_585 vssd1 vccd1 vccd1 vssd1 sky130_fd_sc_hd__fill_2$1
XFILLER_77_447 vccd1 vssd1 vccd1 vssd1 sky130_fd_sc_hd__fill_1$1
XFILLER_38_41 vssd1 vccd1 vccd1 vssd1 sky130_ef_sc_hd__decap_40_12$1
XFILLER_49_149 vssd1 vccd1 vccd1 vssd1 sky130_ef_sc_hd__decap_40_12$1
XFILLER_92_417 vssd1 vccd1 vccd1 vssd1 sky130_fd_sc_hd__fill_2$1
XFILLER_18_525 vssd1 vccd1 vccd1 vssd1 sky130_fd_sc_hd__fill_4$1
XFILLER_38_85 vssd1 vccd1 vccd1 vssd1 sky130_ef_sc_hd__decap_40_12$1
XFILLER_57_193 vssd1 vccd1 vccd1 vssd1 sky130_ef_sc_hd__decap_40_12$1
XFILLER_18_569 vssd1 vccd1 vccd1 vssd1 sky130_ef_sc_hd__decap_40_12$1
XFILLER_45_333 vssd1 vccd1 vccd1 vssd1 sky130_fd_sc_hd__fill_2$1
XFILLER_73_697 vssd1 vccd1 vccd1 vssd1 sky130_fd_sc_hd__fill_2$1
XFILLER_72_141 vssd1 vccd1 vccd1 vssd1 sky130_ef_sc_hd__decap_40_12$1
XFILLER_33_517 vssd1 vccd1 vccd1 vssd1 sky130_ef_sc_hd__decap_40_12$1
XTAP_TAPCELL_ROW_103_1846 vccd1 vssd1 sky130_fd_sc_hd__tapvpwrvgnd_1$1
XFILLER_14_753 vssd1 vccd1 vccd1 vssd1 sky130_fd_sc_hd__fill_2$1
XFILLER_41_561 vssd1 vccd1 vccd1 vssd1 sky130_fd_sc_hd__fill_2$1
XFILLER_9_223 vccd1 vssd1 vccd1 vssd1 sky130_fd_sc_hd__fill_1$1
XTAP_TAPCELL_ROW_136_2345 vccd1 vssd1 sky130_fd_sc_hd__tapvpwrvgnd_1$1
XTAP_TAPCELL_ROW_136_2334 vccd1 vssd1 sky130_fd_sc_hd__tapvpwrvgnd_1$1
Xclkload26 clkload26/X _1757_/CLK vssd1 vccd1 vccd1 vssd1 sky130_fd_sc_hd__clkbuf_8$1
XFILLER_70_83 vccd1 vssd1 vccd1 vssd1 sky130_fd_sc_hd__fill_1$1
XTAP_TAPCELL_ROW_11_464 vccd1 vssd1 sky130_fd_sc_hd__tapvpwrvgnd_1$1
Xclkload15 clkload15/Y _1580_/CLK vccd1 vssd1 vccd1 vssd1 sky130_fd_sc_hd__inv_6$1
XFILLER_126_121 vssd1 vccd1 vccd1 vssd1 sky130_ef_sc_hd__decap_40_12$1
Xclkload37 clkload37/X _1738_/CLK vssd1 vccd1 vccd1 vssd1 sky130_fd_sc_hd__clkbuf_4$1
XFILLER_126_165 vssd1 vccd1 vccd1 vssd1 sky130_ef_sc_hd__decap_40_12$1
XFILLER_114_305 vssd1 vccd1 vccd1 vssd1 sky130_fd_sc_hd__fill_2$1
XFILLER_5_473 vssd1 vccd1 vccd1 vssd1 sky130_ef_sc_hd__decap_40_12$1
X_1421_ _1421_/C1 _1420_/X _1475_/A2 hold61/X _1737_/D vssd1 vccd1 vccd1 vssd1 sky130_fd_sc_hd__o211a_1$1
XFILLER_79_81 vssd1 vccd1 vccd1 vssd1 sky130_ef_sc_hd__decap_40_12$1
XFILLER_96_701 vssd1 vccd1 vccd1 vssd1 sky130_ef_sc_hd__decap_40_12$1
XFILLER_110_533 vssd1 vccd1 vccd1 vssd1 sky130_ef_sc_hd__decap_40_12$1
X_1352_ _1827_/A _1352_/X _1408_/B vssd1 vccd1 vccd1 vssd1 sky130_fd_sc_hd__or2_1$1
X_1283_ _1441_/C1 _1282_/X _1343_/A2 hold73/X _1670_/D vssd1 vccd1 vccd1 vssd1 sky130_fd_sc_hd__o211a_1$1
XFILLER_68_458 vssd1 vccd1 vccd1 vssd1 sky130_ef_sc_hd__decap_40_12$1
XFILLER_49_661 vccd1 vssd1 vccd1 vssd1 sky130_fd_sc_hd__fill_1$1
XFILLER_95_277 vssd1 vccd1 vccd1 vssd1 sky130_fd_sc_hd__fill_2$1
XFILLER_83_417 vssd1 vccd1 vccd1 vssd1 sky130_ef_sc_hd__decap_40_12$1
XFILLER_36_333 vssd1 vccd1 vccd1 vssd1 sky130_ef_sc_hd__decap_40_12$1
XFILLER_48_193 vssd1 vccd1 vccd1 vssd1 sky130_fd_sc_hd__fill_2$1
XFILLER_91_461 vssd1 vccd1 vccd1 vssd1 sky130_ef_sc_hd__decap_40_12$1
XFILLER_36_377 vssd1 vccd1 vccd1 vssd1 sky130_ef_sc_hd__decap_40_12$1
XTAP_TAPCELL_ROW_19_586 vccd1 vssd1 sky130_fd_sc_hd__tapvpwrvgnd_1$1
XFILLER_20_701 vssd1 vccd1 vccd1 vssd1 sky130_ef_sc_hd__decap_40_12$1
Xclkload9 clkload9/X clkload9/A vssd1 vccd1 vccd1 vssd1 sky130_fd_sc_hd__clkbuf_4$1
X_0998_ _0998_/A _0998_/X _1012_/B vssd1 vccd1 vccd1 vssd1 sky130_fd_sc_hd__or2_1$1
XFILLER_118_622 vssd1 vccd1 vccd1 vssd1 sky130_fd_sc_hd__fill_8$1
XTAP_TAPCELL_ROW_30_751 vccd1 vssd1 sky130_fd_sc_hd__tapvpwrvgnd_1$1
Xclkbuf_leaf_22_wb_clk_i _1738_/CLK clkbuf_2_3__f_wb_clk_i/X vssd1 vccd1 vccd1 vssd1
+ sky130_fd_sc_hd__clkbuf_8$1
XFILLER_117_165 vssd1 vccd1 vccd1 vssd1 sky130_fd_sc_hd__fill_2$1
XFILLER_105_305 vssd1 vccd1 vccd1 vssd1 sky130_ef_sc_hd__decap_40_12$1
XTAP_TAPCELL_ROW_76_1447 vccd1 vssd1 sky130_fd_sc_hd__tapvpwrvgnd_1$1
XTAP_TAPCELL_ROW_76_1436 vccd1 vssd1 sky130_fd_sc_hd__tapvpwrvgnd_1$1
XFILLER_105_349 vssd1 vccd1 vccd1 vssd1 sky130_ef_sc_hd__decap_40_12$1
X_1619_ _1823_/A _1739_/CLK _1619_/D vccd1 vssd1 vccd1 vssd1 sky130_fd_sc_hd__dfxtp_1$1
Xfanout213 _1330_/B vccd1 vssd1 _1278_/X vccd1 vssd1 sky130_fd_sc_hd__buf_4$1
Xfanout224 _1081_/Y _1145_/A2 vssd1 vccd1 vccd1 vssd1 sky130_fd_sc_hd__buf_8$1
XFILLER_101_500 vssd1 vccd1 vccd1 vssd1 sky130_fd_sc_hd__fill_4$1
XFILLER_99_594 vssd1 vccd1 vccd1 vssd1 sky130_ef_sc_hd__decap_40_12$1
Xfanout246 _1344_/A _0878_/B1 vssd1 vccd1 vccd1 vssd1 sky130_fd_sc_hd__buf_8$1
XFILLER_87_756 vssd1 vccd1 vccd1 vssd1 sky130_ef_sc_hd__decap_40_12$1
Xfanout235 _0879_/B1 vccd1 vssd1 _0750_/X vccd1 vssd1 sky130_fd_sc_hd__buf_6$1
Xfanout279 _1319_/C1 _0738_/Y vssd1 vccd1 vccd1 vssd1 sky130_fd_sc_hd__clkbuf_8$1
XFILLER_115_57 vssd1 vccd1 vccd1 vssd1 sky130_ef_sc_hd__decap_40_12$1
Xfanout268 _1443_/C1 vccd1 vssd1 _1319_/C1 vccd1 vssd1 sky130_fd_sc_hd__buf_4$1
XFILLER_86_233 vssd1 vccd1 vccd1 vssd1 sky130_ef_sc_hd__decap_40_12$1
Xfanout257 _0878_/A2 vccd1 vssd1 _0740_/X vccd1 vssd1 sky130_fd_sc_hd__buf_6$1
XFILLER_59_469 vssd1 vccd1 vccd1 vssd1 sky130_fd_sc_hd__fill_2$1
XFILLER_86_277 vssd1 vccd1 vccd1 vssd1 sky130_ef_sc_hd__decap_40_12$1
XFILLER_75_39 vssd1 vccd1 vccd1 vssd1 sky130_ef_sc_hd__decap_40_12$1
XFILLER_27_333 vssd1 vccd1 vccd1 vssd1 sky130_fd_sc_hd__fill_2$1
XFILLER_39_193 vssd1 vccd1 vccd1 vssd1 sky130_ef_sc_hd__decap_40_12$1
XTAP_TAPCELL_ROW_120_2102 vccd1 vssd1 sky130_fd_sc_hd__tapvpwrvgnd_1$1
XFILLER_70_601 vssd1 vccd1 vccd1 vssd1 sky130_ef_sc_hd__decap_40_12$1
XFILLER_54_141 vssd1 vccd1 vccd1 vssd1 sky130_ef_sc_hd__decap_40_12$1
XFILLER_15_517 vssd1 vccd1 vccd1 vssd1 sky130_ef_sc_hd__decap_40_12$1
XTAP_TAPCELL_ROW_38_873 vccd1 vssd1 sky130_fd_sc_hd__tapvpwrvgnd_1$1
XFILLER_91_27 vssd1 vccd1 vccd1 vssd1 sky130_ef_sc_hd__decap_40_12$1
XTAP_TAPCELL_ROW_87_1598 vccd1 vssd1 sky130_fd_sc_hd__tapvpwrvgnd_1$1
XFILLER_70_645 vssd1 vccd1 vccd1 vssd1 sky130_ef_sc_hd__decap_40_12$1
XFILLER_55_697 vssd1 vccd1 vccd1 vssd1 sky130_ef_sc_hd__decap_40_12$1
XFILLER_23_561 vssd1 vccd1 vccd1 vssd1 sky130_ef_sc_hd__decap_40_12$1
XFILLER_24_65 vssd1 vccd1 vccd1 vssd1 sky130_ef_sc_hd__decap_40_12$1
XFILLER_138_3 vssd1 vccd1 vccd1 vssd1 sky130_fd_sc_hd__fill_8$1
XFILLER_128_419 vccd1 vssd1 vccd1 vssd1 sky130_fd_sc_hd__fill_1$1
XFILLER_109_600 vccd1 vssd1 vccd1 vssd1 sky130_fd_sc_hd__fill_1$1
XFILLER_10_233 vssd1 vccd1 vccd1 vssd1 sky130_ef_sc_hd__decap_40_12$1
XTAP_TAPCELL_ROW_118_2064 vccd1 vssd1 sky130_fd_sc_hd__tapvpwrvgnd_1$1
XFILLER_10_277 vssd1 vccd1 vccd1 vssd1 sky130_ef_sc_hd__decap_40_12$1
XFILLER_7_727 vccd1 vssd1 vccd1 vssd1 sky130_fd_sc_hd__fill_1$1
XTAP_TAPCELL_ROW_118_2075 vccd1 vssd1 sky130_fd_sc_hd__tapvpwrvgnd_1$1
XFILLER_108_121 vssd1 vccd1 vccd1 vssd1 sky130_ef_sc_hd__decap_40_12$1
XFILLER_40_53 vssd1 vccd1 vccd1 vssd1 sky130_ef_sc_hd__decap_40_12$1
XFILLER_109_699 vccd1 vssd1 vccd1 vssd1 sky130_fd_sc_hd__fill_1$1
XFILLER_109_677 vssd1 vccd1 vccd1 vssd1 sky130_fd_sc_hd__fill_2$1
XFILLER_108_165 vssd1 vccd1 vccd1 vssd1 sky130_ef_sc_hd__decap_40_12$1
XFILLER_40_97 vssd1 vccd1 vccd1 vssd1 sky130_ef_sc_hd__decap_40_12$1
XTAP_TAPCELL_ROW_131_2264 vccd1 vssd1 sky130_fd_sc_hd__tapvpwrvgnd_1$1
XFILLER_124_669 vssd1 vccd1 vccd1 vssd1 sky130_ef_sc_hd__decap_40_12$1
XFILLER_123_113 vssd1 vccd1 vccd1 vssd1 sky130_ef_sc_hd__decap_40_12$1
XFILLER_2_421 vssd1 vccd1 vccd1 vssd1 sky130_ef_sc_hd__decap_40_12$1
XFILLER_49_51 vssd1 vccd1 vccd1 vssd1 sky130_fd_sc_hd__fill_4$1
XFILLER_77_277 vssd1 vccd1 vccd1 vssd1 sky130_fd_sc_hd__fill_2$1
XFILLER_1_69 vssd1 vccd1 vccd1 vssd1 sky130_ef_sc_hd__decap_40_12$1
XFILLER_18_333 vssd1 vccd1 vccd1 vssd1 sky130_ef_sc_hd__decap_40_12$1
XFILLER_73_461 vssd1 vccd1 vccd1 vssd1 sky130_ef_sc_hd__decap_40_12$1
XFILLER_18_377 vssd1 vccd1 vccd1 vssd1 sky130_ef_sc_hd__decap_40_12$1
XFILLER_34_804 vssd1 vccd1 vccd1 vssd1 sky130_fd_sc_hd__fill_2$1
XTAP_TAPCELL_ROW_47_1004 vccd1 vssd1 sky130_fd_sc_hd__tapvpwrvgnd_1$1
XFILLER_46_697 vssd1 vccd1 vccd1 vssd1 sky130_fd_sc_hd__fill_2$1
XFILLER_60_133 vssd1 vccd1 vccd1 vssd1 sky130_fd_sc_hd__fill_4$1
XTAP_TAPCELL_ROW_16_534 vccd1 vssd1 sky130_fd_sc_hd__tapvpwrvgnd_1$1
XTAP_TAPCELL_ROW_16_545 vccd1 vssd1 sky130_fd_sc_hd__tapvpwrvgnd_1$1
X_0921_ _0945_/A _0921_/X _0921_/B _0921_/C vccd1 vssd1 vccd1 vssd1 sky130_fd_sc_hd__or3_1$1
XTAP_TAPCELL_ROW_60_1204 vccd1 vssd1 sky130_fd_sc_hd__tapvpwrvgnd_1$1
XFILLER_60_177 vssd1 vccd1 vccd1 vssd1 sky130_ef_sc_hd__decap_40_12$1
XFILLER_81_93 vssd1 vccd1 vccd1 vssd1 sky130_ef_sc_hd__decap_40_12$1
XFILLER_41_391 vccd1 vssd1 vccd1 vssd1 sky130_fd_sc_hd__fill_1$1
X_0852_ _1345_/A hold39/A _0851_/X _0852_/X vccd1 vssd1 vccd1 vssd1 sky130_fd_sc_hd__a21o_1$1
X_0783_ _0752_/A _1481_/D _0779_/X _1421_/C1 _1481_/Q _0782_/X vssd1 vccd1 vccd1 vssd1
+ sky130_fd_sc_hd__o221a_1$1
XFILLER_53_3 vssd1 vccd1 vccd1 vssd1 sky130_ef_sc_hd__decap_40_12$1
XTAP_TAPCELL_ROW_58_1177 vccd1 vssd1 sky130_fd_sc_hd__tapvpwrvgnd_1$1
XTAP_TAPCELL_ROW_58_1166 vccd1 vssd1 sky130_fd_sc_hd__tapvpwrvgnd_1$1
XFILLER_6_793 vssd1 vccd1 vccd1 vssd1 sky130_ef_sc_hd__decap_40_12$1
XFILLER_5_281 vssd1 vccd1 vccd1 vssd1 sky130_ef_sc_hd__decap_40_12$1
XFILLER_115_669 vssd1 vccd1 vccd1 vssd1 sky130_fd_sc_hd__fill_2$1
XFILLER_130_628 vssd1 vccd1 vccd1 vssd1 sky130_ef_sc_hd__decap_40_12$1
X_1404_ _1404_/A _1404_/X _1408_/B vssd1 vccd1 vccd1 vssd1 sky130_fd_sc_hd__or2_1$1
XFILLER_111_820 vssd1 vccd1 vccd1 vssd1 sky130_ef_sc_hd__decap_40_12$1
XFILLER_69_723 vssd1 vccd1 vccd1 vssd1 sky130_fd_sc_hd__fill_4$1
X_1335_ _1417_/C1 _1334_/X _1343_/A2 hold146/X _1696_/D vssd1 vccd1 vccd1 vssd1 sky130_fd_sc_hd__o211a_1$1
XFILLER_96_553 vssd1 vccd1 vccd1 vssd1 sky130_ef_sc_hd__decap_40_12$1
XTAP_TAPCELL_ROW_71_1366 vccd1 vssd1 sky130_fd_sc_hd__tapvpwrvgnd_1$1
XFILLER_68_233 vssd1 vccd1 vccd1 vssd1 sky130_ef_sc_hd__decap_40_12$1
XFILLER_29_609 vssd1 vccd1 vccd1 vssd1 sky130_fd_sc_hd__fill_4$1
XFILLER_110_363 vccd1 vssd1 vccd1 vssd1 sky130_fd_sc_hd__fill_1$1
XFILLER_96_597 vccd1 vssd1 vccd1 vssd1 sky130_fd_sc_hd__fill_1$1
XFILLER_68_277 vssd1 vccd1 vccd1 vssd1 sky130_ef_sc_hd__decap_40_12$1
Xinput2 vccd1 vssd1 input2/X adc_data[10] vccd1 vssd1 sky130_fd_sc_hd__buf_1$1
X_1266_ _1663_/Q _1266_/X _1270_/B vssd1 vccd1 vccd1 vssd1 sky130_fd_sc_hd__or2_1$1
XFILLER_83_225 vssd1 vccd1 vccd1 vssd1 sky130_ef_sc_hd__decap_40_12$1
X_1197_ _1463_/C1 _1196_/X _1211_/A2 hold86/X hold87/A vssd1 vccd1 vccd1 vssd1 sky130_fd_sc_hd__o211a_1$1
XFILLER_52_601 vssd1 vccd1 vccd1 vssd1 sky130_ef_sc_hd__decap_40_12$1
XFILLER_25_804 vccd1 vssd1 vccd1 vssd1 sky130_fd_sc_hd__fill_1$1
XFILLER_36_141 vssd1 vccd1 vccd1 vssd1 sky130_ef_sc_hd__decap_40_12$1
XFILLER_37_653 vssd1 vccd1 vccd1 vssd1 sky130_ef_sc_hd__decap_40_12$1
XFILLER_101_15 vssd1 vccd1 vccd1 vssd1 sky130_ef_sc_hd__decap_40_12$1
XFILLER_64_472 vssd1 vccd1 vccd1 vssd1 sky130_fd_sc_hd__fill_4$1
XFILLER_52_645 vssd1 vccd1 vccd1 vssd1 sky130_ef_sc_hd__decap_40_12$1
XFILLER_51_111 vccd1 vssd1 vccd1 vssd1 sky130_fd_sc_hd__fill_1$1
XTAP_TAPCELL_ROW_35_821 vccd1 vssd1 sky130_fd_sc_hd__tapvpwrvgnd_1$1
XTAP_TAPCELL_ROW_35_832 vccd1 vssd1 sky130_fd_sc_hd__tapvpwrvgnd_1$1
XFILLER_40_829 vssd1 vccd1 vccd1 vssd1 sky130_ef_sc_hd__decap_40_12$1
XFILLER_20_531 vccd1 vssd1 vccd1 vssd1 sky130_fd_sc_hd__fill_1$1
XFILLER_133_411 vssd1 vccd1 vccd1 vssd1 sky130_fd_sc_hd__fill_8$1
XFILLER_105_113 vssd1 vccd1 vccd1 vssd1 sky130_ef_sc_hd__decap_40_12$1
XFILLER_133_455 vccd1 vssd1 vccd1 vssd1 sky130_fd_sc_hd__fill_1$1
XFILLER_86_27 vccd1 vssd1 vccd1 vssd1 sky130_fd_sc_hd__fill_1$1
XTAP_TAPCELL_ROW_89_1638 vccd1 vssd1 sky130_fd_sc_hd__tapvpwrvgnd_1$1
XFILLER_59_277 vssd1 vccd1 vccd1 vssd1 sky130_fd_sc_hd__fill_2$1
XFILLER_47_417 vssd1 vccd1 vccd1 vssd1 sky130_ef_sc_hd__decap_40_12$1
XFILLER_101_385 vssd1 vccd1 vccd1 vssd1 sky130_fd_sc_hd__fill_2$1
XFILLER_55_461 vssd1 vccd1 vccd1 vssd1 sky130_ef_sc_hd__decap_40_12$1
XFILLER_28_697 vssd1 vccd1 vccd1 vssd1 sky130_fd_sc_hd__fill_2$1
XFILLER_42_133 vssd1 vccd1 vccd1 vssd1 sky130_fd_sc_hd__fill_4$1
XTAP_TAPCELL_ROW_100_1805 vccd1 vssd1 sky130_fd_sc_hd__tapvpwrvgnd_1$1
XFILLER_70_475 vccd1 vssd1 vccd1 vssd1 sky130_fd_sc_hd__fill_1$1
XFILLER_42_177 vssd1 vccd1 vccd1 vssd1 sky130_ef_sc_hd__decap_40_12$1
XFILLER_23_391 vccd1 vssd1 vccd1 vssd1 sky130_fd_sc_hd__fill_1$1
XFILLER_11_553 vssd1 vccd1 vccd1 vssd1 sky130_fd_sc_hd__fill_4$1
XFILLER_128_249 vssd1 vccd1 vccd1 vssd1 sky130_fd_sc_hd__fill_2$1
XFILLER_11_597 vssd1 vccd1 vccd1 vssd1 sky130_ef_sc_hd__decap_40_12$1
XFILLER_7_557 vssd1 vccd1 vccd1 vssd1 sky130_fd_sc_hd__fill_2$1
XFILLER_137_783 vccd1 vssd1 vccd1 vssd1 sky130_fd_sc_hd__fill_1$1
XFILLER_124_433 vssd1 vccd1 vccd1 vssd1 sky130_ef_sc_hd__decap_40_12$1
XFILLER_98_807 vssd1 vccd1 vccd1 vssd1 sky130_fd_sc_hd__fill_4$1
XFILLER_3_741 vssd1 vccd1 vccd1 vssd1 sky130_ef_sc_hd__decap_40_12$1
XFILLER_111_105 vssd1 vccd1 vccd1 vssd1 sky130_fd_sc_hd__fill_4$1
XFILLER_97_317 vssd1 vccd1 vccd1 vssd1 sky130_ef_sc_hd__decap_40_12$1
XFILLER_3_785 vssd1 vccd1 vccd1 vssd1 sky130_ef_sc_hd__decap_40_12$1
XFILLER_2_251 vccd1 vssd1 vccd1 vssd1 sky130_fd_sc_hd__fill_1$1
XTAP_TAPCELL_ROW_111_1967 vccd1 vssd1 sky130_fd_sc_hd__tapvpwrvgnd_1$1
XFILLER_111_149 vssd1 vccd1 vccd1 vssd1 sky130_ef_sc_hd__decap_40_12$1
XFILLER_78_531 vccd1 vssd1 vccd1 vssd1 sky130_fd_sc_hd__fill_1$1
XFILLER_120_683 vssd1 vccd1 vccd1 vssd1 sky130_ef_sc_hd__decap_40_12$1
X_1120_ _1810_/A _1120_/X _1144_/B vssd1 vccd1 vccd1 vssd1 sky130_fd_sc_hd__or2_1$1
XFILLER_93_501 vssd1 vccd1 vccd1 vssd1 sky130_fd_sc_hd__fill_2$1
XTAP_TAPCELL_ROW_53_1096 vccd1 vssd1 sky130_fd_sc_hd__tapvpwrvgnd_1$1
XFILLER_38_417 vssd1 vccd1 vccd1 vssd1 sky130_fd_sc_hd__fill_2$1
XFILLER_65_225 vssd1 vccd1 vccd1 vssd1 sky130_ef_sc_hd__decap_40_12$1
XFILLER_81_729 vssd1 vccd1 vccd1 vssd1 sky130_ef_sc_hd__decap_40_12$1
X_1051_ _1447_/C1 _1050_/X _1053_/A2 hold46/X _1558_/D vssd1 vccd1 vccd1 vssd1 sky130_fd_sc_hd__o211a_1$1
XFILLER_18_141 vssd1 vccd1 vccd1 vssd1 sky130_ef_sc_hd__decap_40_12$1
XFILLER_19_653 vssd1 vccd1 vccd1 vssd1 sky130_ef_sc_hd__decap_40_12$1
XFILLER_34_601 vssd1 vccd1 vccd1 vssd1 sky130_ef_sc_hd__decap_40_12$1
XFILLER_74_781 vssd1 vccd1 vccd1 vssd1 sky130_ef_sc_hd__decap_40_12$1
XFILLER_19_697 vssd1 vccd1 vccd1 vssd1 sky130_ef_sc_hd__decap_40_12$1
XFILLER_33_111 vccd1 vssd1 vccd1 vssd1 sky130_fd_sc_hd__fill_1$1
XFILLER_34_634 vssd1 vccd1 vccd1 vssd1 sky130_fd_sc_hd__fill_8$1
XFILLER_92_81 vssd1 vccd1 vccd1 vssd1 sky130_fd_sc_hd__fill_2$1
XFILLER_61_442 vssd1 vccd1 vccd1 vssd1 sky130_fd_sc_hd__fill_4$1
XFILLER_34_645 vssd1 vccd1 vccd1 vssd1 sky130_fd_sc_hd__fill_8$1
XFILLER_34_667 vssd1 vccd1 vccd1 vssd1 sky130_ef_sc_hd__decap_40_12$1
XFILLER_61_497 vssd1 vccd1 vccd1 vssd1 sky130_fd_sc_hd__fill_4$1
XFILLER_21_317 vssd1 vccd1 vccd1 vssd1 sky130_ef_sc_hd__decap_40_12$1
X_0904_ _0752_/A _1501_/D _0901_/X _1461_/C1 _1501_/Q _0903_/X vssd1 vccd1 vccd1 vssd1
+ sky130_fd_sc_hd__o221a_1$1
XFILLER_119_205 vssd1 vccd1 vccd1 vssd1 sky130_ef_sc_hd__decap_40_12$1
XFILLER_119_249 vssd1 vccd1 vccd1 vssd1 sky130_ef_sc_hd__decap_40_12$1
X_0835_ _1822_/A _0878_/A2 _0835_/X _1554_/Q _0866_/B1 vccd1 vssd1 vccd1 vssd1 sky130_fd_sc_hd__a22o_1$1
XFILLER_127_293 vssd1 vccd1 vccd1 vssd1 sky130_ef_sc_hd__decap_40_12$1
X_0766_ _1789_/A _0879_/A2 _0766_/X _1774_/A _0866_/B1 vccd1 vssd1 vccd1 vssd1 sky130_fd_sc_hd__a22o_1$1
XFILLER_103_617 vssd1 vccd1 vccd1 vssd1 sky130_ef_sc_hd__decap_40_12$1
XFILLER_89_807 vccd1 vssd1 vccd1 vssd1 sky130_fd_sc_hd__fill_1$1
XFILLER_96_361 vssd1 vccd1 vccd1 vssd1 sky130_fd_sc_hd__fill_2$1
XFILLER_69_597 vssd1 vccd1 vccd1 vssd1 sky130_ef_sc_hd__decap_40_12$1
XFILLER_29_417 vssd1 vccd1 vccd1 vssd1 sky130_ef_sc_hd__decap_40_12$1
XFILLER_110_193 vssd1 vccd1 vccd1 vssd1 sky130_fd_sc_hd__fill_2$1
X_1318_ _1318_/A _1318_/X _1330_/B vssd1 vccd1 vccd1 vssd1 sky130_fd_sc_hd__or2_1$1
X_1249_ _1455_/C1 _1248_/X _1277_/A2 hold46/X _1654_/D vssd1 vccd1 vccd1 vssd1 sky130_fd_sc_hd__o211a_1$1
XFILLER_84_589 vssd1 vccd1 vccd1 vssd1 sky130_ef_sc_hd__decap_40_12$1
XFILLER_37_461 vssd1 vccd1 vccd1 vssd1 sky130_ef_sc_hd__decap_40_12$1
XFILLER_71_217 vssd1 vccd1 vccd1 vssd1 sky130_fd_sc_hd__fill_4$1
XFILLER_65_781 vssd1 vccd1 vccd1 vssd1 sky130_fd_sc_hd__fill_2$1
XTAP_TAPCELL_ROW_84_1557 vccd1 vssd1 sky130_fd_sc_hd__tapvpwrvgnd_1$1
XFILLER_80_751 vssd1 vccd1 vccd1 vssd1 sky130_fd_sc_hd__fill_4$1
XFILLER_72_29 vssd1 vccd1 vccd1 vssd1 sky130_ef_sc_hd__decap_40_12$1
XFILLER_24_133 vssd1 vccd1 vccd1 vssd1 sky130_fd_sc_hd__fill_4$1
XFILLER_24_177 vssd1 vccd1 vccd1 vssd1 sky130_ef_sc_hd__decap_40_12$1
XFILLER_138_503 vccd1 vssd1 vccd1 vssd1 sky130_fd_sc_hd__fill_1$1
XFILLER_20_361 vssd1 vccd1 vccd1 vssd1 sky130_fd_sc_hd__fill_2$1
XTAP_TAPCELL_ROW_115_2023 vccd1 vssd1 sky130_fd_sc_hd__tapvpwrvgnd_1$1
XFILLER_21_55 vccd1 vssd1 vccd1 vssd1 sky130_fd_sc_hd__fill_1$1
XFILLER_137_55 vccd1 vssd1 vccd1 vssd1 sky130_fd_sc_hd__fill_1$1
XFILLER_97_15 vssd1 vccd1 vccd1 vssd1 sky130_ef_sc_hd__decap_40_12$1
XFILLER_106_477 vssd1 vccd1 vccd1 vssd1 sky130_ef_sc_hd__decap_40_12$1
XFILLER_79_317 vssd1 vccd1 vccd1 vssd1 sky130_ef_sc_hd__decap_40_12$1
Xoutput191 _1505_/Q wbs_dat_o[28] vssd1 vccd1 vccd1 vssd1 sky130_fd_sc_hd__buf_12$1
Xoutput180 _1495_/Q wbs_dat_o[18] vssd1 vccd1 vccd1 vssd1 sky130_fd_sc_hd__buf_12$1
XFILLER_121_469 vssd1 vccd1 vccd1 vssd1 sky130_fd_sc_hd__fill_2$1
XFILLER_0_755 vccd1 vssd1 vccd1 vssd1 sky130_fd_sc_hd__fill_1$1
XFILLER_94_309 vssd1 vccd1 vccd1 vssd1 sky130_ef_sc_hd__decap_40_12$1
XFILLER_87_361 vssd1 vccd1 vccd1 vssd1 sky130_fd_sc_hd__fill_4$1
XTAP_TAPCELL_ROW_7_398 vccd1 vssd1 sky130_fd_sc_hd__tapvpwrvgnd_1$1
XFILLER_48_737 vssd1 vccd1 vccd1 vssd1 sky130_ef_sc_hd__decap_40_12$1
XFILLER_47_225 vssd1 vccd1 vccd1 vssd1 sky130_ef_sc_hd__decap_40_12$1
XFILLER_101_193 vssd1 vccd1 vccd1 vssd1 sky130_ef_sc_hd__decap_40_12$1
XFILLER_63_729 vssd1 vccd1 vccd1 vssd1 sky130_ef_sc_hd__decap_40_12$1
XFILLER_46_41 vssd1 vccd1 vccd1 vssd1 sky130_ef_sc_hd__decap_40_12$1
XTAP_TAPCELL_ROW_126_2196 vccd1 vssd1 sky130_fd_sc_hd__tapvpwrvgnd_1$1
XTAP_TAPCELL_ROW_126_2185 vccd1 vssd1 sky130_fd_sc_hd__tapvpwrvgnd_1$1
XFILLER_16_601 vssd1 vccd1 vccd1 vssd1 sky130_ef_sc_hd__decap_40_12$1
XFILLER_46_85 vssd1 vccd1 vccd1 vssd1 sky130_ef_sc_hd__decap_40_12$1
XFILLER_90_559 vccd1 vssd1 vccd1 vssd1 sky130_fd_sc_hd__fill_1$1
XFILLER_15_111 vccd1 vssd1 vccd1 vssd1 sky130_fd_sc_hd__fill_1$1
XFILLER_16_645 vssd1 vccd1 vccd1 vssd1 sky130_ef_sc_hd__decap_40_12$1
XFILLER_31_615 vccd1 vssd1 vccd1 vssd1 sky130_fd_sc_hd__fill_1$1
XTAP_TAPCELL_ROW_26_684 vccd1 vssd1 sky130_fd_sc_hd__tapvpwrvgnd_1$1
XTAP_TAPCELL_ROW_26_695 vccd1 vssd1 sky130_fd_sc_hd__tapvpwrvgnd_1$1
XFILLER_129_503 vccd1 vssd1 vccd1 vssd1 sky130_fd_sc_hd__fill_1$1
XFILLER_8_811 vccd1 vssd1 vccd1 vssd1 sky130_fd_sc_hd__fill_1$1
XFILLER_11_361 vssd1 vccd1 vccd1 vssd1 sky130_ef_sc_hd__decap_40_12$1
Xwire252 vccd1 vssd1 wire252/X _0742_/Y vccd1 vssd1 sky130_fd_sc_hd__buf_2$1
XFILLER_7_57 vssd1 vccd1 vccd1 vssd1 sky130_ef_sc_hd__decap_40_12$1
XFILLER_109_293 vssd1 vccd1 vccd1 vssd1 sky130_ef_sc_hd__decap_40_12$1
XTAP_TAPCELL_ROW_55_1125 vccd1 vssd1 sky130_fd_sc_hd__tapvpwrvgnd_1$1
XFILLER_97_125 vssd1 vccd1 vccd1 vssd1 sky130_ef_sc_hd__decap_40_12$1
XFILLER_100_609 vssd1 vccd1 vccd1 vssd1 sky130_ef_sc_hd__decap_40_12$1
XFILLER_97_169 vssd1 vccd1 vccd1 vssd1 sky130_ef_sc_hd__decap_40_12$1
XFILLER_94_821 vccd1 vssd1 vccd1 vssd1 sky130_fd_sc_hd__fill_1$1
XFILLER_87_81 vssd1 vccd1 vccd1 vssd1 sky130_ef_sc_hd__decap_40_12$1
XFILLER_78_361 vssd1 vccd1 vccd1 vssd1 sky130_fd_sc_hd__fill_2$1
XFILLER_39_704 vssd1 vccd1 vccd1 vssd1 sky130_ef_sc_hd__decap_40_12$1
XFILLER_66_545 vssd1 vccd1 vccd1 vssd1 sky130_ef_sc_hd__decap_40_12$1
XFILLER_16_3 vssd1 vccd1 vccd1 vssd1 sky130_ef_sc_hd__decap_40_12$1
XFILLER_66_589 vssd1 vccd1 vccd1 vssd1 sky130_ef_sc_hd__decap_40_12$1
X_1103_ _1305_/C1 _1102_/X _1145_/A2 hold142/X _1583_/D vssd1 vccd1 vccd1 vssd1 sky130_fd_sc_hd__o211a_1$1
X_1034_ _1034_/A _1034_/X _1052_/B vssd1 vccd1 vccd1 vssd1 sky130_fd_sc_hd__or2_1$1
XFILLER_53_217 vssd1 vccd1 vccd1 vssd1 sky130_fd_sc_hd__fill_4$1
XFILLER_19_461 vssd1 vccd1 vccd1 vssd1 sky130_ef_sc_hd__decap_40_12$1
XFILLER_47_770 vccd1 vssd1 vccd1 vssd1 sky130_fd_sc_hd__fill_1$1
XTAP_TAPCELL_ROW_66_1287 vccd1 vssd1 sky130_fd_sc_hd__tapvpwrvgnd_1$1
XFILLER_61_261 vssd1 vccd1 vccd1 vssd1 sky130_ef_sc_hd__decap_40_12$1
XFILLER_34_475 vccd1 vssd1 vccd1 vssd1 sky130_fd_sc_hd__fill_1$1
XTAP_TAPCELL_ROW_45_971 vccd1 vssd1 sky130_fd_sc_hd__tapvpwrvgnd_1$1
XTAP_TAPCELL_ROW_45_982 vccd1 vssd1 sky130_fd_sc_hd__tapvpwrvgnd_1$1
XFILLER_21_125 vssd1 vccd1 vccd1 vssd1 sky130_ef_sc_hd__decap_40_12$1
XFILLER_22_637 vssd1 vccd1 vccd1 vssd1 sky130_fd_sc_hd__fill_4$1
XFILLER_21_169 vssd1 vccd1 vccd1 vssd1 sky130_ef_sc_hd__decap_40_12$1
XFILLER_30_681 vssd1 vccd1 vccd1 vssd1 sky130_ef_sc_hd__decap_40_12$1
XFILLER_135_517 vccd1 vssd1 vccd1 vssd1 sky130_fd_sc_hd__fill_1$1
XFILLER_128_591 vccd1 vssd1 vccd1 vssd1 sky130_fd_sc_hd__fill_1$1
X_1798_ _1798_/A _1798_/X vssd1 vccd1 vccd1 vssd1 sky130_fd_sc_hd__clkbuf_2$1
X_0818_ _0879_/B1 _0818_/X _0817_/X _1519_/Q _0875_/A2 _0816_/X vssd1 vccd1 vccd1
+ vssd1 sky130_fd_sc_hd__a2111o_1$1
XFILLER_116_753 vssd1 vccd1 vccd1 vssd1 sky130_fd_sc_hd__fill_2$1
X_0749_ _0947_/C _1476_/Q _0947_/B _0749_/X _0947_/D vssd1 vccd1 vccd1 vssd1 sky130_fd_sc_hd__and4bb_4$1
XFILLER_130_233 vssd1 vccd1 vccd1 vssd1 sky130_ef_sc_hd__decap_40_12$1
XFILLER_107_69 vssd1 vccd1 vccd1 vssd1 sky130_ef_sc_hd__decap_40_12$1
XFILLER_130_277 vssd1 vccd1 vccd1 vssd1 sky130_ef_sc_hd__decap_40_12$1
XFILLER_97_681 vssd1 vccd1 vccd1 vssd1 sky130_fd_sc_hd__fill_2$1
XFILLER_76_309 vssd1 vccd1 vccd1 vssd1 sky130_ef_sc_hd__decap_40_12$1
XFILLER_69_361 vssd1 vccd1 vccd1 vssd1 sky130_ef_sc_hd__decap_40_12$1
XFILLER_97_692 vssd1 vccd1 vccd1 vssd1 sky130_fd_sc_hd__fill_2$1
XTAP_TAPCELL_ROW_4_357 vccd1 vssd1 sky130_fd_sc_hd__tapvpwrvgnd_1$1
XFILLER_29_225 vssd1 vccd1 vccd1 vssd1 sky130_ef_sc_hd__decap_40_12$1
XFILLER_123_57 vssd1 vccd1 vccd1 vssd1 sky130_ef_sc_hd__decap_40_12$1
XFILLER_45_718 vssd1 vccd1 vccd1 vssd1 sky130_fd_sc_hd__fill_8$1
XFILLER_84_397 vssd1 vccd1 vccd1 vssd1 sky130_fd_sc_hd__fill_2$1
XFILLER_83_39 vssd1 vccd1 vccd1 vssd1 sky130_ef_sc_hd__decap_40_12$1
XFILLER_38_781 vssd1 vccd1 vccd1 vssd1 sky130_ef_sc_hd__decap_40_12$1
XFILLER_45_729 vssd1 vccd1 vccd1 vssd1 sky130_ef_sc_hd__decap_40_12$1
XFILLER_13_615 vccd1 vssd1 vccd1 vssd1 sky130_fd_sc_hd__fill_1$1
XFILLER_16_77 vssd1 vccd1 vccd1 vssd1 sky130_fd_sc_hd__fill_4$1
XFILLER_40_401 vssd1 vccd1 vccd1 vssd1 sky130_ef_sc_hd__decap_40_12$1
XFILLER_25_497 vssd1 vccd1 vccd1 vssd1 sky130_fd_sc_hd__fill_4$1
XFILLER_40_445 vssd1 vccd1 vccd1 vssd1 sky130_ef_sc_hd__decap_40_12$1
XTAP_TAPCELL_ROW_23_643 vccd1 vssd1 sky130_fd_sc_hd__tapvpwrvgnd_1$1
XFILLER_32_65 vssd1 vccd1 vccd1 vssd1 sky130_ef_sc_hd__decap_40_12$1
XFILLER_40_489 vssd1 vccd1 vccd1 vssd1 sky130_ef_sc_hd__decap_40_12$1
XFILLER_120_3 vssd1 vccd1 vccd1 vssd1 sky130_ef_sc_hd__decap_40_12$1
XTAP_TAPCELL_ROW_97_1748 vccd1 vssd1 sky130_fd_sc_hd__tapvpwrvgnd_1$1
XTAP_TAPCELL_ROW_97_1759 vccd1 vssd1 sky130_fd_sc_hd__tapvpwrvgnd_1$1
XFILLER_107_753 vssd1 vccd1 vccd1 vssd1 sky130_ef_sc_hd__decap_40_12$1
XFILLER_4_357 vssd1 vccd1 vccd1 vssd1 sky130_fd_sc_hd__fill_4$1
XFILLER_122_701 vssd1 vccd1 vccd1 vssd1 sky130_ef_sc_hd__decap_40_12$1
XFILLER_107_797 vssd1 vccd1 vccd1 vssd1 sky130_ef_sc_hd__decap_40_12$1
XFILLER_79_125 vssd1 vccd1 vccd1 vssd1 sky130_ef_sc_hd__decap_40_12$1
XTAP_TAPCELL_ROW_128_2225 vccd1 vssd1 sky130_fd_sc_hd__tapvpwrvgnd_1$1
XTAP_TAPCELL_ROW_128_2214 vccd1 vssd1 sky130_fd_sc_hd__tapvpwrvgnd_1$1
XFILLER_121_277 vssd1 vccd1 vccd1 vssd1 sky130_fd_sc_hd__fill_2$1
XFILLER_79_169 vssd1 vccd1 vccd1 vssd1 sky130_ef_sc_hd__decap_40_12$1
XFILLER_48_501 vssd1 vccd1 vccd1 vssd1 sky130_ef_sc_hd__decap_40_12$1
XFILLER_94_139 vccd1 vssd1 vccd1 vssd1 sky130_fd_sc_hd__fill_1$1
XFILLER_88_681 vssd1 vccd1 vccd1 vssd1 sky130_ef_sc_hd__decap_40_12$1
XFILLER_57_51 vssd1 vccd1 vccd1 vssd1 sky130_fd_sc_hd__fill_4$1
XTAP_TAPCELL_ROW_50_1055 vccd1 vssd1 sky130_fd_sc_hd__tapvpwrvgnd_1$1
XTAP_TAPCELL_ROW_50_1044 vccd1 vssd1 sky130_fd_sc_hd__tapvpwrvgnd_1$1
XFILLER_0_585 vssd1 vccd1 vccd1 vssd1 sky130_fd_sc_hd__fill_2$1
XFILLER_90_301 vssd1 vccd1 vccd1 vssd1 sky130_fd_sc_hd__fill_4$1
XFILLER_29_781 vssd1 vccd1 vccd1 vssd1 sky130_fd_sc_hd__fill_2$1
XFILLER_35_217 vssd1 vccd1 vccd1 vssd1 sky130_fd_sc_hd__fill_4$1
XFILLER_48_589 vssd1 vccd1 vccd1 vssd1 sky130_fd_sc_hd__fill_4$1
XFILLER_90_345 vssd1 vccd1 vccd1 vssd1 sky130_ef_sc_hd__decap_40_12$1
XTAP_TAPCELL_ROW_106_1888 vccd1 vssd1 sky130_fd_sc_hd__tapvpwrvgnd_1$1
XFILLER_50_209 vssd1 vccd1 vccd1 vssd1 sky130_ef_sc_hd__decap_40_12$1
XFILLER_16_475 vccd1 vssd1 vccd1 vssd1 sky130_fd_sc_hd__fill_1$1
XFILLER_43_261 vssd1 vccd1 vccd1 vssd1 sky130_ef_sc_hd__decap_40_12$1
XFILLER_71_592 vssd1 vccd1 vccd1 vssd1 sky130_ef_sc_hd__decap_40_12$1
XTAP_TAPCELL_ROW_42_930 vccd1 vssd1 sky130_fd_sc_hd__tapvpwrvgnd_1$1
XFILLER_31_445 vssd1 vccd1 vccd1 vssd1 sky130_fd_sc_hd__fill_2$1
XFILLER_129_333 vssd1 vccd1 vccd1 vssd1 sky130_fd_sc_hd__fill_2$1
XFILLER_12_681 vssd1 vccd1 vccd1 vssd1 sky130_ef_sc_hd__decap_40_12$1
XPHY_EDGE_ROW_130_Left_269 vccd1 vssd1 vccd1 vssd1 sky130_fd_sc_hd__decap_3$1
X_1721_ _1721_/Q _1721_/CLK _1721_/D vccd1 vssd1 vccd1 vssd1 sky130_fd_sc_hd__dfxtp_1$1
XFILLER_8_641 vssd1 vccd1 vccd1 vssd1 sky130_fd_sc_hd__fill_2$1
Xhold107 input33/X hold107/X vssd1 vccd1 vccd1 vssd1 sky130_fd_sc_hd__dlygate4sd3_1$1
X_1652_ _1652_/Q _1716_/CLK _1652_/D vccd1 vssd1 vccd1 vssd1 sky130_fd_sc_hd__dfxtp_2$1
Xhold129 _1691_/Q _1324_/A vssd1 vccd1 vccd1 vssd1 sky130_fd_sc_hd__dlygate4sd3_1$1
Xhold118 _1725_/Q _1394_/A vssd1 vccd1 vccd1 vssd1 sky130_fd_sc_hd__dlygate4sd3_1$1
XFILLER_125_561 vssd1 vccd1 vccd1 vssd1 sky130_fd_sc_hd__fill_8$1
X_1583_ _1801_/A _1585_/CLK _1583_/D vccd1 vssd1 vccd1 vssd1 sky130_fd_sc_hd__dfxtp_1$1
XFILLER_112_233 vssd1 vccd1 vccd1 vssd1 sky130_ef_sc_hd__decap_40_12$1
XFILLER_98_445 vssd1 vccd1 vccd1 vssd1 sky130_ef_sc_hd__decap_40_12$1
XFILLER_112_277 vssd1 vccd1 vccd1 vssd1 sky130_ef_sc_hd__decap_40_12$1
XFILLER_100_417 vssd1 vccd1 vccd1 vssd1 sky130_fd_sc_hd__fill_2$1
XFILLER_98_489 vssd1 vccd1 vccd1 vssd1 sky130_ef_sc_hd__decap_40_12$1
XFILLER_67_810 vssd1 vccd1 vccd1 vssd1 sky130_ef_sc_hd__decap_40_12$1
XFILLER_58_309 vssd1 vccd1 vccd1 vssd1 sky130_ef_sc_hd__decap_40_12$1
XFILLER_39_501 vssd1 vccd1 vccd1 vssd1 sky130_fd_sc_hd__fill_2$1
XFILLER_82_813 vssd1 vccd1 vccd1 vssd1 sky130_fd_sc_hd__fill_8$1
XTAP_TAPCELL_ROW_1_316 vccd1 vssd1 sky130_fd_sc_hd__tapvpwrvgnd_1$1
XFILLER_93_161 vssd1 vccd1 vccd1 vssd1 sky130_fd_sc_hd__fill_4$1
XTAP_TAPCELL_ROW_68_1327 vccd1 vssd1 sky130_fd_sc_hd__tapvpwrvgnd_1$1
XTAP_TAPCELL_ROW_68_1316 vccd1 vssd1 sky130_fd_sc_hd__tapvpwrvgnd_1$1
XFILLER_39_589 vssd1 vccd1 vccd1 vssd1 sky130_fd_sc_hd__fill_2$1
XTAP_TAPCELL_ROW_81_1516 vccd1 vssd1 sky130_fd_sc_hd__tapvpwrvgnd_1$1
XFILLER_22_401 vssd1 vccd1 vccd1 vssd1 sky130_ef_sc_hd__decap_40_12$1
X_1017_ _1091_/C1 _1016_/X _1053_/A2 hold78/X _1541_/D vssd1 vccd1 vccd1 vssd1 sky130_fd_sc_hd__o211a_1$1
XFILLER_50_754 vssd1 vccd1 vccd1 vssd1 sky130_fd_sc_hd__fill_2$1
XFILLER_22_445 vssd1 vccd1 vccd1 vssd1 sky130_ef_sc_hd__decap_40_12$1
XFILLER_50_787 vssd1 vccd1 vccd1 vssd1 sky130_fd_sc_hd__fill_8$1
XTAP_TAPCELL_ROW_20_602 vccd1 vssd1 sky130_fd_sc_hd__tapvpwrvgnd_1$1
XFILLER_22_489 vssd1 vccd1 vccd1 vssd1 sky130_ef_sc_hd__decap_40_12$1
XFILLER_123_509 vssd1 vccd1 vccd1 vssd1 sky130_fd_sc_hd__fill_2$1
XTAP_TAPCELL_ROW_79_1489 vccd1 vssd1 sky130_fd_sc_hd__tapvpwrvgnd_1$1
XTAP_TAPCELL_ROW_79_1478 vccd1 vssd1 sky130_fd_sc_hd__tapvpwrvgnd_1$1
XFILLER_116_583 vssd1 vccd1 vccd1 vssd1 sky130_fd_sc_hd__fill_4$1
XFILLER_104_701 vssd1 vccd1 vccd1 vssd1 sky130_fd_sc_hd__fill_4$1
XFILLER_89_412 vssd1 vccd1 vccd1 vssd1 sky130_ef_sc_hd__decap_40_12$1
XTAP_TAPCELL_ROW_9_438 vccd1 vssd1 sky130_fd_sc_hd__tapvpwrvgnd_1$1
XFILLER_1_305 vssd1 vccd1 vccd1 vssd1 sky130_ef_sc_hd__decap_40_12$1
XTAP_TAPCELL_ROW_92_1678 vccd1 vssd1 sky130_fd_sc_hd__tapvpwrvgnd_1$1
XFILLER_1_349 vssd1 vccd1 vccd1 vssd1 sky130_ef_sc_hd__decap_40_12$1
XFILLER_131_553 vssd1 vccd1 vccd1 vssd1 sky130_fd_sc_hd__fill_4$1
XFILLER_77_629 vssd1 vccd1 vccd1 vssd1 sky130_ef_sc_hd__decap_40_12$1
XFILLER_58_810 vssd1 vccd1 vccd1 vssd1 sky130_fd_sc_hd__fill_2$1
XFILLER_131_597 vssd1 vccd1 vccd1 vssd1 sky130_ef_sc_hd__decap_40_12$1
XFILLER_103_277 vssd1 vccd1 vccd1 vssd1 sky130_fd_sc_hd__fill_2$1
XFILLER_94_27 vccd1 vssd1 vccd1 vssd1 sky130_fd_sc_hd__fill_1$1
XFILLER_76_139 vccd1 vssd1 vccd1 vssd1 sky130_fd_sc_hd__fill_1$1
XFILLER_91_109 vssd1 vccd1 vccd1 vssd1 sky130_fd_sc_hd__fill_2$1
XFILLER_72_301 vssd1 vccd1 vccd1 vssd1 sky130_fd_sc_hd__fill_4$1
XFILLER_57_375 vccd1 vssd1 vccd1 vssd1 sky130_fd_sc_hd__fill_1$1
XFILLER_17_217 vssd1 vccd1 vccd1 vssd1 sky130_fd_sc_hd__fill_4$1
XTAP_TAPCELL_ROW_28_713 vccd1 vssd1 sky130_fd_sc_hd__tapvpwrvgnd_1$1
XTAP_TAPCELL_ROW_28_724 vccd1 vssd1 sky130_fd_sc_hd__tapvpwrvgnd_1$1
XTAP_TAPCELL_ROW_123_2144 vccd1 vssd1 sky130_fd_sc_hd__tapvpwrvgnd_1$1
XFILLER_72_345 vssd1 vccd1 vccd1 vssd1 sky130_ef_sc_hd__decap_40_12$1
XFILLER_45_559 vccd1 vssd1 vccd1 vssd1 sky130_fd_sc_hd__fill_1$1
XFILLER_26_762 vssd1 vccd1 vccd1 vssd1 sky130_ef_sc_hd__decap_40_12$1
XFILLER_32_209 vssd1 vccd1 vccd1 vssd1 sky130_ef_sc_hd__decap_40_12$1
XFILLER_25_261 vssd1 vccd1 vccd1 vssd1 sky130_ef_sc_hd__decap_40_12$1
XFILLER_9_405 vssd1 vccd1 vccd1 vssd1 sky130_ef_sc_hd__decap_40_12$1
XFILLER_13_445 vssd1 vccd1 vccd1 vssd1 sky130_fd_sc_hd__fill_2$1
XFILLER_40_253 vssd1 vccd1 vccd1 vssd1 sky130_ef_sc_hd__decap_40_12$1
XFILLER_9_449 vssd1 vccd1 vccd1 vssd1 sky130_ef_sc_hd__decap_40_12$1
XFILLER_138_141 vssd1 vccd1 vccd1 vssd1 sky130_fd_sc_hd__fill_4$1
XFILLER_4_121 vssd1 vccd1 vccd1 vssd1 sky130_ef_sc_hd__decap_40_12$1
XFILLER_107_583 vssd1 vccd1 vccd1 vssd1 sky130_fd_sc_hd__fill_8$1
XFILLER_4_165 vssd1 vccd1 vccd1 vssd1 sky130_ef_sc_hd__decap_40_12$1
XFILLER_122_531 vccd1 vssd1 vccd1 vssd1 sky130_fd_sc_hd__fill_1$1
XFILLER_122_553 vssd1 vccd1 vccd1 vssd1 sky130_fd_sc_hd__fill_2$1
XFILLER_110_726 vssd1 vccd1 vccd1 vssd1 sky130_ef_sc_hd__decap_40_12$1
XFILLER_68_83 vccd1 vssd1 vccd1 vssd1 sky130_fd_sc_hd__fill_1$1
XFILLER_0_393 vssd1 vccd1 vccd1 vssd1 sky130_ef_sc_hd__decap_40_12$1
XTAP_TAPCELL_ROW_108_1917 vccd1 vssd1 sky130_fd_sc_hd__tapvpwrvgnd_1$1
XFILLER_91_610 vssd1 vccd1 vccd1 vssd1 sky130_fd_sc_hd__fill_4$1
XFILLER_82_109 vssd1 vccd1 vccd1 vssd1 sky130_ef_sc_hd__decap_40_12$1
XFILLER_75_161 vssd1 vccd1 vccd1 vssd1 sky130_fd_sc_hd__fill_4$1
XFILLER_64_813 vssd1 vccd1 vccd1 vssd1 sky130_fd_sc_hd__fill_4$1
XFILLER_91_665 vssd1 vccd1 vccd1 vssd1 sky130_fd_sc_hd__fill_4$1
XFILLER_90_153 vssd1 vccd1 vccd1 vssd1 sky130_ef_sc_hd__decap_40_12$1
XFILLER_51_529 vssd1 vccd1 vccd1 vssd1 sky130_ef_sc_hd__decap_40_12$1
XFILLER_90_197 vssd1 vccd1 vccd1 vssd1 sky130_ef_sc_hd__decap_40_12$1
XFILLER_44_581 vssd1 vccd1 vccd1 vssd1 sky130_fd_sc_hd__fill_4$1
XTAP_TAPCELL_ROW_63_1246 vccd1 vssd1 sky130_fd_sc_hd__tapvpwrvgnd_1$1
XFILLER_83_3 vssd1 vccd1 vccd1 vssd1 sky130_ef_sc_hd__decap_40_12$1
X_1704_ _1827_/A _1704_/CLK _1704_/D vccd1 vssd1 vccd1 vssd1 sky130_fd_sc_hd__dfxtp_1$1
XFILLER_132_317 vssd1 vccd1 vccd1 vssd1 sky130_ef_sc_hd__decap_40_12$1
X_1635_ _1635_/Q _1761_/CLK hold65/X vccd1 vssd1 vccd1 vssd1 sky130_fd_sc_hd__dfxtp_1$1
XFILLER_125_391 vccd1 vssd1 vccd1 vssd1 sky130_fd_sc_hd__fill_1$1
X_1566_ _1566_/Q _1726_/CLK _1566_/D vccd1 vssd1 vccd1 vssd1 sky130_fd_sc_hd__dfxtp_1$1
XFILLER_113_553 vssd1 vccd1 vccd1 vssd1 sky130_fd_sc_hd__fill_4$1
XFILLER_99_765 vssd1 vccd1 vccd1 vssd1 sky130_ef_sc_hd__decap_40_12$1
XFILLER_98_253 vssd1 vccd1 vccd1 vssd1 sky130_ef_sc_hd__decap_40_12$1
XFILLER_59_629 vccd1 vssd1 vccd1 vssd1 sky130_fd_sc_hd__fill_1$1
X_1497_ _1497_/Q _1754_/CLK _1497_/D vccd1 vssd1 vccd1 vssd1 sky130_fd_sc_hd__dfxtp_2$1
XFILLER_58_139 vccd1 vssd1 vccd1 vssd1 sky130_fd_sc_hd__fill_1$1
XFILLER_104_15 vssd1 vccd1 vccd1 vssd1 sky130_ef_sc_hd__decap_40_12$1
XFILLER_82_621 vccd1 vssd1 vccd1 vssd1 sky130_fd_sc_hd__fill_1$1
XFILLER_73_109 vssd1 vccd1 vccd1 vssd1 sky130_fd_sc_hd__fill_2$1
XFILLER_67_673 vssd1 vccd1 vccd1 vssd1 sky130_ef_sc_hd__decap_40_12$1
XFILLER_54_301 vssd1 vccd1 vccd1 vssd1 sky130_fd_sc_hd__fill_4$1
XFILLER_82_643 vccd1 vssd1 vccd1 vssd1 sky130_fd_sc_hd__fill_1$1
XFILLER_54_345 vssd1 vccd1 vccd1 vssd1 sky130_ef_sc_hd__decap_40_12$1
XFILLER_27_559 vccd1 vssd1 vccd1 vssd1 sky130_fd_sc_hd__fill_1$1
XFILLER_70_805 vssd1 vccd1 vccd1 vssd1 sky130_fd_sc_hd__fill_4$1
XFILLER_14_209 vssd1 vccd1 vccd1 vssd1 sky130_ef_sc_hd__decap_40_12$1
XFILLER_42_529 vssd1 vccd1 vccd1 vssd1 sky130_fd_sc_hd__fill_2$1
XFILLER_23_721 vssd1 vccd1 vccd1 vssd1 sky130_fd_sc_hd__fill_4$1
XFILLER_80_29 vssd1 vccd1 vccd1 vssd1 sky130_ef_sc_hd__decap_40_12$1
XFILLER_22_253 vssd1 vccd1 vccd1 vssd1 sky130_ef_sc_hd__decap_40_12$1
XTAP_TAPCELL_ROW_33_793 vccd1 vssd1 sky130_fd_sc_hd__tapvpwrvgnd_1$1
XFILLER_135_111 vccd1 vssd1 vccd1 vssd1 sky130_fd_sc_hd__fill_1$1
XFILLER_6_419 vccd1 vssd1 vccd1 vssd1 sky130_fd_sc_hd__fill_1$1
XFILLER_136_667 vssd1 vccd1 vccd1 vssd1 sky130_ef_sc_hd__decap_40_12$1
XFILLER_136_645 vssd1 vccd1 vccd1 vssd1 sky130_fd_sc_hd__fill_4$1
XTAP_TAPCELL_ROW_94_1707 vccd1 vssd1 sky130_fd_sc_hd__tapvpwrvgnd_1$1
XFILLER_89_27 vssd1 vccd1 vccd1 vssd1 sky130_ef_sc_hd__decap_40_12$1
XFILLER_123_317 vssd1 vccd1 vccd1 vssd1 sky130_ef_sc_hd__decap_40_12$1
XFILLER_1_113 vssd1 vccd1 vccd1 vssd1 sky130_ef_sc_hd__decap_40_12$1
XFILLER_2_625 vssd1 vccd1 vccd1 vssd1 sky130_ef_sc_hd__decap_40_12$1
XFILLER_2_669 vssd1 vccd1 vccd1 vssd1 sky130_ef_sc_hd__decap_40_12$1
XFILLER_131_361 vssd1 vccd1 vccd1 vssd1 sky130_ef_sc_hd__decap_40_12$1
XFILLER_38_53 vssd1 vccd1 vccd1 vssd1 sky130_ef_sc_hd__decap_40_12$1
XFILLER_100_781 vssd1 vccd1 vccd1 vssd1 sky130_ef_sc_hd__decap_40_12$1
XFILLER_64_109 vssd1 vccd1 vccd1 vssd1 sky130_ef_sc_hd__decap_40_12$1
XFILLER_57_161 vssd1 vccd1 vccd1 vssd1 sky130_fd_sc_hd__fill_4$1
XFILLER_38_97 vssd1 vccd1 vccd1 vssd1 sky130_ef_sc_hd__decap_40_12$1
XFILLER_46_813 vssd1 vccd1 vccd1 vssd1 sky130_ef_sc_hd__decap_40_12$1
XFILLER_72_153 vssd1 vccd1 vccd1 vssd1 sky130_ef_sc_hd__decap_40_12$1
XFILLER_54_41 vssd1 vccd1 vccd1 vssd1 sky130_ef_sc_hd__decap_40_12$1
XFILLER_72_197 vssd1 vccd1 vccd1 vssd1 sky130_ef_sc_hd__decap_40_12$1
XFILLER_26_581 vssd1 vccd1 vccd1 vssd1 sky130_fd_sc_hd__fill_4$1
XFILLER_33_529 vssd1 vccd1 vccd1 vssd1 sky130_ef_sc_hd__decap_40_12$1
XFILLER_45_389 vssd1 vccd1 vccd1 vssd1 sky130_fd_sc_hd__fill_2$1
XTAP_TAPCELL_ROW_103_1847 vccd1 vssd1 sky130_fd_sc_hd__tapvpwrvgnd_1$1
XFILLER_54_85 vssd1 vccd1 vccd1 vssd1 sky130_ef_sc_hd__decap_40_12$1
XTAP_TAPCELL_ROW_136_2346 vccd1 vssd1 sky130_fd_sc_hd__tapvpwrvgnd_1$1
XTAP_TAPCELL_ROW_136_2335 vccd1 vssd1 sky130_fd_sc_hd__tapvpwrvgnd_1$1
XFILLER_41_595 vssd1 vccd1 vccd1 vssd1 sky130_fd_sc_hd__fill_2$1
XTAP_TAPCELL_ROW_11_465 vccd1 vssd1 sky130_fd_sc_hd__tapvpwrvgnd_1$1
XFILLER_9_279 vccd1 vssd1 vccd1 vssd1 sky130_fd_sc_hd__fill_1$1
Xclkload16 clkload16/Y _1585_/CLK vccd1 vssd1 vccd1 vssd1 sky130_fd_sc_hd__inv_4$1
XFILLER_126_133 vssd1 vccd1 vccd1 vssd1 sky130_fd_sc_hd__fill_4$1
Xclkload27 clkload27/Y _1759_/CLK vccd1 vssd1 vccd1 vssd1 sky130_fd_sc_hd__clkinv_2$1
Xclkload38 clkload38/Y _1737_/CLK vccd1 vssd1 vccd1 vssd1 sky130_fd_sc_hd__inv_4$1
XFILLER_126_177 vssd1 vccd1 vccd1 vssd1 sky130_ef_sc_hd__decap_40_12$1
XFILLER_5_441 vssd1 vccd1 vccd1 vssd1 sky130_fd_sc_hd__fill_4$1
XFILLER_107_391 vccd1 vssd1 vccd1 vssd1 sky130_fd_sc_hd__fill_1$1
X_1420_ _1845_/A _1420_/X _1474_/B vssd1 vccd1 vccd1 vssd1 sky130_fd_sc_hd__or2_1$1
XFILLER_5_485 vssd1 vccd1 vccd1 vssd1 sky130_ef_sc_hd__decap_40_12$1
XFILLER_96_713 vssd1 vccd1 vccd1 vssd1 sky130_fd_sc_hd__fill_2$1
XFILLER_79_93 vssd1 vccd1 vccd1 vssd1 sky130_ef_sc_hd__decap_40_12$1
X_1351_ _1421_/C1 _1350_/X _1409_/A2 hold71/X _1703_/D vssd1 vccd1 vccd1 vssd1 sky130_fd_sc_hd__o211a_1$1
XFILLER_122_361 vssd1 vccd1 vccd1 vssd1 sky130_fd_sc_hd__fill_2$1
XFILLER_95_223 vccd1 vssd1 vccd1 vssd1 sky130_fd_sc_hd__fill_1$1
XFILLER_110_545 vssd1 vccd1 vccd1 vssd1 sky130_ef_sc_hd__decap_40_12$1
X_1282_ _1838_/A _1282_/X _1342_/B vssd1 vccd1 vccd1 vssd1 sky130_fd_sc_hd__or2_1$1
XFILLER_110_589 vssd1 vccd1 vccd1 vssd1 sky130_ef_sc_hd__decap_40_12$1
XFILLER_95_81 vssd1 vccd1 vccd1 vssd1 sky130_ef_sc_hd__decap_40_12$1
XFILLER_83_429 vssd1 vccd1 vccd1 vssd1 sky130_ef_sc_hd__decap_40_12$1
XFILLER_55_109 vssd1 vccd1 vccd1 vssd1 sky130_fd_sc_hd__fill_2$1
XFILLER_49_673 vssd1 vccd1 vccd1 vssd1 sky130_ef_sc_hd__decap_40_12$1
XFILLER_36_301 vssd1 vccd1 vccd1 vssd1 sky130_fd_sc_hd__fill_4$1
XFILLER_76_481 vccd1 vssd1 vccd1 vssd1 sky130_fd_sc_hd__fill_1$1
XFILLER_64_621 vssd1 vccd1 vccd1 vssd1 sky130_ef_sc_hd__decap_40_12$1
XFILLER_64_643 vccd1 vssd1 vccd1 vssd1 sky130_fd_sc_hd__fill_1$1
XFILLER_36_345 vssd1 vccd1 vccd1 vssd1 sky130_ef_sc_hd__decap_40_12$1
XFILLER_91_473 vssd1 vccd1 vccd1 vssd1 sky130_ef_sc_hd__decap_40_12$1
XFILLER_52_805 vssd1 vccd1 vccd1 vssd1 sky130_fd_sc_hd__fill_4$1
XFILLER_64_698 vssd1 vccd1 vccd1 vssd1 sky130_fd_sc_hd__fill_2$1
XFILLER_51_337 vssd1 vccd1 vccd1 vssd1 sky130_ef_sc_hd__decap_40_12$1
XTAP_TAPCELL_ROW_19_587 vccd1 vssd1 sky130_fd_sc_hd__tapvpwrvgnd_1$1
XFILLER_24_529 vssd1 vccd1 vccd1 vssd1 sky130_fd_sc_hd__fill_2$1
XFILLER_36_389 vssd1 vccd1 vccd1 vssd1 sky130_ef_sc_hd__decap_40_12$1
XFILLER_20_713 vssd1 vccd1 vccd1 vssd1 sky130_ef_sc_hd__decap_40_12$1
XFILLER_20_757 vssd1 vccd1 vccd1 vssd1 sky130_ef_sc_hd__decap_40_12$1
X_0997_ _0739_/D _0996_/X _1013_/A2 hold14/X _1532_/D vssd1 vccd1 vccd1 vssd1 sky130_fd_sc_hd__o211a_1$1
XFILLER_118_601 vssd1 vccd1 vccd1 vssd1 sky130_fd_sc_hd__fill_2$1
XTAP_TAPCELL_ROW_30_752 vccd1 vssd1 sky130_fd_sc_hd__tapvpwrvgnd_1$1
XFILLER_118_645 vssd1 vccd1 vccd1 vssd1 sky130_ef_sc_hd__decap_40_12$1
XFILLER_117_111 vccd1 vssd1 vccd1 vssd1 sky130_fd_sc_hd__fill_1$1
XFILLER_133_615 vccd1 vssd1 vccd1 vssd1 sky130_fd_sc_hd__fill_1$1
XFILLER_118_678 vccd1 vssd1 vccd1 vssd1 sky130_fd_sc_hd__fill_1$1
XFILLER_105_317 vssd1 vccd1 vccd1 vssd1 sky130_ef_sc_hd__decap_40_12$1
XTAP_TAPCELL_ROW_76_1437 vccd1 vssd1 sky130_fd_sc_hd__tapvpwrvgnd_1$1
X_1618_ _1822_/A clkload6/A _1618_/D vccd1 vssd1 vccd1 vssd1 sky130_fd_sc_hd__dfxtp_1$1
Xfanout203 _1475_/A2 _1465_/A2 vssd1 vccd1 vccd1 vssd1 sky130_fd_sc_hd__clkbuf_8$1
XFILLER_120_309 vssd1 vccd1 vccd1 vssd1 sky130_ef_sc_hd__decap_40_12$1
Xfanout214 _1342_/B vccd1 vssd1 _1278_/X vccd1 vssd1 sky130_fd_sc_hd__buf_4$1
XFILLER_99_551 vssd1 vccd1 vccd1 vssd1 sky130_fd_sc_hd__fill_8$1
Xfanout247 _1345_/A _1344_/A vssd1 vccd1 vccd1 vssd1 sky130_fd_sc_hd__buf_8$1
XFILLER_113_361 vssd1 vccd1 vccd1 vssd1 sky130_ef_sc_hd__decap_40_12$1
Xfanout236 _0880_/A2 vccd1 vssd1 _0752_/A vccd1 vssd1 sky130_fd_sc_hd__buf_6$1
Xfanout225 _1122_/B vccd1 vssd1 _1144_/B vccd1 vssd1 sky130_fd_sc_hd__buf_4$1
X_1549_ _1549_/Q clkload2/A _1549_/D vccd1 vssd1 vccd1 vssd1 sky130_fd_sc_hd__dfxtp_1$1
Xfanout269 _1463_/C1 vccd1 vssd1 _0739_/D vccd1 vssd1 sky130_fd_sc_hd__buf_4$1
XFILLER_115_69 vssd1 vccd1 vccd1 vssd1 sky130_ef_sc_hd__decap_40_12$1
XFILLER_87_768 vssd1 vccd1 vccd1 vssd1 sky130_fd_sc_hd__fill_4$1
XFILLER_86_245 vssd1 vccd1 vccd1 vssd1 sky130_fd_sc_hd__fill_4$1
Xfanout258 _1449_/C1 vccd1 vssd1 _1447_/C1 vccd1 vssd1 sky130_fd_sc_hd__buf_4$1
XFILLER_86_289 vssd1 vccd1 vccd1 vssd1 sky130_ef_sc_hd__decap_40_12$1
XFILLER_74_418 vssd1 vccd1 vccd1 vssd1 sky130_fd_sc_hd__fill_2$1
XFILLER_28_813 vssd1 vccd1 vccd1 vssd1 sky130_ef_sc_hd__decap_40_12$1
XFILLER_39_161 vssd1 vccd1 vccd1 vssd1 sky130_fd_sc_hd__fill_4$1
XFILLER_46_109 vssd1 vccd1 vccd1 vssd1 sky130_ef_sc_hd__decap_40_12$1
XFILLER_55_621 vssd1 vccd1 vccd1 vssd1 sky130_ef_sc_hd__decap_40_12$1
XFILLER_131_57 vssd1 vccd1 vccd1 vssd1 sky130_ef_sc_hd__decap_40_12$1
XTAP_TAPCELL_ROW_120_2103 vccd1 vssd1 sky130_fd_sc_hd__tapvpwrvgnd_1$1
XFILLER_54_153 vssd1 vccd1 vccd1 vssd1 sky130_ef_sc_hd__decap_40_12$1
XTAP_TAPCELL_ROW_38_863 vccd1 vssd1 sky130_fd_sc_hd__tapvpwrvgnd_1$1
XTAP_TAPCELL_ROW_38_874 vccd1 vssd1 sky130_fd_sc_hd__tapvpwrvgnd_1$1
XFILLER_91_39 vssd1 vccd1 vccd1 vssd1 sky130_ef_sc_hd__decap_40_12$1
XTAP_TAPCELL_ROW_87_1599 vccd1 vssd1 sky130_fd_sc_hd__tapvpwrvgnd_1$1
XFILLER_82_473 vssd1 vccd1 vccd1 vssd1 sky130_fd_sc_hd__fill_2$1
XFILLER_70_613 vssd1 vccd1 vccd1 vssd1 sky130_ef_sc_hd__decap_40_12$1
XFILLER_54_197 vssd1 vccd1 vccd1 vssd1 sky130_ef_sc_hd__decap_40_12$1
XFILLER_15_529 vssd1 vccd1 vccd1 vssd1 sky130_ef_sc_hd__decap_40_12$1
XFILLER_27_389 vssd1 vccd1 vccd1 vssd1 sky130_fd_sc_hd__fill_2$1
XFILLER_70_679 vssd1 vccd1 vccd1 vssd1 sky130_fd_sc_hd__fill_2$1
XFILLER_70_657 vssd1 vccd1 vccd1 vssd1 sky130_ef_sc_hd__decap_40_12$1
XFILLER_23_573 vssd1 vccd1 vccd1 vssd1 sky130_ef_sc_hd__decap_40_12$1
XFILLER_24_77 vssd1 vccd1 vccd1 vssd1 sky130_fd_sc_hd__fill_4$1
XFILLER_10_245 vssd1 vccd1 vccd1 vssd1 sky130_fd_sc_hd__fill_4$1
XTAP_TAPCELL_ROW_118_2076 vccd1 vssd1 sky130_fd_sc_hd__tapvpwrvgnd_1$1
XTAP_TAPCELL_ROW_118_2065 vccd1 vssd1 sky130_fd_sc_hd__tapvpwrvgnd_1$1
XFILLER_109_645 vssd1 vccd1 vccd1 vssd1 sky130_ef_sc_hd__decap_40_12$1
XFILLER_108_133 vssd1 vccd1 vccd1 vssd1 sky130_fd_sc_hd__fill_4$1
XFILLER_10_289 vssd1 vccd1 vccd1 vssd1 sky130_ef_sc_hd__decap_40_12$1
XFILLER_6_249 vssd1 vccd1 vccd1 vssd1 sky130_fd_sc_hd__fill_2$1
XFILLER_136_486 vssd1 vccd1 vccd1 vssd1 sky130_ef_sc_hd__decap_40_12$1
XFILLER_136_475 vccd1 vssd1 vccd1 vssd1 sky130_fd_sc_hd__fill_1$1
XFILLER_136_453 vssd1 vccd1 vccd1 vssd1 sky130_fd_sc_hd__fill_2$1
XFILLER_108_177 vssd1 vccd1 vccd1 vssd1 sky130_ef_sc_hd__decap_40_12$1
XFILLER_40_65 vssd1 vccd1 vccd1 vssd1 sky130_ef_sc_hd__decap_40_12$1
XTAP_TAPCELL_ROW_131_2265 vccd1 vssd1 sky130_fd_sc_hd__tapvpwrvgnd_1$1
XFILLER_123_125 vssd1 vccd1 vccd1 vssd1 sky130_ef_sc_hd__decap_40_12$1
XFILLER_123_169 vssd1 vccd1 vccd1 vssd1 sky130_ef_sc_hd__decap_40_12$1
XFILLER_2_433 vssd1 vccd1 vccd1 vssd1 sky130_ef_sc_hd__decap_40_12$1
XFILLER_132_681 vssd1 vccd1 vccd1 vssd1 sky130_fd_sc_hd__fill_8$1
XFILLER_104_361 vssd1 vccd1 vccd1 vssd1 sky130_fd_sc_hd__fill_2$1
XFILLER_77_223 vccd1 vssd1 vccd1 vssd1 sky130_fd_sc_hd__fill_1$1
XFILLER_2_477 vssd1 vccd1 vccd1 vssd1 sky130_ef_sc_hd__decap_40_12$1
XFILLER_78_757 vssd1 vccd1 vccd1 vssd1 sky130_ef_sc_hd__decap_40_12$1
XFILLER_93_727 vccd1 vssd1 vccd1 vssd1 sky130_fd_sc_hd__fill_1$1
XFILLER_1_15 vssd1 vccd1 vccd1 vssd1 sky130_ef_sc_hd__decap_40_12$1
XFILLER_18_301 vssd1 vccd1 vccd1 vssd1 sky130_fd_sc_hd__fill_4$1
XFILLER_37_109 vssd1 vccd1 vccd1 vssd1 sky130_fd_sc_hd__fill_2$1
XFILLER_86_790 vssd1 vccd1 vccd1 vssd1 sky130_ef_sc_hd__decap_40_12$1
XFILLER_65_51 vssd1 vccd1 vccd1 vssd1 sky130_fd_sc_hd__fill_4$1
XFILLER_46_643 vccd1 vssd1 vccd1 vssd1 sky130_fd_sc_hd__fill_1$1
XFILLER_18_345 vssd1 vccd1 vccd1 vssd1 sky130_ef_sc_hd__decap_40_12$1
XTAP_TAPCELL_ROW_47_1005 vccd1 vssd1 sky130_fd_sc_hd__tapvpwrvgnd_1$1
XFILLER_73_473 vssd1 vccd1 vccd1 vssd1 sky130_ef_sc_hd__decap_40_12$1
XFILLER_61_613 vssd1 vccd1 vccd1 vssd1 sky130_fd_sc_hd__fill_2$1
XFILLER_18_389 vssd1 vccd1 vccd1 vssd1 sky130_ef_sc_hd__decap_40_12$1
XFILLER_33_337 vssd1 vccd1 vccd1 vssd1 sky130_ef_sc_hd__decap_40_12$1
XTAP_TAPCELL_ROW_16_535 vccd1 vssd1 sky130_fd_sc_hd__tapvpwrvgnd_1$1
XTAP_TAPCELL_ROW_16_546 vccd1 vssd1 sky130_fd_sc_hd__tapvpwrvgnd_1$1
X_0920_ _1536_/Q wire252/X _0921_/C _1696_/Q _1279_/A vccd1 vssd1 vccd1 vssd1 sky130_fd_sc_hd__a22o_1$1
XTAP_TAPCELL_ROW_60_1205 vccd1 vssd1 sky130_fd_sc_hd__tapvpwrvgnd_1$1
XFILLER_60_189 vssd1 vccd1 vccd1 vssd1 sky130_fd_sc_hd__fill_4$1
X_0851_ hold38/A _1147_/A _0851_/X hold42/A _1411_/A vccd1 vssd1 vccd1 vssd1 sky130_fd_sc_hd__a22o_1$1
X_0782_ _0879_/B1 _0782_/X _0781_/X _1786_/A _0875_/A2 _0780_/X vssd1 vccd1 vccd1
+ vssd1 sky130_fd_sc_hd__a2111o_1$1
XFILLER_115_626 vssd1 vccd1 vccd1 vssd1 sky130_fd_sc_hd__fill_2$1
XTAP_TAPCELL_ROW_58_1167 vccd1 vssd1 sky130_fd_sc_hd__tapvpwrvgnd_1$1
XFILLER_102_309 vssd1 vccd1 vccd1 vssd1 sky130_ef_sc_hd__decap_40_12$1
XFILLER_5_293 vssd1 vccd1 vccd1 vssd1 sky130_ef_sc_hd__decap_40_12$1
XFILLER_46_3 vssd1 vccd1 vccd1 vssd1 sky130_ef_sc_hd__decap_40_12$1
XFILLER_111_832 vssd1 vccd1 vccd1 vssd1 sky130_fd_sc_hd__fill_4$1
X_1403_ _1471_/C1 _1402_/X _1345_/Y hold49/X _1729_/D vssd1 vccd1 vccd1 vssd1 sky130_fd_sc_hd__o211a_1$1
XPHY_EDGE_ROW_18_Right_18 vccd1 vssd1 vccd1 vssd1 sky130_fd_sc_hd__decap_3$1
X_1334_ _1334_/A _1334_/X _1342_/B vssd1 vccd1 vccd1 vssd1 sky130_fd_sc_hd__or2_1$1
XFILLER_96_565 vssd1 vccd1 vccd1 vssd1 sky130_ef_sc_hd__decap_40_12$1
XTAP_TAPCELL_ROW_71_1367 vccd1 vssd1 sky130_fd_sc_hd__tapvpwrvgnd_1$1
XFILLER_68_245 vssd1 vccd1 vccd1 vssd1 sky130_fd_sc_hd__fill_4$1
X_1265_ _1471_/C1 _1264_/X _1213_/Y hold81/X _1662_/D vssd1 vccd1 vccd1 vssd1 sky130_fd_sc_hd__o211a_1$1
XFILLER_96_587 vccd1 vssd1 vccd1 vssd1 sky130_fd_sc_hd__fill_1$1
XFILLER_68_289 vssd1 vccd1 vccd1 vssd1 sky130_ef_sc_hd__decap_40_12$1
XFILLER_28_109 vssd1 vccd1 vccd1 vssd1 sky130_ef_sc_hd__decap_40_12$1
XFILLER_83_237 vssd1 vccd1 vccd1 vssd1 sky130_ef_sc_hd__decap_40_12$1
Xinput3 adc_data[11] input3/X vccd1 vssd1 vccd1 vssd1 sky130_fd_sc_hd__dlymetal6s2s_1$1
X_1196_ _1629_/Q _1196_/X _1210_/B vssd1 vccd1 vccd1 vssd1 sky130_fd_sc_hd__or2_1$1
XFILLER_36_153 vssd1 vccd1 vccd1 vssd1 sky130_ef_sc_hd__decap_40_12$1
XFILLER_37_665 vssd1 vccd1 vccd1 vssd1 sky130_fd_sc_hd__fill_4$1
XFILLER_91_281 vssd1 vccd1 vccd1 vssd1 sky130_ef_sc_hd__decap_40_12$1
XFILLER_52_613 vssd1 vccd1 vccd1 vssd1 sky130_ef_sc_hd__decap_40_12$1
XTAP_TAPCELL_ROW_35_822 vccd1 vssd1 sky130_fd_sc_hd__tapvpwrvgnd_1$1
XFILLER_101_27 vssd1 vccd1 vccd1 vssd1 sky130_ef_sc_hd__decap_40_12$1
XFILLER_52_657 vssd1 vccd1 vccd1 vssd1 sky130_ef_sc_hd__decap_40_12$1
XPHY_EDGE_ROW_27_Right_27 vccd1 vssd1 vccd1 vssd1 sky130_fd_sc_hd__decap_3$1
XFILLER_36_197 vssd1 vccd1 vccd1 vssd1 sky130_ef_sc_hd__decap_40_12$1
XFILLER_51_167 vccd1 vssd1 vccd1 vssd1 sky130_fd_sc_hd__fill_1$1
XFILLER_118_431 vssd1 vccd1 vccd1 vssd1 sky130_ef_sc_hd__decap_40_12$1
XFILLER_20_587 vccd1 vssd1 vccd1 vssd1 sky130_fd_sc_hd__fill_1$1
XFILLER_105_125 vssd1 vccd1 vccd1 vssd1 sky130_ef_sc_hd__decap_40_12$1
XFILLER_121_607 vccd1 vssd1 vccd1 vssd1 sky130_fd_sc_hd__fill_1$1
XFILLER_105_169 vssd1 vccd1 vccd1 vssd1 sky130_ef_sc_hd__decap_40_12$1
XPHY_EDGE_ROW_36_Right_36 vccd1 vssd1 vccd1 vssd1 sky130_fd_sc_hd__decap_3$1
XFILLER_102_832 vssd1 vccd1 vccd1 vssd1 sky130_fd_sc_hd__fill_8$1
XFILLER_120_139 vccd1 vssd1 vccd1 vssd1 sky130_fd_sc_hd__fill_1$1
XFILLER_59_223 vccd1 vssd1 vccd1 vssd1 sky130_fd_sc_hd__fill_1$1
XTAP_TAPCELL_ROW_89_1639 vccd1 vssd1 sky130_fd_sc_hd__tapvpwrvgnd_1$1
XTAP_TAPCELL_ROW_89_1628 vccd1 vssd1 sky130_fd_sc_hd__tapvpwrvgnd_1$1
XFILLER_75_727 vccd1 vssd1 vccd1 vssd1 sky130_fd_sc_hd__fill_1$1
XFILLER_19_55 vccd1 vssd1 vccd1 vssd1 sky130_fd_sc_hd__fill_1$1
XFILLER_19_109 vssd1 vccd1 vccd1 vssd1 sky130_fd_sc_hd__fill_2$1
XFILLER_47_429 vssd1 vccd1 vccd1 vssd1 sky130_fd_sc_hd__fill_4$1
XFILLER_28_643 vccd1 vssd1 vccd1 vssd1 sky130_fd_sc_hd__fill_1$1
XFILLER_16_805 vssd1 vccd1 vccd1 vssd1 sky130_fd_sc_hd__fill_4$1
XFILLER_83_793 vccd1 vssd1 vccd1 vssd1 sky130_fd_sc_hd__fill_1$1
XFILLER_55_473 vssd1 vccd1 vccd1 vssd1 sky130_ef_sc_hd__decap_40_12$1
XPHY_EDGE_ROW_45_Right_45 vccd1 vssd1 vccd1 vssd1 sky130_fd_sc_hd__decap_3$1
XFILLER_15_337 vssd1 vccd1 vccd1 vssd1 sky130_ef_sc_hd__decap_40_12$1
XTAP_TAPCELL_ROW_100_1806 vccd1 vssd1 sky130_fd_sc_hd__tapvpwrvgnd_1$1
XFILLER_30_307 vccd1 vssd1 vccd1 vssd1 sky130_fd_sc_hd__fill_1$1
XFILLER_51_690 vssd1 vccd1 vccd1 vssd1 sky130_ef_sc_hd__decap_40_12$1
XFILLER_42_189 vssd1 vccd1 vccd1 vssd1 sky130_fd_sc_hd__fill_4$1
XFILLER_129_729 vssd1 vccd1 vccd1 vssd1 sky130_ef_sc_hd__decap_40_12$1
XFILLER_7_503 vccd1 vssd1 vccd1 vssd1 sky130_fd_sc_hd__fill_1$1
XFILLER_124_401 vssd1 vccd1 vccd1 vssd1 sky130_ef_sc_hd__decap_40_12$1
XPHY_EDGE_ROW_54_Right_54 vccd1 vssd1 vccd1 vssd1 sky130_fd_sc_hd__decap_3$1
XFILLER_124_445 vssd1 vccd1 vccd1 vssd1 sky130_ef_sc_hd__decap_40_12$1
XFILLER_3_753 vssd1 vccd1 vccd1 vssd1 sky130_ef_sc_hd__decap_40_12$1
XFILLER_97_329 vssd1 vccd1 vccd1 vssd1 sky130_fd_sc_hd__fill_4$1
XFILLER_3_797 vssd1 vccd1 vccd1 vssd1 sky130_ef_sc_hd__decap_40_12$1
XTAP_TAPCELL_ROW_111_1968 vccd1 vssd1 sky130_fd_sc_hd__tapvpwrvgnd_1$1
XFILLER_78_587 vccd1 vssd1 vccd1 vssd1 sky130_fd_sc_hd__fill_1$1
XTAP_TAPCELL_ROW_53_1097 vccd1 vssd1 sky130_fd_sc_hd__tapvpwrvgnd_1$1
XFILLER_120_695 vssd1 vccd1 vccd1 vssd1 sky130_fd_sc_hd__fill_4$1
XFILLER_76_83 vccd1 vssd1 vccd1 vssd1 sky130_fd_sc_hd__fill_1$1
XFILLER_65_237 vssd1 vccd1 vccd1 vssd1 sky130_ef_sc_hd__decap_40_12$1
XFILLER_93_557 vssd1 vccd1 vccd1 vssd1 sky130_fd_sc_hd__fill_2$1
XFILLER_81_719 vccd1 vssd1 vccd1 vssd1 sky130_fd_sc_hd__fill_1$1
X_1050_ _1050_/A _1050_/X _1052_/B vssd1 vccd1 vccd1 vssd1 sky130_fd_sc_hd__or2_1$1
XPHY_EDGE_ROW_63_Right_63 vccd1 vssd1 vccd1 vssd1 sky130_fd_sc_hd__decap_3$1
XFILLER_19_665 vssd1 vccd1 vccd1 vssd1 sky130_fd_sc_hd__fill_4$1
XFILLER_74_793 vssd1 vccd1 vccd1 vssd1 sky130_ef_sc_hd__decap_40_12$1
XFILLER_18_153 vssd1 vccd1 vccd1 vssd1 sky130_ef_sc_hd__decap_40_12$1
XFILLER_34_613 vccd1 vssd1 vccd1 vssd1 sky130_fd_sc_hd__fill_1$1
XFILLER_46_473 vssd1 vccd1 vccd1 vssd1 sky130_fd_sc_hd__fill_2$1
XFILLER_73_281 vssd1 vccd1 vccd1 vssd1 sky130_ef_sc_hd__decap_40_12$1
XFILLER_18_197 vssd1 vccd1 vccd1 vssd1 sky130_ef_sc_hd__decap_40_12$1
XFILLER_33_167 vccd1 vssd1 vccd1 vssd1 sky130_fd_sc_hd__fill_1$1
XFILLER_34_679 vssd1 vccd1 vccd1 vssd1 sky130_ef_sc_hd__decap_40_12$1
XFILLER_21_329 vssd1 vccd1 vccd1 vssd1 sky130_fd_sc_hd__fill_4$1
XFILLER_42_690 vssd1 vccd1 vccd1 vssd1 sky130_fd_sc_hd__fill_8$1
XFILLER_119_217 vssd1 vccd1 vccd1 vssd1 sky130_fd_sc_hd__fill_4$1
X_0903_ _0945_/A _0903_/X _0903_/B _0903_/C vccd1 vssd1 vccd1 vssd1 sky130_fd_sc_hd__or3_1$1
X_0834_ _1854_/A _1411_/A _0834_/X hold44/A _1279_/A vccd1 vssd1 vccd1 vssd1 sky130_fd_sc_hd__a22o_1$1
XFILLER_134_209 vssd1 vccd1 vccd1 vssd1 sky130_ef_sc_hd__decap_40_12$1
XPHY_EDGE_ROW_72_Right_72 vccd1 vssd1 vccd1 vssd1 sky130_fd_sc_hd__decap_3$1
XFILLER_127_261 vssd1 vccd1 vccd1 vssd1 sky130_ef_sc_hd__decap_40_12$1
X_0765_ _0880_/A2 _1478_/D _0761_/X _1441_/C1 _1478_/Q _0764_/X vssd1 vccd1 vccd1
+ vssd1 sky130_fd_sc_hd__o221a_1$1
XFILLER_88_307 vccd1 vssd1 vccd1 vssd1 sky130_fd_sc_hd__fill_1$1
XFILLER_103_629 vssd1 vccd1 vccd1 vssd1 sky130_ef_sc_hd__decap_40_12$1
XFILLER_102_139 vccd1 vssd1 vccd1 vssd1 sky130_fd_sc_hd__fill_1$1
XFILLER_97_841 vccd1 vssd1 vccd1 vssd1 sky130_fd_sc_hd__fill_1$1
XFILLER_111_673 vccd1 vssd1 vccd1 vssd1 sky130_fd_sc_hd__fill_1$1
XFILLER_57_727 vccd1 vssd1 vccd1 vssd1 sky130_fd_sc_hd__fill_1$1
XPHY_EDGE_ROW_81_Right_81 vccd1 vssd1 vccd1 vssd1 sky130_fd_sc_hd__decap_3$1
X_1317_ _1449_/C1 _1316_/X _1331_/A2 hold98/X _1687_/D vssd1 vccd1 vccd1 vssd1 sky130_fd_sc_hd__o211a_1$1
XPHY_EDGE_ROW_16_Left_155 vccd1 vssd1 vccd1 vssd1 sky130_fd_sc_hd__decap_3$1
XFILLER_29_429 vssd1 vccd1 vccd1 vssd1 sky130_ef_sc_hd__decap_40_12$1
XFILLER_112_15 vssd1 vccd1 vccd1 vssd1 sky130_ef_sc_hd__decap_40_12$1
X_1248_ _1654_/Q _1248_/X _1276_/B vssd1 vccd1 vccd1 vssd1 sky130_fd_sc_hd__or2_1$1
XFILLER_25_613 vssd1 vccd1 vccd1 vssd1 sky130_fd_sc_hd__fill_2$1
XFILLER_37_473 vssd1 vccd1 vccd1 vssd1 sky130_ef_sc_hd__decap_40_12$1
XTAP_TAPCELL_ROW_84_1558 vccd1 vssd1 sky130_fd_sc_hd__tapvpwrvgnd_1$1
X_1179_ _1449_/C1 _1178_/X _1189_/A2 hold90/X _1620_/D vssd1 vccd1 vccd1 vssd1 sky130_fd_sc_hd__o211a_1$1
XFILLER_12_307 vccd1 vssd1 vccd1 vssd1 sky130_fd_sc_hd__fill_1$1
XFILLER_21_841 vccd1 vssd1 vccd1 vssd1 sky130_fd_sc_hd__fill_1$1
XFILLER_24_189 vssd1 vccd1 vccd1 vssd1 sky130_fd_sc_hd__fill_4$1
XANTENNA_30 _1480_/Q vssd1 vccd1 vccd1 vssd1 sky130_fd_sc_hd__diode_2$1
XPHY_EDGE_ROW_25_Left_164 vccd1 vssd1 vccd1 vssd1 sky130_fd_sc_hd__decap_3$1
XFILLER_138_559 vccd1 vssd1 vccd1 vssd1 sky130_fd_sc_hd__fill_1$1
XPHY_EDGE_ROW_90_Right_90 vccd1 vssd1 vccd1 vssd1 sky130_fd_sc_hd__decap_3$1
XTAP_TAPCELL_ROW_115_2024 vccd1 vssd1 sky130_fd_sc_hd__tapvpwrvgnd_1$1
XTAP_TAPCELL_ROW_99_1790 vccd1 vssd1 sky130_fd_sc_hd__tapvpwrvgnd_1$1
XFILLER_134_765 vssd1 vccd1 vccd1 vssd1 sky130_ef_sc_hd__decap_40_12$1
XFILLER_97_27 vssd1 vccd1 vccd1 vssd1 sky130_ef_sc_hd__decap_40_12$1
Xoutput170 _1476_/Q wbs_ack_o vssd1 vccd1 vccd1 vssd1 sky130_fd_sc_hd__buf_12$1
XFILLER_121_415 vccd1 vssd1 vccd1 vssd1 sky130_fd_sc_hd__fill_1$1
XFILLER_106_489 vssd1 vccd1 vccd1 vssd1 sky130_ef_sc_hd__decap_40_12$1
XFILLER_79_329 vssd1 vccd1 vccd1 vssd1 sky130_fd_sc_hd__fill_4$1
XFILLER_0_701 vssd1 vccd1 vccd1 vssd1 sky130_ef_sc_hd__decap_40_12$1
Xoutput192 _1506_/Q wbs_dat_o[29] vssd1 vccd1 vccd1 vssd1 sky130_fd_sc_hd__buf_12$1
Xoutput181 _1496_/Q wbs_dat_o[19] vssd1 vccd1 vccd1 vssd1 sky130_fd_sc_hd__buf_12$1
XTAP_TAPCELL_ROW_7_399 vccd1 vssd1 sky130_fd_sc_hd__tapvpwrvgnd_1$1
XFILLER_0_767 vssd1 vccd1 vccd1 vssd1 sky130_ef_sc_hd__decap_40_12$1
XPHY_EDGE_ROW_34_Left_173 vccd1 vssd1 vccd1 vssd1 sky130_fd_sc_hd__decap_3$1
XFILLER_101_161 vssd1 vccd1 vccd1 vssd1 sky130_fd_sc_hd__fill_4$1
XFILLER_47_237 vssd1 vccd1 vccd1 vssd1 sky130_ef_sc_hd__decap_40_12$1
XFILLER_48_749 vssd1 vccd1 vccd1 vssd1 sky130_fd_sc_hd__fill_2$1
XFILLER_75_557 vssd1 vccd1 vccd1 vssd1 sky130_fd_sc_hd__fill_2$1
XFILLER_63_708 vssd1 vccd1 vccd1 vssd1 sky130_ef_sc_hd__decap_40_12$1
XTAP_TAPCELL_ROW_126_2197 vccd1 vssd1 sky130_fd_sc_hd__tapvpwrvgnd_1$1
XTAP_TAPCELL_ROW_126_2186 vccd1 vssd1 sky130_fd_sc_hd__tapvpwrvgnd_1$1
XFILLER_90_516 vssd1 vccd1 vccd1 vssd1 sky130_ef_sc_hd__decap_40_12$1
XFILLER_16_613 vssd1 vccd1 vccd1 vssd1 sky130_ef_sc_hd__decap_40_12$1
XFILLER_28_473 vssd1 vccd1 vccd1 vssd1 sky130_fd_sc_hd__fill_2$1
XFILLER_46_53 vssd1 vccd1 vccd1 vssd1 sky130_ef_sc_hd__decap_40_12$1
XFILLER_83_590 vssd1 vccd1 vccd1 vssd1 sky130_fd_sc_hd__fill_4$1
XFILLER_71_741 vssd1 vccd1 vccd1 vssd1 sky130_ef_sc_hd__decap_40_12$1
XFILLER_55_281 vssd1 vccd1 vccd1 vssd1 sky130_ef_sc_hd__decap_40_12$1
XFILLER_16_657 vssd1 vccd1 vccd1 vssd1 sky130_ef_sc_hd__decap_40_12$1
XFILLER_46_97 vssd1 vccd1 vccd1 vssd1 sky130_ef_sc_hd__decap_40_12$1
XFILLER_102_81 vssd1 vccd1 vccd1 vssd1 sky130_fd_sc_hd__fill_2$1
XFILLER_70_251 vccd1 vssd1 vccd1 vssd1 sky130_fd_sc_hd__fill_1$1
XFILLER_15_167 vccd1 vssd1 vccd1 vssd1 sky130_fd_sc_hd__fill_1$1
XFILLER_62_41 vssd1 vccd1 vccd1 vssd1 sky130_ef_sc_hd__decap_40_12$1
XTAP_TAPCELL_ROW_26_685 vccd1 vssd1 sky130_fd_sc_hd__tapvpwrvgnd_1$1
XTAP_TAPCELL_ROW_26_696 vccd1 vssd1 sky130_fd_sc_hd__tapvpwrvgnd_1$1
XFILLER_30_137 vssd1 vccd1 vccd1 vssd1 sky130_fd_sc_hd__fill_2$1
XPHY_EDGE_ROW_43_Left_182 vccd1 vssd1 vccd1 vssd1 sky130_fd_sc_hd__decap_3$1
XFILLER_62_85 vssd1 vccd1 vccd1 vssd1 sky130_ef_sc_hd__decap_40_12$1
XFILLER_129_559 vccd1 vssd1 vccd1 vssd1 sky130_fd_sc_hd__fill_1$1
XFILLER_11_373 vssd1 vccd1 vccd1 vssd1 sky130_ef_sc_hd__decap_40_12$1
XFILLER_7_333 vssd1 vccd1 vccd1 vssd1 sky130_fd_sc_hd__fill_2$1
XFILLER_116_209 vssd1 vccd1 vccd1 vssd1 sky130_ef_sc_hd__decap_40_12$1
XFILLER_7_69 vssd1 vccd1 vccd1 vssd1 sky130_ef_sc_hd__decap_40_12$1
XFILLER_109_261 vssd1 vccd1 vccd1 vssd1 sky130_ef_sc_hd__decap_40_12$1
XFILLER_125_765 vssd1 vccd1 vccd1 vssd1 sky130_ef_sc_hd__decap_40_12$1
XFILLER_124_253 vssd1 vccd1 vccd1 vssd1 sky130_ef_sc_hd__decap_40_12$1
XTAP_TAPCELL_ROW_55_1126 vccd1 vssd1 sky130_fd_sc_hd__tapvpwrvgnd_1$1
XFILLER_3_561 vssd1 vccd1 vccd1 vssd1 sky130_ef_sc_hd__decap_40_12$1
XFILLER_97_137 vssd1 vccd1 vccd1 vssd1 sky130_ef_sc_hd__decap_40_12$1
XFILLER_79_841 vccd1 vssd1 vccd1 vssd1 sky130_fd_sc_hd__fill_1$1
XPHY_EDGE_ROW_52_Left_191 vccd1 vssd1 vccd1 vssd1 sky130_fd_sc_hd__decap_3$1
XFILLER_94_811 vccd1 vssd1 vccd1 vssd1 sky130_fd_sc_hd__fill_1$1
XFILLER_87_93 vssd1 vccd1 vccd1 vssd1 sky130_ef_sc_hd__decap_40_12$1
XFILLER_39_716 vssd1 vccd1 vccd1 vssd1 sky130_ef_sc_hd__decap_40_12$1
XFILLER_81_505 vssd1 vccd1 vccd1 vssd1 sky130_ef_sc_hd__decap_40_12$1
XFILLER_66_557 vssd1 vccd1 vccd1 vssd1 sky130_ef_sc_hd__decap_40_12$1
X_1102_ _1801_/A _1102_/X _1144_/B vssd1 vccd1 vccd1 vssd1 sky130_fd_sc_hd__or2_1$1
X_1033_ _1447_/C1 _1032_/X _1053_/A2 hold183/X _1033_/X vssd1 vccd1 vccd1 vssd1 sky130_fd_sc_hd__o211a_1$1
XFILLER_19_473 vssd1 vccd1 vccd1 vssd1 sky130_ef_sc_hd__decap_40_12$1
XFILLER_47_782 vssd1 vccd1 vccd1 vssd1 sky130_fd_sc_hd__fill_2$1
XFILLER_34_421 vssd1 vccd1 vccd1 vssd1 sky130_ef_sc_hd__decap_40_12$1
XTAP_TAPCELL_ROW_66_1288 vccd1 vssd1 sky130_fd_sc_hd__tapvpwrvgnd_1$1
XTAP_TAPCELL_ROW_45_972 vccd1 vssd1 sky130_fd_sc_hd__tapvpwrvgnd_1$1
XFILLER_61_273 vssd1 vccd1 vccd1 vssd1 sky130_fd_sc_hd__fill_4$1
XFILLER_21_137 vssd1 vccd1 vccd1 vssd1 sky130_ef_sc_hd__decap_40_12$1
XFILLER_30_693 vssd1 vccd1 vccd1 vssd1 sky130_fd_sc_hd__fill_4$1
Xinput50 input50/X vccd1 vssd1 input50/A vccd1 vssd1 sky130_fd_sc_hd__buf_4$1
XFILLER_128_581 vssd1 vccd1 vccd1 vssd1 sky130_fd_sc_hd__fill_2$1
X_0817_ _1679_/Q _0875_/B1 _0817_/X _1647_/Q _0906_/B1 vccd1 vssd1 vccd1 vssd1 sky130_fd_sc_hd__a22o_1$1
X_1797_ _1797_/A _1797_/X vssd1 vccd1 vccd1 vssd1 sky130_fd_sc_hd__clkbuf_2$1
X_0748_ hold18/A hold8/A hold17/A hold5/A hold24/A vssd1 vccd1 vccd1 vssd1 sky130_fd_sc_hd__and4b_4$1
XFILLER_107_15 vssd1 vccd1 vccd1 vssd1 sky130_ef_sc_hd__decap_40_12$1
XFILLER_103_415 vccd1 vssd1 vccd1 vssd1 sky130_fd_sc_hd__fill_1$1
XFILLER_89_627 vssd1 vccd1 vccd1 vssd1 sky130_ef_sc_hd__decap_40_12$1
XFILLER_131_746 vssd1 vccd1 vccd1 vssd1 sky130_fd_sc_hd__fill_2$1
XFILLER_103_459 vccd1 vssd1 vccd1 vssd1 sky130_fd_sc_hd__fill_1$1
XFILLER_88_137 vssd1 vccd1 vccd1 vssd1 sky130_fd_sc_hd__fill_2$1
XFILLER_130_245 vssd1 vccd1 vccd1 vssd1 sky130_fd_sc_hd__fill_4$1
XFILLER_97_671 vccd1 vssd1 vccd1 vssd1 sky130_fd_sc_hd__fill_1$1
XFILLER_130_289 vssd1 vccd1 vccd1 vssd1 sky130_ef_sc_hd__decap_40_12$1
XFILLER_84_321 vssd1 vccd1 vccd1 vssd1 sky130_ef_sc_hd__decap_40_12$1
XFILLER_69_373 vssd1 vccd1 vccd1 vssd1 sky130_ef_sc_hd__decap_40_12$1
XTAP_TAPCELL_ROW_4_358 vccd1 vssd1 sky130_fd_sc_hd__tapvpwrvgnd_1$1
XFILLER_57_557 vssd1 vccd1 vccd1 vssd1 sky130_fd_sc_hd__fill_2$1
XFILLER_29_237 vssd1 vccd1 vccd1 vssd1 sky130_ef_sc_hd__decap_40_12$1
XFILLER_123_69 vssd1 vccd1 vccd1 vssd1 sky130_ef_sc_hd__decap_40_12$1
XFILLER_84_365 vssd1 vccd1 vccd1 vssd1 sky130_ef_sc_hd__decap_40_12$1
XFILLER_38_793 vssd1 vccd1 vccd1 vssd1 sky130_fd_sc_hd__fill_4$1
XFILLER_53_741 vssd1 vccd1 vccd1 vssd1 sky130_ef_sc_hd__decap_40_12$1
XFILLER_37_281 vssd1 vccd1 vccd1 vssd1 sky130_ef_sc_hd__decap_40_12$1
XFILLER_53_785 vssd1 vccd1 vccd1 vssd1 sky130_ef_sc_hd__decap_40_12$1
XFILLER_52_251 vccd1 vssd1 vccd1 vssd1 sky130_fd_sc_hd__fill_1$1
XPHY_EDGE_ROW_0_Right_0 vccd1 vssd1 vccd1 vssd1 sky130_fd_sc_hd__decap_3$1
XFILLER_40_413 vssd1 vccd1 vccd1 vssd1 sky130_fd_sc_hd__fill_4$1
XFILLER_12_137 vssd1 vccd1 vccd1 vssd1 sky130_fd_sc_hd__fill_2$1
XFILLER_9_609 vssd1 vccd1 vccd1 vssd1 sky130_fd_sc_hd__fill_4$1
XTAP_TAPCELL_ROW_23_644 vccd1 vssd1 sky130_fd_sc_hd__tapvpwrvgnd_1$1
XFILLER_40_457 vssd1 vccd1 vccd1 vssd1 sky130_ef_sc_hd__decap_40_12$1
XFILLER_21_671 vccd1 vssd1 vccd1 vssd1 sky130_fd_sc_hd__fill_1$1
XTAP_TAPCELL_ROW_97_1749 vccd1 vssd1 sky130_fd_sc_hd__tapvpwrvgnd_1$1
XFILLER_32_77 vssd1 vccd1 vccd1 vssd1 sky130_fd_sc_hd__fill_4$1
XFILLER_138_389 vssd1 vccd1 vccd1 vssd1 sky130_fd_sc_hd__fill_2$1
XFILLER_126_529 vssd1 vccd1 vccd1 vssd1 sky130_fd_sc_hd__fill_2$1
XFILLER_113_3 vssd1 vccd1 vccd1 vssd1 sky130_ef_sc_hd__decap_40_12$1
XFILLER_107_721 vssd1 vccd1 vccd1 vssd1 sky130_fd_sc_hd__fill_4$1
XFILLER_5_837 vssd1 vccd1 vccd1 vssd1 sky130_fd_sc_hd__fill_2$1
XFILLER_107_765 vssd1 vccd1 vccd1 vssd1 sky130_ef_sc_hd__decap_40_12$1
XFILLER_122_713 vssd1 vccd1 vccd1 vssd1 sky130_ef_sc_hd__decap_40_12$1
XFILLER_106_253 vssd1 vccd1 vccd1 vssd1 sky130_ef_sc_hd__decap_40_12$1
XFILLER_122_757 vssd1 vccd1 vccd1 vssd1 sky130_ef_sc_hd__decap_40_12$1
XFILLER_121_223 vccd1 vssd1 vccd1 vssd1 sky130_fd_sc_hd__fill_1$1
XFILLER_79_137 vssd1 vccd1 vccd1 vssd1 sky130_ef_sc_hd__decap_40_12$1
XFILLER_0_531 vccd1 vssd1 vccd1 vssd1 sky130_fd_sc_hd__fill_1$1
XTAP_TAPCELL_ROW_128_2226 vccd1 vssd1 sky130_fd_sc_hd__tapvpwrvgnd_1$1
XTAP_TAPCELL_ROW_128_2215 vccd1 vssd1 sky130_fd_sc_hd__tapvpwrvgnd_1$1
XFILLER_0_553 vssd1 vccd1 vccd1 vssd1 sky130_fd_sc_hd__fill_2$1
XFILLER_88_693 vssd1 vccd1 vccd1 vssd1 sky130_fd_sc_hd__fill_4$1
XFILLER_87_181 vssd1 vccd1 vccd1 vssd1 sky130_ef_sc_hd__decap_40_12$1
XTAP_TAPCELL_ROW_50_1045 vccd1 vssd1 sky130_fd_sc_hd__tapvpwrvgnd_1$1
XFILLER_48_513 vssd1 vccd1 vccd1 vssd1 sky130_fd_sc_hd__fill_2$1
XTAP_TAPCELL_ROW_50_1056 vccd1 vssd1 sky130_fd_sc_hd__tapvpwrvgnd_1$1
XFILLER_48_546 vssd1 vccd1 vccd1 vssd1 sky130_ef_sc_hd__decap_40_12$1
XFILLER_63_538 vssd1 vccd1 vccd1 vssd1 sky130_fd_sc_hd__fill_4$1
XFILLER_63_505 vssd1 vccd1 vccd1 vssd1 sky130_ef_sc_hd__decap_40_12$1
XPHY_EDGE_ROW_121_Right_121 vccd1 vssd1 vccd1 vssd1 sky130_fd_sc_hd__decap_3$1
XFILLER_90_357 vssd1 vccd1 vccd1 vssd1 sky130_fd_sc_hd__fill_4$1
XFILLER_16_421 vssd1 vccd1 vccd1 vssd1 sky130_ef_sc_hd__decap_40_12$1
XFILLER_44_741 vccd1 vssd1 vccd1 vssd1 sky130_fd_sc_hd__fill_1$1
XTAP_TAPCELL_ROW_106_1889 vccd1 vssd1 sky130_fd_sc_hd__tapvpwrvgnd_1$1
XFILLER_73_51 vssd1 vccd1 vccd1 vssd1 sky130_fd_sc_hd__fill_4$1
XTAP_TAPCELL_ROW_42_931 vccd1 vssd1 sky130_fd_sc_hd__tapvpwrvgnd_1$1
XFILLER_43_273 vssd1 vccd1 vccd1 vssd1 sky130_fd_sc_hd__fill_4$1
X_1720_ _1720_/Q _1720_/CLK _1720_/D vccd1 vssd1 vccd1 vssd1 sky130_fd_sc_hd__dfxtp_1$1
XFILLER_11_181 vssd1 vccd1 vccd1 vssd1 sky130_ef_sc_hd__decap_40_12$1
XFILLER_12_693 vssd1 vccd1 vccd1 vssd1 sky130_fd_sc_hd__fill_4$1
Xhold108 wbs_dat_i[29] input41/A vssd1 vccd1 vccd1 vssd1 sky130_fd_sc_hd__dlygate4sd3_1$1
XFILLER_129_389 vssd1 vccd1 vccd1 vssd1 sky130_fd_sc_hd__fill_2$1
X_1651_ _1651_/Q _1739_/CLK _1651_/D vccd1 vssd1 vccd1 vssd1 sky130_fd_sc_hd__dfxtp_1$1
XFILLER_8_697 vssd1 vccd1 vccd1 vssd1 sky130_fd_sc_hd__fill_2$1
Xhold119 wbs_dat_i[19] input30/A vssd1 vccd1 vccd1 vssd1 sky130_fd_sc_hd__dlygate4sd3_1$1
X_1582_ _1800_/A _1585_/CLK _1582_/D vccd1 vssd1 vccd1 vssd1 sky130_fd_sc_hd__dfxtp_1$1
XFILLER_98_457 vssd1 vccd1 vccd1 vssd1 sky130_ef_sc_hd__decap_40_12$1
XFILLER_98_81 vssd1 vccd1 vccd1 vssd1 sky130_fd_sc_hd__fill_2$1
XFILLER_112_245 vssd1 vccd1 vccd1 vssd1 sky130_fd_sc_hd__fill_4$1
XFILLER_3_391 vccd1 vssd1 vccd1 vssd1 sky130_fd_sc_hd__fill_1$1
XFILLER_112_289 vssd1 vccd1 vccd1 vssd1 sky130_ef_sc_hd__decap_40_12$1
XFILLER_79_671 vccd1 vssd1 vccd1 vssd1 sky130_fd_sc_hd__fill_1$1
XFILLER_67_822 vssd1 vccd1 vccd1 vssd1 sky130_fd_sc_hd__fill_2$1
XFILLER_66_321 vssd1 vccd1 vccd1 vssd1 sky130_ef_sc_hd__decap_40_12$1
XFILLER_39_557 vssd1 vccd1 vccd1 vssd1 sky130_fd_sc_hd__fill_2$1
XTAP_TAPCELL_ROW_68_1317 vccd1 vssd1 sky130_fd_sc_hd__tapvpwrvgnd_1$1
XFILLER_66_387 vccd1 vssd1 vccd1 vssd1 sky130_fd_sc_hd__fill_1$1
XFILLER_66_365 vssd1 vccd1 vccd1 vssd1 sky130_ef_sc_hd__decap_40_12$1
XTAP_TAPCELL_ROW_1_317 vccd1 vssd1 sky130_fd_sc_hd__tapvpwrvgnd_1$1
XFILLER_81_335 vccd1 vssd1 vccd1 vssd1 sky130_fd_sc_hd__fill_1$1
XFILLER_54_549 vssd1 vccd1 vccd1 vssd1 sky130_ef_sc_hd__decap_40_12$1
XFILLER_19_281 vssd1 vccd1 vccd1 vssd1 sky130_ef_sc_hd__decap_40_12$1
XFILLER_35_741 vssd1 vccd1 vccd1 vssd1 sky130_fd_sc_hd__fill_2$1
Xclkbuf_leaf_16_wb_clk_i _1760_/CLK clkbuf_2_3__f_wb_clk_i/X vssd1 vccd1 vccd1 vssd1
+ sky130_fd_sc_hd__clkbuf_8$1
XTAP_TAPCELL_ROW_81_1517 vccd1 vssd1 sky130_fd_sc_hd__tapvpwrvgnd_1$1
X_1016_ _1772_/A _1016_/X _1052_/B vssd1 vccd1 vccd1 vssd1 sky130_fd_sc_hd__or2_1$1
XFILLER_34_251 vccd1 vssd1 vccd1 vssd1 sky130_fd_sc_hd__fill_1$1
XFILLER_22_413 vssd1 vccd1 vccd1 vssd1 sky130_fd_sc_hd__fill_4$1
XFILLER_35_785 vssd1 vccd1 vccd1 vssd1 sky130_ef_sc_hd__decap_40_12$1
XFILLER_22_457 vssd1 vccd1 vccd1 vssd1 sky130_ef_sc_hd__decap_40_12$1
XTAP_TAPCELL_ROW_20_603 vccd1 vssd1 sky130_fd_sc_hd__tapvpwrvgnd_1$1
X_1849_ vccd1 vssd1 _1849_/X _1849_/A vccd1 vssd1 sky130_fd_sc_hd__buf_2$1
XTAP_TAPCELL_ROW_79_1479 vccd1 vssd1 sky130_fd_sc_hd__tapvpwrvgnd_1$1
XFILLER_78_29 vssd1 vccd1 vccd1 vssd1 sky130_ef_sc_hd__decap_40_12$1
XTAP_TAPCELL_ROW_9_439 vccd1 vssd1 sky130_fd_sc_hd__tapvpwrvgnd_1$1
XTAP_TAPCELL_ROW_9_428 vccd1 vssd1 sky130_fd_sc_hd__tapvpwrvgnd_1$1
XFILLER_103_223 vccd1 vssd1 vccd1 vssd1 sky130_fd_sc_hd__fill_1$1
XTAP_TAPCELL_ROW_92_1679 vccd1 vssd1 sky130_fd_sc_hd__tapvpwrvgnd_1$1
XFILLER_89_424 vssd1 vccd1 vccd1 vssd1 sky130_ef_sc_hd__decap_40_12$1
XFILLER_1_317 vssd1 vccd1 vccd1 vssd1 sky130_ef_sc_hd__decap_40_12$1
XFILLER_77_608 vssd1 vccd1 vccd1 vssd1 sky130_fd_sc_hd__fill_8$1
XFILLER_85_663 vccd1 vssd1 vccd1 vssd1 sky130_fd_sc_hd__fill_1$1
XFILLER_85_641 vssd1 vccd1 vccd1 vssd1 sky130_ef_sc_hd__decap_40_12$1
XFILLER_69_181 vssd1 vccd1 vccd1 vssd1 sky130_ef_sc_hd__decap_40_12$1
XTAP_TAPCELL_ROW_28_714 vccd1 vssd1 sky130_fd_sc_hd__tapvpwrvgnd_1$1
XFILLER_45_505 vssd1 vccd1 vccd1 vssd1 sky130_ef_sc_hd__decap_40_12$1
XTAP_TAPCELL_ROW_123_2145 vccd1 vssd1 sky130_fd_sc_hd__tapvpwrvgnd_1$1
XFILLER_84_195 vccd1 vssd1 vccd1 vssd1 sky130_fd_sc_hd__fill_1$1
XFILLER_27_55 vccd1 vssd1 vccd1 vssd1 sky130_fd_sc_hd__fill_1$1
XTAP_TAPCELL_ROW_28_725 vccd1 vssd1 sky130_fd_sc_hd__tapvpwrvgnd_1$1
XFILLER_72_357 vssd1 vccd1 vccd1 vssd1 sky130_fd_sc_hd__fill_4$1
XFILLER_26_774 vssd1 vccd1 vccd1 vssd1 sky130_ef_sc_hd__decap_40_12$1
XFILLER_25_273 vssd1 vccd1 vccd1 vssd1 sky130_fd_sc_hd__fill_4$1
XFILLER_9_417 vssd1 vccd1 vccd1 vssd1 sky130_ef_sc_hd__decap_40_12$1
XFILLER_40_221 vssd1 vccd1 vccd1 vssd1 sky130_ef_sc_hd__decap_40_12$1
XFILLER_41_777 vssd1 vccd1 vccd1 vssd1 sky130_fd_sc_hd__fill_4$1
XFILLER_40_265 vssd1 vccd1 vccd1 vssd1 sky130_ef_sc_hd__decap_40_12$1
XFILLER_41_799 vccd1 vssd1 vccd1 vssd1 sky130_fd_sc_hd__fill_1$1
XFILLER_4_133 vssd1 vccd1 vccd1 vssd1 sky130_fd_sc_hd__fill_4$1
XFILLER_4_15 vssd1 vccd1 vccd1 vssd1 sky130_ef_sc_hd__decap_40_12$1
XFILLER_4_177 vssd1 vccd1 vccd1 vssd1 sky130_ef_sc_hd__decap_40_12$1
XFILLER_95_405 vssd1 vccd1 vccd1 vssd1 sky130_fd_sc_hd__fill_8$1
XFILLER_122_587 vccd1 vssd1 vccd1 vssd1 sky130_fd_sc_hd__fill_1$1
XFILLER_0_361 vssd1 vccd1 vccd1 vssd1 sky130_fd_sc_hd__fill_2$1
XFILLER_48_321 vssd1 vccd1 vccd1 vssd1 sky130_ef_sc_hd__decap_40_12$1
XTAP_TAPCELL_ROW_108_1918 vccd1 vssd1 sky130_fd_sc_hd__tapvpwrvgnd_1$1
XFILLER_48_365 vssd1 vccd1 vccd1 vssd1 sky130_ef_sc_hd__decap_40_12$1
XFILLER_90_121 vssd1 vccd1 vccd1 vssd1 sky130_ef_sc_hd__decap_40_12$1
XFILLER_84_83 vccd1 vssd1 vccd1 vssd1 sky130_fd_sc_hd__fill_1$1
XFILLER_63_335 vccd1 vssd1 vccd1 vssd1 sky130_fd_sc_hd__fill_1$1
XFILLER_17_741 vssd1 vccd1 vccd1 vssd1 sky130_ef_sc_hd__decap_40_12$1
XFILLER_90_165 vssd1 vccd1 vccd1 vssd1 sky130_ef_sc_hd__decap_40_12$1
XFILLER_16_251 vccd1 vssd1 vccd1 vssd1 sky130_fd_sc_hd__fill_1$1
XFILLER_17_785 vssd1 vccd1 vccd1 vssd1 sky130_ef_sc_hd__decap_40_12$1
XTAP_TAPCELL_ROW_63_1247 vccd1 vssd1 sky130_fd_sc_hd__tapvpwrvgnd_1$1
XFILLER_31_221 vssd1 vccd1 vccd1 vssd1 sky130_fd_sc_hd__fill_2$1
XFILLER_76_3 vssd1 vccd1 vccd1 vssd1 sky130_ef_sc_hd__decap_40_12$1
X_1703_ _1826_/A _1704_/CLK _1703_/D vccd1 vssd1 vccd1 vssd1 sky130_fd_sc_hd__dfxtp_1$1
XFILLER_117_337 vssd1 vccd1 vccd1 vssd1 sky130_ef_sc_hd__decap_40_12$1
XFILLER_132_307 vccd1 vssd1 vccd1 vssd1 sky130_fd_sc_hd__fill_1$1
X_1634_ _1634_/Q _1738_/CLK _1634_/D vccd1 vssd1 vccd1 vssd1 sky130_fd_sc_hd__dfxtp_1$1
X_1565_ _1565_/Q _1757_/CLK _1565_/D vccd1 vssd1 vccd1 vssd1 sky130_fd_sc_hd__dfxtp_1$1
XFILLER_132_329 vssd1 vccd1 vccd1 vssd1 sky130_ef_sc_hd__decap_40_12$1
XFILLER_98_221 vssd1 vccd1 vccd1 vssd1 sky130_ef_sc_hd__decap_40_12$1
XFILLER_99_777 vssd1 vccd1 vccd1 vssd1 sky130_fd_sc_hd__fill_4$1
XFILLER_98_265 vssd1 vccd1 vccd1 vssd1 sky130_ef_sc_hd__decap_40_12$1
X_1496_ _1496_/Q _1752_/CLK _1496_/D vccd1 vssd1 vccd1 vssd1 sky130_fd_sc_hd__dfxtp_1$1
XFILLER_101_727 vccd1 vssd1 vccd1 vssd1 sky130_fd_sc_hd__fill_1$1
XFILLER_104_27 vccd1 vssd1 vccd1 vssd1 sky130_fd_sc_hd__fill_1$1
XFILLER_82_611 vssd1 vccd1 vccd1 vssd1 sky130_fd_sc_hd__fill_8$1
XFILLER_67_685 vssd1 vccd1 vccd1 vssd1 sky130_fd_sc_hd__fill_2$1
XFILLER_27_505 vssd1 vccd1 vccd1 vssd1 sky130_ef_sc_hd__decap_40_12$1
XFILLER_94_493 vssd1 vccd1 vccd1 vssd1 sky130_ef_sc_hd__decap_40_12$1
XFILLER_66_195 vccd1 vssd1 vccd1 vssd1 sky130_fd_sc_hd__fill_1$1
XFILLER_81_165 vssd1 vccd1 vccd1 vssd1 sky130_fd_sc_hd__fill_2$1
XFILLER_54_357 vssd1 vccd1 vccd1 vssd1 sky130_fd_sc_hd__fill_4$1
XFILLER_120_15 vssd1 vccd1 vccd1 vssd1 sky130_ef_sc_hd__decap_40_12$1
XFILLER_22_221 vssd1 vccd1 vccd1 vssd1 sky130_ef_sc_hd__decap_40_12$1
XFILLER_50_585 vssd1 vccd1 vccd1 vssd1 sky130_fd_sc_hd__fill_2$1
XFILLER_22_265 vssd1 vccd1 vccd1 vssd1 sky130_ef_sc_hd__decap_40_12$1
XFILLER_13_57 vssd1 vccd1 vccd1 vssd1 sky130_ef_sc_hd__decap_40_12$1
XTAP_TAPCELL_ROW_33_794 vccd1 vssd1 sky130_fd_sc_hd__tapvpwrvgnd_1$1
XFILLER_129_57 vssd1 vccd1 vccd1 vssd1 sky130_ef_sc_hd__decap_40_12$1
XTAP_TAPCELL_ROW_94_1708 vccd1 vssd1 sky130_fd_sc_hd__tapvpwrvgnd_1$1
XFILLER_89_39 vssd1 vccd1 vccd1 vssd1 sky130_ef_sc_hd__decap_40_12$1
XFILLER_136_679 vssd1 vccd1 vccd1 vssd1 sky130_ef_sc_hd__decap_40_12$1
XFILLER_135_167 vccd1 vssd1 vccd1 vssd1 sky130_fd_sc_hd__fill_1$1
XFILLER_123_329 vssd1 vccd1 vccd1 vssd1 sky130_fd_sc_hd__fill_4$1
XFILLER_116_381 vssd1 vccd1 vccd1 vssd1 sky130_fd_sc_hd__fill_2$1
XFILLER_89_221 vssd1 vccd1 vccd1 vssd1 sky130_fd_sc_hd__fill_2$1
XFILLER_1_125 vssd1 vccd1 vccd1 vssd1 sky130_ef_sc_hd__decap_40_12$1
XFILLER_2_637 vssd1 vccd1 vccd1 vssd1 sky130_fd_sc_hd__fill_4$1
XFILLER_77_405 vssd1 vccd1 vccd1 vssd1 sky130_ef_sc_hd__decap_40_12$1
XPHY_EDGE_ROW_8_Left_147 vccd1 vssd1 vccd1 vssd1 sky130_fd_sc_hd__decap_3$1
XFILLER_131_373 vssd1 vccd1 vccd1 vssd1 sky130_ef_sc_hd__decap_40_12$1
XFILLER_104_587 vccd1 vssd1 vccd1 vssd1 sky130_fd_sc_hd__fill_1$1
XFILLER_1_169 vssd1 vccd1 vccd1 vssd1 sky130_ef_sc_hd__decap_40_12$1
XFILLER_131_395 vccd1 vssd1 vccd1 vssd1 sky130_fd_sc_hd__fill_1$1
XFILLER_58_630 vccd1 vssd1 vccd1 vssd1 sky130_fd_sc_hd__fill_1$1
XFILLER_92_419 vccd1 vssd1 vccd1 vssd1 sky130_fd_sc_hd__fill_1$1
XFILLER_73_600 vssd1 vccd1 vccd1 vssd1 sky130_ef_sc_hd__decap_40_12$1
XFILLER_38_65 vssd1 vccd1 vccd1 vssd1 sky130_ef_sc_hd__decap_40_12$1
XFILLER_46_825 vccd1 vssd1 vccd1 vssd1 sky130_fd_sc_hd__fill_1$1
XFILLER_100_793 vssd1 vccd1 vccd1 vssd1 sky130_fd_sc_hd__fill_4$1
XFILLER_85_482 vssd1 vccd1 vccd1 vssd1 sky130_fd_sc_hd__fill_2$1
XFILLER_72_121 vssd1 vccd1 vccd1 vssd1 sky130_ef_sc_hd__decap_40_12$1
XFILLER_45_335 vccd1 vssd1 vccd1 vssd1 sky130_fd_sc_hd__fill_1$1
XFILLER_72_165 vssd1 vccd1 vccd1 vssd1 sky130_ef_sc_hd__decap_40_12$1
XFILLER_60_305 vssd1 vccd1 vccd1 vssd1 sky130_fd_sc_hd__fill_2$1
XFILLER_54_53 vssd1 vccd1 vccd1 vssd1 sky130_ef_sc_hd__decap_40_12$1
XTAP_TAPCELL_ROW_103_1848 vccd1 vssd1 sky130_fd_sc_hd__tapvpwrvgnd_1$1
XFILLER_54_97 vssd1 vccd1 vccd1 vssd1 sky130_ef_sc_hd__decap_40_12$1
XFILLER_13_221 vssd1 vccd1 vccd1 vssd1 sky130_fd_sc_hd__fill_2$1
XFILLER_14_755 vccd1 vssd1 vccd1 vssd1 sky130_fd_sc_hd__fill_1$1
XFILLER_9_225 vssd1 vccd1 vccd1 vssd1 sky130_ef_sc_hd__decap_40_12$1
XFILLER_41_563 vccd1 vssd1 vccd1 vssd1 sky130_fd_sc_hd__fill_1$1
XTAP_TAPCELL_ROW_136_2336 vccd1 vssd1 sky130_fd_sc_hd__tapvpwrvgnd_1$1
XFILLER_110_81 vssd1 vccd1 vccd1 vssd1 sky130_fd_sc_hd__fill_2$1
XFILLER_70_41 vssd1 vccd1 vccd1 vssd1 sky130_ef_sc_hd__decap_40_12$1
XTAP_TAPCELL_ROW_136_2347 vccd1 vssd1 sky130_fd_sc_hd__tapvpwrvgnd_1$1
XFILLER_70_85 vssd1 vccd1 vccd1 vssd1 sky130_ef_sc_hd__decap_40_12$1
Xclkload17 clkload17/Y _1679_/CLK vccd1 vssd1 vccd1 vssd1 sky130_fd_sc_hd__inv_6$1
Xclkload28 _1690_/CLK clkload28/Y vccd1 vssd1 vccd1 vssd1 sky130_fd_sc_hd__clkinv_4$1
Xclkload39 clkload39/Y _1739_/CLK vccd1 vssd1 vccd1 vssd1 sky130_fd_sc_hd__inv_4$1
XTAP_TAPCELL_ROW_11_466 vccd1 vssd1 sky130_fd_sc_hd__tapvpwrvgnd_1$1
XFILLER_114_307 vccd1 vssd1 vccd1 vssd1 sky130_fd_sc_hd__fill_1$1
XFILLER_126_189 vssd1 vccd1 vccd1 vssd1 sky130_fd_sc_hd__fill_4$1
XFILLER_123_841 vccd1 vssd1 vccd1 vssd1 sky130_fd_sc_hd__fill_1$1
XFILLER_5_497 vssd1 vccd1 vccd1 vssd1 sky130_fd_sc_hd__fill_4$1
X_1350_ _1826_/A _1350_/X _1408_/B vssd1 vccd1 vccd1 vssd1 sky130_fd_sc_hd__or2_1$1
XFILLER_122_373 vssd1 vccd1 vccd1 vssd1 sky130_fd_sc_hd__fill_2$1
XFILLER_110_502 vssd1 vccd1 vccd1 vssd1 sky130_ef_sc_hd__decap_40_12$1
XFILLER_96_747 vccd1 vssd1 vccd1 vssd1 sky130_fd_sc_hd__fill_1$1
XFILLER_110_557 vssd1 vccd1 vccd1 vssd1 sky130_ef_sc_hd__decap_40_12$1
X_1281_ _1421_/C1 _1280_/X _1343_/A2 hold78/X _1669_/D vssd1 vccd1 vccd1 vssd1 sky130_fd_sc_hd__o211a_1$1
XFILLER_95_279 vccd1 vssd1 vccd1 vssd1 sky130_fd_sc_hd__fill_1$1
XFILLER_95_93 vssd1 vccd1 vccd1 vssd1 sky130_ef_sc_hd__decap_40_12$1
XFILLER_49_685 vssd1 vccd1 vccd1 vssd1 sky130_ef_sc_hd__decap_40_12$1
XFILLER_64_633 vssd1 vccd1 vccd1 vssd1 sky130_fd_sc_hd__fill_8$1
XFILLER_48_195 vccd1 vssd1 vccd1 vssd1 sky130_fd_sc_hd__fill_1$1
XFILLER_91_441 vssd1 vccd1 vccd1 vssd1 sky130_fd_sc_hd__fill_4$1
XFILLER_36_357 vssd1 vccd1 vccd1 vssd1 sky130_fd_sc_hd__fill_4$1
XFILLER_91_485 vssd1 vccd1 vccd1 vssd1 sky130_ef_sc_hd__decap_40_12$1
XFILLER_63_165 vssd1 vccd1 vccd1 vssd1 sky130_fd_sc_hd__fill_2$1
XFILLER_51_305 vssd1 vccd1 vccd1 vssd1 sky130_ef_sc_hd__decap_40_12$1
XTAP_TAPCELL_ROW_19_588 vccd1 vssd1 sky130_fd_sc_hd__tapvpwrvgnd_1$1
XFILLER_51_349 vssd1 vccd1 vccd1 vssd1 sky130_ef_sc_hd__decap_40_12$1
XFILLER_20_725 vssd1 vccd1 vccd1 vssd1 sky130_ef_sc_hd__decap_40_12$1
XFILLER_32_585 vssd1 vccd1 vccd1 vssd1 sky130_fd_sc_hd__fill_2$1
X_0996_ hold36/X _0996_/X _1012_/B vssd1 vccd1 vccd1 vssd1 sky130_fd_sc_hd__or2_1$1
XFILLER_9_781 vssd1 vccd1 vccd1 vssd1 sky130_fd_sc_hd__fill_2$1
XFILLER_20_769 vssd1 vccd1 vccd1 vssd1 sky130_ef_sc_hd__decap_40_12$1
XTAP_TAPCELL_ROW_30_753 vccd1 vssd1 sky130_fd_sc_hd__tapvpwrvgnd_1$1
XFILLER_118_657 vssd1 vccd1 vccd1 vssd1 sky130_ef_sc_hd__decap_40_12$1
XFILLER_117_167 vccd1 vssd1 vccd1 vssd1 sky130_fd_sc_hd__fill_1$1
XTAP_TAPCELL_ROW_76_1438 vccd1 vssd1 sky130_fd_sc_hd__tapvpwrvgnd_1$1
XFILLER_132_137 vssd1 vccd1 vccd1 vssd1 sky130_fd_sc_hd__fill_2$1
XFILLER_105_329 vssd1 vccd1 vccd1 vssd1 sky130_fd_sc_hd__fill_4$1
X_1617_ _1821_/A _1742_/CLK _1617_/D vccd1 vssd1 vccd1 vssd1 sky130_fd_sc_hd__dfxtp_1$1
Xfanout204 _1465_/A2 vccd1 vssd1 _1411_/Y vccd1 vssd1 sky130_fd_sc_hd__buf_6$1
Xfanout237 _0749_/X _0752_/A vssd1 vccd1 vccd1 vssd1 sky130_fd_sc_hd__buf_8$1
Xfanout226 _1144_/B vccd1 vssd1 _1140_/B vccd1 vssd1 sky130_fd_sc_hd__buf_6$1
XFILLER_115_15 vssd1 vccd1 vccd1 vssd1 sky130_ef_sc_hd__decap_40_12$1
XFILLER_113_373 vssd1 vccd1 vccd1 vssd1 sky130_fd_sc_hd__fill_4$1
Xfanout215 _1273_/A2 _1277_/A2 vssd1 vccd1 vccd1 vssd1 sky130_fd_sc_hd__clkbuf_8$1
XFILLER_87_725 vssd1 vccd1 vccd1 vssd1 sky130_fd_sc_hd__fill_2$1
X_1548_ _1548_/Q clkload8/A _1548_/D vccd1 vssd1 vccd1 vssd1 sky130_fd_sc_hd__dfxtp_1$1
XFILLER_101_535 vssd1 vccd1 vccd1 vssd1 sky130_ef_sc_hd__decap_40_12$1
Xfanout259 _1447_/C1 vccd1 vssd1 _1387_/C1 vccd1 vssd1 sky130_fd_sc_hd__buf_4$1
X_1479_ _1479_/D _1704_/CLK _1479_/Q vssd1 vccd1 vccd1 vssd1 sky130_fd_sc_hd__dfxtp_4$1
XFILLER_28_825 vccd1 vssd1 vccd1 vssd1 sky130_fd_sc_hd__fill_1$1
Xclkbuf_leaf_31_wb_clk_i _1671_/CLK clkload1/A vssd1 vccd1 vccd1 vssd1 sky130_fd_sc_hd__clkbuf_8$1
XFILLER_55_633 vssd1 vccd1 vccd1 vssd1 sky130_ef_sc_hd__decap_40_12$1
XFILLER_54_121 vssd1 vccd1 vccd1 vssd1 sky130_ef_sc_hd__decap_40_12$1
XFILLER_27_335 vccd1 vssd1 vccd1 vssd1 sky130_fd_sc_hd__fill_1$1
XTAP_TAPCELL_ROW_120_2104 vccd1 vssd1 sky130_fd_sc_hd__tapvpwrvgnd_1$1
XTAP_TAPCELL_ROW_38_864 vccd1 vssd1 sky130_fd_sc_hd__tapvpwrvgnd_1$1
XFILLER_131_69 vssd1 vccd1 vccd1 vssd1 sky130_ef_sc_hd__decap_40_12$1
XFILLER_70_625 vssd1 vccd1 vccd1 vssd1 sky130_ef_sc_hd__decap_40_12$1
XFILLER_54_165 vssd1 vccd1 vccd1 vssd1 sky130_ef_sc_hd__decap_40_12$1
XTAP_TAPCELL_ROW_38_875 vccd1 vssd1 sky130_fd_sc_hd__tapvpwrvgnd_1$1
XFILLER_42_305 vssd1 vccd1 vccd1 vssd1 sky130_fd_sc_hd__fill_2$1
XFILLER_70_669 vssd1 vccd1 vccd1 vssd1 sky130_fd_sc_hd__fill_4$1
XFILLER_23_541 vssd1 vccd1 vccd1 vssd1 sky130_ef_sc_hd__decap_40_12$1
XFILLER_11_725 vssd1 vccd1 vccd1 vssd1 sky130_fd_sc_hd__fill_2$1
XFILLER_23_585 vssd1 vccd1 vccd1 vssd1 sky130_ef_sc_hd__decap_40_12$1
XFILLER_109_613 vssd1 vccd1 vccd1 vssd1 sky130_fd_sc_hd__fill_2$1
XFILLER_7_729 vssd1 vccd1 vccd1 vssd1 sky130_ef_sc_hd__decap_40_12$1
XFILLER_136_421 vssd1 vccd1 vccd1 vssd1 sky130_ef_sc_hd__decap_40_12$1
XTAP_TAPCELL_ROW_118_2077 vccd1 vssd1 sky130_fd_sc_hd__tapvpwrvgnd_1$1
XTAP_TAPCELL_ROW_118_2066 vccd1 vssd1 sky130_fd_sc_hd__tapvpwrvgnd_1$1
XFILLER_109_657 vssd1 vccd1 vccd1 vssd1 sky130_ef_sc_hd__decap_40_12$1
XFILLER_40_77 vssd1 vccd1 vccd1 vssd1 sky130_fd_sc_hd__fill_4$1
XFILLER_136_498 vssd1 vccd1 vccd1 vssd1 sky130_ef_sc_hd__decap_40_12$1
XTAP_TAPCELL_ROW_131_2266 vccd1 vssd1 sky130_fd_sc_hd__tapvpwrvgnd_1$1
XFILLER_108_189 vssd1 vccd1 vccd1 vssd1 sky130_fd_sc_hd__fill_4$1
XFILLER_2_401 vssd1 vccd1 vccd1 vssd1 sky130_ef_sc_hd__decap_40_12$1
XFILLER_123_137 vssd1 vccd1 vccd1 vssd1 sky130_ef_sc_hd__decap_40_12$1
XFILLER_105_841 vccd1 vssd1 vccd1 vssd1 sky130_fd_sc_hd__fill_1$1
XFILLER_6_3 vssd1 vccd1 vccd1 vssd1 sky130_ef_sc_hd__decap_40_12$1
XFILLER_2_445 vssd1 vccd1 vccd1 vssd1 sky130_ef_sc_hd__decap_40_12$1
XFILLER_120_811 vccd1 vssd1 vccd1 vssd1 sky130_fd_sc_hd__fill_1$1
XFILLER_104_373 vssd1 vccd1 vccd1 vssd1 sky130_fd_sc_hd__fill_2$1
XFILLER_2_489 vssd1 vccd1 vccd1 vssd1 sky130_ef_sc_hd__decap_40_12$1
XFILLER_131_181 vssd1 vccd1 vccd1 vssd1 sky130_ef_sc_hd__decap_40_12$1
XFILLER_78_769 vssd1 vccd1 vccd1 vssd1 sky130_ef_sc_hd__decap_40_12$1
XFILLER_93_706 vssd1 vccd1 vccd1 vssd1 sky130_fd_sc_hd__fill_8$1
XFILLER_77_279 vccd1 vssd1 vccd1 vssd1 sky130_fd_sc_hd__fill_1$1
XFILLER_1_27 vssd1 vccd1 vccd1 vssd1 sky130_ef_sc_hd__decap_40_12$1
XFILLER_105_81 vssd1 vccd1 vccd1 vssd1 sky130_ef_sc_hd__decap_40_12$1
XFILLER_92_249 vssd1 vccd1 vccd1 vssd1 sky130_fd_sc_hd__fill_2$1
XFILLER_18_357 vssd1 vccd1 vccd1 vssd1 sky130_fd_sc_hd__fill_4$1
XTAP_TAPCELL_ROW_47_1006 vccd1 vssd1 sky130_fd_sc_hd__tapvpwrvgnd_1$1
XFILLER_73_485 vssd1 vccd1 vccd1 vssd1 sky130_ef_sc_hd__decap_40_12$1
XFILLER_33_305 vssd1 vccd1 vccd1 vssd1 sky130_ef_sc_hd__decap_40_12$1
XFILLER_45_165 vssd1 vccd1 vccd1 vssd1 sky130_fd_sc_hd__fill_2$1
XFILLER_46_699 vccd1 vssd1 vccd1 vssd1 sky130_fd_sc_hd__fill_1$1
XFILLER_61_658 vssd1 vccd1 vccd1 vssd1 sky130_ef_sc_hd__decap_40_12$1
XTAP_TAPCELL_ROW_16_536 vccd1 vssd1 sky130_fd_sc_hd__tapvpwrvgnd_1$1
XTAP_TAPCELL_ROW_16_547 vccd1 vssd1 sky130_fd_sc_hd__tapvpwrvgnd_1$1
XFILLER_33_349 vssd1 vccd1 vccd1 vssd1 sky130_ef_sc_hd__decap_40_12$1
XFILLER_81_51 vssd1 vccd1 vccd1 vssd1 sky130_fd_sc_hd__fill_4$1
XTAP_TAPCELL_ROW_60_1206 vccd1 vssd1 sky130_fd_sc_hd__tapvpwrvgnd_1$1
XFILLER_14_585 vssd1 vccd1 vccd1 vssd1 sky130_fd_sc_hd__fill_2$1
XFILLER_41_393 vssd1 vccd1 vccd1 vssd1 sky130_ef_sc_hd__decap_40_12$1
X_0850_ _1015_/A hold51/A _0750_/X _0850_/X vccd1 vssd1 vccd1 vssd1 sky130_fd_sc_hd__a21o_1$1
X_0781_ _1813_/A _0878_/A2 _0781_/X _1835_/A _0875_/B1 vccd1 vssd1 vccd1 vssd1 sky130_fd_sc_hd__a22o_1$1
XTAP_TAPCELL_ROW_58_1168 vccd1 vssd1 sky130_fd_sc_hd__tapvpwrvgnd_1$1
XFILLER_5_261 vssd1 vccd1 vccd1 vssd1 sky130_ef_sc_hd__decap_40_12$1
XFILLER_114_137 vssd1 vccd1 vccd1 vssd1 sky130_fd_sc_hd__fill_2$1
X_1402_ hold57/X _1402_/X _1408_/B vssd1 vccd1 vccd1 vssd1 sky130_fd_sc_hd__or2_1$1
XFILLER_123_671 vccd1 vssd1 vccd1 vssd1 sky130_fd_sc_hd__fill_1$1
XFILLER_96_522 vssd1 vccd1 vccd1 vssd1 sky130_fd_sc_hd__fill_2$1
XFILLER_39_3 vssd1 vccd1 vccd1 vssd1 sky130_ef_sc_hd__decap_40_12$1
XFILLER_110_321 vssd1 vccd1 vccd1 vssd1 sky130_ef_sc_hd__decap_40_12$1
X_1333_ _1437_/C1 _1332_/X _1343_/A2 hold83/X _1695_/D vssd1 vccd1 vccd1 vssd1 sky130_fd_sc_hd__o211a_1$1
XTAP_TAPCELL_ROW_71_1368 vccd1 vssd1 sky130_fd_sc_hd__tapvpwrvgnd_1$1
X_1264_ _1662_/Q _1264_/X _1270_/B vssd1 vccd1 vccd1 vssd1 sky130_fd_sc_hd__or2_1$1
XFILLER_110_365 vssd1 vccd1 vccd1 vssd1 sky130_ef_sc_hd__decap_40_12$1
XFILLER_96_577 vssd1 vccd1 vccd1 vssd1 sky130_fd_sc_hd__fill_8$1
XFILLER_83_205 vssd1 vccd1 vccd1 vssd1 sky130_ef_sc_hd__decap_40_12$1
XFILLER_56_419 vccd1 vssd1 vccd1 vssd1 sky130_fd_sc_hd__fill_1$1
XFILLER_83_249 vssd1 vccd1 vccd1 vssd1 sky130_ef_sc_hd__decap_40_12$1
Xinput4 vccd1 vssd1 input4/X adc_data[1] vccd1 vssd1 sky130_fd_sc_hd__buf_2$1
X_1195_ _1463_/C1 _1194_/X _1211_/A2 hold14/X _1628_/D vssd1 vccd1 vccd1 vssd1 sky130_fd_sc_hd__o211a_1$1
XFILLER_36_121 vssd1 vccd1 vccd1 vssd1 sky130_ef_sc_hd__decap_40_12$1
XFILLER_52_625 vssd1 vccd1 vccd1 vssd1 sky130_fd_sc_hd__fill_8$1
XFILLER_24_305 vssd1 vccd1 vccd1 vssd1 sky130_fd_sc_hd__fill_2$1
XTAP_TAPCELL_ROW_35_823 vccd1 vssd1 sky130_fd_sc_hd__tapvpwrvgnd_1$1
XFILLER_36_165 vssd1 vccd1 vccd1 vssd1 sky130_ef_sc_hd__decap_40_12$1
XFILLER_101_39 vssd1 vccd1 vccd1 vssd1 sky130_ef_sc_hd__decap_40_12$1
XFILLER_91_293 vssd1 vccd1 vccd1 vssd1 sky130_ef_sc_hd__decap_40_12$1
XFILLER_52_669 vssd1 vccd1 vccd1 vssd1 sky130_fd_sc_hd__fill_2$1
XFILLER_51_113 vssd1 vccd1 vccd1 vssd1 sky130_ef_sc_hd__decap_40_12$1
XFILLER_20_533 vssd1 vccd1 vccd1 vssd1 sky130_ef_sc_hd__decap_40_12$1
X_0979_ _1437_/C1 _0978_/X _1013_/A2 hold172/X _1523_/D vssd1 vccd1 vccd1 vssd1 sky130_fd_sc_hd__o211a_1$1
XFILLER_118_443 vssd1 vccd1 vccd1 vssd1 sky130_fd_sc_hd__fill_8$1
XFILLER_106_605 vccd1 vssd1 vccd1 vssd1 sky130_fd_sc_hd__fill_1$1
XPHY_EDGE_ROW_89_Left_228 vccd1 vssd1 vccd1 vssd1 sky130_fd_sc_hd__decap_3$1
XFILLER_133_446 vssd1 vccd1 vccd1 vssd1 sky130_fd_sc_hd__fill_2$1
XFILLER_105_137 vssd1 vccd1 vccd1 vssd1 sky130_ef_sc_hd__decap_40_12$1
XFILLER_133_479 vssd1 vccd1 vccd1 vssd1 sky130_ef_sc_hd__decap_40_12$1
XFILLER_102_811 vccd1 vssd1 vccd1 vssd1 sky130_fd_sc_hd__fill_1$1
XFILLER_86_29 vssd1 vccd1 vccd1 vssd1 sky130_ef_sc_hd__decap_40_12$1
XFILLER_113_181 vssd1 vccd1 vccd1 vssd1 sky130_ef_sc_hd__decap_40_12$1
XTAP_TAPCELL_ROW_89_1629 vccd1 vssd1 sky130_fd_sc_hd__tapvpwrvgnd_1$1
XFILLER_87_577 vssd1 vccd1 vccd1 vssd1 sky130_fd_sc_hd__fill_2$1
XFILLER_59_279 vccd1 vssd1 vccd1 vssd1 sky130_fd_sc_hd__fill_1$1
XFILLER_101_387 vccd1 vssd1 vccd1 vssd1 sky130_fd_sc_hd__fill_1$1
XPHY_EDGE_ROW_98_Left_237 vccd1 vssd1 vccd1 vssd1 sky130_fd_sc_hd__decap_3$1
XFILLER_74_249 vssd1 vccd1 vccd1 vssd1 sky130_fd_sc_hd__fill_2$1
XFILLER_83_783 vccd1 vssd1 vccd1 vssd1 sky130_fd_sc_hd__fill_1$1
XFILLER_70_411 vccd1 vssd1 vccd1 vssd1 sky130_fd_sc_hd__fill_1$1
XFILLER_55_485 vssd1 vccd1 vccd1 vssd1 sky130_ef_sc_hd__decap_40_12$1
XFILLER_15_305 vssd1 vccd1 vccd1 vssd1 sky130_ef_sc_hd__decap_40_12$1
XFILLER_27_165 vssd1 vccd1 vccd1 vssd1 sky130_fd_sc_hd__fill_2$1
XFILLER_28_699 vccd1 vssd1 vccd1 vssd1 sky130_fd_sc_hd__fill_1$1
XFILLER_43_603 vssd1 vccd1 vccd1 vssd1 sky130_ef_sc_hd__decap_40_12$1
XFILLER_43_625 vccd1 vssd1 vccd1 vssd1 sky130_fd_sc_hd__fill_1$1
XFILLER_15_349 vssd1 vccd1 vccd1 vssd1 sky130_ef_sc_hd__decap_40_12$1
XFILLER_31_809 vssd1 vccd1 vccd1 vssd1 sky130_fd_sc_hd__fill_4$1
XFILLER_35_55 vccd1 vssd1 vccd1 vssd1 sky130_fd_sc_hd__fill_1$1
XTAP_TAPCELL_ROW_100_1807 vccd1 vssd1 sky130_fd_sc_hd__tapvpwrvgnd_1$1
XFILLER_23_393 vssd1 vccd1 vccd1 vssd1 sky130_ef_sc_hd__decap_40_12$1
XFILLER_137_741 vssd1 vccd1 vccd1 vssd1 sky130_fd_sc_hd__fill_2$1
XFILLER_136_251 vccd1 vssd1 vccd1 vssd1 sky130_fd_sc_hd__fill_1$1
XFILLER_7_559 vccd1 vssd1 vccd1 vssd1 sky130_fd_sc_hd__fill_1$1
XFILLER_137_785 vssd1 vccd1 vccd1 vssd1 sky130_fd_sc_hd__fill_2$1
XFILLER_124_413 vssd1 vccd1 vccd1 vssd1 sky130_fd_sc_hd__fill_4$1
XFILLER_109_487 vssd1 vccd1 vccd1 vssd1 sky130_ef_sc_hd__decap_40_12$1
XFILLER_3_721 vssd1 vccd1 vccd1 vssd1 sky130_fd_sc_hd__fill_4$1
XFILLER_136_295 vssd1 vccd1 vccd1 vssd1 sky130_ef_sc_hd__decap_40_12$1
XFILLER_124_457 vssd1 vccd1 vccd1 vssd1 sky130_fd_sc_hd__fill_4$1
XFILLER_105_671 vccd1 vssd1 vccd1 vssd1 sky130_fd_sc_hd__fill_1$1
XFILLER_3_765 vssd1 vccd1 vccd1 vssd1 sky130_ef_sc_hd__decap_40_12$1
XFILLER_2_253 vssd1 vccd1 vccd1 vssd1 sky130_ef_sc_hd__decap_40_12$1
XFILLER_120_641 vssd1 vccd1 vccd1 vssd1 sky130_fd_sc_hd__fill_2$1
XTAP_TAPCELL_ROW_111_1969 vccd1 vssd1 sky130_fd_sc_hd__tapvpwrvgnd_1$1
XTAP_TAPCELL_ROW_111_1958 vccd1 vssd1 sky130_fd_sc_hd__tapvpwrvgnd_1$1
XFILLER_78_533 vssd1 vccd1 vccd1 vssd1 sky130_ef_sc_hd__decap_40_12$1
XFILLER_120_674 vssd1 vccd1 vccd1 vssd1 sky130_fd_sc_hd__fill_2$1
XFILLER_93_503 vccd1 vssd1 vccd1 vssd1 sky130_fd_sc_hd__fill_1$1
XFILLER_66_706 vssd1 vccd1 vccd1 vssd1 sky130_ef_sc_hd__decap_40_12$1
XFILLER_65_205 vssd1 vccd1 vccd1 vssd1 sky130_ef_sc_hd__decap_40_12$1
XTAP_TAPCELL_ROW_53_1098 vccd1 vssd1 sky130_fd_sc_hd__tapvpwrvgnd_1$1
XFILLER_38_419 vccd1 vssd1 vccd1 vssd1 sky130_fd_sc_hd__fill_1$1
XFILLER_81_709 vssd1 vccd1 vccd1 vssd1 sky130_fd_sc_hd__fill_8$1
XFILLER_65_249 vssd1 vccd1 vccd1 vssd1 sky130_ef_sc_hd__decap_40_12$1
XFILLER_18_121 vssd1 vccd1 vccd1 vssd1 sky130_ef_sc_hd__decap_40_12$1
XFILLER_18_165 vssd1 vccd1 vccd1 vssd1 sky130_ef_sc_hd__decap_40_12$1
XFILLER_73_293 vssd1 vccd1 vccd1 vssd1 sky130_ef_sc_hd__decap_40_12$1
XFILLER_61_433 vccd1 vssd1 vccd1 vssd1 sky130_fd_sc_hd__fill_1$1
XFILLER_22_809 vssd1 vccd1 vccd1 vssd1 sky130_fd_sc_hd__fill_2$1
XFILLER_33_113 vssd1 vccd1 vccd1 vssd1 sky130_ef_sc_hd__decap_40_12$1
XFILLER_34_658 vccd1 vssd1 vccd1 vssd1 sky130_fd_sc_hd__fill_1$1
XFILLER_92_83 vccd1 vssd1 vccd1 vssd1 sky130_fd_sc_hd__fill_1$1
X_0902_ _1725_/Q _1344_/A _0903_/C hold94/A _1279_/A vccd1 vssd1 vccd1 vssd1 sky130_fd_sc_hd__a22o_1$1
X_0833_ _0878_/B1 _1714_/Q _0832_/X _0833_/X vccd1 vssd1 vccd1 vssd1 sky130_fd_sc_hd__a21o_1$1
XFILLER_127_273 vssd1 vccd1 vccd1 vssd1 sky130_fd_sc_hd__fill_4$1
XFILLER_6_581 vssd1 vccd1 vccd1 vssd1 sky130_fd_sc_hd__fill_4$1
X_0764_ _0879_/B1 _0764_/X _0763_/X _1782_/A _0875_/A2 _0762_/X vssd1 vccd1 vccd1
+ vssd1 sky130_fd_sc_hd__a2111o_1$1
XFILLER_115_457 vssd1 vccd1 vccd1 vssd1 sky130_fd_sc_hd__fill_2$1
XFILLER_115_468 vssd1 vccd1 vccd1 vssd1 sky130_ef_sc_hd__decap_40_12$1
XFILLER_115_446 vssd1 vccd1 vccd1 vssd1 sky130_fd_sc_hd__fill_2$1
XPHY_EDGE_ROW_135_Right_135 vccd1 vssd1 vccd1 vssd1 sky130_fd_sc_hd__decap_3$1
XFILLER_130_438 vssd1 vccd1 vccd1 vssd1 sky130_fd_sc_hd__fill_4$1
XFILLER_111_641 vssd1 vccd1 vccd1 vssd1 sky130_ef_sc_hd__decap_40_12$1
XFILLER_96_363 vccd1 vssd1 vccd1 vssd1 sky130_fd_sc_hd__fill_1$1
X_1316_ _1316_/A _1316_/X _1330_/B vssd1 vccd1 vccd1 vssd1 sky130_fd_sc_hd__or2_1$1
XFILLER_96_385 vssd1 vccd1 vccd1 vssd1 sky130_ef_sc_hd__decap_40_12$1
XFILLER_110_195 vccd1 vssd1 vccd1 vssd1 sky130_fd_sc_hd__fill_1$1
X_1247_ _1443_/C1 _1246_/X _1277_/A2 hold32/X _1653_/D vssd1 vccd1 vccd1 vssd1 sky130_fd_sc_hd__o211a_1$1
XFILLER_56_249 vssd1 vccd1 vccd1 vssd1 sky130_fd_sc_hd__fill_2$1
XFILLER_2_81 vssd1 vccd1 vccd1 vssd1 sky130_fd_sc_hd__fill_2$1
XFILLER_37_441 vssd1 vccd1 vccd1 vssd1 sky130_fd_sc_hd__fill_4$1
XFILLER_112_27 vccd1 vssd1 vccd1 vssd1 sky130_fd_sc_hd__fill_1$1
X_1178_ _1178_/A _1178_/X _1188_/B vssd1 vccd1 vccd1 vssd1 sky130_fd_sc_hd__or2_1$1
XFILLER_65_783 vccd1 vssd1 vccd1 vssd1 sky130_fd_sc_hd__fill_1$1
XFILLER_37_485 vssd1 vccd1 vccd1 vssd1 sky130_ef_sc_hd__decap_40_12$1
XTAP_TAPCELL_ROW_84_1559 vccd1 vssd1 sky130_fd_sc_hd__tapvpwrvgnd_1$1
XFILLER_52_477 vssd1 vccd1 vccd1 vssd1 sky130_fd_sc_hd__fill_2$1
XFILLER_13_809 vssd1 vccd1 vccd1 vssd1 sky130_ef_sc_hd__decap_40_12$1
XFILLER_25_669 vssd1 vccd1 vccd1 vssd1 sky130_fd_sc_hd__fill_2$1
XFILLER_138_505 vssd1 vccd1 vccd1 vssd1 sky130_fd_sc_hd__fill_2$1
XANTENNA_20 _1144_/B vssd1 vccd1 vccd1 vssd1 sky130_fd_sc_hd__diode_2$1
XFILLER_119_741 vssd1 vccd1 vccd1 vssd1 sky130_ef_sc_hd__decap_40_12$1
XFILLER_20_363 vccd1 vssd1 vccd1 vssd1 sky130_fd_sc_hd__fill_1$1
XFILLER_118_251 vccd1 vssd1 vccd1 vssd1 sky130_fd_sc_hd__fill_1$1
XTAP_TAPCELL_ROW_115_2025 vccd1 vssd1 sky130_fd_sc_hd__tapvpwrvgnd_1$1
XTAP_TAPCELL_ROW_99_1791 vccd1 vssd1 sky130_fd_sc_hd__tapvpwrvgnd_1$1
XTAP_TAPCELL_ROW_99_1780 vccd1 vssd1 sky130_fd_sc_hd__tapvpwrvgnd_1$1
XFILLER_137_35 vssd1 vccd1 vccd1 vssd1 sky130_ef_sc_hd__decap_40_12$1
XFILLER_119_785 vssd1 vccd1 vccd1 vssd1 sky130_ef_sc_hd__decap_40_12$1
XFILLER_4_529 vssd1 vccd1 vccd1 vssd1 sky130_fd_sc_hd__fill_2$1
XFILLER_21_57 vssd1 vccd1 vccd1 vssd1 sky130_ef_sc_hd__decap_40_12$1
XFILLER_137_57 vssd1 vccd1 vccd1 vssd1 sky130_fd_sc_hd__fill_2$1
XFILLER_133_221 vssd1 vccd1 vccd1 vssd1 sky130_fd_sc_hd__fill_2$1
XFILLER_134_777 vssd1 vccd1 vccd1 vssd1 sky130_fd_sc_hd__fill_8$1
XFILLER_97_39 vssd1 vccd1 vccd1 vssd1 sky130_ef_sc_hd__decap_40_12$1
XFILLER_0_713 vssd1 vccd1 vccd1 vssd1 sky130_ef_sc_hd__decap_40_12$1
Xoutput160 _1779_/X analog_ctrl[8] vssd1 vccd1 vccd1 vssd1 sky130_fd_sc_hd__buf_12$1
Xoutput182 _1478_/Q wbs_dat_o[1] vssd1 vccd1 vccd1 vssd1 sky130_fd_sc_hd__buf_12$1
Xoutput171 _1477_/Q wbs_dat_o[0] vssd1 vccd1 vccd1 vssd1 sky130_fd_sc_hd__buf_12$1
Xoutput193 _1479_/Q wbs_dat_o[2] vssd1 vccd1 vccd1 vssd1 sky130_fd_sc_hd__buf_12$1
XFILLER_121_449 vssd1 vccd1 vccd1 vssd1 sky130_ef_sc_hd__decap_40_12$1
XPHY_EDGE_ROW_102_Right_102 vccd1 vssd1 vccd1 vssd1 sky130_fd_sc_hd__decap_3$1
XFILLER_102_641 vssd1 vccd1 vccd1 vssd1 sky130_fd_sc_hd__fill_2$1
XFILLER_0_779 vssd1 vccd1 vccd1 vssd1 sky130_fd_sc_hd__fill_4$1
XFILLER_47_205 vssd1 vccd1 vccd1 vssd1 sky130_ef_sc_hd__decap_40_12$1
XFILLER_47_249 vssd1 vccd1 vccd1 vssd1 sky130_ef_sc_hd__decap_40_12$1
XTAP_TAPCELL_ROW_126_2187 vccd1 vssd1 sky130_fd_sc_hd__tapvpwrvgnd_1$1
XFILLER_90_528 vssd1 vccd1 vccd1 vssd1 sky130_fd_sc_hd__fill_4$1
XFILLER_16_625 vssd1 vccd1 vccd1 vssd1 sky130_ef_sc_hd__decap_40_12$1
XFILLER_46_65 vssd1 vccd1 vccd1 vssd1 sky130_ef_sc_hd__decap_40_12$1
XFILLER_71_753 vssd1 vccd1 vccd1 vssd1 sky130_ef_sc_hd__decap_40_12$1
XFILLER_55_293 vssd1 vccd1 vccd1 vssd1 sky130_ef_sc_hd__decap_40_12$1
XFILLER_15_113 vssd1 vccd1 vccd1 vssd1 sky130_ef_sc_hd__decap_40_12$1
XFILLER_16_669 vssd1 vccd1 vccd1 vssd1 sky130_ef_sc_hd__decap_40_12$1
XFILLER_31_617 vssd1 vccd1 vccd1 vssd1 sky130_ef_sc_hd__decap_40_12$1
XFILLER_62_53 vssd1 vccd1 vccd1 vssd1 sky130_ef_sc_hd__decap_40_12$1
XTAP_TAPCELL_ROW_26_686 vccd1 vssd1 sky130_fd_sc_hd__tapvpwrvgnd_1$1
XTAP_TAPCELL_ROW_26_697 vccd1 vssd1 sky130_fd_sc_hd__tapvpwrvgnd_1$1
XFILLER_129_505 vssd1 vccd1 vccd1 vssd1 sky130_ef_sc_hd__decap_40_12$1
XFILLER_62_97 vssd1 vccd1 vccd1 vssd1 sky130_ef_sc_hd__decap_40_12$1
XFILLER_8_813 vssd1 vccd1 vccd1 vssd1 sky130_ef_sc_hd__decap_40_12$1
XFILLER_7_15 vssd1 vccd1 vccd1 vssd1 sky130_ef_sc_hd__decap_40_12$1
XFILLER_11_385 vssd1 vccd1 vccd1 vssd1 sky130_fd_sc_hd__fill_4$1
XFILLER_125_700 vccd1 vssd1 vccd1 vssd1 sky130_fd_sc_hd__fill_1$1
XFILLER_125_711 vssd1 vccd1 vccd1 vssd1 sky130_ef_sc_hd__decap_40_12$1
XFILLER_109_273 vssd1 vccd1 vccd1 vssd1 sky130_fd_sc_hd__fill_4$1
XFILLER_7_389 vssd1 vccd1 vccd1 vssd1 sky130_fd_sc_hd__fill_2$1
XFILLER_124_221 vssd1 vccd1 vccd1 vssd1 sky130_ef_sc_hd__decap_40_12$1
XFILLER_125_777 vssd1 vccd1 vccd1 vssd1 sky130_fd_sc_hd__fill_4$1
XFILLER_124_265 vssd1 vccd1 vccd1 vssd1 sky130_ef_sc_hd__decap_40_12$1
XFILLER_97_105 vssd1 vccd1 vccd1 vssd1 sky130_fd_sc_hd__fill_4$1
XTAP_TAPCELL_ROW_55_1127 vccd1 vssd1 sky130_fd_sc_hd__tapvpwrvgnd_1$1
XFILLER_3_573 vssd1 vccd1 vccd1 vssd1 sky130_ef_sc_hd__decap_40_12$1
XFILLER_97_149 vssd1 vccd1 vccd1 vssd1 sky130_ef_sc_hd__decap_40_12$1
XFILLER_78_363 vccd1 vssd1 vccd1 vssd1 sky130_fd_sc_hd__fill_1$1
XFILLER_120_460 vccd1 vssd1 vccd1 vssd1 sky130_fd_sc_hd__fill_1$1
XFILLER_93_333 vssd1 vccd1 vccd1 vssd1 sky130_fd_sc_hd__fill_2$1
XFILLER_66_569 vssd1 vccd1 vccd1 vssd1 sky130_ef_sc_hd__decap_40_12$1
XFILLER_54_709 vssd1 vccd1 vccd1 vssd1 sky130_ef_sc_hd__decap_40_12$1
XFILLER_19_441 vssd1 vccd1 vccd1 vssd1 sky130_fd_sc_hd__fill_4$1
XFILLER_38_249 vssd1 vccd1 vccd1 vssd1 sky130_fd_sc_hd__fill_2$1
X_1101_ _1305_/C1 _1100_/X _1123_/A2 hold155/X _1582_/D vssd1 vccd1 vccd1 vssd1 sky130_fd_sc_hd__o211a_1$1
XFILLER_93_377 vssd1 vccd1 vccd1 vssd1 sky130_fd_sc_hd__fill_2$1
XFILLER_81_517 vssd1 vccd1 vccd1 vssd1 sky130_ef_sc_hd__decap_40_12$1
X_1032_ _1549_/Q _1032_/X _1052_/B vssd1 vccd1 vccd1 vssd1 sky130_fd_sc_hd__or2_1$1
XFILLER_93_399 vssd1 vccd1 vccd1 vssd1 sky130_ef_sc_hd__decap_40_12$1
XFILLER_19_485 vssd1 vccd1 vccd1 vssd1 sky130_ef_sc_hd__decap_40_12$1
XFILLER_34_433 vssd1 vccd1 vccd1 vssd1 sky130_ef_sc_hd__decap_40_12$1
XFILLER_34_477 vssd1 vccd1 vccd1 vssd1 sky130_ef_sc_hd__decap_40_12$1
XTAP_TAPCELL_ROW_45_973 vccd1 vssd1 sky130_fd_sc_hd__tapvpwrvgnd_1$1
XTAP_TAPCELL_ROW_66_1289 vccd1 vssd1 sky130_fd_sc_hd__tapvpwrvgnd_1$1
XFILLER_62_797 vssd1 vccd1 vccd1 vssd1 sky130_fd_sc_hd__fill_2$1
XFILLER_21_105 vssd1 vccd1 vccd1 vssd1 sky130_fd_sc_hd__fill_4$1
XFILLER_21_149 vssd1 vccd1 vccd1 vssd1 sky130_ef_sc_hd__decap_40_12$1
Xinput40 vccd1 vssd1 hold49/A hold48/X vccd1 vssd1 sky130_fd_sc_hd__buf_2$1
Xinput51 input51/X vccd1 vssd1 input51/A vccd1 vssd1 sky130_fd_sc_hd__buf_4$1
X_1796_ _1796_/A _1796_/X vssd1 vccd1 vccd1 vssd1 sky130_fd_sc_hd__clkbuf_2$1
X_0816_ _1801_/A hold10/A _0816_/X input2/X _0826_/B1 vccd1 vssd1 vccd1 vssd1 sky130_fd_sc_hd__a22o_1$1
X_0747_ hold24/A hold8/A hold17/A _0747_/X hold5/A vssd1 vccd1 vccd1 vssd1 sky130_fd_sc_hd__and4bb_4$1
XFILLER_116_755 vccd1 vssd1 vccd1 vssd1 sky130_fd_sc_hd__fill_1$1
XFILLER_115_221 vssd1 vccd1 vccd1 vssd1 sky130_fd_sc_hd__fill_2$1
XFILLER_131_725 vssd1 vccd1 vccd1 vssd1 sky130_fd_sc_hd__fill_2$1
XFILLER_107_27 vssd1 vccd1 vccd1 vssd1 sky130_ef_sc_hd__decap_40_12$1
XFILLER_89_639 vssd1 vccd1 vccd1 vssd1 sky130_ef_sc_hd__decap_40_12$1
XFILLER_89_617 vssd1 vccd1 vccd1 vssd1 sky130_fd_sc_hd__fill_2$1
XFILLER_103_449 vssd1 vccd1 vccd1 vssd1 sky130_fd_sc_hd__fill_8$1
XFILLER_57_503 vccd1 vssd1 vccd1 vssd1 sky130_fd_sc_hd__fill_1$1
XFILLER_123_15 vssd1 vccd1 vccd1 vssd1 sky130_ef_sc_hd__decap_40_12$1
XFILLER_97_694 vccd1 vssd1 vccd1 vssd1 sky130_fd_sc_hd__fill_1$1
XFILLER_69_385 vssd1 vccd1 vccd1 vssd1 sky130_fd_sc_hd__fill_4$1
XFILLER_29_205 vssd1 vccd1 vccd1 vssd1 sky130_ef_sc_hd__decap_40_12$1
XFILLER_96_193 vssd1 vccd1 vccd1 vssd1 sky130_fd_sc_hd__fill_2$1
XFILLER_84_333 vssd1 vccd1 vccd1 vssd1 sky130_ef_sc_hd__decap_40_12$1
XTAP_TAPCELL_ROW_4_359 vccd1 vssd1 sky130_fd_sc_hd__tapvpwrvgnd_1$1
XFILLER_29_249 vssd1 vccd1 vccd1 vssd1 sky130_ef_sc_hd__decap_40_12$1
XFILLER_84_377 vssd1 vccd1 vccd1 vssd1 sky130_ef_sc_hd__decap_40_12$1
XFILLER_37_293 vssd1 vccd1 vccd1 vssd1 sky130_ef_sc_hd__decap_40_12$1
XFILLER_53_753 vssd1 vccd1 vccd1 vssd1 sky130_ef_sc_hd__decap_40_12$1
XFILLER_13_617 vssd1 vccd1 vccd1 vssd1 sky130_ef_sc_hd__decap_40_12$1
XFILLER_53_797 vssd1 vccd1 vccd1 vssd1 sky130_ef_sc_hd__decap_40_12$1
XFILLER_8_109 vssd1 vccd1 vccd1 vssd1 sky130_ef_sc_hd__decap_40_12$1
XTAP_TAPCELL_ROW_23_645 vccd1 vssd1 sky130_fd_sc_hd__tapvpwrvgnd_1$1
XFILLER_40_469 vssd1 vccd1 vccd1 vssd1 sky130_fd_sc_hd__fill_4$1
XFILLER_138_335 vccd1 vssd1 vccd1 vssd1 sky130_fd_sc_hd__fill_1$1
XFILLER_20_193 vssd1 vccd1 vccd1 vssd1 sky130_fd_sc_hd__fill_2$1
XFILLER_106_221 vssd1 vccd1 vccd1 vssd1 sky130_ef_sc_hd__decap_40_12$1
XFILLER_106_3 vssd1 vccd1 vccd1 vssd1 sky130_ef_sc_hd__decap_40_12$1
XFILLER_122_725 vssd1 vccd1 vccd1 vssd1 sky130_ef_sc_hd__decap_40_12$1
XFILLER_107_777 vssd1 vccd1 vccd1 vssd1 sky130_fd_sc_hd__fill_4$1
XFILLER_106_265 vssd1 vccd1 vccd1 vssd1 sky130_ef_sc_hd__decap_40_12$1
XFILLER_79_105 vssd1 vccd1 vccd1 vssd1 sky130_fd_sc_hd__fill_4$1
XTAP_TAPCELL_ROW_128_2216 vccd1 vssd1 sky130_fd_sc_hd__tapvpwrvgnd_1$1
XFILLER_122_769 vssd1 vccd1 vccd1 vssd1 sky130_ef_sc_hd__decap_40_12$1
XFILLER_95_609 vssd1 vccd1 vccd1 vssd1 sky130_fd_sc_hd__fill_4$1
XFILLER_79_149 vssd1 vccd1 vccd1 vssd1 sky130_ef_sc_hd__decap_40_12$1
XFILLER_76_801 vssd1 vccd1 vccd1 vssd1 sky130_fd_sc_hd__fill_2$1
XTAP_TAPCELL_ROW_128_2227 vccd1 vssd1 sky130_fd_sc_hd__tapvpwrvgnd_1$1
XFILLER_121_279 vccd1 vssd1 vccd1 vssd1 sky130_fd_sc_hd__fill_1$1
XFILLER_76_834 vssd1 vccd1 vccd1 vssd1 sky130_fd_sc_hd__fill_8$1
XTAP_TAPCELL_ROW_50_1046 vccd1 vssd1 sky130_fd_sc_hd__tapvpwrvgnd_1$1
XFILLER_0_587 vccd1 vssd1 vccd1 vssd1 sky130_fd_sc_hd__fill_1$1
XFILLER_87_193 vssd1 vccd1 vccd1 vssd1 sky130_ef_sc_hd__decap_40_12$1
XFILLER_75_333 vssd1 vccd1 vccd1 vssd1 sky130_fd_sc_hd__fill_2$1
XTAP_TAPCELL_ROW_50_1057 vccd1 vssd1 sky130_fd_sc_hd__tapvpwrvgnd_1$1
XFILLER_48_558 vssd1 vccd1 vccd1 vssd1 sky130_fd_sc_hd__fill_4$1
XFILLER_63_517 vssd1 vccd1 vccd1 vssd1 sky130_ef_sc_hd__decap_40_12$1
XFILLER_29_783 vccd1 vssd1 vccd1 vssd1 sky130_fd_sc_hd__fill_1$1
XFILLER_113_81 vssd1 vccd1 vccd1 vssd1 sky130_ef_sc_hd__decap_40_12$1
XFILLER_16_433 vssd1 vccd1 vccd1 vssd1 sky130_ef_sc_hd__decap_40_12$1
XFILLER_71_561 vssd1 vccd1 vccd1 vssd1 sky130_fd_sc_hd__fill_2$1
XFILLER_16_477 vssd1 vccd1 vccd1 vssd1 sky130_ef_sc_hd__decap_40_12$1
XTAP_TAPCELL_ROW_42_932 vccd1 vssd1 sky130_fd_sc_hd__tapvpwrvgnd_1$1
XFILLER_31_447 vccd1 vssd1 vccd1 vssd1 sky130_fd_sc_hd__fill_1$1
XFILLER_129_335 vccd1 vssd1 vccd1 vssd1 sky130_fd_sc_hd__fill_1$1
XFILLER_129_313 vssd1 vccd1 vccd1 vssd1 sky130_ef_sc_hd__decap_40_12$1
XFILLER_8_643 vccd1 vssd1 vccd1 vssd1 sky130_fd_sc_hd__fill_1$1
X_1650_ _1650_/Q _1719_/CLK _1650_/D vccd1 vssd1 vccd1 vssd1 sky130_fd_sc_hd__dfxtp_2$1
XFILLER_11_193 vssd1 vccd1 vccd1 vssd1 sky130_ef_sc_hd__decap_40_12$1
XFILLER_125_541 vssd1 vccd1 vccd1 vssd1 sky130_ef_sc_hd__decap_40_12$1
Xhold109 input41/X hold109/X vssd1 vccd1 vccd1 vssd1 sky130_fd_sc_hd__dlygate4sd3_1$1
X_1581_ _1799_/A clkload4/A _1581_/D vccd1 vssd1 vccd1 vssd1 sky130_fd_sc_hd__dfxtp_1$1
XFILLER_113_725 vssd1 vccd1 vccd1 vssd1 sky130_fd_sc_hd__fill_2$1
XFILLER_98_469 vssd1 vccd1 vccd1 vssd1 sky130_fd_sc_hd__fill_4$1
XFILLER_100_419 vccd1 vssd1 vccd1 vssd1 sky130_fd_sc_hd__fill_1$1
XFILLER_21_3 vssd1 vccd1 vccd1 vssd1 sky130_ef_sc_hd__decap_40_12$1
XFILLER_39_503 vccd1 vssd1 vccd1 vssd1 sky130_fd_sc_hd__fill_1$1
XFILLER_94_642 vssd1 vccd1 vccd1 vssd1 sky130_fd_sc_hd__fill_2$1
XFILLER_78_193 vssd1 vccd1 vccd1 vssd1 sky130_fd_sc_hd__fill_2$1
XFILLER_66_333 vssd1 vccd1 vccd1 vssd1 sky130_ef_sc_hd__decap_40_12$1
XFILLER_39_569 vssd1 vccd1 vccd1 vssd1 sky130_ef_sc_hd__decap_40_12$1
XFILLER_94_697 vssd1 vccd1 vccd1 vssd1 sky130_fd_sc_hd__fill_2$1
XTAP_TAPCELL_ROW_68_1318 vccd1 vssd1 sky130_fd_sc_hd__tapvpwrvgnd_1$1
XFILLER_66_377 vssd1 vccd1 vccd1 vssd1 sky130_fd_sc_hd__fill_8$1
XTAP_TAPCELL_ROW_1_318 vccd1 vssd1 sky130_fd_sc_hd__tapvpwrvgnd_1$1
XFILLER_19_293 vssd1 vccd1 vccd1 vssd1 sky130_ef_sc_hd__decap_40_12$1
X_1015_ _1015_/Y _1015_/A _1411_/B vssd1 vccd1 vccd1 vssd1 sky130_fd_sc_hd__nand2_2$1
XFILLER_50_701 vssd1 vccd1 vccd1 vssd1 sky130_ef_sc_hd__decap_40_12$1
XTAP_TAPCELL_ROW_81_1518 vccd1 vssd1 sky130_fd_sc_hd__tapvpwrvgnd_1$1
XFILLER_50_734 vssd1 vccd1 vccd1 vssd1 sky130_ef_sc_hd__decap_40_12$1
XFILLER_35_797 vssd1 vccd1 vccd1 vssd1 sky130_ef_sc_hd__decap_40_12$1
XTAP_TAPCELL_ROW_20_604 vccd1 vssd1 sky130_fd_sc_hd__tapvpwrvgnd_1$1
XFILLER_22_469 vssd1 vccd1 vccd1 vssd1 sky130_fd_sc_hd__fill_4$1
XFILLER_135_305 vssd1 vccd1 vccd1 vssd1 sky130_ef_sc_hd__decap_40_12$1
XFILLER_118_15 vssd1 vccd1 vccd1 vssd1 sky130_ef_sc_hd__decap_40_12$1
X_1848_ _1848_/A _1848_/X vssd1 vccd1 vccd1 vssd1 sky130_fd_sc_hd__clkbuf_2$1
XTAP_TAPCELL_ROW_9_429 vccd1 vssd1 sky130_fd_sc_hd__tapvpwrvgnd_1$1
X_1779_ vccd1 vssd1 _1779_/X _1779_/A vccd1 vssd1 sky130_fd_sc_hd__buf_1$1
XFILLER_104_747 vccd1 vssd1 vccd1 vssd1 sky130_fd_sc_hd__fill_1$1
XFILLER_89_436 vssd1 vccd1 vccd1 vssd1 sky130_ef_sc_hd__decap_40_12$1
XFILLER_1_329 vssd1 vccd1 vccd1 vssd1 sky130_fd_sc_hd__fill_4$1
XFILLER_103_279 vccd1 vssd1 vccd1 vssd1 sky130_fd_sc_hd__fill_1$1
XFILLER_94_29 vssd1 vccd1 vccd1 vssd1 sky130_ef_sc_hd__decap_40_12$1
XFILLER_85_653 vssd1 vccd1 vccd1 vssd1 sky130_fd_sc_hd__fill_8$1
XFILLER_69_193 vssd1 vccd1 vccd1 vssd1 sky130_ef_sc_hd__decap_40_12$1
XFILLER_57_333 vssd1 vccd1 vccd1 vssd1 sky130_fd_sc_hd__fill_2$1
XFILLER_84_141 vssd1 vccd1 vccd1 vssd1 sky130_ef_sc_hd__decap_40_12$1
XTAP_TAPCELL_ROW_28_715 vccd1 vssd1 sky130_fd_sc_hd__tapvpwrvgnd_1$1
XFILLER_45_517 vssd1 vccd1 vccd1 vssd1 sky130_ef_sc_hd__decap_40_12$1
XTAP_TAPCELL_ROW_123_2146 vccd1 vssd1 sky130_fd_sc_hd__tapvpwrvgnd_1$1
XTAP_TAPCELL_ROW_28_726 vccd1 vssd1 sky130_fd_sc_hd__tapvpwrvgnd_1$1
XFILLER_53_550 vssd1 vccd1 vccd1 vssd1 sky130_fd_sc_hd__fill_8$1
XFILLER_26_742 vccd1 vssd1 vccd1 vssd1 sky130_fd_sc_hd__fill_1$1
XFILLER_53_561 vssd1 vccd1 vccd1 vssd1 sky130_ef_sc_hd__decap_40_12$1
XFILLER_26_786 vssd1 vccd1 vccd1 vssd1 sky130_fd_sc_hd__fill_4$1
XFILLER_13_447 vccd1 vssd1 vccd1 vssd1 sky130_fd_sc_hd__fill_1$1
XFILLER_40_233 vssd1 vccd1 vccd1 vssd1 sky130_ef_sc_hd__decap_40_12$1
XFILLER_43_55 vccd1 vssd1 vccd1 vssd1 sky130_fd_sc_hd__fill_1$1
XFILLER_9_429 vssd1 vccd1 vccd1 vssd1 sky130_ef_sc_hd__decap_40_12$1
XFILLER_40_277 vssd1 vccd1 vccd1 vssd1 sky130_ef_sc_hd__decap_40_12$1
XFILLER_126_305 vssd1 vccd1 vccd1 vssd1 sky130_fd_sc_hd__fill_2$1
XFILLER_5_613 vssd1 vccd1 vccd1 vssd1 sky130_fd_sc_hd__fill_2$1
XFILLER_122_533 vssd1 vccd1 vccd1 vssd1 sky130_ef_sc_hd__decap_40_12$1
XFILLER_4_189 vssd1 vccd1 vccd1 vssd1 sky130_fd_sc_hd__fill_4$1
XFILLER_4_27 vccd1 vssd1 vccd1 vssd1 sky130_fd_sc_hd__fill_1$1
XFILLER_122_555 vccd1 vssd1 vccd1 vssd1 sky130_fd_sc_hd__fill_1$1
XFILLER_108_81 vssd1 vccd1 vccd1 vssd1 sky130_fd_sc_hd__fill_2$1
XFILLER_68_41 vssd1 vccd1 vccd1 vssd1 sky130_ef_sc_hd__decap_40_12$1
XFILLER_49_801 vssd1 vccd1 vccd1 vssd1 sky130_fd_sc_hd__fill_2$1
XFILLER_1_841 vccd1 vssd1 vccd1 vssd1 sky130_fd_sc_hd__fill_1$1
XFILLER_68_85 vssd1 vccd1 vccd1 vssd1 sky130_ef_sc_hd__decap_40_12$1
XFILLER_48_333 vssd1 vccd1 vccd1 vssd1 sky130_ef_sc_hd__decap_40_12$1
XTAP_TAPCELL_ROW_108_1919 vccd1 vssd1 sky130_fd_sc_hd__tapvpwrvgnd_1$1
XFILLER_48_377 vssd1 vccd1 vccd1 vssd1 sky130_ef_sc_hd__decap_40_12$1
XFILLER_76_697 vssd1 vccd1 vccd1 vssd1 sky130_fd_sc_hd__fill_2$1
XFILLER_91_689 vccd1 vssd1 vccd1 vssd1 sky130_fd_sc_hd__fill_1$1
XFILLER_90_133 vssd1 vccd1 vccd1 vssd1 sky130_fd_sc_hd__fill_4$1
XFILLER_17_753 vssd1 vccd1 vccd1 vssd1 sky130_ef_sc_hd__decap_40_12$1
XFILLER_90_177 vssd1 vccd1 vccd1 vssd1 sky130_ef_sc_hd__decap_40_12$1
XFILLER_17_797 vssd1 vccd1 vccd1 vssd1 sky130_ef_sc_hd__decap_40_12$1
XFILLER_32_712 vssd1 vccd1 vccd1 vssd1 sky130_ef_sc_hd__decap_40_12$1
XFILLER_71_391 vccd1 vssd1 vccd1 vssd1 sky130_fd_sc_hd__fill_1$1
XTAP_TAPCELL_ROW_63_1248 vccd1 vssd1 sky130_fd_sc_hd__tapvpwrvgnd_1$1
XFILLER_31_277 vssd1 vccd1 vccd1 vssd1 sky130_fd_sc_hd__fill_2$1
XFILLER_129_165 vssd1 vccd1 vccd1 vssd1 sky130_fd_sc_hd__fill_2$1
XFILLER_117_305 vssd1 vccd1 vccd1 vssd1 sky130_ef_sc_hd__decap_40_12$1
X_1702_ _1825_/A _1737_/CLK _1702_/D vccd1 vssd1 vccd1 vssd1 sky130_fd_sc_hd__dfxtp_1$1
XFILLER_8_473 vssd1 vccd1 vccd1 vssd1 sky130_fd_sc_hd__fill_2$1
XFILLER_133_809 vssd1 vccd1 vccd1 vssd1 sky130_ef_sc_hd__decap_40_12$1
X_1633_ _1633_/Q _1633_/CLK _1633_/D vccd1 vssd1 vccd1 vssd1 sky130_fd_sc_hd__dfxtp_1$1
XFILLER_117_349 vssd1 vccd1 vccd1 vssd1 sky130_ef_sc_hd__decap_40_12$1
XFILLER_69_3 vssd1 vccd1 vccd1 vssd1 sky130_ef_sc_hd__decap_40_12$1
XFILLER_99_701 vssd1 vccd1 vccd1 vssd1 sky130_ef_sc_hd__decap_40_12$1
X_1564_ hold40/A _1756_/CLK _1564_/D vccd1 vssd1 vccd1 vssd1 sky130_fd_sc_hd__dfxtp_1$1
XFILLER_125_393 vssd1 vccd1 vccd1 vssd1 sky130_ef_sc_hd__decap_40_12$1
XFILLER_98_233 vssd1 vccd1 vccd1 vssd1 sky130_ef_sc_hd__decap_40_12$1
X_1495_ _1495_/Q _1719_/CLK _1495_/D vccd1 vssd1 vccd1 vssd1 sky130_fd_sc_hd__dfxtp_2$1
XFILLER_59_609 vssd1 vccd1 vccd1 vssd1 sky130_fd_sc_hd__fill_4$1
XFILLER_98_277 vssd1 vccd1 vccd1 vssd1 sky130_ef_sc_hd__decap_40_12$1
XFILLER_100_249 vssd1 vccd1 vccd1 vssd1 sky130_fd_sc_hd__fill_2$1
XFILLER_79_491 vssd1 vccd1 vccd1 vssd1 sky130_ef_sc_hd__decap_40_12$1
XFILLER_39_333 vssd1 vccd1 vccd1 vssd1 sky130_fd_sc_hd__fill_2$1
XFILLER_67_664 vssd1 vccd1 vccd1 vssd1 sky130_fd_sc_hd__fill_8$1
XFILLER_66_141 vssd1 vccd1 vccd1 vssd1 sky130_ef_sc_hd__decap_40_12$1
XFILLER_27_517 vssd1 vccd1 vccd1 vssd1 sky130_ef_sc_hd__decap_40_12$1
XFILLER_82_645 vssd1 vccd1 vccd1 vssd1 sky130_ef_sc_hd__decap_40_12$1
XFILLER_81_111 vccd1 vssd1 vccd1 vssd1 sky130_fd_sc_hd__fill_1$1
XFILLER_120_27 vccd1 vssd1 vccd1 vssd1 sky130_fd_sc_hd__fill_1$1
XFILLER_35_561 vssd1 vccd1 vccd1 vssd1 sky130_ef_sc_hd__decap_40_12$1
XFILLER_22_233 vssd1 vccd1 vccd1 vssd1 sky130_ef_sc_hd__decap_40_12$1
XFILLER_10_417 vssd1 vccd1 vccd1 vssd1 sky130_fd_sc_hd__fill_2$1
XFILLER_22_277 vssd1 vccd1 vccd1 vssd1 sky130_ef_sc_hd__decap_40_12$1
XTAP_TAPCELL_ROW_33_795 vccd1 vssd1 sky130_fd_sc_hd__tapvpwrvgnd_1$1
XFILLER_108_305 vssd1 vccd1 vccd1 vssd1 sky130_fd_sc_hd__fill_2$1
XPHY_EDGE_ROW_70_Left_209 vccd1 vssd1 vccd1 vssd1 sky130_fd_sc_hd__decap_3$1
XFILLER_13_69 vssd1 vccd1 vccd1 vssd1 sky130_ef_sc_hd__decap_40_12$1
XFILLER_135_113 vssd1 vccd1 vccd1 vssd1 sky130_ef_sc_hd__decap_40_12$1
XFILLER_129_69 vssd1 vccd1 vccd1 vssd1 sky130_ef_sc_hd__decap_40_12$1
XTAP_TAPCELL_ROW_94_1709 vccd1 vssd1 sky130_fd_sc_hd__tapvpwrvgnd_1$1
XFILLER_104_533 vssd1 vccd1 vccd1 vssd1 sky130_ef_sc_hd__decap_40_12$1
XFILLER_1_137 vssd1 vccd1 vccd1 vssd1 sky130_ef_sc_hd__decap_40_12$1
XFILLER_131_385 vssd1 vccd1 vccd1 vssd1 sky130_fd_sc_hd__fill_4$1
XFILLER_89_277 vssd1 vccd1 vccd1 vssd1 sky130_fd_sc_hd__fill_2$1
XFILLER_77_417 vssd1 vccd1 vccd1 vssd1 sky130_ef_sc_hd__decap_40_12$1
XFILLER_73_612 vssd1 vccd1 vccd1 vssd1 sky130_fd_sc_hd__fill_4$1
XFILLER_38_77 vssd1 vccd1 vccd1 vssd1 sky130_fd_sc_hd__fill_4$1
XFILLER_72_133 vssd1 vccd1 vccd1 vssd1 sky130_fd_sc_hd__fill_4$1
XFILLER_72_177 vssd1 vccd1 vccd1 vssd1 sky130_ef_sc_hd__decap_40_12$1
XFILLER_54_65 vssd1 vccd1 vccd1 vssd1 sky130_ef_sc_hd__decap_40_12$1
XFILLER_14_701 vssd1 vccd1 vccd1 vssd1 sky130_ef_sc_hd__decap_40_12$1
XTAP_TAPCELL_ROW_103_1849 vccd1 vssd1 sky130_fd_sc_hd__tapvpwrvgnd_1$1
XTAP_TAPCELL_ROW_103_1838 vccd1 vssd1 sky130_fd_sc_hd__tapvpwrvgnd_1$1
XFILLER_53_391 vccd1 vssd1 vccd1 vssd1 sky130_fd_sc_hd__fill_1$1
XPHY_EDGE_ROW_109_Left_248 vccd1 vssd1 vccd1 vssd1 sky130_fd_sc_hd__decap_3$1
XFILLER_41_575 vssd1 vccd1 vccd1 vssd1 sky130_ef_sc_hd__decap_40_12$1
XTAP_TAPCELL_ROW_136_2337 vccd1 vssd1 sky130_fd_sc_hd__tapvpwrvgnd_1$1
XFILLER_70_53 vssd1 vccd1 vccd1 vssd1 sky130_ef_sc_hd__decap_40_12$1
XFILLER_9_237 vssd1 vccd1 vccd1 vssd1 sky130_ef_sc_hd__decap_40_12$1
XFILLER_13_277 vssd1 vccd1 vccd1 vssd1 sky130_fd_sc_hd__fill_2$1
XFILLER_41_597 vccd1 vssd1 vccd1 vssd1 sky130_fd_sc_hd__fill_1$1
XFILLER_127_625 vssd1 vccd1 vccd1 vssd1 sky130_fd_sc_hd__fill_2$1
XFILLER_127_614 vssd1 vccd1 vccd1 vssd1 sky130_fd_sc_hd__fill_2$1
Xclkload29 clkload29/X _1754_/CLK vssd1 vccd1 vccd1 vssd1 sky130_fd_sc_hd__clkbuf_8$1
Xclkload18 _1753_/CLK clkload18/Y vccd1 vssd1 vccd1 vssd1 sky130_fd_sc_hd__clkinvlp_4$1
XFILLER_70_97 vssd1 vccd1 vccd1 vssd1 sky130_ef_sc_hd__decap_40_12$1
XTAP_TAPCELL_ROW_11_467 vccd1 vssd1 sky130_fd_sc_hd__tapvpwrvgnd_1$1
XFILLER_115_809 vssd1 vccd1 vccd1 vssd1 sky130_ef_sc_hd__decap_40_12$1
Xclkbuf_leaf_1_wb_clk_i _1753_/CLK clkbuf_leaf_9_wb_clk_i/A vssd1 vccd1 vccd1 vssd1
+ sky130_fd_sc_hd__clkbuf_8$1
XFILLER_79_51 vssd1 vccd1 vccd1 vssd1 sky130_fd_sc_hd__fill_4$1
XFILLER_107_393 vssd1 vccd1 vccd1 vssd1 sky130_ef_sc_hd__decap_40_12$1
XFILLER_122_363 vccd1 vssd1 vccd1 vssd1 sky130_fd_sc_hd__fill_1$1
XPHY_EDGE_ROW_118_Left_257 vccd1 vssd1 vccd1 vssd1 sky130_fd_sc_hd__decap_3$1
XFILLER_110_514 vssd1 vccd1 vccd1 vssd1 sky130_ef_sc_hd__decap_40_12$1
XFILLER_68_417 vssd1 vccd1 vccd1 vssd1 sky130_fd_sc_hd__fill_2$1
XFILLER_1_671 vccd1 vssd1 vccd1 vssd1 sky130_fd_sc_hd__fill_1$1
XFILLER_95_225 vssd1 vccd1 vccd1 vssd1 sky130_ef_sc_hd__decap_40_12$1
X_1280_ _1837_/A _1280_/X _1342_/B vssd1 vccd1 vccd1 vssd1 sky130_fd_sc_hd__or2_1$1
XFILLER_0_181 vssd1 vccd1 vccd1 vssd1 sky130_ef_sc_hd__decap_40_12$1
XFILLER_110_569 vssd1 vccd1 vccd1 vssd1 sky130_ef_sc_hd__decap_40_12$1
XFILLER_48_141 vssd1 vccd1 vccd1 vssd1 sky130_ef_sc_hd__decap_40_12$1
XFILLER_64_645 vssd1 vccd1 vccd1 vssd1 sky130_fd_sc_hd__fill_4$1
XFILLER_63_111 vccd1 vssd1 vccd1 vssd1 sky130_fd_sc_hd__fill_1$1
XFILLER_49_697 vssd1 vccd1 vccd1 vssd1 sky130_fd_sc_hd__fill_2$1
XFILLER_91_497 vssd1 vccd1 vccd1 vssd1 sky130_fd_sc_hd__fill_4$1
XFILLER_51_317 vssd1 vccd1 vccd1 vssd1 sky130_ef_sc_hd__decap_40_12$1
XFILLER_17_561 vssd1 vccd1 vccd1 vssd1 sky130_ef_sc_hd__decap_40_12$1
XTAP_TAPCELL_ROW_19_578 vccd1 vssd1 sky130_fd_sc_hd__tapvpwrvgnd_1$1
XTAP_TAPCELL_ROW_19_589 vccd1 vssd1 sky130_fd_sc_hd__tapvpwrvgnd_1$1
XPHY_EDGE_ROW_127_Left_266 vccd1 vssd1 vccd1 vssd1 sky130_fd_sc_hd__decap_3$1
XFILLER_32_531 vccd1 vssd1 vccd1 vssd1 sky130_fd_sc_hd__fill_1$1
XFILLER_20_737 vssd1 vccd1 vccd1 vssd1 sky130_ef_sc_hd__decap_40_12$1
XFILLER_118_603 vccd1 vssd1 vccd1 vssd1 sky130_fd_sc_hd__fill_1$1
X_0995_ _1463_/C1 _0994_/X _1013_/A2 hold59/X _1531_/D vssd1 vccd1 vccd1 vssd1 sky130_fd_sc_hd__o211a_1$1
XTAP_TAPCELL_ROW_30_743 vccd1 vssd1 sky130_fd_sc_hd__tapvpwrvgnd_1$1
XTAP_TAPCELL_ROW_30_754 vccd1 vssd1 sky130_fd_sc_hd__tapvpwrvgnd_1$1
XFILLER_117_113 vssd1 vccd1 vccd1 vssd1 sky130_ef_sc_hd__decap_40_12$1
XFILLER_118_669 vssd1 vccd1 vccd1 vssd1 sky130_fd_sc_hd__fill_4$1
XFILLER_106_809 vssd1 vccd1 vccd1 vssd1 sky130_fd_sc_hd__fill_2$1
XTAP_TAPCELL_ROW_76_1439 vccd1 vssd1 sky130_fd_sc_hd__tapvpwrvgnd_1$1
XPHY_EDGE_ROW_136_Left_275 vccd1 vssd1 vccd1 vssd1 sky130_fd_sc_hd__decap_3$1
XFILLER_126_680 vssd1 vccd1 vccd1 vssd1 sky130_fd_sc_hd__fill_2$1
X_1616_ _1820_/A _1742_/CLK _1616_/D vccd1 vssd1 vccd1 vssd1 sky130_fd_sc_hd__dfxtp_1$1
Xfanout205 _1474_/B vccd1 vssd1 _1464_/B vccd1 vssd1 sky130_fd_sc_hd__buf_4$1
XFILLER_5_81 vssd1 vccd1 vccd1 vssd1 sky130_ef_sc_hd__decap_40_12$1
Xfanout227 _1079_/A2 vccd1 vssd1 _1053_/A2 vccd1 vssd1 sky130_fd_sc_hd__buf_6$1
Xfanout238 _1213_/A vccd1 vssd1 _0906_/B1 vccd1 vssd1 sky130_fd_sc_hd__buf_6$1
XFILLER_115_27 vssd1 vccd1 vccd1 vssd1 sky130_ef_sc_hd__decap_40_12$1
Xfanout216 _1277_/A2 vccd1 vssd1 _1213_/Y vccd1 vssd1 sky130_fd_sc_hd__buf_6$1
X_1547_ _1778_/A _1579_/CLK _1547_/D vccd1 vssd1 vccd1 vssd1 sky130_fd_sc_hd__dfxtp_1$1
XFILLER_101_547 vssd1 vccd1 vccd1 vssd1 sky130_ef_sc_hd__decap_40_12$1
XFILLER_101_525 vccd1 vssd1 vccd1 vssd1 sky130_fd_sc_hd__fill_1$1
X_1478_ _1478_/D _1737_/CLK _1478_/Q vssd1 vccd1 vccd1 vssd1 sky130_fd_sc_hd__dfxtp_4$1
XFILLER_59_439 vccd1 vssd1 vccd1 vssd1 sky130_fd_sc_hd__fill_1$1
XFILLER_67_461 vssd1 vccd1 vccd1 vssd1 sky130_ef_sc_hd__decap_40_12$1
XFILLER_131_15 vssd1 vccd1 vccd1 vssd1 sky130_ef_sc_hd__decap_40_12$1
XFILLER_55_645 vssd1 vccd1 vccd1 vssd1 sky130_ef_sc_hd__decap_40_12$1
XFILLER_54_133 vssd1 vccd1 vccd1 vssd1 sky130_fd_sc_hd__fill_4$1
XTAP_TAPCELL_ROW_38_865 vccd1 vssd1 sky130_fd_sc_hd__tapvpwrvgnd_1$1
XTAP_TAPCELL_ROW_120_2105 vccd1 vssd1 sky130_fd_sc_hd__tapvpwrvgnd_1$1
XFILLER_82_475 vccd1 vssd1 vccd1 vssd1 sky130_fd_sc_hd__fill_1$1
XFILLER_70_637 vssd1 vccd1 vccd1 vssd1 sky130_fd_sc_hd__fill_4$1
XFILLER_54_177 vssd1 vccd1 vccd1 vssd1 sky130_ef_sc_hd__decap_40_12$1
XTAP_TAPCELL_ROW_38_876 vccd1 vssd1 sky130_fd_sc_hd__tapvpwrvgnd_1$1
XFILLER_35_391 vccd1 vssd1 vccd1 vssd1 sky130_fd_sc_hd__fill_1$1
XFILLER_50_361 vssd1 vccd1 vccd1 vssd1 sky130_fd_sc_hd__fill_2$1
XFILLER_23_553 vssd1 vccd1 vccd1 vssd1 sky130_fd_sc_hd__fill_4$1
XFILLER_23_597 vssd1 vccd1 vccd1 vssd1 sky130_ef_sc_hd__decap_40_12$1
XFILLER_136_433 vssd1 vccd1 vccd1 vssd1 sky130_ef_sc_hd__decap_40_12$1
XFILLER_136_411 vssd1 vccd1 vccd1 vssd1 sky130_fd_sc_hd__fill_8$1
XTAP_TAPCELL_ROW_118_2067 vccd1 vssd1 sky130_fd_sc_hd__tapvpwrvgnd_1$1
XFILLER_109_669 vssd1 vccd1 vccd1 vssd1 sky130_fd_sc_hd__fill_2$1
XTAP_TAPCELL_ROW_131_2267 vccd1 vssd1 sky130_fd_sc_hd__tapvpwrvgnd_1$1
XFILLER_123_105 vssd1 vccd1 vccd1 vssd1 sky130_fd_sc_hd__fill_4$1
XFILLER_2_413 vssd1 vccd1 vccd1 vssd1 sky130_fd_sc_hd__fill_4$1
XFILLER_123_149 vssd1 vccd1 vccd1 vssd1 sky130_ef_sc_hd__decap_40_12$1
XFILLER_2_457 vssd1 vccd1 vccd1 vssd1 sky130_ef_sc_hd__decap_40_12$1
XFILLER_104_363 vccd1 vssd1 vccd1 vssd1 sky130_fd_sc_hd__fill_1$1
XFILLER_131_193 vssd1 vccd1 vccd1 vssd1 sky130_ef_sc_hd__decap_40_12$1
XFILLER_77_225 vssd1 vccd1 vccd1 vssd1 sky130_ef_sc_hd__decap_40_12$1
XFILLER_93_729 vssd1 vccd1 vccd1 vssd1 sky130_ef_sc_hd__decap_40_12$1
XFILLER_105_93 vssd1 vccd1 vccd1 vssd1 sky130_ef_sc_hd__decap_40_12$1
XFILLER_1_39 vssd1 vccd1 vccd1 vssd1 sky130_ef_sc_hd__decap_40_12$1
XFILLER_45_111 vccd1 vssd1 vccd1 vssd1 sky130_fd_sc_hd__fill_1$1
XFILLER_73_431 vssd1 vccd1 vccd1 vssd1 sky130_ef_sc_hd__decap_40_12$1
XFILLER_46_645 vssd1 vccd1 vccd1 vssd1 sky130_ef_sc_hd__decap_40_12$1
XFILLER_61_615 vccd1 vssd1 vccd1 vssd1 sky130_fd_sc_hd__fill_1$1
XFILLER_33_317 vssd1 vccd1 vccd1 vssd1 sky130_ef_sc_hd__decap_40_12$1
XTAP_TAPCELL_ROW_47_1007 vccd1 vssd1 sky130_fd_sc_hd__tapvpwrvgnd_1$1
XFILLER_73_497 vssd1 vccd1 vccd1 vssd1 sky130_fd_sc_hd__fill_4$1
XFILLER_14_531 vccd1 vssd1 vccd1 vssd1 sky130_fd_sc_hd__fill_1$1
XTAP_TAPCELL_ROW_16_537 vccd1 vssd1 sky130_fd_sc_hd__tapvpwrvgnd_1$1
XFILLER_121_81 vssd1 vccd1 vccd1 vssd1 sky130_ef_sc_hd__decap_40_12$1
XTAP_TAPCELL_ROW_60_1207 vccd1 vssd1 sky130_fd_sc_hd__tapvpwrvgnd_1$1
XFILLER_41_361 vssd1 vccd1 vccd1 vssd1 sky130_ef_sc_hd__decap_40_12$1
X_0780_ _1791_/A _0879_/A2 _0780_/X input7/X _0784_/B1 vccd1 vssd1 vccd1 vssd1 sky130_fd_sc_hd__a22o_1$1
XPHY_EDGE_ROW_116_Right_116 vccd1 vssd1 vccd1 vssd1 sky130_fd_sc_hd__decap_3$1
XFILLER_5_273 vssd1 vccd1 vccd1 vssd1 sky130_fd_sc_hd__fill_4$1
X_1401_ _1471_/C1 _1400_/X _1409_/A2 hold146/X _1728_/D vssd1 vccd1 vccd1 vssd1 sky130_fd_sc_hd__o211a_1$1
XTAP_TAPCELL_ROW_58_1169 vccd1 vssd1 sky130_fd_sc_hd__tapvpwrvgnd_1$1
XFILLER_123_661 vssd1 vccd1 vccd1 vssd1 sky130_fd_sc_hd__fill_8$1
XFILLER_69_737 vccd1 vssd1 vccd1 vssd1 sky130_fd_sc_hd__fill_1$1
XFILLER_122_193 vssd1 vccd1 vccd1 vssd1 sky130_fd_sc_hd__fill_2$1
XFILLER_110_333 vssd1 vccd1 vccd1 vssd1 sky130_ef_sc_hd__decap_40_12$1
X_1332_ _1332_/A _1332_/X _1342_/B vssd1 vccd1 vccd1 vssd1 sky130_fd_sc_hd__or2_1$1
XTAP_TAPCELL_ROW_71_1369 vccd1 vssd1 sky130_fd_sc_hd__tapvpwrvgnd_1$1
XTAP_TAPCELL_ROW_71_1358 vccd1 vssd1 sky130_fd_sc_hd__tapvpwrvgnd_1$1
X_1263_ _1437_/C1 _1262_/X _1277_/A2 hold86/X _1661_/D vssd1 vccd1 vccd1 vssd1 sky130_fd_sc_hd__o211a_1$1
XFILLER_96_589 vssd1 vccd1 vccd1 vssd1 sky130_fd_sc_hd__fill_8$1
XFILLER_110_388 vssd1 vccd1 vccd1 vssd1 sky130_ef_sc_hd__decap_40_12$1
XFILLER_110_377 vssd1 vccd1 vccd1 vssd1 sky130_fd_sc_hd__fill_2$1
XFILLER_83_217 vssd1 vccd1 vccd1 vssd1 sky130_fd_sc_hd__fill_4$1
XFILLER_77_781 vssd1 vccd1 vccd1 vssd1 sky130_fd_sc_hd__fill_2$1
Xinput5 input5/X adc_data[2] vssd1 vccd1 vccd1 vssd1 sky130_fd_sc_hd__clkbuf_4$1
X_1194_ hold33/X _1194_/X _1210_/B vssd1 vccd1 vccd1 vssd1 sky130_fd_sc_hd__or2_1$1
XFILLER_36_133 vssd1 vccd1 vccd1 vssd1 sky130_fd_sc_hd__fill_4$1
XFILLER_91_261 vssd1 vccd1 vccd1 vssd1 sky130_ef_sc_hd__decap_40_12$1
XFILLER_36_177 vssd1 vccd1 vccd1 vssd1 sky130_ef_sc_hd__decap_40_12$1
XTAP_TAPCELL_ROW_86_1590 vccd1 vssd1 sky130_fd_sc_hd__tapvpwrvgnd_1$1
XFILLER_51_125 vssd1 vccd1 vccd1 vssd1 sky130_ef_sc_hd__decap_40_12$1
XFILLER_17_391 vccd1 vssd1 vccd1 vssd1 sky130_fd_sc_hd__fill_1$1
XTAP_TAPCELL_ROW_35_824 vccd1 vssd1 sky130_fd_sc_hd__tapvpwrvgnd_1$1
XFILLER_51_169 vssd1 vccd1 vccd1 vssd1 sky130_ef_sc_hd__decap_40_12$1
XFILLER_20_501 vssd1 vccd1 vccd1 vssd1 sky130_ef_sc_hd__decap_40_12$1
XFILLER_32_361 vssd1 vccd1 vccd1 vssd1 sky130_fd_sc_hd__fill_2$1
XFILLER_20_545 vssd1 vccd1 vccd1 vssd1 sky130_ef_sc_hd__decap_40_12$1
X_0978_ _0978_/A _0978_/X _1012_/B vssd1 vccd1 vccd1 vssd1 sky130_fd_sc_hd__or2_1$1
XFILLER_20_589 vssd1 vccd1 vccd1 vssd1 sky130_ef_sc_hd__decap_40_12$1
XFILLER_118_488 vssd1 vccd1 vccd1 vssd1 sky130_ef_sc_hd__decap_40_12$1
XFILLER_105_105 vssd1 vccd1 vccd1 vssd1 sky130_fd_sc_hd__fill_4$1
XFILLER_10_15 vssd1 vccd1 vccd1 vssd1 sky130_ef_sc_hd__decap_40_12$1
XFILLER_126_15 vssd1 vccd1 vccd1 vssd1 sky130_ef_sc_hd__decap_40_12$1
XFILLER_105_149 vssd1 vccd1 vccd1 vssd1 sky130_ef_sc_hd__decap_40_12$1
XFILLER_99_361 vssd1 vccd1 vccd1 vssd1 sky130_ef_sc_hd__decap_40_12$1
XFILLER_87_501 vssd1 vccd1 vccd1 vssd1 sky130_fd_sc_hd__fill_2$1
XFILLER_59_225 vssd1 vccd1 vccd1 vssd1 sky130_ef_sc_hd__decap_40_12$1
XFILLER_113_193 vssd1 vccd1 vccd1 vssd1 sky130_ef_sc_hd__decap_40_12$1
XFILLER_101_333 vssd1 vccd1 vccd1 vssd1 sky130_fd_sc_hd__fill_2$1
XFILLER_75_729 vssd1 vccd1 vccd1 vssd1 sky130_fd_sc_hd__fill_8$1
XFILLER_75_707 vssd1 vccd1 vccd1 vssd1 sky130_ef_sc_hd__decap_40_12$1
XFILLER_68_781 vssd1 vccd1 vccd1 vssd1 sky130_ef_sc_hd__decap_40_12$1
XFILLER_19_57 vssd1 vccd1 vccd1 vssd1 sky130_ef_sc_hd__decap_40_12$1
XFILLER_28_601 vssd1 vccd1 vccd1 vssd1 sky130_ef_sc_hd__decap_40_12$1
XFILLER_27_111 vccd1 vssd1 vccd1 vssd1 sky130_fd_sc_hd__fill_1$1
XFILLER_28_645 vssd1 vccd1 vccd1 vssd1 sky130_ef_sc_hd__decap_40_12$1
XFILLER_70_401 vssd1 vccd1 vccd1 vssd1 sky130_fd_sc_hd__fill_8$1
XFILLER_15_317 vssd1 vccd1 vccd1 vssd1 sky130_ef_sc_hd__decap_40_12$1
XFILLER_43_615 vccd1 vssd1 vccd1 vssd1 sky130_fd_sc_hd__fill_1$1
XFILLER_70_445 vssd1 vccd1 vccd1 vssd1 sky130_ef_sc_hd__decap_40_12$1
XFILLER_55_497 vssd1 vccd1 vccd1 vssd1 sky130_fd_sc_hd__fill_4$1
XFILLER_30_309 vssd1 vccd1 vccd1 vssd1 sky130_ef_sc_hd__decap_40_12$1
XFILLER_129_709 vssd1 vccd1 vccd1 vssd1 sky130_ef_sc_hd__decap_40_12$1
XFILLER_11_501 vssd1 vccd1 vccd1 vssd1 sky130_fd_sc_hd__fill_2$1
XFILLER_23_361 vssd1 vccd1 vccd1 vssd1 sky130_ef_sc_hd__decap_40_12$1
XFILLER_136_3 vssd1 vccd1 vccd1 vssd1 sky130_ef_sc_hd__decap_40_12$1
XFILLER_7_505 vssd1 vccd1 vccd1 vssd1 sky130_ef_sc_hd__decap_40_12$1
XFILLER_51_55 vccd1 vssd1 vccd1 vssd1 sky130_fd_sc_hd__fill_1$1
XFILLER_136_285 vssd1 vccd1 vccd1 vssd1 sky130_fd_sc_hd__fill_2$1
XFILLER_109_499 vssd1 vccd1 vccd1 vssd1 sky130_fd_sc_hd__fill_4$1
XFILLER_2_221 vssd1 vccd1 vccd1 vssd1 sky130_ef_sc_hd__decap_40_12$1
XFILLER_3_777 vssd1 vccd1 vccd1 vssd1 sky130_fd_sc_hd__fill_4$1
XFILLER_2_265 vssd1 vccd1 vccd1 vssd1 sky130_ef_sc_hd__decap_40_12$1
XTAP_TAPCELL_ROW_111_1959 vccd1 vssd1 sky130_fd_sc_hd__tapvpwrvgnd_1$1
XFILLER_78_545 vssd1 vccd1 vccd1 vssd1 sky130_ef_sc_hd__decap_40_12$1
XFILLER_116_81 vssd1 vccd1 vccd1 vssd1 sky130_fd_sc_hd__fill_2$1
XFILLER_104_193 vssd1 vccd1 vccd1 vssd1 sky130_fd_sc_hd__fill_2$1
XFILLER_76_41 vssd1 vccd1 vccd1 vssd1 sky130_ef_sc_hd__decap_40_12$1
XFILLER_66_718 vssd1 vccd1 vccd1 vssd1 sky130_ef_sc_hd__decap_40_12$1
XTAP_TAPCELL_ROW_53_1088 vccd1 vssd1 sky130_fd_sc_hd__tapvpwrvgnd_1$1
XFILLER_76_85 vssd1 vccd1 vccd1 vssd1 sky130_ef_sc_hd__decap_40_12$1
XFILLER_65_217 vssd1 vccd1 vccd1 vssd1 sky130_fd_sc_hd__fill_4$1
XFILLER_59_781 vssd1 vccd1 vccd1 vssd1 sky130_fd_sc_hd__fill_2$1
XTAP_TAPCELL_ROW_53_1099 vccd1 vssd1 sky130_fd_sc_hd__tapvpwrvgnd_1$1
XFILLER_93_559 vccd1 vssd1 vccd1 vssd1 sky130_fd_sc_hd__fill_1$1
XFILLER_18_133 vssd1 vccd1 vccd1 vssd1 sky130_fd_sc_hd__fill_4$1
XFILLER_80_209 vssd1 vccd1 vccd1 vssd1 sky130_ef_sc_hd__decap_40_12$1
XFILLER_73_261 vssd1 vccd1 vccd1 vssd1 sky130_ef_sc_hd__decap_40_12$1
XFILLER_18_177 vssd1 vccd1 vccd1 vssd1 sky130_ef_sc_hd__decap_40_12$1
XFILLER_46_475 vccd1 vssd1 vccd1 vssd1 sky130_fd_sc_hd__fill_1$1
XFILLER_33_125 vssd1 vccd1 vccd1 vssd1 sky130_ef_sc_hd__decap_40_12$1
XFILLER_33_169 vssd1 vccd1 vccd1 vssd1 sky130_ef_sc_hd__decap_40_12$1
XFILLER_14_361 vssd1 vccd1 vccd1 vssd1 sky130_fd_sc_hd__fill_2$1
X_0901_ _0901_/X _1015_/A _1597_/Q _1565_/Q hold10/A vssd1 vccd1 _0899_/X vccd1 vssd1
+ sky130_fd_sc_hd__a221o_1$1
X_0832_ _1804_/A _0879_/A2 _0832_/X _1650_/Q _0906_/B1 vccd1 vssd1 vccd1 vssd1 sky130_fd_sc_hd__a22o_1$1
XFILLER_128_753 vssd1 vccd1 vccd1 vssd1 sky130_fd_sc_hd__fill_2$1
XTAP_TAPCELL_ROW_40_893 vccd1 vssd1 sky130_fd_sc_hd__tapvpwrvgnd_1$1
X_0763_ _1793_/A _0878_/A2 _0763_/X _1773_/A _0866_/B1 vccd1 vssd1 vccd1 vssd1 sky130_fd_sc_hd__a22o_1$1
XFILLER_51_3 vssd1 vccd1 vccd1 vssd1 sky130_ef_sc_hd__decap_40_12$1
XFILLER_130_417 vssd1 vccd1 vccd1 vssd1 sky130_fd_sc_hd__fill_2$1
XFILLER_103_609 vssd1 vccd1 vccd1 vssd1 sky130_fd_sc_hd__fill_4$1
XFILLER_88_309 vssd1 vccd1 vccd1 vssd1 sky130_ef_sc_hd__decap_40_12$1
XFILLER_97_821 vssd1 vccd1 vccd1 vssd1 sky130_fd_sc_hd__fill_2$1
XFILLER_111_653 vssd1 vccd1 vccd1 vssd1 sky130_ef_sc_hd__decap_40_12$1
XFILLER_110_141 vssd1 vccd1 vccd1 vssd1 sky130_ef_sc_hd__decap_40_12$1
X_1315_ _1387_/C1 _1314_/X _1331_/A2 hold46/X _1686_/D vssd1 vccd1 vccd1 vssd1 sky130_fd_sc_hd__o211a_1$1
XFILLER_96_397 vssd1 vccd1 vccd1 vssd1 sky130_ef_sc_hd__decap_40_12$1
XFILLER_57_729 vssd1 vccd1 vccd1 vssd1 sky130_ef_sc_hd__decap_40_12$1
X_1246_ _1653_/Q _1246_/X _1276_/B vssd1 vccd1 vccd1 vssd1 sky130_fd_sc_hd__or2_1$1
XFILLER_84_548 vssd1 vccd1 vccd1 vssd1 sky130_ef_sc_hd__decap_40_12$1
X_1177_ _1441_/C1 _1176_/X _1211_/A2 hold172/X _1619_/D vssd1 vccd1 vccd1 vssd1 sky130_fd_sc_hd__o211a_1$1
XFILLER_52_401 vssd1 vccd1 vccd1 vssd1 sky130_ef_sc_hd__decap_40_12$1
XFILLER_25_615 vccd1 vssd1 vccd1 vssd1 sky130_fd_sc_hd__fill_1$1
XFILLER_92_581 vccd1 vssd1 vccd1 vssd1 sky130_fd_sc_hd__fill_1$1
XFILLER_37_497 vssd1 vccd1 vccd1 vssd1 sky130_fd_sc_hd__fill_4$1
XFILLER_12_309 vssd1 vccd1 vccd1 vssd1 sky130_ef_sc_hd__decap_40_12$1
XFILLER_21_821 vssd1 vccd1 vccd1 vssd1 sky130_fd_sc_hd__fill_2$1
XANTENNA_10 hold73/A vssd1 vccd1 vccd1 vssd1 sky130_fd_sc_hd__diode_2$1
XANTENNA_21 _1078_/B vssd1 vccd1 vccd1 vssd1 sky130_fd_sc_hd__diode_2$1
XFILLER_119_753 vssd1 vccd1 vccd1 vssd1 sky130_fd_sc_hd__fill_4$1
XTAP_TAPCELL_ROW_115_2026 vccd1 vssd1 sky130_fd_sc_hd__tapvpwrvgnd_1$1
XTAP_TAPCELL_ROW_99_1781 vccd1 vssd1 sky130_fd_sc_hd__tapvpwrvgnd_1$1
XFILLER_137_47 vssd1 vccd1 vccd1 vssd1 sky130_fd_sc_hd__fill_8$1
XFILLER_119_797 vssd1 vccd1 vccd1 vssd1 sky130_ef_sc_hd__decap_40_12$1
XTAP_TAPCELL_ROW_99_1792 vccd1 vssd1 sky130_fd_sc_hd__tapvpwrvgnd_1$1
XFILLER_21_69 vssd1 vccd1 vccd1 vssd1 sky130_ef_sc_hd__decap_40_12$1
XFILLER_133_277 vssd1 vccd1 vccd1 vssd1 sky130_fd_sc_hd__fill_2$1
Xoutput161 _1663_/Q analog_ctrl[90] vssd1 vccd1 vccd1 vssd1 sky130_fd_sc_hd__buf_12$1
Xoutput150 _1653_/Q analog_ctrl[80] vssd1 vccd1 vccd1 vssd1 sky130_fd_sc_hd__buf_12$1
Xoutput194 _1507_/Q wbs_dat_o[30] vssd1 vccd1 vccd1 vssd1 sky130_fd_sc_hd__buf_12$1
Xoutput172 _1487_/Q wbs_dat_o[10] vssd1 vccd1 vccd1 vssd1 sky130_fd_sc_hd__buf_12$1
Xoutput183 _1497_/Q wbs_dat_o[20] vssd1 vccd1 vccd1 vssd1 sky130_fd_sc_hd__buf_12$1
XFILLER_121_439 vccd1 vssd1 vccd1 vssd1 sky130_fd_sc_hd__fill_1$1
XFILLER_0_725 vssd1 vccd1 vccd1 vssd1 sky130_fd_sc_hd__fill_2$1
XFILLER_102_697 vssd1 vccd1 vccd1 vssd1 sky130_fd_sc_hd__fill_2$1
XFILLER_47_217 vssd1 vccd1 vccd1 vssd1 sky130_fd_sc_hd__fill_4$1
XFILLER_75_559 vccd1 vssd1 vccd1 vssd1 sky130_fd_sc_hd__fill_1$1
XTAP_TAPCELL_ROW_126_2188 vccd1 vssd1 sky130_fd_sc_hd__tapvpwrvgnd_1$1
XFILLER_62_209 vssd1 vccd1 vccd1 vssd1 sky130_ef_sc_hd__decap_40_12$1
XFILLER_55_261 vssd1 vccd1 vccd1 vssd1 sky130_ef_sc_hd__decap_40_12$1
XFILLER_28_475 vccd1 vssd1 vccd1 vssd1 sky130_fd_sc_hd__fill_1$1
XFILLER_46_77 vssd1 vccd1 vccd1 vssd1 sky130_fd_sc_hd__fill_4$1
XFILLER_15_125 vssd1 vccd1 vccd1 vssd1 sky130_ef_sc_hd__decap_40_12$1
XFILLER_16_637 vssd1 vccd1 vccd1 vssd1 sky130_fd_sc_hd__fill_4$1
XFILLER_71_765 vssd1 vccd1 vccd1 vssd1 sky130_fd_sc_hd__fill_8$1
XFILLER_70_253 vssd1 vccd1 vccd1 vssd1 sky130_ef_sc_hd__decap_40_12$1
XFILLER_15_169 vssd1 vccd1 vccd1 vssd1 sky130_ef_sc_hd__decap_40_12$1
XFILLER_43_445 vssd1 vccd1 vccd1 vssd1 sky130_fd_sc_hd__fill_2$1
XFILLER_102_83 vccd1 vssd1 vccd1 vssd1 sky130_fd_sc_hd__fill_1$1
XFILLER_12_821 vssd1 vccd1 vccd1 vssd1 sky130_fd_sc_hd__fill_2$1
XFILLER_24_681 vssd1 vccd1 vccd1 vssd1 sky130_ef_sc_hd__decap_40_12$1
XTAP_TAPCELL_ROW_26_687 vccd1 vssd1 sky130_fd_sc_hd__tapvpwrvgnd_1$1
XFILLER_31_629 vssd1 vccd1 vccd1 vssd1 sky130_ef_sc_hd__decap_40_12$1
XFILLER_62_65 vssd1 vccd1 vccd1 vssd1 sky130_ef_sc_hd__decap_40_12$1
XFILLER_30_139 vccd1 vssd1 vccd1 vssd1 sky130_fd_sc_hd__fill_1$1
XFILLER_8_825 vccd1 vssd1 vccd1 vssd1 sky130_fd_sc_hd__fill_1$1
XFILLER_7_27 vssd1 vccd1 vccd1 vssd1 sky130_ef_sc_hd__decap_40_12$1
XFILLER_7_335 vccd1 vssd1 vccd1 vssd1 sky130_fd_sc_hd__fill_1$1
XFILLER_137_561 vssd1 vccd1 vccd1 vssd1 sky130_ef_sc_hd__decap_40_12$1
XFILLER_125_723 vssd1 vccd1 vccd1 vssd1 sky130_fd_sc_hd__fill_4$1
XFILLER_124_233 vssd1 vccd1 vccd1 vssd1 sky130_ef_sc_hd__decap_40_12$1
XFILLER_125_789 vssd1 vccd1 vccd1 vssd1 sky130_fd_sc_hd__fill_2$1
XTAP_TAPCELL_ROW_55_1128 vccd1 vssd1 sky130_fd_sc_hd__tapvpwrvgnd_1$1
XFILLER_3_541 vssd1 vccd1 vccd1 vssd1 sky130_ef_sc_hd__decap_40_12$1
XFILLER_124_277 vssd1 vccd1 vccd1 vssd1 sky130_ef_sc_hd__decap_40_12$1
XFILLER_87_51 vssd1 vccd1 vccd1 vssd1 sky130_fd_sc_hd__fill_4$1
XFILLER_3_585 vssd1 vccd1 vccd1 vssd1 sky130_ef_sc_hd__decap_40_12$1
XFILLER_94_813 vssd1 vccd1 vccd1 vssd1 sky130_fd_sc_hd__fill_8$1
XFILLER_66_504 vssd1 vccd1 vccd1 vssd1 sky130_ef_sc_hd__decap_40_12$1
XFILLER_39_729 vssd1 vccd1 vccd1 vssd1 sky130_ef_sc_hd__decap_40_12$1
X_1100_ _1800_/A _1100_/X _1122_/B vssd1 vccd1 vccd1 vssd1 sky130_fd_sc_hd__or2_1$1
XTAP_TAPCELL_ROW_6_390 vccd1 vssd1 sky130_fd_sc_hd__tapvpwrvgnd_1$1
XFILLER_93_389 vssd1 vccd1 vccd1 vssd1 sky130_fd_sc_hd__fill_2$1
XFILLER_81_529 vssd1 vccd1 vccd1 vssd1 sky130_ef_sc_hd__decap_40_12$1
X_1031_ _1431_/C1 _1030_/X _1053_/A2 hold199/X _1548_/D vssd1 vccd1 vccd1 vssd1 sky130_fd_sc_hd__o211a_1$1
XFILLER_34_401 vssd1 vccd1 vccd1 vssd1 sky130_ef_sc_hd__decap_40_12$1
XFILLER_19_497 vssd1 vccd1 vccd1 vssd1 sky130_fd_sc_hd__fill_4$1
XFILLER_34_445 vssd1 vccd1 vccd1 vssd1 sky130_ef_sc_hd__decap_40_12$1
XFILLER_99_3 vssd1 vccd1 vccd1 vssd1 sky130_ef_sc_hd__decap_40_12$1
XFILLER_34_489 vssd1 vccd1 vccd1 vssd1 sky130_ef_sc_hd__decap_40_12$1
XTAP_TAPCELL_ROW_45_974 vccd1 vssd1 sky130_fd_sc_hd__tapvpwrvgnd_1$1
Xinput30 vccd1 vssd1 input30/X input30/A vccd1 vssd1 sky130_fd_sc_hd__buf_2$1
Xinput52 wbs_stb_i _0947_/B vssd1 vccd1 vccd1 vssd1 sky130_fd_sc_hd__clkbuf_2$1
Xinput41 vccd1 vssd1 input41/X input41/A vccd1 vssd1 sky130_fd_sc_hd__buf_2$1
XFILLER_116_701 vssd1 vccd1 vccd1 vssd1 sky130_fd_sc_hd__fill_2$1
X_0815_ _0815_/X _0866_/B1 _1834_/A _1551_/Q _1344_/A vssd1 vccd1 _0814_/X vccd1 vssd1
+ sky130_fd_sc_hd__a221o_1$1
X_1795_ vccd1 vssd1 _1795_/X _1795_/A vccd1 vssd1 sky130_fd_sc_hd__buf_1$1
X_0746_ input1/X _0784_/B1 _0758_/B _1824_/A _0878_/B1 vccd1 vssd1 vccd1 vssd1 sky130_fd_sc_hd__a22o_1$1
XFILLER_116_789 vssd1 vccd1 vccd1 vssd1 sky130_fd_sc_hd__fill_2$1
XFILLER_107_39 vssd1 vccd1 vccd1 vssd1 sky130_ef_sc_hd__decap_40_12$1
XFILLER_131_737 vccd1 vssd1 vccd1 vssd1 sky130_fd_sc_hd__fill_1$1
XFILLER_115_277 vssd1 vccd1 vccd1 vssd1 sky130_fd_sc_hd__fill_2$1
XFILLER_88_139 vccd1 vssd1 vccd1 vssd1 sky130_fd_sc_hd__fill_1$1
XFILLER_111_461 vssd1 vccd1 vccd1 vssd1 sky130_fd_sc_hd__fill_2$1
XFILLER_97_673 vssd1 vccd1 vccd1 vssd1 sky130_fd_sc_hd__fill_8$1
XFILLER_84_301 vssd1 vccd1 vccd1 vssd1 sky130_fd_sc_hd__fill_4$1
XFILLER_29_217 vssd1 vccd1 vccd1 vssd1 sky130_fd_sc_hd__fill_4$1
XFILLER_123_27 vssd1 vccd1 vccd1 vssd1 sky130_ef_sc_hd__decap_40_12$1
XFILLER_84_345 vssd1 vccd1 vccd1 vssd1 sky130_ef_sc_hd__decap_40_12$1
XFILLER_57_559 vccd1 vssd1 vccd1 vssd1 sky130_fd_sc_hd__fill_1$1
XFILLER_84_389 vssd1 vccd1 vccd1 vssd1 sky130_fd_sc_hd__fill_8$1
X_1229_ _1431_/C1 _1228_/X _1273_/A2 hold199/X _1644_/D vssd1 vccd1 vccd1 vssd1 sky130_fd_sc_hd__o211a_1$1
XFILLER_44_209 vssd1 vccd1 vccd1 vssd1 sky130_ef_sc_hd__decap_40_12$1
XFILLER_65_592 vssd1 vccd1 vccd1 vssd1 sky130_ef_sc_hd__decap_40_12$1
XFILLER_37_261 vssd1 vccd1 vccd1 vssd1 sky130_ef_sc_hd__decap_40_12$1
XFILLER_53_765 vssd1 vccd1 vccd1 vssd1 sky130_ef_sc_hd__decap_40_12$1
XFILLER_52_253 vssd1 vccd1 vccd1 vssd1 sky130_ef_sc_hd__decap_40_12$1
XFILLER_25_445 vssd1 vccd1 vccd1 vssd1 sky130_fd_sc_hd__fill_2$1
XFILLER_13_629 vssd1 vccd1 vccd1 vssd1 sky130_ef_sc_hd__decap_40_12$1
XFILLER_12_139 vccd1 vssd1 vccd1 vssd1 sky130_fd_sc_hd__fill_1$1
XTAP_TAPCELL_ROW_23_646 vccd1 vssd1 sky130_fd_sc_hd__tapvpwrvgnd_1$1
XFILLER_21_673 vssd1 vccd1 vccd1 vssd1 sky130_ef_sc_hd__decap_40_12$1
XFILLER_119_561 vssd1 vccd1 vccd1 vssd1 sky130_ef_sc_hd__decap_40_12$1
XFILLER_5_839 vccd1 vssd1 vccd1 vssd1 sky130_fd_sc_hd__fill_1$1
XFILLER_4_305 vssd1 vccd1 vccd1 vssd1 sky130_fd_sc_hd__fill_2$1
XFILLER_134_531 vccd1 vssd1 vccd1 vssd1 sky130_fd_sc_hd__fill_1$1
XFILLER_106_233 vssd1 vccd1 vccd1 vssd1 sky130_ef_sc_hd__decap_40_12$1
XFILLER_134_564 vssd1 vccd1 vccd1 vssd1 sky130_ef_sc_hd__decap_40_12$1
XFILLER_122_737 vssd1 vccd1 vccd1 vssd1 sky130_ef_sc_hd__decap_40_12$1
XFILLER_121_225 vssd1 vccd1 vccd1 vssd1 sky130_ef_sc_hd__decap_40_12$1
XFILLER_106_277 vssd1 vccd1 vccd1 vssd1 sky130_ef_sc_hd__decap_40_12$1
XTAP_TAPCELL_ROW_128_2217 vccd1 vssd1 sky130_fd_sc_hd__tapvpwrvgnd_1$1
XFILLER_0_533 vssd1 vccd1 vccd1 vssd1 sky130_ef_sc_hd__decap_40_12$1
XFILLER_130_781 vssd1 vccd1 vccd1 vssd1 sky130_fd_sc_hd__fill_8$1
XFILLER_94_109 vssd1 vccd1 vccd1 vssd1 sky130_ef_sc_hd__decap_40_12$1
XFILLER_87_161 vssd1 vccd1 vccd1 vssd1 sky130_fd_sc_hd__fill_4$1
XFILLER_48_515 vccd1 vssd1 vccd1 vssd1 sky130_fd_sc_hd__fill_1$1
XTAP_TAPCELL_ROW_50_1047 vccd1 vssd1 sky130_fd_sc_hd__tapvpwrvgnd_1$1
XFILLER_91_805 vssd1 vccd1 vccd1 vssd1 sky130_fd_sc_hd__fill_8$1
XFILLER_63_529 vssd1 vccd1 vccd1 vssd1 sky130_fd_sc_hd__fill_4$1
XFILLER_75_389 vssd1 vccd1 vccd1 vssd1 sky130_fd_sc_hd__fill_2$1
XFILLER_16_401 vssd1 vccd1 vccd1 vssd1 sky130_ef_sc_hd__decap_40_12$1
XFILLER_113_93 vssd1 vccd1 vccd1 vssd1 sky130_ef_sc_hd__decap_40_12$1
XFILLER_16_445 vssd1 vccd1 vccd1 vssd1 sky130_ef_sc_hd__decap_40_12$1
XFILLER_44_754 vssd1 vccd1 vccd1 vssd1 sky130_fd_sc_hd__fill_2$1
XFILLER_16_489 vssd1 vccd1 vccd1 vssd1 sky130_ef_sc_hd__decap_40_12$1
XTAP_TAPCELL_ROW_42_933 vccd1 vssd1 sky130_fd_sc_hd__tapvpwrvgnd_1$1
XFILLER_129_325 vssd1 vccd1 vccd1 vssd1 sky130_fd_sc_hd__fill_8$1
XFILLER_117_509 vccd1 vssd1 vccd1 vssd1 sky130_fd_sc_hd__fill_1$1
XFILLER_11_161 vssd1 vccd1 vccd1 vssd1 sky130_fd_sc_hd__fill_4$1
XFILLER_129_369 vssd1 vccd1 vccd1 vssd1 sky130_fd_sc_hd__fill_2$1
XFILLER_7_165 vssd1 vccd1 vccd1 vssd1 sky130_fd_sc_hd__fill_2$1
XFILLER_137_391 vccd1 vssd1 vccd1 vssd1 sky130_fd_sc_hd__fill_1$1
XFILLER_8_699 vccd1 vssd1 vccd1 vssd1 sky130_fd_sc_hd__fill_1$1
X_1580_ _1798_/A _1580_/CLK _1580_/D vccd1 vssd1 vccd1 vssd1 sky130_fd_sc_hd__dfxtp_1$1
XFILLER_125_553 vssd1 vccd1 vccd1 vssd1 sky130_fd_sc_hd__fill_4$1
XFILLER_125_597 vccd1 vssd1 vccd1 vssd1 sky130_fd_sc_hd__fill_1$1
XFILLER_98_83 vccd1 vssd1 vccd1 vssd1 sky130_fd_sc_hd__fill_1$1
XFILLER_3_393 vssd1 vccd1 vccd1 vssd1 sky130_ef_sc_hd__decap_40_12$1
XFILLER_121_781 vssd1 vccd1 vccd1 vssd1 sky130_fd_sc_hd__fill_2$1
XFILLER_85_109 vssd1 vccd1 vccd1 vssd1 sky130_fd_sc_hd__fill_2$1
XFILLER_79_673 vssd1 vccd1 vccd1 vssd1 sky130_ef_sc_hd__decap_40_12$1
XFILLER_66_301 vssd1 vccd1 vccd1 vssd1 sky130_fd_sc_hd__fill_4$1
XFILLER_66_345 vssd1 vccd1 vccd1 vssd1 sky130_ef_sc_hd__decap_40_12$1
XFILLER_14_3 vssd1 vccd1 vccd1 vssd1 sky130_ef_sc_hd__decap_40_12$1
XFILLER_39_559 vccd1 vssd1 vccd1 vssd1 sky130_fd_sc_hd__fill_1$1
XTAP_TAPCELL_ROW_68_1319 vccd1 vssd1 sky130_fd_sc_hd__tapvpwrvgnd_1$1
XTAP_TAPCELL_ROW_1_308 vccd1 vssd1 sky130_fd_sc_hd__tapvpwrvgnd_1$1
XTAP_TAPCELL_ROW_1_319 vccd1 vssd1 sky130_fd_sc_hd__tapvpwrvgnd_1$1
XFILLER_26_209 vssd1 vccd1 vccd1 vssd1 sky130_ef_sc_hd__decap_40_12$1
XFILLER_81_337 vssd1 vccd1 vccd1 vssd1 sky130_ef_sc_hd__decap_40_12$1
XFILLER_54_529 vssd1 vccd1 vccd1 vssd1 sky130_fd_sc_hd__fill_2$1
XFILLER_19_261 vssd1 vccd1 vccd1 vssd1 sky130_ef_sc_hd__decap_40_12$1
X_1014_ _1015_/A _1066_/B _1411_/B vccd1 vssd1 vccd1 vssd1 sky130_fd_sc_hd__and2_2$1
XTAP_TAPCELL_ROW_81_1508 vccd1 vssd1 sky130_fd_sc_hd__tapvpwrvgnd_1$1
XFILLER_35_743 vccd1 vssd1 vccd1 vssd1 sky130_fd_sc_hd__fill_1$1
XTAP_TAPCELL_ROW_81_1519 vccd1 vssd1 sky130_fd_sc_hd__tapvpwrvgnd_1$1
XFILLER_50_713 vssd1 vccd1 vccd1 vssd1 sky130_ef_sc_hd__decap_40_12$1
XFILLER_34_253 vssd1 vccd1 vccd1 vssd1 sky130_ef_sc_hd__decap_40_12$1
XFILLER_50_746 vssd1 vccd1 vccd1 vssd1 sky130_fd_sc_hd__fill_8$1
XFILLER_50_757 vssd1 vccd1 vccd1 vssd1 sky130_fd_sc_hd__fill_2$1
XTAP_TAPCELL_ROW_20_605 vccd1 vssd1 sky130_fd_sc_hd__tapvpwrvgnd_1$1
X_1847_ _1847_/A _1847_/X vssd1 vccd1 vccd1 vssd1 sky130_fd_sc_hd__clkbuf_2$1
XFILLER_8_81 vssd1 vccd1 vccd1 vssd1 sky130_fd_sc_hd__fill_2$1
XFILLER_118_27 vccd1 vssd1 vccd1 vssd1 sky130_fd_sc_hd__fill_1$1
XFILLER_116_531 vccd1 vssd1 vccd1 vssd1 sky130_fd_sc_hd__fill_1$1
Xclkbuf_leaf_25_wb_clk_i _1747_/CLK clkbuf_2_3__f_wb_clk_i/X vssd1 vccd1 vccd1 vssd1
+ sky130_fd_sc_hd__clkbuf_8$1
XTAP_TAPCELL_ROW_96_1740 vccd1 vssd1 sky130_fd_sc_hd__tapvpwrvgnd_1$1
XFILLER_2_809 vssd1 vccd1 vccd1 vssd1 sky130_fd_sc_hd__fill_2$1
X_1778_ _1778_/A _1778_/X vssd1 vccd1 vccd1 vssd1 sky130_fd_sc_hd__clkbuf_2$1
XFILLER_103_225 vssd1 vccd1 vccd1 vssd1 sky130_ef_sc_hd__decap_40_12$1
XFILLER_134_15 vssd1 vccd1 vccd1 vssd1 sky130_ef_sc_hd__decap_40_12$1
XFILLER_76_109 vssd1 vccd1 vccd1 vssd1 sky130_ef_sc_hd__decap_40_12$1
XFILLER_69_161 vssd1 vccd1 vccd1 vssd1 sky130_fd_sc_hd__fill_4$1
XFILLER_58_813 vssd1 vccd1 vccd1 vssd1 sky130_ef_sc_hd__decap_40_12$1
XFILLER_84_153 vssd1 vccd1 vccd1 vssd1 sky130_ef_sc_hd__decap_40_12$1
XTAP_TAPCELL_ROW_123_2147 vccd1 vssd1 sky130_fd_sc_hd__tapvpwrvgnd_1$1
XFILLER_84_197 vssd1 vccd1 vccd1 vssd1 sky130_ef_sc_hd__decap_40_12$1
XFILLER_27_57 vssd1 vccd1 vccd1 vssd1 sky130_ef_sc_hd__decap_40_12$1
XTAP_TAPCELL_ROW_28_716 vccd1 vssd1 sky130_fd_sc_hd__tapvpwrvgnd_1$1
XTAP_TAPCELL_ROW_28_727 vccd1 vssd1 sky130_fd_sc_hd__tapvpwrvgnd_1$1
XFILLER_45_529 vssd1 vccd1 vccd1 vssd1 sky130_ef_sc_hd__decap_40_12$1
Xclkbuf_2_3__f_wb_clk_i clkbuf_2_3__f_wb_clk_i/X clkbuf_0_wb_clk_i/X vssd1 vccd1 vccd1
+ vssd1 sky130_fd_sc_hd__clkbuf_16$1
XFILLER_53_573 vssd1 vccd1 vccd1 vssd1 sky130_fd_sc_hd__fill_4$1
XFILLER_41_713 vccd1 vssd1 vccd1 vssd1 sky130_fd_sc_hd__fill_1$1
XTAP_TAPCELL_ROW_105_1880 vccd1 vssd1 sky130_fd_sc_hd__tapvpwrvgnd_1$1
XFILLER_41_768 vccd1 vssd1 vccd1 vssd1 sky130_fd_sc_hd__fill_1$1
XFILLER_40_245 vssd1 vccd1 vccd1 vssd1 sky130_fd_sc_hd__fill_4$1
XFILLER_127_807 vssd1 vccd1 vccd1 vssd1 sky130_ef_sc_hd__decap_40_12$1
XFILLER_40_289 vssd1 vccd1 vccd1 vssd1 sky130_ef_sc_hd__decap_40_12$1
XTAP_TAPCELL_ROW_138_2390 vccd1 vssd1 sky130_fd_sc_hd__tapvpwrvgnd_1$1
XFILLER_138_166 vssd1 vccd1 vccd1 vssd1 sky130_fd_sc_hd__fill_2$1
XFILLER_119_391 vccd1 vssd1 vccd1 vssd1 sky130_fd_sc_hd__fill_1$1
XFILLER_5_669 vssd1 vccd1 vccd1 vssd1 sky130_fd_sc_hd__fill_2$1
XFILLER_122_545 vssd1 vccd1 vccd1 vssd1 sky130_fd_sc_hd__fill_8$1
XFILLER_68_53 vssd1 vccd1 vccd1 vssd1 sky130_ef_sc_hd__decap_40_12$1
XFILLER_122_589 vssd1 vccd1 vccd1 vssd1 sky130_ef_sc_hd__decap_40_12$1
XFILLER_103_770 vssd1 vccd1 vccd1 vssd1 sky130_ef_sc_hd__decap_40_12$1
XFILLER_67_109 vssd1 vccd1 vccd1 vssd1 sky130_fd_sc_hd__fill_2$1
XFILLER_0_363 vccd1 vssd1 vccd1 vssd1 sky130_fd_sc_hd__fill_1$1
XFILLER_48_301 vssd1 vccd1 vccd1 vssd1 sky130_fd_sc_hd__fill_4$1
XFILLER_68_97 vssd1 vccd1 vccd1 vssd1 sky130_ef_sc_hd__decap_40_12$1
XFILLER_124_81 vssd1 vccd1 vccd1 vssd1 sky130_fd_sc_hd__fill_2$1
XFILLER_84_41 vssd1 vccd1 vccd1 vssd1 sky130_ef_sc_hd__decap_40_12$1
XFILLER_48_345 vssd1 vccd1 vccd1 vssd1 sky130_ef_sc_hd__decap_40_12$1
XFILLER_63_337 vssd1 vccd1 vccd1 vssd1 sky130_ef_sc_hd__decap_40_12$1
XFILLER_17_721 vssd1 vccd1 vccd1 vssd1 sky130_fd_sc_hd__fill_4$1
XFILLER_36_529 vssd1 vccd1 vccd1 vssd1 sky130_fd_sc_hd__fill_2$1
XFILLER_48_389 vssd1 vccd1 vccd1 vssd1 sky130_ef_sc_hd__decap_40_12$1
XFILLER_84_85 vssd1 vccd1 vccd1 vssd1 sky130_ef_sc_hd__decap_40_12$1
XFILLER_17_765 vssd1 vccd1 vccd1 vssd1 sky130_ef_sc_hd__decap_40_12$1
XFILLER_90_189 vssd1 vccd1 vccd1 vssd1 sky130_fd_sc_hd__fill_4$1
XFILLER_16_253 vssd1 vccd1 vccd1 vssd1 sky130_ef_sc_hd__decap_40_12$1
XFILLER_32_724 vssd1 vccd1 vccd1 vssd1 sky130_ef_sc_hd__decap_40_12$1
XTAP_TAPCELL_ROW_63_1249 vccd1 vssd1 sky130_fd_sc_hd__tapvpwrvgnd_1$1
XTAP_TAPCELL_ROW_63_1238 vccd1 vssd1 sky130_fd_sc_hd__tapvpwrvgnd_1$1
XFILLER_31_223 vccd1 vssd1 vccd1 vssd1 sky130_fd_sc_hd__fill_1$1
XFILLER_32_757 vssd1 vccd1 vccd1 vssd1 sky130_ef_sc_hd__decap_40_12$1
XFILLER_129_111 vccd1 vssd1 vccd1 vssd1 sky130_fd_sc_hd__fill_1$1
XFILLER_117_317 vssd1 vccd1 vccd1 vssd1 sky130_ef_sc_hd__decap_40_12$1
X_1701_ _1824_/A clkload9/A _1701_/D vccd1 vssd1 vccd1 vssd1 sky130_fd_sc_hd__dfxtp_1$1
X_1632_ _1632_/Q _1747_/CLK _1632_/D vccd1 vssd1 vccd1 vssd1 sky130_fd_sc_hd__dfxtp_1$1
XFILLER_99_713 vssd1 vccd1 vccd1 vssd1 sky130_ef_sc_hd__decap_40_12$1
XTAP_TAPCELL_ROW_78_1470 vccd1 vssd1 sky130_fd_sc_hd__tapvpwrvgnd_1$1
X_1563_ hold79/A _1757_/CLK _1563_/D vccd1 vssd1 vccd1 vssd1 sky130_fd_sc_hd__dfxtp_1$1
XFILLER_125_361 vssd1 vccd1 vccd1 vssd1 sky130_ef_sc_hd__decap_40_12$1
XFILLER_113_501 vssd1 vccd1 vccd1 vssd1 sky130_fd_sc_hd__fill_2$1
XFILLER_101_707 vssd1 vccd1 vccd1 vssd1 sky130_ef_sc_hd__decap_40_12$1
XFILLER_98_245 vssd1 vccd1 vccd1 vssd1 sky130_fd_sc_hd__fill_4$1
X_1494_ _1494_/Q _1753_/CLK _1494_/D vccd1 vssd1 vccd1 vssd1 sky130_fd_sc_hd__dfxtp_2$1
XFILLER_101_729 vssd1 vccd1 vccd1 vssd1 sky130_ef_sc_hd__decap_40_12$1
XFILLER_98_289 vssd1 vccd1 vccd1 vssd1 sky130_ef_sc_hd__decap_40_12$1
XTAP_TAPCELL_ROW_91_1670 vccd1 vssd1 sky130_fd_sc_hd__tapvpwrvgnd_1$1
XFILLER_58_109 vssd1 vccd1 vccd1 vssd1 sky130_ef_sc_hd__decap_40_12$1
XFILLER_67_621 vssd1 vccd1 vccd1 vssd1 sky130_ef_sc_hd__decap_40_12$1
XFILLER_104_29 vssd1 vccd1 vccd1 vssd1 sky130_ef_sc_hd__decap_40_12$1
XFILLER_94_451 vssd1 vccd1 vccd1 vssd1 sky130_ef_sc_hd__decap_40_12$1
XFILLER_66_153 vssd1 vccd1 vccd1 vssd1 sky130_ef_sc_hd__decap_40_12$1
XFILLER_67_687 vccd1 vssd1 vccd1 vssd1 sky130_fd_sc_hd__fill_1$1
XFILLER_27_529 vssd1 vccd1 vccd1 vssd1 sky130_ef_sc_hd__decap_40_12$1
XFILLER_39_389 vssd1 vccd1 vccd1 vssd1 sky130_fd_sc_hd__fill_2$1
XFILLER_82_657 vssd1 vccd1 vccd1 vssd1 sky130_fd_sc_hd__fill_4$1
XFILLER_66_197 vssd1 vccd1 vccd1 vssd1 sky130_ef_sc_hd__decap_40_12$1
XFILLER_81_167 vccd1 vssd1 vccd1 vssd1 sky130_fd_sc_hd__fill_1$1
XFILLER_35_573 vssd1 vccd1 vccd1 vssd1 sky130_ef_sc_hd__decap_40_12$1
XFILLER_62_392 vccd1 vssd1 vccd1 vssd1 sky130_fd_sc_hd__fill_1$1
XFILLER_23_757 vssd1 vccd1 vccd1 vssd1 sky130_fd_sc_hd__fill_2$1
XFILLER_13_15 vssd1 vccd1 vccd1 vssd1 sky130_ef_sc_hd__decap_40_12$1
XFILLER_22_245 vssd1 vccd1 vccd1 vssd1 sky130_fd_sc_hd__fill_4$1
XFILLER_129_15 vssd1 vccd1 vccd1 vssd1 sky130_ef_sc_hd__decap_40_12$1
XFILLER_50_587 vccd1 vssd1 vccd1 vssd1 sky130_fd_sc_hd__fill_1$1
XFILLER_22_289 vssd1 vccd1 vccd1 vssd1 sky130_ef_sc_hd__decap_40_12$1
XTAP_TAPCELL_ROW_33_796 vccd1 vssd1 sky130_fd_sc_hd__tapvpwrvgnd_1$1
XFILLER_135_125 vssd1 vccd1 vccd1 vssd1 sky130_ef_sc_hd__decap_40_12$1
XFILLER_135_169 vssd1 vccd1 vccd1 vssd1 sky130_ef_sc_hd__decap_40_12$1
XFILLER_116_383 vccd1 vssd1 vccd1 vssd1 sky130_fd_sc_hd__fill_1$1
XFILLER_116_361 vssd1 vccd1 vccd1 vssd1 sky130_fd_sc_hd__fill_2$1
XFILLER_1_105 vssd1 vccd1 vccd1 vssd1 sky130_fd_sc_hd__fill_4$1
XFILLER_116_394 vssd1 vccd1 vccd1 vssd1 sky130_ef_sc_hd__decap_40_12$1
XFILLER_104_545 vssd1 vccd1 vccd1 vssd1 sky130_ef_sc_hd__decap_40_12$1
XFILLER_89_223 vccd1 vssd1 vccd1 vssd1 sky130_fd_sc_hd__fill_1$1
XFILLER_1_149 vssd1 vccd1 vccd1 vssd1 sky130_ef_sc_hd__decap_40_12$1
XFILLER_104_589 vssd1 vccd1 vccd1 vssd1 sky130_ef_sc_hd__decap_40_12$1
XFILLER_77_429 vssd1 vccd1 vccd1 vssd1 sky130_ef_sc_hd__decap_40_12$1
XFILLER_49_109 vssd1 vccd1 vccd1 vssd1 sky130_fd_sc_hd__fill_2$1
XFILLER_58_643 vccd1 vssd1 vccd1 vssd1 sky130_fd_sc_hd__fill_1$1
XFILLER_18_529 vssd1 vccd1 vccd1 vssd1 sky130_fd_sc_hd__fill_2$1
XFILLER_45_337 vssd1 vccd1 vccd1 vssd1 sky130_ef_sc_hd__decap_40_12$1
XFILLER_72_189 vssd1 vccd1 vccd1 vssd1 sky130_fd_sc_hd__fill_4$1
XFILLER_60_307 vccd1 vssd1 vccd1 vssd1 sky130_fd_sc_hd__fill_1$1
XFILLER_14_713 vssd1 vccd1 vccd1 vssd1 sky130_ef_sc_hd__decap_40_12$1
XTAP_TAPCELL_ROW_103_1839 vccd1 vssd1 sky130_fd_sc_hd__tapvpwrvgnd_1$1
XFILLER_54_77 vssd1 vccd1 vccd1 vssd1 sky130_fd_sc_hd__fill_4$1
XFILLER_13_223 vccd1 vssd1 vccd1 vssd1 sky130_fd_sc_hd__fill_1$1
XFILLER_14_757 vssd1 vccd1 vccd1 vssd1 sky130_ef_sc_hd__decap_40_12$1
XFILLER_9_205 vssd1 vccd1 vccd1 vssd1 sky130_ef_sc_hd__decap_40_12$1
XFILLER_41_554 vssd1 vccd1 vccd1 vssd1 sky130_fd_sc_hd__fill_4$1
XFILLER_110_83 vccd1 vssd1 vccd1 vssd1 sky130_fd_sc_hd__fill_1$1
XFILLER_9_249 vssd1 vccd1 vccd1 vssd1 sky130_ef_sc_hd__decap_40_12$1
XFILLER_41_587 vssd1 vccd1 vccd1 vssd1 sky130_fd_sc_hd__fill_8$1
XTAP_TAPCELL_ROW_136_2338 vccd1 vssd1 sky130_fd_sc_hd__tapvpwrvgnd_1$1
XFILLER_70_65 vssd1 vccd1 vccd1 vssd1 sky130_ef_sc_hd__decap_40_12$1
Xclkload19 clkload19/X _1720_/CLK vssd1 vccd1 vccd1 vssd1 sky130_fd_sc_hd__clkbuf_8$1
XTAP_TAPCELL_ROW_11_468 vccd1 vssd1 sky130_fd_sc_hd__tapvpwrvgnd_1$1
XFILLER_119_81 vssd1 vccd1 vccd1 vssd1 sky130_ef_sc_hd__decap_40_12$1
XFILLER_114_309 vssd1 vccd1 vccd1 vssd1 sky130_ef_sc_hd__decap_40_12$1
XFILLER_135_670 vssd1 vccd1 vccd1 vssd1 sky130_fd_sc_hd__fill_2$1
XFILLER_123_821 vssd1 vccd1 vccd1 vssd1 sky130_fd_sc_hd__fill_2$1
XFILLER_107_361 vssd1 vccd1 vccd1 vssd1 sky130_ef_sc_hd__decap_40_12$1
XFILLER_122_375 vccd1 vssd1 vccd1 vssd1 sky130_fd_sc_hd__fill_1$1
XFILLER_68_429 vssd1 vccd1 vccd1 vssd1 sky130_fd_sc_hd__fill_2$1
XFILLER_110_526 vssd1 vccd1 vccd1 vssd1 sky130_fd_sc_hd__fill_4$1
XFILLER_95_237 vssd1 vccd1 vccd1 vssd1 sky130_ef_sc_hd__decap_40_12$1
XFILLER_95_51 vssd1 vccd1 vccd1 vssd1 sky130_fd_sc_hd__fill_4$1
XFILLER_0_193 vssd1 vccd1 vccd1 vssd1 sky130_fd_sc_hd__fill_2$1
XFILLER_37_805 vssd1 vccd1 vccd1 vssd1 sky130_fd_sc_hd__fill_2$1
XFILLER_48_153 vssd1 vccd1 vccd1 vssd1 sky130_ef_sc_hd__decap_40_12$1
XFILLER_48_197 vssd1 vccd1 vccd1 vssd1 sky130_ef_sc_hd__decap_40_12$1
XFILLER_63_167 vccd1 vssd1 vccd1 vssd1 sky130_fd_sc_hd__fill_1$1
XFILLER_51_329 vssd1 vccd1 vccd1 vssd1 sky130_fd_sc_hd__fill_4$1
XFILLER_17_573 vssd1 vccd1 vccd1 vssd1 sky130_ef_sc_hd__decap_40_12$1
XTAP_TAPCELL_ROW_19_579 vccd1 vssd1 sky130_fd_sc_hd__tapvpwrvgnd_1$1
XFILLER_81_3 vssd1 vccd1 vccd1 vssd1 sky130_ef_sc_hd__decap_40_12$1
XFILLER_20_749 vssd1 vccd1 vccd1 vssd1 sky130_fd_sc_hd__fill_4$1
XFILLER_32_587 vccd1 vssd1 vccd1 vssd1 sky130_fd_sc_hd__fill_1$1
X_0994_ hold95/X _0994_/X _1012_/B vssd1 vccd1 vccd1 vssd1 sky130_fd_sc_hd__or2_1$1
XTAP_TAPCELL_ROW_30_744 vccd1 vssd1 sky130_fd_sc_hd__tapvpwrvgnd_1$1
XTAP_TAPCELL_ROW_30_755 vccd1 vssd1 sky130_fd_sc_hd__tapvpwrvgnd_1$1
XFILLER_117_125 vssd1 vccd1 vccd1 vssd1 sky130_ef_sc_hd__decap_40_12$1
XFILLER_9_783 vccd1 vssd1 vccd1 vssd1 sky130_fd_sc_hd__fill_1$1
XFILLER_117_169 vssd1 vccd1 vccd1 vssd1 sky130_ef_sc_hd__decap_40_12$1
X_1615_ _1819_/A _1679_/CLK _1615_/D vccd1 vssd1 vccd1 vssd1 sky130_fd_sc_hd__dfxtp_1$1
XFILLER_132_139 vccd1 vssd1 vccd1 vssd1 sky130_fd_sc_hd__fill_1$1
X_1546_ _1777_/A _1671_/CLK _1546_/D vccd1 vssd1 vccd1 vssd1 sky130_fd_sc_hd__dfxtp_1$1
Xfanout228 _1015_/Y _1053_/A2 vssd1 vccd1 vccd1 vssd1 sky130_fd_sc_hd__buf_8$1
Xfanout206 _1464_/B _1422_/B vssd1 vccd1 vccd1 vssd1 sky130_fd_sc_hd__clkbuf_8$1
Xfanout217 _1270_/B vccd1 vssd1 _1276_/B vccd1 vssd1 sky130_fd_sc_hd__buf_4$1
XFILLER_87_727 vccd1 vssd1 vccd1 vssd1 sky130_fd_sc_hd__fill_1$1
XFILLER_5_93 vssd1 vccd1 vccd1 vssd1 sky130_ef_sc_hd__decap_40_12$1
Xfanout239 hold6/X _0906_/B1 vssd1 vccd1 vccd1 vssd1 sky130_fd_sc_hd__buf_8$1
XFILLER_115_39 vssd1 vccd1 vccd1 vssd1 sky130_ef_sc_hd__decap_40_12$1
X_1477_ _1477_/D _1736_/CLK _1477_/Q vssd1 vccd1 vccd1 vssd1 sky130_fd_sc_hd__dfxtp_4$1
XFILLER_101_559 vccd1 vssd1 vccd1 vssd1 sky130_fd_sc_hd__fill_1$1
XFILLER_28_805 vssd1 vccd1 vccd1 vssd1 sky130_fd_sc_hd__fill_4$1
XFILLER_95_793 vccd1 vssd1 vccd1 vssd1 sky130_fd_sc_hd__fill_1$1
XFILLER_67_473 vssd1 vccd1 vccd1 vssd1 sky130_ef_sc_hd__decap_40_12$1
XFILLER_131_27 vssd1 vccd1 vccd1 vssd1 sky130_ef_sc_hd__decap_40_12$1
XFILLER_82_421 vssd1 vccd1 vccd1 vssd1 sky130_ef_sc_hd__decap_40_12$1
XFILLER_55_657 vssd1 vccd1 vccd1 vssd1 sky130_ef_sc_hd__decap_40_12$1
XFILLER_27_337 vssd1 vccd1 vccd1 vssd1 sky130_ef_sc_hd__decap_40_12$1
XTAP_TAPCELL_ROW_120_2106 vccd1 vssd1 sky130_fd_sc_hd__tapvpwrvgnd_1$1
XTAP_TAPCELL_ROW_38_866 vccd1 vssd1 sky130_fd_sc_hd__tapvpwrvgnd_1$1
XTAP_TAPCELL_ROW_38_877 vccd1 vssd1 sky130_fd_sc_hd__tapvpwrvgnd_1$1
XFILLER_42_307 vccd1 vssd1 vccd1 vssd1 sky130_fd_sc_hd__fill_1$1
XFILLER_54_189 vssd1 vccd1 vccd1 vssd1 sky130_fd_sc_hd__fill_4$1
XFILLER_51_841 vccd1 vssd1 vccd1 vssd1 sky130_fd_sc_hd__fill_1$1
XFILLER_11_727 vccd1 vssd1 vccd1 vssd1 sky130_fd_sc_hd__fill_1$1
XFILLER_109_615 vccd1 vssd1 vccd1 vssd1 sky130_fd_sc_hd__fill_1$1
Xclkbuf_leaf_40_wb_clk_i _1721_/CLK clkload0/A vssd1 vccd1 vccd1 vssd1 sky130_fd_sc_hd__clkbuf_8$1
XFILLER_7_709 vssd1 vccd1 vccd1 vssd1 sky130_ef_sc_hd__decap_40_12$1
XTAP_TAPCELL_ROW_118_2068 vccd1 vssd1 sky130_fd_sc_hd__tapvpwrvgnd_1$1
XFILLER_136_445 vssd1 vccd1 vccd1 vssd1 sky130_fd_sc_hd__fill_8$1
XFILLER_105_821 vssd1 vccd1 vccd1 vssd1 sky130_fd_sc_hd__fill_2$1
XTAP_TAPCELL_ROW_131_2268 vccd1 vssd1 sky130_fd_sc_hd__tapvpwrvgnd_1$1
XFILLER_2_469 vssd1 vccd1 vccd1 vssd1 sky130_fd_sc_hd__fill_4$1
XFILLER_49_55 vccd1 vssd1 vccd1 vssd1 sky130_fd_sc_hd__fill_1$1
XFILLER_131_161 vssd1 vccd1 vccd1 vssd1 sky130_fd_sc_hd__fill_4$1
XTAP_TAPCELL_ROW_113_1990 vccd1 vssd1 sky130_fd_sc_hd__tapvpwrvgnd_1$1
XFILLER_104_375 vccd1 vssd1 vccd1 vssd1 sky130_fd_sc_hd__fill_1$1
XFILLER_77_237 vssd1 vccd1 vccd1 vssd1 sky130_ef_sc_hd__decap_40_12$1
XFILLER_58_451 vssd1 vccd1 vccd1 vssd1 sky130_ef_sc_hd__decap_40_12$1
XFILLER_46_613 vssd1 vccd1 vccd1 vssd1 sky130_ef_sc_hd__decap_40_12$1
XFILLER_85_281 vssd1 vccd1 vccd1 vssd1 sky130_ef_sc_hd__decap_40_12$1
XFILLER_73_443 vssd1 vccd1 vccd1 vssd1 sky130_fd_sc_hd__fill_4$1
XFILLER_46_657 vssd1 vccd1 vccd1 vssd1 sky130_ef_sc_hd__decap_40_12$1
XFILLER_45_167 vccd1 vssd1 vccd1 vssd1 sky130_fd_sc_hd__fill_1$1
XTAP_TAPCELL_ROW_47_1008 vccd1 vssd1 sky130_fd_sc_hd__tapvpwrvgnd_1$1
XFILLER_60_137 vssd1 vccd1 vccd1 vssd1 sky130_fd_sc_hd__fill_2$1
XTAP_TAPCELL_ROW_16_538 vccd1 vssd1 sky130_fd_sc_hd__tapvpwrvgnd_1$1
XFILLER_33_329 vssd1 vccd1 vccd1 vssd1 sky130_fd_sc_hd__fill_4$1
XFILLER_121_93 vssd1 vccd1 vccd1 vssd1 sky130_ef_sc_hd__decap_40_12$1
XFILLER_14_587 vccd1 vssd1 vccd1 vssd1 sky130_fd_sc_hd__fill_1$1
XFILLER_41_373 vssd1 vccd1 vccd1 vssd1 sky130_ef_sc_hd__decap_40_12$1
XFILLER_127_423 vssd1 vccd1 vccd1 vssd1 sky130_fd_sc_hd__fill_2$1
XFILLER_6_753 vssd1 vccd1 vccd1 vssd1 sky130_fd_sc_hd__fill_2$1
XFILLER_127_478 vssd1 vccd1 vccd1 vssd1 sky130_ef_sc_hd__decap_40_12$1
X_1400_ _1400_/A _1400_/X _1408_/B vssd1 vccd1 vccd1 vssd1 sky130_fd_sc_hd__or2_1$1
XFILLER_114_139 vccd1 vssd1 vccd1 vssd1 sky130_fd_sc_hd__fill_1$1
XFILLER_123_673 vssd1 vccd1 vccd1 vssd1 sky130_fd_sc_hd__fill_4$1
XFILLER_96_502 vssd1 vccd1 vccd1 vssd1 sky130_ef_sc_hd__decap_40_12$1
XFILLER_69_727 vccd1 vssd1 vccd1 vssd1 sky130_fd_sc_hd__fill_1$1
X_1331_ _1463_/C1 _1330_/X _1331_/A2 hold81/X _1694_/D vssd1 vccd1 vccd1 vssd1 sky130_fd_sc_hd__o211a_1$1
XFILLER_110_301 vssd1 vccd1 vccd1 vssd1 sky130_fd_sc_hd__fill_4$1
XFILLER_96_524 vccd1 vssd1 vccd1 vssd1 sky130_fd_sc_hd__fill_1$1
XTAP_TAPCELL_ROW_71_1359 vccd1 vssd1 sky130_fd_sc_hd__tapvpwrvgnd_1$1
XFILLER_110_345 vssd1 vccd1 vccd1 vssd1 sky130_ef_sc_hd__decap_40_12$1
X_1262_ _1661_/Q _1262_/X _1276_/B vssd1 vccd1 vccd1 vssd1 sky130_fd_sc_hd__or2_1$1
XFILLER_49_473 vssd1 vccd1 vccd1 vssd1 sky130_ef_sc_hd__decap_40_12$1
Xinput6 adc_data[3] input6/X vssd1 vccd1 vccd1 vssd1 sky130_fd_sc_hd__clkbuf_2$1
XFILLER_37_613 vssd1 vccd1 vccd1 vssd1 sky130_fd_sc_hd__fill_2$1
X_1193_ _1463_/C1 _1192_/X _1211_/A2 hold59/X _1627_/D vssd1 vccd1 vccd1 vssd1 sky130_fd_sc_hd__o211a_1$1
XFILLER_64_421 vssd1 vccd1 vccd1 vssd1 sky130_fd_sc_hd__fill_8$1
XFILLER_24_307 vccd1 vssd1 vccd1 vssd1 sky130_fd_sc_hd__fill_1$1
XFILLER_91_273 vssd1 vccd1 vccd1 vssd1 sky130_fd_sc_hd__fill_4$1
XTAP_TAPCELL_ROW_86_1591 vccd1 vssd1 sky130_fd_sc_hd__tapvpwrvgnd_1$1
XFILLER_51_137 vssd1 vccd1 vccd1 vssd1 sky130_ef_sc_hd__decap_40_12$1
XFILLER_33_841 vccd1 vssd1 vccd1 vssd1 sky130_fd_sc_hd__fill_1$1
XTAP_TAPCELL_ROW_35_825 vccd1 vssd1 sky130_fd_sc_hd__tapvpwrvgnd_1$1
XFILLER_36_189 vssd1 vccd1 vccd1 vssd1 sky130_fd_sc_hd__fill_4$1
XFILLER_60_671 vssd1 vccd1 vccd1 vssd1 sky130_fd_sc_hd__fill_8$1
XFILLER_20_513 vssd1 vccd1 vccd1 vssd1 sky130_ef_sc_hd__decap_40_12$1
XFILLER_20_557 vssd1 vccd1 vccd1 vssd1 sky130_ef_sc_hd__decap_40_12$1
X_0977_ _1449_/C1 _0976_/X _0991_/A2 hold21/X _1522_/D vssd1 vccd1 vccd1 vssd1 sky130_fd_sc_hd__o211a_1$1
XFILLER_10_27 vccd1 vssd1 vccd1 vssd1 sky130_fd_sc_hd__fill_1$1
XFILLER_126_27 vccd1 vssd1 vccd1 vssd1 sky130_fd_sc_hd__fill_1$1
XFILLER_120_109 vssd1 vccd1 vccd1 vssd1 sky130_ef_sc_hd__decap_40_12$1
XFILLER_113_161 vssd1 vccd1 vccd1 vssd1 sky130_fd_sc_hd__fill_4$1
XFILLER_99_373 vssd1 vccd1 vccd1 vssd1 sky130_fd_sc_hd__fill_2$1
XFILLER_59_237 vssd1 vccd1 vccd1 vssd1 sky130_ef_sc_hd__decap_40_12$1
X_1529_ _1529_/Q _1721_/CLK _1529_/D vccd1 vssd1 vccd1 vssd1 sky130_fd_sc_hd__dfxtp_1$1
XFILLER_75_719 vssd1 vccd1 vccd1 vssd1 sky130_fd_sc_hd__fill_8$1
XFILLER_68_793 vssd1 vccd1 vccd1 vssd1 sky130_fd_sc_hd__fill_8$1
XFILLER_19_69 vssd1 vccd1 vccd1 vssd1 sky130_ef_sc_hd__decap_40_12$1
XFILLER_28_613 vssd1 vccd1 vccd1 vssd1 sky130_ef_sc_hd__decap_40_12$1
XFILLER_67_281 vssd1 vccd1 vccd1 vssd1 sky130_ef_sc_hd__decap_40_12$1
XFILLER_28_657 vssd1 vccd1 vccd1 vssd1 sky130_fd_sc_hd__fill_2$1
XFILLER_83_785 vssd1 vccd1 vccd1 vssd1 sky130_fd_sc_hd__fill_8$1
XFILLER_82_251 vccd1 vssd1 vccd1 vssd1 sky130_fd_sc_hd__fill_1$1
XFILLER_27_167 vccd1 vssd1 vccd1 vssd1 sky130_fd_sc_hd__fill_1$1
XFILLER_15_329 vssd1 vccd1 vccd1 vssd1 sky130_fd_sc_hd__fill_4$1
XFILLER_35_57 vssd1 vccd1 vccd1 vssd1 sky130_ef_sc_hd__decap_40_12$1
XFILLER_70_457 vssd1 vccd1 vccd1 vssd1 sky130_ef_sc_hd__decap_40_12$1
XFILLER_42_137 vssd1 vccd1 vccd1 vssd1 sky130_fd_sc_hd__fill_2$1
XFILLER_51_671 vccd1 vssd1 vccd1 vssd1 sky130_fd_sc_hd__fill_1$1
XFILLER_23_373 vssd1 vccd1 vccd1 vssd1 sky130_ef_sc_hd__decap_40_12$1
XFILLER_128_209 vssd1 vccd1 vccd1 vssd1 sky130_ef_sc_hd__decap_40_12$1
XFILLER_11_557 vssd1 vccd1 vccd1 vssd1 sky130_fd_sc_hd__fill_2$1
XPHY_EDGE_ROW_14_Right_14 vccd1 vssd1 vccd1 vssd1 sky130_fd_sc_hd__decap_3$1
XFILLER_137_721 vssd1 vccd1 vccd1 vssd1 sky130_fd_sc_hd__fill_4$1
XFILLER_129_3 vssd1 vccd1 vccd1 vssd1 sky130_ef_sc_hd__decap_40_12$1
XFILLER_7_517 vssd1 vccd1 vccd1 vssd1 sky130_ef_sc_hd__decap_40_12$1
XFILLER_136_253 vssd1 vccd1 vccd1 vssd1 sky130_ef_sc_hd__decap_40_12$1
XFILLER_111_109 vssd1 vccd1 vccd1 vssd1 sky130_fd_sc_hd__fill_2$1
XFILLER_105_673 vssd1 vccd1 vccd1 vssd1 sky130_ef_sc_hd__decap_40_12$1
XFILLER_2_233 vssd1 vccd1 vccd1 vssd1 sky130_ef_sc_hd__decap_40_12$1
XFILLER_120_621 vssd1 vccd1 vccd1 vssd1 sky130_ef_sc_hd__decap_40_12$1
XFILLER_78_513 vssd1 vccd1 vccd1 vssd1 sky130_ef_sc_hd__decap_40_12$1
XFILLER_2_277 vssd1 vccd1 vccd1 vssd1 sky130_ef_sc_hd__decap_40_12$1
XPHY_EDGE_ROW_23_Right_23 vccd1 vssd1 vccd1 vssd1 sky130_fd_sc_hd__decap_3$1
XFILLER_120_654 vssd1 vccd1 vccd1 vssd1 sky130_ef_sc_hd__decap_40_12$1
XFILLER_120_643 vccd1 vssd1 vccd1 vssd1 sky130_fd_sc_hd__fill_1$1
XFILLER_93_505 vssd1 vccd1 vccd1 vssd1 sky130_ef_sc_hd__decap_40_12$1
XFILLER_78_557 vssd1 vccd1 vccd1 vssd1 sky130_ef_sc_hd__decap_40_12$1
XTAP_TAPCELL_ROW_53_1089 vccd1 vssd1 sky130_fd_sc_hd__tapvpwrvgnd_1$1
XFILLER_76_53 vssd1 vccd1 vccd1 vssd1 sky130_ef_sc_hd__decap_40_12$1
XFILLER_19_613 vssd1 vccd1 vccd1 vssd1 sky130_fd_sc_hd__fill_2$1
XFILLER_76_97 vssd1 vccd1 vccd1 vssd1 sky130_ef_sc_hd__decap_40_12$1
XFILLER_74_730 vssd1 vccd1 vccd1 vssd1 sky130_fd_sc_hd__fill_4$1
XFILLER_46_421 vssd1 vccd1 vccd1 vssd1 sky130_ef_sc_hd__decap_40_12$1
XFILLER_132_81 vssd1 vccd1 vccd1 vssd1 sky130_fd_sc_hd__fill_2$1
XFILLER_92_41 vssd1 vccd1 vccd1 vssd1 sky130_ef_sc_hd__decap_40_12$1
XFILLER_73_273 vssd1 vccd1 vccd1 vssd1 sky130_fd_sc_hd__fill_4$1
XFILLER_61_413 vccd1 vssd1 vccd1 vssd1 sky130_fd_sc_hd__fill_1$1
XFILLER_18_189 vssd1 vccd1 vccd1 vssd1 sky130_fd_sc_hd__fill_4$1
XFILLER_92_85 vssd1 vccd1 vccd1 vssd1 sky130_ef_sc_hd__decap_40_12$1
XFILLER_61_446 vssd1 vccd1 vccd1 vssd1 sky130_fd_sc_hd__fill_2$1
XFILLER_15_841 vccd1 vssd1 vccd1 vssd1 sky130_fd_sc_hd__fill_1$1
XPHY_EDGE_ROW_32_Right_32 vccd1 vssd1 vccd1 vssd1 sky130_fd_sc_hd__decap_3$1
XFILLER_33_137 vssd1 vccd1 vccd1 vssd1 sky130_ef_sc_hd__decap_40_12$1
X_0900_ _1629_/Q _1147_/A _0903_/B _1661_/Q _1213_/A vccd1 vssd1 vccd1 vssd1 sky130_fd_sc_hd__a22o_1$1
XFILLER_30_811 vccd1 vssd1 vccd1 vssd1 sky130_fd_sc_hd__fill_1$1
XFILLER_41_181 vssd1 vccd1 vccd1 vssd1 sky130_ef_sc_hd__decap_40_12$1
X_0831_ _0752_/A _1489_/D _0827_/X _1437_/C1 _1489_/Q _0830_/X vssd1 vccd1 vccd1 vssd1
+ sky130_fd_sc_hd__o221a_1$1
X_0762_ _1788_/A _0879_/A2 _0762_/X input4/X _0784_/B1 vccd1 vssd1 vccd1 vssd1 sky130_fd_sc_hd__a22o_1$1
XTAP_TAPCELL_ROW_40_894 vccd1 vssd1 sky130_fd_sc_hd__tapvpwrvgnd_1$1
XFILLER_115_459 vccd1 vssd1 vccd1 vssd1 sky130_fd_sc_hd__fill_1$1
XFILLER_102_109 vssd1 vccd1 vccd1 vssd1 sky130_ef_sc_hd__decap_40_12$1
XFILLER_69_502 vssd1 vccd1 vccd1 vssd1 sky130_fd_sc_hd__fill_2$1
XPHY_EDGE_ROW_41_Right_41 vccd1 vssd1 vccd1 vssd1 sky130_fd_sc_hd__decap_3$1
XFILLER_44_3 vssd1 vccd1 vccd1 vssd1 sky130_ef_sc_hd__decap_40_12$1
XFILLER_130_429 vccd1 vssd1 vccd1 vssd1 sky130_fd_sc_hd__fill_1$1
XFILLER_96_321 vssd1 vccd1 vccd1 vssd1 sky130_ef_sc_hd__decap_40_12$1
XFILLER_111_665 vssd1 vccd1 vccd1 vssd1 sky130_fd_sc_hd__fill_4$1
X_1314_ _1314_/A _1314_/X _1330_/B vssd1 vccd1 vccd1 vssd1 sky130_fd_sc_hd__or2_1$1
XFILLER_110_153 vssd1 vccd1 vccd1 vssd1 sky130_ef_sc_hd__decap_40_12$1
XFILLER_96_365 vssd1 vccd1 vccd1 vssd1 sky130_ef_sc_hd__decap_40_12$1
XFILLER_110_197 vssd1 vccd1 vccd1 vssd1 sky130_ef_sc_hd__decap_40_12$1
XTAP_TAPCELL_ROW_88_1620 vccd1 vssd1 sky130_fd_sc_hd__tapvpwrvgnd_1$1
X_1245_ _1449_/C1 _1244_/X _1277_/A2 hold90/X _1652_/D vssd1 vccd1 vccd1 vssd1 sky130_fd_sc_hd__o211a_1$1
XFILLER_65_741 vssd1 vccd1 vccd1 vssd1 sky130_ef_sc_hd__decap_40_12$1
XFILLER_2_83 vccd1 vssd1 vccd1 vssd1 sky130_fd_sc_hd__fill_1$1
XFILLER_49_281 vssd1 vccd1 vccd1 vssd1 sky130_ef_sc_hd__decap_40_12$1
XFILLER_112_29 vssd1 vccd1 vccd1 vssd1 sky130_ef_sc_hd__decap_40_12$1
X_1176_ _1823_/A _1176_/X _1210_/B vssd1 vccd1 vccd1 vssd1 sky130_fd_sc_hd__or2_1$1
XFILLER_65_785 vssd1 vccd1 vccd1 vssd1 sky130_ef_sc_hd__decap_40_12$1
XFILLER_64_251 vccd1 vssd1 vccd1 vssd1 sky130_fd_sc_hd__fill_1$1
XFILLER_52_413 vssd1 vccd1 vccd1 vssd1 sky130_fd_sc_hd__fill_4$1
XPHY_EDGE_ROW_50_Right_50 vccd1 vssd1 vccd1 vssd1 sky130_fd_sc_hd__decap_3$1
XFILLER_80_755 vccd1 vssd1 vccd1 vssd1 sky130_fd_sc_hd__fill_1$1
XFILLER_24_137 vssd1 vccd1 vccd1 vssd1 sky130_fd_sc_hd__fill_2$1
XFILLER_33_671 vccd1 vssd1 vccd1 vssd1 sky130_fd_sc_hd__fill_1$1
XANTENNA_11 hold71/A vssd1 vccd1 vccd1 vssd1 sky130_fd_sc_hd__diode_2$1
XANTENNA_22 _1052_/B vssd1 vccd1 vccd1 vssd1 sky130_fd_sc_hd__diode_2$1
XFILLER_20_321 vssd1 vccd1 vccd1 vssd1 sky130_ef_sc_hd__decap_40_12$1
XFILLER_33_693 vssd1 vccd1 vccd1 vssd1 sky130_fd_sc_hd__fill_2$1
XFILLER_20_365 vssd1 vccd1 vccd1 vssd1 sky130_ef_sc_hd__decap_40_12$1
XTAP_TAPCELL_ROW_115_2027 vccd1 vssd1 sky130_fd_sc_hd__tapvpwrvgnd_1$1
XTAP_TAPCELL_ROW_99_1782 vccd1 vssd1 sky130_fd_sc_hd__tapvpwrvgnd_1$1
XFILLER_21_15 vssd1 vccd1 vccd1 vssd1 sky130_ef_sc_hd__decap_40_12$1
XFILLER_137_15 vssd1 vccd1 vccd1 vssd1 sky130_fd_sc_hd__fill_4$1
XFILLER_118_253 vssd1 vccd1 vccd1 vssd1 sky130_ef_sc_hd__decap_40_12$1
XFILLER_133_223 vccd1 vssd1 vccd1 vssd1 sky130_fd_sc_hd__fill_1$1
XFILLER_106_426 vssd1 vccd1 vccd1 vssd1 sky130_ef_sc_hd__decap_40_12$1
Xoutput151 _1654_/Q analog_ctrl[81] vssd1 vccd1 vccd1 vssd1 sky130_fd_sc_hd__buf_12$1
XFILLER_88_811 vccd1 vssd1 vccd1 vssd1 sky130_fd_sc_hd__fill_1$1
Xoutput140 _1643_/Q analog_ctrl[70] vssd1 vccd1 vccd1 vssd1 sky130_fd_sc_hd__buf_12$1
Xoutput184 _1498_/Q wbs_dat_o[21] vssd1 vccd1 vccd1 vssd1 sky130_fd_sc_hd__buf_12$1
Xoutput173 _1488_/Q wbs_dat_o[11] vssd1 vccd1 vccd1 vssd1 sky130_fd_sc_hd__buf_12$1
Xoutput195 _1508_/Q wbs_dat_o[31] vssd1 vccd1 vccd1 vssd1 sky130_fd_sc_hd__buf_12$1
Xoutput162 _1664_/Q analog_ctrl[91] vssd1 vccd1 vccd1 vssd1 sky130_fd_sc_hd__buf_12$1
XFILLER_99_181 vssd1 vccd1 vccd1 vssd1 sky130_ef_sc_hd__decap_40_12$1
XFILLER_102_643 vccd1 vssd1 vccd1 vssd1 sky130_fd_sc_hd__fill_1$1
XFILLER_87_365 vssd1 vccd1 vccd1 vssd1 sky130_fd_sc_hd__fill_2$1
XFILLER_75_505 vssd1 vccd1 vccd1 vssd1 sky130_ef_sc_hd__decap_40_12$1
XFILLER_28_421 vssd1 vccd1 vccd1 vssd1 sky130_ef_sc_hd__decap_40_12$1
XTAP_TAPCELL_ROW_126_2189 vccd1 vssd1 sky130_fd_sc_hd__tapvpwrvgnd_1$1
XFILLER_55_273 vssd1 vccd1 vccd1 vssd1 sky130_fd_sc_hd__fill_4$1
XFILLER_70_221 vssd1 vccd1 vccd1 vssd1 sky130_ef_sc_hd__decap_40_12$1
XFILLER_15_137 vssd1 vccd1 vccd1 vssd1 sky130_ef_sc_hd__decap_40_12$1
XFILLER_70_265 vssd1 vccd1 vccd1 vssd1 sky130_ef_sc_hd__decap_40_12$1
XFILLER_12_811 vccd1 vssd1 vccd1 vssd1 sky130_fd_sc_hd__fill_1$1
XTAP_TAPCELL_ROW_26_688 vccd1 vssd1 sky130_fd_sc_hd__tapvpwrvgnd_1$1
XFILLER_62_77 vssd1 vccd1 vccd1 vssd1 sky130_fd_sc_hd__fill_4$1
XFILLER_51_490 vssd1 vccd1 vccd1 vssd1 sky130_ef_sc_hd__decap_40_12$1
XFILLER_23_181 vssd1 vccd1 vccd1 vssd1 sky130_ef_sc_hd__decap_40_12$1
XFILLER_24_693 vssd1 vccd1 vccd1 vssd1 sky130_fd_sc_hd__fill_4$1
XFILLER_7_39 vssd1 vccd1 vccd1 vssd1 sky130_ef_sc_hd__decap_40_12$1
XPHY_EDGE_ROW_12_Left_151 vccd1 vssd1 vccd1 vssd1 sky130_fd_sc_hd__decap_3$1
XFILLER_124_245 vssd1 vccd1 vccd1 vssd1 sky130_fd_sc_hd__fill_4$1
XFILLER_98_608 vssd1 vccd1 vccd1 vssd1 sky130_ef_sc_hd__decap_40_12$1
XFILLER_79_800 vssd1 vccd1 vccd1 vssd1 sky130_ef_sc_hd__decap_40_12$1
XTAP_TAPCELL_ROW_55_1129 vccd1 vssd1 sky130_fd_sc_hd__tapvpwrvgnd_1$1
XTAP_TAPCELL_ROW_55_1118 vccd1 vssd1 sky130_fd_sc_hd__tapvpwrvgnd_1$1
XFILLER_11_81 vssd1 vccd1 vccd1 vssd1 sky130_ef_sc_hd__decap_40_12$1
XFILLER_3_553 vssd1 vccd1 vccd1 vssd1 sky130_fd_sc_hd__fill_4$1
XFILLER_127_81 vssd1 vccd1 vccd1 vssd1 sky130_ef_sc_hd__decap_40_12$1
XFILLER_124_289 vssd1 vccd1 vccd1 vssd1 sky130_ef_sc_hd__decap_40_12$1
XFILLER_3_597 vssd1 vccd1 vccd1 vssd1 sky130_ef_sc_hd__decap_40_12$1
XFILLER_78_321 vssd1 vccd1 vccd1 vssd1 sky130_ef_sc_hd__decap_40_12$1
XFILLER_78_365 vssd1 vccd1 vccd1 vssd1 sky130_ef_sc_hd__decap_40_12$1
XFILLER_66_516 vssd1 vccd1 vccd1 vssd1 sky130_ef_sc_hd__decap_40_12$1
XFILLER_93_335 vccd1 vssd1 vccd1 vssd1 sky130_fd_sc_hd__fill_1$1
XTAP_TAPCELL_ROW_6_391 vccd1 vssd1 sky130_fd_sc_hd__tapvpwrvgnd_1$1
XPHY_EDGE_ROW_21_Left_160 vccd1 vssd1 vccd1 vssd1 sky130_fd_sc_hd__decap_3$1
XFILLER_47_741 vssd1 vccd1 vccd1 vssd1 sky130_ef_sc_hd__decap_40_12$1
X_1030_ _1030_/A _1030_/X _1052_/B vssd1 vccd1 vccd1 vssd1 sky130_fd_sc_hd__or2_1$1
XFILLER_46_251 vccd1 vssd1 vccd1 vssd1 sky130_fd_sc_hd__fill_1$1
XFILLER_74_593 vssd1 vccd1 vccd1 vssd1 sky130_ef_sc_hd__decap_40_12$1
XFILLER_62_711 vccd1 vssd1 vccd1 vssd1 sky130_fd_sc_hd__fill_1$1
XFILLER_34_413 vssd1 vccd1 vccd1 vssd1 sky130_fd_sc_hd__fill_4$1
XFILLER_47_785 vssd1 vccd1 vccd1 vssd1 sky130_ef_sc_hd__decap_40_12$1
XFILLER_61_221 vssd1 vccd1 vccd1 vssd1 sky130_fd_sc_hd__fill_2$1
XFILLER_34_457 vssd1 vccd1 vccd1 vssd1 sky130_ef_sc_hd__decap_40_12$1
XTAP_TAPCELL_ROW_83_1550 vccd1 vssd1 sky130_fd_sc_hd__tapvpwrvgnd_1$1
XFILLER_15_671 vccd1 vssd1 vccd1 vssd1 sky130_fd_sc_hd__fill_1$1
XTAP_TAPCELL_ROW_45_975 vccd1 vssd1 sky130_fd_sc_hd__tapvpwrvgnd_1$1
XFILLER_30_641 vssd1 vccd1 vccd1 vssd1 sky130_fd_sc_hd__fill_2$1
Xinput31 hold73/A hold72/X vssd1 vccd1 vccd1 vssd1 sky130_fd_sc_hd__clkbuf_8$1
Xinput20 hold78/A hold77/X vssd1 vccd1 vccd1 vssd1 sky130_fd_sc_hd__clkbuf_8$1
X_0814_ _1819_/A _0878_/A2 _0814_/X _1851_/A _0881_/B1 vccd1 vssd1 vccd1 vssd1 sky130_fd_sc_hd__a22o_1$1
Xinput42 hold71/A hold70/X vssd1 vccd1 vccd1 vssd1 sky130_fd_sc_hd__clkbuf_8$1
Xinput53 wbs_we_i _0947_/D vssd1 vccd1 vccd1 vssd1 sky130_fd_sc_hd__clkbuf_2$1
X_1794_ vccd1 vssd1 _1794_/X _1794_/A vccd1 vssd1 sky130_fd_sc_hd__buf_1$1
X_0745_ hold17/X hold8/X hold24/X hold5/X _1345_/A vssd1 vccd1 vccd1 vssd1 sky130_fd_sc_hd__nor4b_4$1
XFILLER_116_757 vssd1 vccd1 vccd1 vssd1 sky130_ef_sc_hd__decap_40_12$1
XFILLER_115_223 vccd1 vssd1 vccd1 vssd1 sky130_fd_sc_hd__fill_1$1
XFILLER_89_608 vssd1 vccd1 vccd1 vssd1 sky130_fd_sc_hd__fill_8$1
XFILLER_131_727 vccd1 vssd1 vccd1 vssd1 sky130_fd_sc_hd__fill_1$1
XFILLER_97_641 vssd1 vccd1 vccd1 vssd1 sky130_ef_sc_hd__decap_40_12$1
XFILLER_57_505 vssd1 vccd1 vccd1 vssd1 sky130_ef_sc_hd__decap_40_12$1
XFILLER_123_39 vssd1 vccd1 vccd1 vssd1 sky130_ef_sc_hd__decap_40_12$1
XFILLER_96_195 vccd1 vssd1 vccd1 vssd1 sky130_fd_sc_hd__fill_1$1
Xclkbuf_2_2__f_wb_clk_i clkbuf_leaf_9_wb_clk_i/A clkbuf_0_wb_clk_i/X vssd1 vccd1 vccd1
+ vssd1 sky130_fd_sc_hd__clkbuf_16$1
XFILLER_84_357 vssd1 vccd1 vccd1 vssd1 sky130_fd_sc_hd__fill_4$1
X_1228_ _1644_/Q _1228_/X _1270_/B vssd1 vccd1 vccd1 vssd1 sky130_fd_sc_hd__or2_1$1
XFILLER_16_15 vssd1 vccd1 vccd1 vssd1 sky130_ef_sc_hd__decap_40_12$1
XFILLER_37_273 vssd1 vccd1 vccd1 vssd1 sky130_fd_sc_hd__fill_4$1
XFILLER_52_221 vssd1 vccd1 vccd1 vssd1 sky130_ef_sc_hd__decap_40_12$1
X_1159_ _1289_/C1 _1158_/X _1189_/A2 hold30/X _1610_/D vssd1 vccd1 vccd1 vssd1 sky130_fd_sc_hd__o211a_1$1
XFILLER_53_777 vssd1 vccd1 vccd1 vssd1 sky130_fd_sc_hd__fill_4$1
XFILLER_52_265 vssd1 vccd1 vccd1 vssd1 sky130_ef_sc_hd__decap_40_12$1
XTAP_TAPCELL_ROW_23_647 vccd1 vssd1 sky130_fd_sc_hd__tapvpwrvgnd_1$1
XFILLER_21_641 vssd1 vccd1 vccd1 vssd1 sky130_ef_sc_hd__decap_40_12$1
XFILLER_138_337 vssd1 vccd1 vccd1 vssd1 sky130_fd_sc_hd__fill_2$1
XFILLER_21_685 vssd1 vccd1 vccd1 vssd1 sky130_ef_sc_hd__decap_40_12$1
XFILLER_119_573 vssd1 vccd1 vccd1 vssd1 sky130_ef_sc_hd__decap_40_12$1
XFILLER_20_195 vccd1 vssd1 vccd1 vssd1 sky130_fd_sc_hd__fill_1$1
XFILLER_106_245 vssd1 vccd1 vccd1 vssd1 sky130_fd_sc_hd__fill_4$1
XFILLER_134_576 vssd1 vccd1 vccd1 vssd1 sky130_ef_sc_hd__decap_40_12$1
XFILLER_122_749 vssd1 vccd1 vccd1 vssd1 sky130_fd_sc_hd__fill_4$1
XFILLER_106_289 vssd1 vccd1 vccd1 vssd1 sky130_ef_sc_hd__decap_40_12$1
XFILLER_121_237 vssd1 vccd1 vccd1 vssd1 sky130_ef_sc_hd__decap_40_12$1
XFILLER_0_545 vssd1 vccd1 vccd1 vssd1 sky130_fd_sc_hd__fill_8$1
XTAP_TAPCELL_ROW_128_2218 vccd1 vssd1 sky130_fd_sc_hd__tapvpwrvgnd_1$1
XFILLER_76_803 vccd1 vssd1 vccd1 vssd1 sky130_fd_sc_hd__fill_1$1
XFILLER_0_589 vssd1 vccd1 vccd1 vssd1 sky130_ef_sc_hd__decap_40_12$1
XFILLER_75_335 vccd1 vssd1 vccd1 vssd1 sky130_fd_sc_hd__fill_1$1
XFILLER_57_55 vccd1 vssd1 vccd1 vssd1 sky130_fd_sc_hd__fill_1$1
XTAP_TAPCELL_ROW_50_1048 vccd1 vssd1 sky130_fd_sc_hd__tapvpwrvgnd_1$1
XFILLER_90_305 vssd1 vccd1 vccd1 vssd1 sky130_fd_sc_hd__fill_2$1
XTAP_TAPCELL_ROW_3_350 vccd1 vssd1 sky130_fd_sc_hd__tapvpwrvgnd_1$1
XFILLER_29_741 vssd1 vccd1 vccd1 vssd1 sky130_ef_sc_hd__decap_40_12$1
XFILLER_56_571 vccd1 vssd1 vccd1 vssd1 sky130_fd_sc_hd__fill_1$1
XFILLER_16_413 vssd1 vccd1 vccd1 vssd1 sky130_fd_sc_hd__fill_4$1
XFILLER_28_251 vccd1 vssd1 vccd1 vssd1 sky130_fd_sc_hd__fill_1$1
XFILLER_29_785 vssd1 vccd1 vccd1 vssd1 sky130_fd_sc_hd__fill_8$1
XFILLER_16_457 vssd1 vccd1 vccd1 vssd1 sky130_ef_sc_hd__decap_40_12$1
XFILLER_43_221 vssd1 vccd1 vccd1 vssd1 sky130_fd_sc_hd__fill_2$1
XFILLER_31_405 vssd1 vccd1 vccd1 vssd1 sky130_ef_sc_hd__decap_40_12$1
XTAP_TAPCELL_ROW_42_923 vccd1 vssd1 sky130_fd_sc_hd__tapvpwrvgnd_1$1
XTAP_TAPCELL_ROW_65_1280 vccd1 vssd1 sky130_fd_sc_hd__tapvpwrvgnd_1$1
XFILLER_31_449 vssd1 vccd1 vccd1 vssd1 sky130_ef_sc_hd__decap_40_12$1
XTAP_TAPCELL_ROW_42_934 vccd1 vssd1 sky130_fd_sc_hd__tapvpwrvgnd_1$1
XFILLER_8_601 vssd1 vccd1 vccd1 vssd1 sky130_ef_sc_hd__decap_40_12$1
XFILLER_12_641 vssd1 vccd1 vccd1 vssd1 sky130_fd_sc_hd__fill_2$1
XFILLER_129_337 vssd1 vccd1 vccd1 vssd1 sky130_ef_sc_hd__decap_40_12$1
XFILLER_8_645 vssd1 vccd1 vccd1 vssd1 sky130_ef_sc_hd__decap_40_12$1
XFILLER_7_111 vccd1 vssd1 vccd1 vssd1 sky130_fd_sc_hd__fill_1$1
XFILLER_113_727 vccd1 vssd1 vccd1 vssd1 sky130_fd_sc_hd__fill_1$1
XFILLER_3_361 vssd1 vccd1 vccd1 vssd1 sky130_ef_sc_hd__decap_40_12$1
XFILLER_79_641 vssd1 vccd1 vccd1 vssd1 sky130_ef_sc_hd__decap_40_12$1
XFILLER_79_685 vssd1 vccd1 vccd1 vssd1 sky130_fd_sc_hd__fill_2$1
XFILLER_39_505 vssd1 vccd1 vccd1 vssd1 sky130_ef_sc_hd__decap_40_12$1
XFILLER_78_195 vccd1 vssd1 vccd1 vssd1 sky130_fd_sc_hd__fill_1$1
XFILLER_81_305 vssd1 vccd1 vccd1 vssd1 sky130_ef_sc_hd__decap_40_12$1
XFILLER_66_357 vssd1 vccd1 vccd1 vssd1 sky130_fd_sc_hd__fill_4$1
XTAP_TAPCELL_ROW_1_309 vccd1 vssd1 sky130_fd_sc_hd__tapvpwrvgnd_1$1
X_1013_ _1409_/C1 _1012_/X _1013_/A2 hold2/X _1540_/D vssd1 vccd1 vccd1 vssd1 sky130_fd_sc_hd__o211a_1$1
XFILLER_94_699 vccd1 vssd1 vccd1 vssd1 sky130_fd_sc_hd__fill_1$1
XFILLER_93_165 vssd1 vccd1 vccd1 vssd1 sky130_fd_sc_hd__fill_2$1
XFILLER_19_273 vssd1 vccd1 vccd1 vssd1 sky130_fd_sc_hd__fill_4$1
XFILLER_35_700 vccd1 vssd1 vccd1 vssd1 sky130_fd_sc_hd__fill_1$1
XFILLER_81_349 vssd1 vccd1 vccd1 vssd1 sky130_ef_sc_hd__decap_40_12$1
XFILLER_34_221 vssd1 vccd1 vccd1 vssd1 sky130_ef_sc_hd__decap_40_12$1
XTAP_TAPCELL_ROW_81_1509 vccd1 vssd1 sky130_fd_sc_hd__tapvpwrvgnd_1$1
XFILLER_34_265 vssd1 vccd1 vccd1 vssd1 sky130_ef_sc_hd__decap_40_12$1
XTAP_TAPCELL_ROW_20_606 vccd1 vssd1 sky130_fd_sc_hd__tapvpwrvgnd_1$1
X_1846_ vccd1 vssd1 _1846_/X _1846_/A vccd1 vssd1 sky130_fd_sc_hd__buf_1$1
XTAP_TAPCELL_ROW_96_1741 vccd1 vssd1 sky130_fd_sc_hd__tapvpwrvgnd_1$1
X_1777_ _1777_/A _1777_/X vssd1 vccd1 vccd1 vssd1 sky130_fd_sc_hd__clkbuf_2$1
XFILLER_104_705 vccd1 vssd1 vccd1 vssd1 sky130_fd_sc_hd__fill_1$1
XFILLER_131_502 vssd1 vccd1 vccd1 vssd1 sky130_fd_sc_hd__fill_2$1
XFILLER_116_587 vccd1 vssd1 vccd1 vssd1 sky130_fd_sc_hd__fill_1$1
XPHY_EDGE_ROW_4_Right_4 vccd1 vssd1 vccd1 vssd1 sky130_fd_sc_hd__decap_3$1
XFILLER_131_557 vssd1 vccd1 vccd1 vssd1 sky130_fd_sc_hd__fill_2$1
XFILLER_103_237 vssd1 vccd1 vccd1 vssd1 sky130_ef_sc_hd__decap_40_12$1
XFILLER_89_449 vssd1 vccd1 vccd1 vssd1 sky130_ef_sc_hd__decap_40_12$1
XFILLER_134_27 vccd1 vssd1 vccd1 vssd1 sky130_fd_sc_hd__fill_1$1
XFILLER_58_825 vccd1 vssd1 vccd1 vssd1 sky130_fd_sc_hd__fill_1$1
XFILLER_111_281 vssd1 vccd1 vccd1 vssd1 sky130_ef_sc_hd__decap_40_12$1
XFILLER_84_121 vssd1 vccd1 vccd1 vssd1 sky130_ef_sc_hd__decap_40_12$1
XFILLER_57_335 vccd1 vssd1 vccd1 vssd1 sky130_fd_sc_hd__fill_1$1
XFILLER_84_165 vssd1 vccd1 vccd1 vssd1 sky130_ef_sc_hd__decap_40_12$1
XFILLER_72_305 vssd1 vccd1 vccd1 vssd1 sky130_fd_sc_hd__fill_2$1
XFILLER_27_69 vssd1 vccd1 vccd1 vssd1 sky130_ef_sc_hd__decap_40_12$1
XFILLER_26_722 vssd1 vccd1 vccd1 vssd1 sky130_ef_sc_hd__decap_40_12$1
XTAP_TAPCELL_ROW_28_717 vccd1 vssd1 sky130_fd_sc_hd__tapvpwrvgnd_1$1
XTAP_TAPCELL_ROW_123_2148 vccd1 vssd1 sky130_fd_sc_hd__tapvpwrvgnd_1$1
XFILLER_25_221 vssd1 vccd1 vccd1 vssd1 sky130_fd_sc_hd__fill_2$1
XFILLER_13_405 vssd1 vccd1 vccd1 vssd1 sky130_ef_sc_hd__decap_40_12$1
XTAP_TAPCELL_ROW_105_1881 vccd1 vssd1 sky130_fd_sc_hd__tapvpwrvgnd_1$1
XTAP_TAPCELL_ROW_105_1870 vccd1 vssd1 sky130_fd_sc_hd__tapvpwrvgnd_1$1
XFILLER_13_449 vssd1 vccd1 vccd1 vssd1 sky130_ef_sc_hd__decap_40_12$1
XFILLER_41_736 vssd1 vccd1 vccd1 vssd1 sky130_ef_sc_hd__decap_40_12$1
XFILLER_43_57 vssd1 vccd1 vccd1 vssd1 sky130_ef_sc_hd__decap_40_12$1
XFILLER_138_134 vssd1 vccd1 vccd1 vssd1 sky130_fd_sc_hd__fill_4$1
XTAP_TAPCELL_ROW_138_2391 vccd1 vssd1 sky130_fd_sc_hd__tapvpwrvgnd_1$1
XTAP_TAPCELL_ROW_138_2380 vccd1 vssd1 sky130_fd_sc_hd__tapvpwrvgnd_1$1
XFILLER_138_145 vssd1 vccd1 vccd1 vssd1 sky130_fd_sc_hd__fill_2$1
XFILLER_127_819 vssd1 vccd1 vccd1 vssd1 sky130_fd_sc_hd__fill_4$1
XFILLER_126_307 vccd1 vssd1 vccd1 vssd1 sky130_fd_sc_hd__fill_1$1
XFILLER_111_3 vssd1 vccd1 vccd1 vssd1 sky130_ef_sc_hd__decap_40_12$1
XFILLER_5_615 vccd1 vssd1 vccd1 vssd1 sky130_fd_sc_hd__fill_1$1
XFILLER_135_841 vccd1 vssd1 vccd1 vssd1 sky130_fd_sc_hd__fill_1$1
XFILLER_107_576 vccd1 vssd1 vccd1 vssd1 sky130_fd_sc_hd__fill_1$1
XTAP_TAPCELL_ROW_8_420 vccd1 vssd1 sky130_fd_sc_hd__tapvpwrvgnd_1$1
XFILLER_4_29 vssd1 vccd1 vccd1 vssd1 sky130_ef_sc_hd__decap_40_12$1
XFILLER_108_83 vccd1 vssd1 vccd1 vssd1 sky130_fd_sc_hd__fill_1$1
XFILLER_1_821 vssd1 vccd1 vccd1 vssd1 sky130_ef_sc_hd__decap_40_12$1
XFILLER_68_65 vssd1 vccd1 vccd1 vssd1 sky130_ef_sc_hd__decap_40_12$1
XFILLER_103_782 vssd1 vccd1 vccd1 vssd1 sky130_fd_sc_hd__fill_2$1
XFILLER_64_817 vssd1 vccd1 vccd1 vssd1 sky130_fd_sc_hd__fill_2$1
XFILLER_48_357 vssd1 vccd1 vccd1 vssd1 sky130_fd_sc_hd__fill_4$1
XFILLER_91_614 vssd1 vccd1 vccd1 vssd1 sky130_fd_sc_hd__fill_2$1
XFILLER_84_53 vssd1 vccd1 vccd1 vssd1 sky130_ef_sc_hd__decap_40_12$1
XFILLER_76_699 vccd1 vssd1 vccd1 vssd1 sky130_fd_sc_hd__fill_1$1
XFILLER_75_165 vssd1 vccd1 vccd1 vssd1 sky130_fd_sc_hd__fill_2$1
XFILLER_63_305 vssd1 vccd1 vccd1 vssd1 sky130_ef_sc_hd__decap_40_12$1
XFILLER_91_669 vssd1 vccd1 vccd1 vssd1 sky130_fd_sc_hd__fill_2$1
XFILLER_84_97 vssd1 vccd1 vccd1 vssd1 sky130_ef_sc_hd__decap_40_12$1
XFILLER_63_349 vssd1 vccd1 vccd1 vssd1 sky130_ef_sc_hd__decap_40_12$1
XFILLER_56_390 vccd1 vssd1 vccd1 vssd1 sky130_fd_sc_hd__fill_1$1
XFILLER_16_221 vssd1 vccd1 vccd1 vssd1 sky130_ef_sc_hd__decap_40_12$1
XFILLER_16_265 vssd1 vccd1 vccd1 vssd1 sky130_ef_sc_hd__decap_40_12$1
XFILLER_17_777 vssd1 vccd1 vccd1 vssd1 sky130_fd_sc_hd__fill_4$1
XFILLER_71_393 vssd1 vccd1 vccd1 vssd1 sky130_fd_sc_hd__fill_2$1
XTAP_TAPCELL_ROW_63_1239 vccd1 vssd1 sky130_fd_sc_hd__tapvpwrvgnd_1$1
XFILLER_32_736 vssd1 vccd1 vccd1 vssd1 sky130_fd_sc_hd__fill_2$1
XFILLER_44_585 vssd1 vccd1 vccd1 vssd1 sky130_fd_sc_hd__fill_2$1
XFILLER_32_769 vssd1 vccd1 vccd1 vssd1 sky130_ef_sc_hd__decap_40_12$1
XFILLER_31_279 vccd1 vssd1 vccd1 vssd1 sky130_fd_sc_hd__fill_1$1
XFILLER_129_167 vccd1 vssd1 vccd1 vssd1 sky130_fd_sc_hd__fill_1$1
X_1700_ _1700_/Q _1764_/CLK hold19/X vccd1 vssd1 vccd1 vssd1 sky130_fd_sc_hd__dfxtp_1$1
X_1631_ _1631_/Q _1726_/CLK _1631_/D vccd1 vssd1 vccd1 vssd1 sky130_fd_sc_hd__dfxtp_1$1
XFILLER_117_329 vssd1 vccd1 vccd1 vssd1 sky130_fd_sc_hd__fill_4$1
XFILLER_8_475 vccd1 vssd1 vccd1 vssd1 sky130_fd_sc_hd__fill_1$1
XFILLER_126_841 vccd1 vssd1 vccd1 vssd1 sky130_fd_sc_hd__fill_1$1
XTAP_TAPCELL_ROW_78_1471 vccd1 vssd1 sky130_fd_sc_hd__tapvpwrvgnd_1$1
XFILLER_125_373 vssd1 vccd1 vccd1 vssd1 sky130_ef_sc_hd__decap_40_12$1
XFILLER_99_725 vssd1 vccd1 vccd1 vssd1 sky130_fd_sc_hd__fill_2$1
X_1562_ _1562_/Q _1754_/CLK _1562_/D vccd1 vssd1 vccd1 vssd1 sky130_fd_sc_hd__dfxtp_1$1
X_1493_ _1493_/Q _1717_/CLK _1493_/D vccd1 vssd1 vccd1 vssd1 sky130_fd_sc_hd__dfxtp_1$1
XFILLER_113_557 vssd1 vccd1 vccd1 vssd1 sky130_fd_sc_hd__fill_2$1
XFILLER_4_681 vssd1 vccd1 vccd1 vssd1 sky130_ef_sc_hd__decap_40_12$1
XFILLER_101_719 vssd1 vccd1 vccd1 vssd1 sky130_fd_sc_hd__fill_8$1
XTAP_TAPCELL_ROW_91_1671 vccd1 vssd1 sky130_fd_sc_hd__tapvpwrvgnd_1$1
XTAP_TAPCELL_ROW_91_1660 vccd1 vssd1 sky130_fd_sc_hd__tapvpwrvgnd_1$1
XFILLER_79_460 vssd1 vccd1 vccd1 vssd1 sky130_ef_sc_hd__decap_40_12$1
XFILLER_67_633 vssd1 vccd1 vccd1 vssd1 sky130_ef_sc_hd__decap_40_12$1
XFILLER_39_335 vccd1 vssd1 vccd1 vssd1 sky130_fd_sc_hd__fill_1$1
XFILLER_94_463 vssd1 vccd1 vccd1 vssd1 sky130_ef_sc_hd__decap_40_12$1
XFILLER_94_430 vssd1 vccd1 vccd1 vssd1 sky130_fd_sc_hd__fill_4$1
XFILLER_66_121 vssd1 vccd1 vccd1 vssd1 sky130_ef_sc_hd__decap_40_12$1
XFILLER_94_485 vssd1 vccd1 vccd1 vssd1 sky130_fd_sc_hd__fill_2$1
XFILLER_81_113 vssd1 vccd1 vccd1 vssd1 sky130_ef_sc_hd__decap_40_12$1
XFILLER_66_165 vssd1 vccd1 vccd1 vssd1 sky130_ef_sc_hd__decap_40_12$1
XFILLER_54_305 vssd1 vccd1 vccd1 vssd1 sky130_fd_sc_hd__fill_2$1
XFILLER_70_809 vssd1 vccd1 vccd1 vssd1 sky130_fd_sc_hd__fill_2$1
XFILLER_35_541 vssd1 vccd1 vccd1 vssd1 sky130_ef_sc_hd__decap_40_12$1
XFILLER_120_29 vssd1 vccd1 vccd1 vssd1 sky130_ef_sc_hd__decap_40_12$1
XFILLER_90_680 vssd1 vccd1 vccd1 vssd1 sky130_fd_sc_hd__fill_8$1
XFILLER_50_533 vssd1 vccd1 vccd1 vssd1 sky130_ef_sc_hd__decap_40_12$1
XFILLER_23_725 vssd1 vccd1 vccd1 vssd1 sky130_fd_sc_hd__fill_2$1
XFILLER_35_585 vssd1 vccd1 vccd1 vssd1 sky130_ef_sc_hd__decap_40_12$1
XFILLER_10_419 vccd1 vssd1 vccd1 vssd1 sky130_fd_sc_hd__fill_1$1
XFILLER_13_27 vssd1 vccd1 vccd1 vssd1 sky130_ef_sc_hd__decap_40_12$1
XTAP_TAPCELL_ROW_33_797 vccd1 vssd1 sky130_fd_sc_hd__tapvpwrvgnd_1$1
XFILLER_129_27 vssd1 vccd1 vccd1 vssd1 sky130_ef_sc_hd__decap_40_12$1
XFILLER_108_307 vccd1 vssd1 vccd1 vssd1 sky130_fd_sc_hd__fill_1$1
XFILLER_136_649 vccd1 vssd1 vccd1 vssd1 sky130_fd_sc_hd__fill_1$1
XFILLER_135_137 vssd1 vccd1 vccd1 vssd1 sky130_ef_sc_hd__decap_40_12$1
XFILLER_117_841 vccd1 vssd1 vccd1 vssd1 sky130_fd_sc_hd__fill_1$1
X_1829_ _1829_/A _1829_/X vssd1 vccd1 vccd1 vssd1 sky130_fd_sc_hd__clkbuf_2$1
XFILLER_104_557 vssd1 vccd1 vccd1 vssd1 sky130_ef_sc_hd__decap_40_12$1
XFILLER_89_279 vccd1 vssd1 vccd1 vssd1 sky130_fd_sc_hd__fill_1$1
XTAP_TAPCELL_ROW_107_1910 vccd1 vssd1 sky130_fd_sc_hd__tapvpwrvgnd_1$1
XPHY_EDGE_ROW_79_Right_79 vccd1 vssd1 vccd1 vssd1 sky130_fd_sc_hd__decap_3$1
XFILLER_58_699 vccd1 vssd1 vccd1 vssd1 sky130_fd_sc_hd__fill_1$1
XFILLER_57_165 vssd1 vccd1 vccd1 vssd1 sky130_fd_sc_hd__fill_2$1
XFILLER_45_305 vssd1 vccd1 vccd1 vssd1 sky130_ef_sc_hd__decap_40_12$1
XFILLER_73_669 vssd1 vccd1 vccd1 vssd1 sky130_fd_sc_hd__fill_2$1
XFILLER_61_809 vssd1 vccd1 vccd1 vssd1 sky130_ef_sc_hd__decap_40_12$1
XFILLER_45_349 vssd1 vccd1 vccd1 vssd1 sky130_ef_sc_hd__decap_40_12$1
XFILLER_53_393 vssd1 vccd1 vccd1 vssd1 sky130_ef_sc_hd__decap_40_12$1
XFILLER_14_725 vssd1 vccd1 vccd1 vssd1 sky130_ef_sc_hd__decap_40_12$1
XFILLER_26_585 vssd1 vccd1 vccd1 vssd1 sky130_fd_sc_hd__fill_2$1
XFILLER_14_769 vssd1 vccd1 vccd1 vssd1 sky130_ef_sc_hd__decap_40_12$1
XFILLER_9_217 vssd1 vccd1 vccd1 vssd1 sky130_fd_sc_hd__fill_4$1
XFILLER_13_279 vccd1 vssd1 vccd1 vssd1 sky130_fd_sc_hd__fill_1$1
XTAP_TAPCELL_ROW_136_2339 vccd1 vssd1 sky130_fd_sc_hd__tapvpwrvgnd_1$1
XFILLER_70_77 vssd1 vccd1 vccd1 vssd1 sky130_fd_sc_hd__fill_4$1
XPHY_EDGE_ROW_88_Right_88 vccd1 vssd1 vccd1 vssd1 sky130_fd_sc_hd__decap_3$1
XTAP_TAPCELL_ROW_11_469 vccd1 vssd1 sky130_fd_sc_hd__tapvpwrvgnd_1$1
XTAP_TAPCELL_ROW_11_458 vccd1 vssd1 sky130_fd_sc_hd__tapvpwrvgnd_1$1
XFILLER_126_137 vssd1 vccd1 vccd1 vssd1 sky130_fd_sc_hd__fill_2$1
XFILLER_5_445 vssd1 vccd1 vccd1 vssd1 sky130_fd_sc_hd__fill_2$1
XFILLER_119_93 vssd1 vccd1 vccd1 vssd1 sky130_ef_sc_hd__decap_40_12$1
XFILLER_107_373 vssd1 vccd1 vccd1 vssd1 sky130_ef_sc_hd__decap_40_12$1
XFILLER_122_321 vssd1 vccd1 vccd1 vssd1 sky130_ef_sc_hd__decap_40_12$1
XFILLER_122_365 vssd1 vccd1 vccd1 vssd1 sky130_fd_sc_hd__fill_8$1
XFILLER_95_205 vssd1 vccd1 vccd1 vssd1 sky130_ef_sc_hd__decap_40_12$1
XFILLER_68_419 vccd1 vssd1 vccd1 vssd1 sky130_fd_sc_hd__fill_1$1
XFILLER_135_81 vssd1 vccd1 vccd1 vssd1 sky130_ef_sc_hd__decap_40_12$1
XTAP_TAPCELL_ROW_73_1390 vccd1 vssd1 sky130_fd_sc_hd__tapvpwrvgnd_1$1
XFILLER_1_673 vssd1 vccd1 vccd1 vssd1 sky130_ef_sc_hd__decap_40_12$1
XPHY_EDGE_ROW_97_Right_97 vccd1 vssd1 vccd1 vssd1 sky130_fd_sc_hd__decap_3$1
XFILLER_95_249 vssd1 vccd1 vccd1 vssd1 sky130_ef_sc_hd__decap_40_12$1
XFILLER_76_441 vssd1 vccd1 vccd1 vssd1 sky130_fd_sc_hd__fill_2$1
XFILLER_48_121 vssd1 vccd1 vccd1 vssd1 sky130_ef_sc_hd__decap_40_12$1
XFILLER_49_699 vccd1 vssd1 vccd1 vssd1 sky130_fd_sc_hd__fill_1$1
XFILLER_36_305 vssd1 vccd1 vccd1 vssd1 sky130_fd_sc_hd__fill_2$1
XFILLER_48_165 vssd1 vccd1 vccd1 vssd1 sky130_ef_sc_hd__decap_40_12$1
XFILLER_64_658 vssd1 vccd1 vccd1 vssd1 sky130_ef_sc_hd__decap_40_12$1
XFILLER_63_113 vssd1 vccd1 vccd1 vssd1 sky130_ef_sc_hd__decap_40_12$1
XFILLER_52_809 vssd1 vccd1 vccd1 vssd1 sky130_fd_sc_hd__fill_2$1
XFILLER_17_541 vssd1 vccd1 vccd1 vssd1 sky130_ef_sc_hd__decap_40_12$1
XFILLER_17_585 vssd1 vccd1 vccd1 vssd1 sky130_ef_sc_hd__decap_40_12$1
XFILLER_32_533 vssd1 vccd1 vccd1 vssd1 sky130_ef_sc_hd__decap_40_12$1
X_0993_ _1455_/C1 _0992_/X _1013_/A2 hold107/X _1530_/D vssd1 vccd1 vccd1 vssd1 sky130_fd_sc_hd__o211a_1$1
XPHY_EDGE_ROW_4_Left_143 vccd1 vssd1 vccd1 vssd1 sky130_fd_sc_hd__decap_3$1
XFILLER_74_3 vssd1 vccd1 vccd1 vssd1 sky130_ef_sc_hd__decap_40_12$1
XTAP_TAPCELL_ROW_30_745 vccd1 vssd1 sky130_fd_sc_hd__tapvpwrvgnd_1$1
XTAP_TAPCELL_ROW_30_756 vccd1 vssd1 sky130_fd_sc_hd__tapvpwrvgnd_1$1
XFILLER_117_137 vssd1 vccd1 vccd1 vssd1 sky130_ef_sc_hd__decap_40_12$1
XTAP_TAPCELL_ROW_93_1700 vccd1 vssd1 sky130_fd_sc_hd__tapvpwrvgnd_1$1
XFILLER_126_671 vccd1 vssd1 vccd1 vssd1 sky130_fd_sc_hd__fill_1$1
XFILLER_114_811 vccd1 vssd1 vccd1 vssd1 sky130_fd_sc_hd__fill_1$1
X_1614_ _1818_/A _1742_/CLK _1614_/D vccd1 vssd1 vccd1 vssd1 sky130_fd_sc_hd__dfxtp_1$1
XFILLER_125_181 vssd1 vccd1 vccd1 vssd1 sky130_ef_sc_hd__decap_40_12$1
X_1545_ _1776_/A _1575_/CLK _1545_/D vccd1 vssd1 vccd1 vssd1 sky130_fd_sc_hd__dfxtp_1$1
Xfanout229 _1078_/B _1052_/B vssd1 vccd1 vccd1 vssd1 sky130_fd_sc_hd__clkbuf_8$1
Xfanout207 _1409_/A2 vccd1 vssd1 _1399_/A2 vccd1 vssd1 sky130_fd_sc_hd__buf_6$1
Xfanout218 _1276_/B vccd1 vssd1 _1272_/B vccd1 vssd1 sky130_fd_sc_hd__buf_4$1
XFILLER_101_505 vssd1 vccd1 vccd1 vssd1 sky130_ef_sc_hd__decap_40_12$1
X_1476_ _1476_/Q _1717_/CLK _1476_/D vccd1 vssd1 vccd1 vssd1 sky130_fd_sc_hd__dfxtp_2$1
XFILLER_86_249 vssd1 vccd1 vccd1 vssd1 sky130_fd_sc_hd__fill_2$1
XFILLER_95_783 vccd1 vssd1 vccd1 vssd1 sky130_fd_sc_hd__fill_1$1
XFILLER_67_485 vssd1 vccd1 vccd1 vssd1 sky130_ef_sc_hd__decap_40_12$1
XFILLER_27_305 vssd1 vccd1 vccd1 vssd1 sky130_ef_sc_hd__decap_40_12$1
XFILLER_39_165 vssd1 vccd1 vccd1 vssd1 sky130_fd_sc_hd__fill_2$1
XFILLER_131_39 vssd1 vccd1 vccd1 vssd1 sky130_ef_sc_hd__decap_40_12$1
XFILLER_82_433 vssd1 vccd1 vccd1 vssd1 sky130_ef_sc_hd__decap_40_12$1
XFILLER_55_669 vssd1 vccd1 vccd1 vssd1 sky130_fd_sc_hd__fill_2$1
XFILLER_27_349 vssd1 vccd1 vccd1 vssd1 sky130_ef_sc_hd__decap_40_12$1
XFILLER_43_809 vssd1 vccd1 vccd1 vssd1 sky130_ef_sc_hd__decap_40_12$1
XTAP_TAPCELL_ROW_120_2107 vccd1 vssd1 sky130_fd_sc_hd__tapvpwrvgnd_1$1
XFILLER_82_477 vssd1 vccd1 vccd1 vssd1 sky130_ef_sc_hd__decap_40_12$1
XTAP_TAPCELL_ROW_38_867 vccd1 vssd1 sky130_fd_sc_hd__tapvpwrvgnd_1$1
XFILLER_24_15 vssd1 vccd1 vccd1 vssd1 sky130_ef_sc_hd__decap_40_12$1
XFILLER_35_393 vssd1 vccd1 vccd1 vssd1 sky130_ef_sc_hd__decap_40_12$1
XPHY_EDGE_ROW_59_Left_198 vccd1 vssd1 vccd1 vssd1 sky130_fd_sc_hd__decap_3$1
XFILLER_50_363 vccd1 vssd1 vccd1 vssd1 sky130_fd_sc_hd__fill_1$1
XFILLER_10_249 vssd1 vccd1 vccd1 vssd1 sky130_fd_sc_hd__fill_2$1
XTAP_TAPCELL_ROW_118_2069 vccd1 vssd1 sky130_fd_sc_hd__tapvpwrvgnd_1$1
XFILLER_6_209 vssd1 vccd1 vccd1 vssd1 sky130_ef_sc_hd__decap_40_12$1
XFILLER_124_608 vssd1 vccd1 vccd1 vssd1 sky130_ef_sc_hd__decap_40_12$1
XFILLER_108_137 vssd1 vccd1 vccd1 vssd1 sky130_fd_sc_hd__fill_2$1
XTAP_TAPCELL_ROW_131_2258 vccd1 vssd1 sky130_fd_sc_hd__tapvpwrvgnd_1$1
XFILLER_117_671 vccd1 vssd1 vccd1 vssd1 sky130_fd_sc_hd__fill_1$1
XTAP_TAPCELL_ROW_131_2269 vccd1 vssd1 sky130_fd_sc_hd__tapvpwrvgnd_1$1
XFILLER_104_321 vssd1 vccd1 vccd1 vssd1 sky130_ef_sc_hd__decap_40_12$1
XFILLER_104_365 vssd1 vccd1 vccd1 vssd1 sky130_fd_sc_hd__fill_8$1
XFILLER_78_706 vssd1 vccd1 vccd1 vssd1 sky130_ef_sc_hd__decap_40_12$1
XFILLER_77_205 vssd1 vccd1 vccd1 vssd1 sky130_ef_sc_hd__decap_40_12$1
XTAP_TAPCELL_ROW_113_1991 vccd1 vssd1 sky130_fd_sc_hd__tapvpwrvgnd_1$1
XPHY_EDGE_ROW_130_Right_130 vccd1 vssd1 vccd1 vssd1 sky130_fd_sc_hd__decap_3$1
XFILLER_105_51 vssd1 vccd1 vccd1 vssd1 sky130_fd_sc_hd__fill_4$1
XFILLER_77_249 vssd1 vccd1 vccd1 vssd1 sky130_ef_sc_hd__decap_40_12$1
XFILLER_58_463 vssd1 vccd1 vccd1 vssd1 sky130_ef_sc_hd__decap_40_12$1
XFILLER_18_305 vssd1 vccd1 vccd1 vssd1 sky130_fd_sc_hd__fill_2$1
XFILLER_46_625 vssd1 vccd1 vccd1 vssd1 sky130_ef_sc_hd__decap_40_12$1
XFILLER_85_293 vssd1 vccd1 vccd1 vssd1 sky130_ef_sc_hd__decap_40_12$1
XFILLER_65_55 vccd1 vssd1 vccd1 vssd1 sky130_fd_sc_hd__fill_1$1
XFILLER_45_113 vssd1 vccd1 vccd1 vssd1 sky130_ef_sc_hd__decap_40_12$1
XFILLER_61_617 vssd1 vccd1 vccd1 vssd1 sky130_ef_sc_hd__decap_40_12$1
XFILLER_46_669 vssd1 vccd1 vccd1 vssd1 sky130_ef_sc_hd__decap_40_12$1
XTAP_TAPCELL_ROW_47_1009 vccd1 vssd1 sky130_fd_sc_hd__tapvpwrvgnd_1$1
XTAP_TAPCELL_ROW_16_539 vccd1 vssd1 sky130_fd_sc_hd__tapvpwrvgnd_1$1
XFILLER_14_533 vssd1 vccd1 vccd1 vssd1 sky130_ef_sc_hd__decap_40_12$1
XFILLER_41_385 vssd1 vccd1 vccd1 vssd1 sky130_fd_sc_hd__fill_4$1
XFILLER_14_81 vssd1 vccd1 vccd1 vssd1 sky130_fd_sc_hd__fill_2$1
XFILLER_107_181 vssd1 vccd1 vccd1 vssd1 sky130_ef_sc_hd__decap_40_12$1
XTAP_TAPCELL_ROW_75_1430 vccd1 vssd1 sky130_fd_sc_hd__tapvpwrvgnd_1$1
X_1330_ _1330_/A _1330_/X _1330_/B vssd1 vccd1 vccd1 vssd1 sky130_fd_sc_hd__or2_1$1
XFILLER_123_685 vssd1 vccd1 vccd1 vssd1 sky130_ef_sc_hd__decap_40_12$1
XFILLER_111_836 vccd1 vssd1 vccd1 vssd1 sky130_fd_sc_hd__fill_1$1
XFILLER_96_514 vssd1 vccd1 vccd1 vssd1 sky130_fd_sc_hd__fill_8$1
XFILLER_122_195 vccd1 vssd1 vccd1 vssd1 sky130_fd_sc_hd__fill_1$1
XFILLER_110_357 vssd1 vccd1 vccd1 vssd1 sky130_fd_sc_hd__fill_4$1
X_1261_ _1463_/C1 _1260_/X _1277_/A2 hold14/X _1660_/D vssd1 vccd1 vccd1 vssd1 sky130_fd_sc_hd__o211a_1$1
XFILLER_68_249 vssd1 vccd1 vccd1 vssd1 sky130_fd_sc_hd__fill_2$1
XFILLER_49_441 vssd1 vccd1 vccd1 vssd1 sky130_fd_sc_hd__fill_4$1
X_1192_ hold62/X _1192_/X _1210_/B vssd1 vccd1 vccd1 vssd1 sky130_fd_sc_hd__or2_1$1
XFILLER_110_379 vccd1 vssd1 vccd1 vssd1 sky130_fd_sc_hd__fill_1$1
XFILLER_77_783 vccd1 vssd1 vccd1 vssd1 sky130_fd_sc_hd__fill_1$1
XFILLER_49_485 vssd1 vccd1 vccd1 vssd1 sky130_fd_sc_hd__fill_2$1
Xinput7 adc_data[4] input7/X vssd1 vccd1 vccd1 vssd1 sky130_fd_sc_hd__clkbuf_2$1
XFILLER_64_477 vssd1 vccd1 vccd1 vssd1 sky130_ef_sc_hd__decap_40_12$1
XFILLER_37_669 vssd1 vccd1 vccd1 vssd1 sky130_fd_sc_hd__fill_2$1
XTAP_TAPCELL_ROW_86_1592 vccd1 vssd1 sky130_fd_sc_hd__tapvpwrvgnd_1$1
XFILLER_52_639 vssd1 vccd1 vccd1 vssd1 sky130_fd_sc_hd__fill_4$1
XFILLER_51_105 vssd1 vccd1 vccd1 vssd1 sky130_fd_sc_hd__fill_4$1
XTAP_TAPCELL_ROW_35_826 vccd1 vssd1 sky130_fd_sc_hd__tapvpwrvgnd_1$1
XFILLER_51_149 vssd1 vccd1 vccd1 vssd1 sky130_ef_sc_hd__decap_40_12$1
XFILLER_17_393 vssd1 vccd1 vccd1 vssd1 sky130_ef_sc_hd__decap_40_12$1
XFILLER_32_363 vccd1 vssd1 vccd1 vssd1 sky130_fd_sc_hd__fill_1$1
XFILLER_20_525 vssd1 vccd1 vccd1 vssd1 sky130_fd_sc_hd__fill_4$1
XFILLER_118_413 vssd1 vccd1 vccd1 vssd1 sky130_fd_sc_hd__fill_2$1
X_0976_ hold28/X _0976_/X _0990_/B vssd1 vccd1 vccd1 vssd1 sky130_fd_sc_hd__or2_1$1
XFILLER_20_569 vssd1 vccd1 vccd1 vssd1 sky130_ef_sc_hd__decap_40_12$1
XFILLER_133_449 vssd1 vccd1 vccd1 vssd1 sky130_fd_sc_hd__fill_4$1
XFILLER_133_438 vssd1 vccd1 vccd1 vssd1 sky130_fd_sc_hd__fill_8$1
XFILLER_87_503 vccd1 vssd1 vccd1 vssd1 sky130_fd_sc_hd__fill_1$1
X_1528_ _1528_/Q _1720_/CLK _1528_/D vccd1 vssd1 vccd1 vssd1 sky130_fd_sc_hd__dfxtp_1$1
XFILLER_87_536 vssd1 vccd1 vccd1 vssd1 sky130_ef_sc_hd__decap_40_12$1
XFILLER_59_205 vssd1 vccd1 vccd1 vssd1 sky130_ef_sc_hd__decap_40_12$1
X_1459_ _0739_/D _1458_/X _1465_/A2 hold14/X _1756_/D vssd1 vccd1 vccd1 vssd1 sky130_fd_sc_hd__o211a_1$1
XFILLER_101_335 vccd1 vssd1 vccd1 vssd1 sky130_fd_sc_hd__fill_1$1
XFILLER_59_249 vssd1 vccd1 vccd1 vssd1 sky130_ef_sc_hd__decap_40_12$1
XFILLER_19_15 vssd1 vccd1 vccd1 vssd1 sky130_ef_sc_hd__decap_40_12$1
XFILLER_28_625 vssd1 vccd1 vccd1 vssd1 sky130_ef_sc_hd__decap_40_12$1
XFILLER_67_293 vssd1 vccd1 vccd1 vssd1 sky130_ef_sc_hd__decap_40_12$1
XFILLER_27_113 vssd1 vccd1 vccd1 vssd1 sky130_ef_sc_hd__decap_40_12$1
XFILLER_16_809 vssd1 vccd1 vccd1 vssd1 sky130_fd_sc_hd__fill_2$1
XFILLER_28_669 vssd1 vccd1 vccd1 vssd1 sky130_ef_sc_hd__decap_40_12$1
XFILLER_43_617 vssd1 vccd1 vccd1 vssd1 sky130_fd_sc_hd__fill_8$1
XPHY_EDGE_ROW_67_Left_206 vccd1 vssd1 vccd1 vssd1 sky130_fd_sc_hd__decap_3$1
XFILLER_70_469 vssd1 vccd1 vccd1 vssd1 sky130_fd_sc_hd__fill_4$1
XFILLER_35_69 vssd1 vccd1 vccd1 vssd1 sky130_ef_sc_hd__decap_40_12$1
XFILLER_11_503 vccd1 vssd1 vccd1 vssd1 sky130_fd_sc_hd__fill_1$1
XFILLER_50_193 vssd1 vccd1 vccd1 vssd1 sky130_fd_sc_hd__fill_2$1
XFILLER_23_385 vssd1 vccd1 vccd1 vssd1 sky130_fd_sc_hd__fill_4$1
XFILLER_51_57 vssd1 vccd1 vccd1 vssd1 sky130_ef_sc_hd__decap_40_12$1
XFILLER_7_529 vssd1 vccd1 vccd1 vssd1 sky130_ef_sc_hd__decap_40_12$1
XFILLER_136_221 vssd1 vccd1 vccd1 vssd1 sky130_ef_sc_hd__decap_40_12$1
XFILLER_109_457 vssd1 vccd1 vccd1 vssd1 sky130_fd_sc_hd__fill_2$1
XFILLER_136_265 vssd1 vccd1 vccd1 vssd1 sky130_ef_sc_hd__decap_40_12$1
XFILLER_117_490 vssd1 vccd1 vccd1 vssd1 sky130_ef_sc_hd__decap_40_12$1
XPHY_EDGE_ROW_76_Left_215 vccd1 vssd1 vccd1 vssd1 sky130_fd_sc_hd__decap_3$1
XFILLER_105_641 vssd1 vccd1 vccd1 vssd1 sky130_ef_sc_hd__decap_40_12$1
XTAP_TAPCELL_ROW_57_1160 vccd1 vssd1 sky130_fd_sc_hd__tapvpwrvgnd_1$1
XFILLER_4_3 vssd1 vccd1 vccd1 vssd1 sky130_ef_sc_hd__decap_40_12$1
XFILLER_2_245 vssd1 vccd1 vccd1 vssd1 sky130_fd_sc_hd__fill_4$1
XFILLER_105_685 vssd1 vccd1 vccd1 vssd1 sky130_ef_sc_hd__decap_40_12$1
XFILLER_78_525 vssd1 vccd1 vccd1 vssd1 sky130_fd_sc_hd__fill_4$1
XFILLER_2_289 vssd1 vccd1 vccd1 vssd1 sky130_ef_sc_hd__decap_40_12$1
XFILLER_120_666 vssd1 vccd1 vccd1 vssd1 sky130_fd_sc_hd__fill_8$1
XFILLER_120_633 vssd1 vccd1 vccd1 vssd1 sky130_fd_sc_hd__fill_8$1
XFILLER_116_83 vccd1 vssd1 vccd1 vssd1 sky130_fd_sc_hd__fill_1$1
XFILLER_104_195 vccd1 vssd1 vccd1 vssd1 sky130_fd_sc_hd__fill_1$1
XFILLER_78_569 vssd1 vccd1 vccd1 vssd1 sky130_ef_sc_hd__decap_40_12$1
XFILLER_120_699 vccd1 vssd1 vccd1 vssd1 sky130_fd_sc_hd__fill_1$1
XFILLER_93_517 vssd1 vccd1 vccd1 vssd1 sky130_fd_sc_hd__fill_2$1
XFILLER_76_65 vssd1 vccd1 vccd1 vssd1 sky130_ef_sc_hd__decap_40_12$1
XFILLER_59_783 vccd1 vssd1 vccd1 vssd1 sky130_fd_sc_hd__fill_1$1
XFILLER_59_761 vssd1 vccd1 vccd1 vssd1 sky130_ef_sc_hd__decap_40_12$1
XFILLER_46_433 vssd1 vccd1 vccd1 vssd1 sky130_ef_sc_hd__decap_40_12$1
XPHY_EDGE_ROW_85_Left_224 vccd1 vssd1 vccd1 vssd1 sky130_fd_sc_hd__decap_3$1
XFILLER_19_669 vssd1 vccd1 vccd1 vssd1 sky130_fd_sc_hd__fill_2$1
XFILLER_46_477 vssd1 vccd1 vccd1 vssd1 sky130_ef_sc_hd__decap_40_12$1
XFILLER_92_53 vssd1 vccd1 vccd1 vssd1 sky130_ef_sc_hd__decap_40_12$1
XFILLER_33_105 vssd1 vccd1 vccd1 vssd1 sky130_fd_sc_hd__fill_4$1
XFILLER_92_97 vssd1 vccd1 vccd1 vssd1 sky130_ef_sc_hd__decap_40_12$1
XFILLER_33_149 vssd1 vccd1 vccd1 vssd1 sky130_ef_sc_hd__decap_40_12$1
XFILLER_14_363 vccd1 vssd1 vccd1 vssd1 sky130_fd_sc_hd__fill_1$1
XFILLER_42_650 vssd1 vccd1 vccd1 vssd1 sky130_ef_sc_hd__decap_40_12$1
XFILLER_41_193 vssd1 vccd1 vccd1 vssd1 sky130_ef_sc_hd__decap_40_12$1
X_0830_ _0879_/B1 _0830_/X _0829_/X _1853_/A _0747_/X _0828_/X vssd1 vccd1 vccd1 vssd1
+ sky130_fd_sc_hd__a2111o_1$1
XFILLER_128_755 vccd1 vssd1 vccd1 vssd1 sky130_fd_sc_hd__fill_1$1
XFILLER_128_766 vssd1 vccd1 vccd1 vssd1 sky130_ef_sc_hd__decap_40_12$1
XFILLER_127_221 vssd1 vccd1 vccd1 vssd1 sky130_fd_sc_hd__fill_2$1
X_0761_ _0761_/X _1279_/A _1825_/A _1838_/A _0878_/B1 vssd1 vccd1 _0760_/X vccd1 vssd1
+ sky130_fd_sc_hd__a221o_1$1
XTAP_TAPCELL_ROW_40_895 vccd1 vssd1 sky130_fd_sc_hd__tapvpwrvgnd_1$1
XFILLER_115_405 vssd1 vccd1 vccd1 vssd1 sky130_ef_sc_hd__decap_40_12$1
XPHY_EDGE_ROW_94_Left_233 vccd1 vssd1 vccd1 vssd1 sky130_fd_sc_hd__decap_3$1
XFILLER_115_449 vssd1 vccd1 vccd1 vssd1 sky130_fd_sc_hd__fill_8$1
XFILLER_97_801 vssd1 vccd1 vccd1 vssd1 sky130_ef_sc_hd__decap_40_12$1
XFILLER_130_419 vccd1 vssd1 vccd1 vssd1 sky130_fd_sc_hd__fill_1$1
XFILLER_97_823 vccd1 vssd1 vccd1 vssd1 sky130_fd_sc_hd__fill_1$1
XFILLER_37_3 vssd1 vccd1 vccd1 vssd1 sky130_ef_sc_hd__decap_40_12$1
X_1313_ _0739_/D _1312_/X _1331_/A2 hold32/X _1685_/D vssd1 vccd1 vccd1 vssd1 sky130_fd_sc_hd__o211a_1$1
XFILLER_110_121 vssd1 vccd1 vccd1 vssd1 sky130_ef_sc_hd__decap_40_12$1
XFILLER_96_333 vssd1 vccd1 vccd1 vssd1 sky130_ef_sc_hd__decap_40_12$1
XFILLER_69_547 vssd1 vccd1 vccd1 vssd1 sky130_ef_sc_hd__decap_40_12$1
XFILLER_57_709 vssd1 vccd1 vccd1 vssd1 sky130_ef_sc_hd__decap_40_12$1
XFILLER_110_165 vssd1 vccd1 vccd1 vssd1 sky130_ef_sc_hd__decap_40_12$1
X_1244_ _1652_/Q _1244_/X _1276_/B vssd1 vccd1 vccd1 vssd1 sky130_fd_sc_hd__or2_1$1
XTAP_TAPCELL_ROW_88_1621 vccd1 vssd1 sky130_fd_sc_hd__tapvpwrvgnd_1$1
Xclkbuf_2_1__f_wb_clk_i clkload1/A clkbuf_0_wb_clk_i/X vssd1 vccd1 vccd1 vssd1 sky130_fd_sc_hd__clkbuf_16$1
XFILLER_49_293 vssd1 vccd1 vccd1 vssd1 sky130_ef_sc_hd__decap_40_12$1
XFILLER_80_701 vssd1 vccd1 vccd1 vssd1 sky130_ef_sc_hd__decap_40_12$1
X_1175_ _1447_/C1 _1174_/X _1189_/A2 hold21/X _1618_/D vssd1 vccd1 vccd1 vssd1 sky130_fd_sc_hd__o211a_1$1
XFILLER_65_753 vssd1 vccd1 vccd1 vssd1 sky130_ef_sc_hd__decap_40_12$1
XFILLER_65_797 vssd1 vccd1 vccd1 vssd1 sky130_ef_sc_hd__decap_40_12$1
XFILLER_25_617 vssd1 vccd1 vccd1 vssd1 sky130_ef_sc_hd__decap_40_12$1
XFILLER_52_458 vssd1 vccd1 vccd1 vssd1 sky130_ef_sc_hd__decap_40_12$1
Xclkbuf_leaf_19_wb_clk_i _1761_/CLK clkbuf_2_3__f_wb_clk_i/X vssd1 vccd1 vccd1 vssd1
+ sky130_fd_sc_hd__clkbuf_8$1
XFILLER_21_823 vccd1 vssd1 vccd1 vssd1 sky130_fd_sc_hd__fill_1$1
XANTENNA_12 hold67/A vssd1 vccd1 vccd1 vssd1 sky130_fd_sc_hd__diode_2$1
XANTENNA_23 _0747_/X vssd1 vccd1 vccd1 vssd1 sky130_fd_sc_hd__diode_2$1
XFILLER_20_333 vssd1 vccd1 vccd1 vssd1 sky130_ef_sc_hd__decap_40_12$1
XFILLER_32_193 vssd1 vccd1 vccd1 vssd1 sky130_fd_sc_hd__fill_2$1
XFILLER_119_711 vssd1 vccd1 vccd1 vssd1 sky130_ef_sc_hd__decap_40_12$1
XFILLER_118_221 vssd1 vccd1 vccd1 vssd1 sky130_ef_sc_hd__decap_40_12$1
XTAP_TAPCELL_ROW_115_2028 vccd1 vssd1 sky130_fd_sc_hd__tapvpwrvgnd_1$1
XFILLER_20_377 vssd1 vccd1 vccd1 vssd1 sky130_ef_sc_hd__decap_40_12$1
XFILLER_21_27 vssd1 vccd1 vccd1 vssd1 sky130_ef_sc_hd__decap_40_12$1
XFILLER_118_265 vssd1 vccd1 vccd1 vssd1 sky130_ef_sc_hd__decap_40_12$1
XTAP_TAPCELL_ROW_99_1783 vccd1 vssd1 sky130_fd_sc_hd__tapvpwrvgnd_1$1
X_0959_ _1091_/C1 _0958_/X _0991_/A2 hold61/X _1513_/D vssd1 vccd1 vccd1 vssd1 sky130_fd_sc_hd__o211a_1$1
XFILLER_106_438 vssd1 vccd1 vccd1 vssd1 sky130_ef_sc_hd__decap_40_12$1
Xoutput152 _1655_/Q analog_ctrl[82] vssd1 vccd1 vccd1 vssd1 sky130_fd_sc_hd__buf_12$1
Xoutput141 _1644_/Q analog_ctrl[71] vssd1 vccd1 vccd1 vssd1 sky130_fd_sc_hd__buf_12$1
Xoutput130 _1832_/X analog_ctrl[61] vssd1 vccd1 vccd1 vssd1 sky130_fd_sc_hd__buf_12$1
Xoutput185 _1499_/Q wbs_dat_o[22] vssd1 vccd1 vccd1 vssd1 sky130_fd_sc_hd__buf_12$1
Xoutput174 _1489_/Q wbs_dat_o[12] vssd1 vccd1 vccd1 vssd1 sky130_fd_sc_hd__buf_12$1
XFILLER_133_279 vccd1 vssd1 vccd1 vssd1 sky130_fd_sc_hd__fill_1$1
Xoutput163 _1665_/Q analog_ctrl[92] vssd1 vccd1 vccd1 vssd1 sky130_fd_sc_hd__buf_12$1
XFILLER_0_727 vccd1 vssd1 vccd1 vssd1 sky130_fd_sc_hd__fill_1$1
Xoutput196 _1480_/Q wbs_dat_o[3] vssd1 vccd1 vccd1 vssd1 sky130_fd_sc_hd__buf_12$1
XTAP_TAPCELL_ROW_110_1950 vccd1 vssd1 sky130_fd_sc_hd__tapvpwrvgnd_1$1
XFILLER_102_633 vssd1 vccd1 vccd1 vssd1 sky130_fd_sc_hd__fill_2$1
XFILLER_99_193 vssd1 vccd1 vccd1 vssd1 sky130_ef_sc_hd__decap_40_12$1
XFILLER_87_333 vssd1 vccd1 vccd1 vssd1 sky130_fd_sc_hd__fill_2$1
XFILLER_101_165 vssd1 vccd1 vccd1 vssd1 sky130_fd_sc_hd__fill_2$1
XFILLER_87_388 vssd1 vccd1 vccd1 vssd1 sky130_fd_sc_hd__fill_4$1
XFILLER_75_517 vssd1 vccd1 vccd1 vssd1 sky130_ef_sc_hd__decap_40_12$1
XFILLER_102_699 vccd1 vssd1 vccd1 vssd1 sky130_fd_sc_hd__fill_1$1
XFILLER_28_433 vssd1 vccd1 vccd1 vssd1 sky130_ef_sc_hd__decap_40_12$1
XFILLER_90_509 vssd1 vccd1 vccd1 vssd1 sky130_fd_sc_hd__fill_2$1
XFILLER_71_701 vssd1 vccd1 vccd1 vssd1 sky130_ef_sc_hd__decap_40_12$1
XFILLER_56_764 vssd1 vccd1 vccd1 vssd1 sky130_ef_sc_hd__decap_40_12$1
XFILLER_56_753 vssd1 vccd1 vccd1 vssd1 sky130_fd_sc_hd__fill_2$1
XFILLER_83_594 vssd1 vccd1 vccd1 vssd1 sky130_fd_sc_hd__fill_2$1
XFILLER_15_105 vssd1 vccd1 vccd1 vssd1 sky130_fd_sc_hd__fill_4$1
XFILLER_28_477 vssd1 vccd1 vccd1 vssd1 sky130_ef_sc_hd__decap_40_12$1
XFILLER_102_41 vssd1 vccd1 vccd1 vssd1 sky130_ef_sc_hd__decap_40_12$1
XFILLER_70_233 vssd1 vccd1 vccd1 vssd1 sky130_ef_sc_hd__decap_40_12$1
XFILLER_15_149 vssd1 vccd1 vccd1 vssd1 sky130_ef_sc_hd__decap_40_12$1
XFILLER_31_609 vssd1 vccd1 vccd1 vssd1 sky130_fd_sc_hd__fill_4$1
XFILLER_43_447 vccd1 vssd1 vccd1 vssd1 sky130_fd_sc_hd__fill_1$1
XFILLER_43_458 vssd1 vccd1 vccd1 vssd1 sky130_ef_sc_hd__decap_40_12$1
XFILLER_102_85 vssd1 vccd1 vccd1 vssd1 sky130_ef_sc_hd__decap_40_12$1
XFILLER_70_277 vssd1 vccd1 vccd1 vssd1 sky130_ef_sc_hd__decap_40_12$1
XTAP_TAPCELL_ROW_26_689 vccd1 vssd1 sky130_fd_sc_hd__tapvpwrvgnd_1$1
XFILLER_8_805 vssd1 vccd1 vccd1 vssd1 sky130_fd_sc_hd__fill_4$1
XFILLER_11_333 vssd1 vccd1 vccd1 vssd1 sky130_fd_sc_hd__fill_2$1
XFILLER_23_193 vssd1 vccd1 vccd1 vssd1 sky130_ef_sc_hd__decap_40_12$1
XFILLER_137_541 vssd1 vccd1 vccd1 vssd1 sky130_fd_sc_hd__fill_8$1
XFILLER_109_221 vssd1 vccd1 vccd1 vssd1 sky130_fd_sc_hd__fill_2$1
XFILLER_7_337 vssd1 vccd1 vccd1 vssd1 sky130_ef_sc_hd__decap_40_12$1
XFILLER_125_747 vssd1 vccd1 vccd1 vssd1 sky130_fd_sc_hd__fill_2$1
XTAP_TAPCELL_ROW_55_1119 vccd1 vssd1 sky130_fd_sc_hd__tapvpwrvgnd_1$1
XFILLER_11_93 vssd1 vccd1 vccd1 vssd1 sky130_ef_sc_hd__decap_40_12$1
XFILLER_127_93 vssd1 vccd1 vccd1 vssd1 sky130_ef_sc_hd__decap_40_12$1
XFILLER_79_812 vssd1 vccd1 vccd1 vssd1 sky130_fd_sc_hd__fill_8$1
XFILLER_105_482 vssd1 vccd1 vccd1 vssd1 sky130_ef_sc_hd__decap_40_12$1
XFILLER_78_333 vssd1 vccd1 vccd1 vssd1 sky130_ef_sc_hd__decap_40_12$1
XFILLER_120_474 vssd1 vccd1 vccd1 vssd1 sky130_fd_sc_hd__fill_2$1
XFILLER_78_377 vssd1 vccd1 vccd1 vssd1 sky130_fd_sc_hd__fill_4$1
XFILLER_66_528 vssd1 vccd1 vccd1 vssd1 sky130_fd_sc_hd__fill_4$1
XFILLER_78_399 vccd1 vssd1 vccd1 vssd1 sky130_fd_sc_hd__fill_1$1
XTAP_TAPCELL_ROW_6_392 vccd1 vssd1 sky130_fd_sc_hd__tapvpwrvgnd_1$1
XFILLER_74_550 vssd1 vccd1 vccd1 vssd1 sky130_ef_sc_hd__decap_40_12$1
XFILLER_62_701 vssd1 vccd1 vccd1 vssd1 sky130_fd_sc_hd__fill_8$1
XFILLER_47_753 vssd1 vccd1 vccd1 vssd1 sky130_fd_sc_hd__fill_4$1
XFILLER_47_797 vssd1 vccd1 vccd1 vssd1 sky130_fd_sc_hd__fill_8$1
XTAP_TAPCELL_ROW_83_1540 vccd1 vssd1 sky130_fd_sc_hd__tapvpwrvgnd_1$1
XTAP_TAPCELL_ROW_83_1551 vccd1 vssd1 sky130_fd_sc_hd__tapvpwrvgnd_1$1
XFILLER_61_277 vssd1 vccd1 vccd1 vssd1 sky130_fd_sc_hd__fill_2$1
XFILLER_34_469 vssd1 vccd1 vccd1 vssd1 sky130_fd_sc_hd__fill_4$1
XTAP_TAPCELL_ROW_45_976 vccd1 vssd1 sky130_fd_sc_hd__tapvpwrvgnd_1$1
XFILLER_14_193 vssd1 vccd1 vccd1 vssd1 sky130_fd_sc_hd__fill_2$1
Xinput21 input21/X vccd1 vssd1 input21/A vccd1 vssd1 sky130_fd_sc_hd__buf_4$1
X_0813_ _0880_/A2 _1486_/D _0809_/X _1431_/C1 _1486_/Q _0812_/X vssd1 vccd1 vccd1
+ vssd1 sky130_fd_sc_hd__o221a_1$1
Xinput10 vccd1 vssd1 input10/X adc_data[7] vccd1 vssd1 sky130_fd_sc_hd__buf_1$1
XFILLER_30_697 vssd1 vccd1 vccd1 vssd1 sky130_fd_sc_hd__fill_2$1
Xinput43 vccd1 vssd1 hold64/A hold63/X vccd1 vssd1 sky130_fd_sc_hd__buf_2$1
Xinput32 input32/X input32/A vssd1 vccd1 vccd1 vssd1 sky130_fd_sc_hd__clkbuf_4$1
X_1793_ vccd1 vssd1 _1793_/X _1793_/A vccd1 vssd1 sky130_fd_sc_hd__buf_1$1
X_0744_ hold5/A hold17/A hold8/A hold24/A _0744_/Y vssd1 vccd1 vccd1 vssd1 sky130_fd_sc_hd__nor4b_4$1
XFILLER_116_769 vssd1 vccd1 vccd1 vssd1 sky130_ef_sc_hd__decap_40_12$1
XFILLER_115_279 vccd1 vssd1 vccd1 vssd1 sky130_fd_sc_hd__fill_1$1
XFILLER_130_249 vssd1 vccd1 vccd1 vssd1 sky130_fd_sc_hd__fill_2$1
XFILLER_97_653 vssd1 vccd1 vccd1 vssd1 sky130_ef_sc_hd__decap_40_12$1
XFILLER_69_333 vssd1 vccd1 vccd1 vssd1 sky130_fd_sc_hd__fill_2$1
XFILLER_111_463 vccd1 vssd1 vccd1 vssd1 sky130_fd_sc_hd__fill_1$1
XFILLER_96_141 vssd1 vccd1 vccd1 vssd1 sky130_ef_sc_hd__decap_40_12$1
XFILLER_85_815 vssd1 vccd1 vccd1 vssd1 sky130_fd_sc_hd__fill_4$1
XFILLER_57_517 vssd1 vccd1 vccd1 vssd1 sky130_fd_sc_hd__fill_4$1
X_1227_ _1435_/C1 _1226_/X _1273_/A2 hold197/X _1643_/D vssd1 vccd1 vccd1 vssd1 sky130_fd_sc_hd__o211a_1$1
XFILLER_38_753 vssd1 vccd1 vccd1 vssd1 sky130_fd_sc_hd__fill_2$1
XFILLER_65_572 vssd1 vccd1 vccd1 vssd1 sky130_ef_sc_hd__decap_40_12$1
X_1158_ _1814_/A _1158_/X _1188_/B vssd1 vccd1 vccd1 vssd1 sky130_fd_sc_hd__or2_1$1
XFILLER_38_797 vssd1 vccd1 vccd1 vssd1 sky130_fd_sc_hd__fill_2$1
XFILLER_80_531 vccd1 vssd1 vccd1 vssd1 sky130_fd_sc_hd__fill_1$1
XFILLER_52_233 vssd1 vccd1 vccd1 vssd1 sky130_ef_sc_hd__decap_40_12$1
XFILLER_16_27 vccd1 vssd1 vccd1 vssd1 sky130_fd_sc_hd__fill_1$1
XFILLER_25_447 vccd1 vssd1 vccd1 vssd1 sky130_fd_sc_hd__fill_1$1
XFILLER_52_277 vssd1 vccd1 vccd1 vssd1 sky130_ef_sc_hd__decap_40_12$1
XFILLER_13_609 vssd1 vccd1 vccd1 vssd1 sky130_fd_sc_hd__fill_4$1
X_1089_ _1305_/C1 _1088_/X _1123_/A2 hold67/X _1576_/D vssd1 vccd1 vccd1 vssd1 sky130_fd_sc_hd__o211a_1$1
XFILLER_40_417 vssd1 vccd1 vccd1 vssd1 sky130_fd_sc_hd__fill_2$1
XTAP_TAPCELL_ROW_23_648 vccd1 vssd1 sky130_fd_sc_hd__tapvpwrvgnd_1$1
XFILLER_20_141 vssd1 vccd1 vccd1 vssd1 sky130_ef_sc_hd__decap_40_12$1
XFILLER_21_653 vssd1 vccd1 vccd1 vssd1 sky130_ef_sc_hd__decap_40_12$1
XFILLER_32_15 vssd1 vccd1 vccd1 vssd1 sky130_ef_sc_hd__decap_40_12$1
XFILLER_21_697 vssd1 vccd1 vccd1 vssd1 sky130_ef_sc_hd__decap_40_12$1
XFILLER_4_307 vccd1 vssd1 vccd1 vssd1 sky130_fd_sc_hd__fill_1$1
XFILLER_134_533 vssd1 vccd1 vccd1 vssd1 sky130_fd_sc_hd__fill_4$1
XFILLER_119_585 vssd1 vccd1 vccd1 vssd1 sky130_ef_sc_hd__decap_40_12$1
XFILLER_107_725 vssd1 vccd1 vccd1 vssd1 sky130_fd_sc_hd__fill_2$1
XFILLER_121_205 vssd1 vccd1 vccd1 vssd1 sky130_ef_sc_hd__decap_40_12$1
XFILLER_121_249 vssd1 vccd1 vccd1 vssd1 sky130_ef_sc_hd__decap_40_12$1
XTAP_TAPCELL_ROW_128_2219 vccd1 vssd1 sky130_fd_sc_hd__tapvpwrvgnd_1$1
XFILLER_102_485 vssd1 vccd1 vccd1 vssd1 sky130_fd_sc_hd__fill_4$1
XFILLER_88_697 vssd1 vccd1 vccd1 vssd1 sky130_fd_sc_hd__fill_2$1
XTAP_TAPCELL_ROW_50_1049 vccd1 vssd1 sky130_fd_sc_hd__tapvpwrvgnd_1$1
XTAP_TAPCELL_ROW_3_351 vccd1 vssd1 sky130_fd_sc_hd__tapvpwrvgnd_1$1
XTAP_TAPCELL_ROW_3_340 vccd1 vssd1 sky130_fd_sc_hd__tapvpwrvgnd_1$1
XFILLER_29_753 vssd1 vccd1 vccd1 vssd1 sky130_ef_sc_hd__decap_40_12$1
XFILLER_113_51 vssd1 vccd1 vccd1 vssd1 sky130_fd_sc_hd__fill_4$1
XFILLER_56_561 vssd1 vccd1 vccd1 vssd1 sky130_fd_sc_hd__fill_8$1
XFILLER_44_701 vssd1 vccd1 vccd1 vssd1 sky130_ef_sc_hd__decap_40_12$1
XFILLER_83_391 vccd1 vssd1 vccd1 vssd1 sky130_fd_sc_hd__fill_1$1
XFILLER_73_55 vccd1 vssd1 vccd1 vssd1 sky130_fd_sc_hd__fill_1$1
XFILLER_16_469 vssd1 vccd1 vccd1 vssd1 sky130_fd_sc_hd__fill_4$1
XFILLER_31_417 vssd1 vccd1 vccd1 vssd1 sky130_ef_sc_hd__decap_40_12$1
XFILLER_43_277 vssd1 vccd1 vccd1 vssd1 sky130_fd_sc_hd__fill_2$1
XTAP_TAPCELL_ROW_65_1281 vccd1 vssd1 sky130_fd_sc_hd__tapvpwrvgnd_1$1
XTAP_TAPCELL_ROW_65_1270 vccd1 vssd1 sky130_fd_sc_hd__tapvpwrvgnd_1$1
XTAP_TAPCELL_ROW_42_924 vccd1 vssd1 sky130_fd_sc_hd__tapvpwrvgnd_1$1
XTAP_TAPCELL_ROW_42_935 vccd1 vssd1 sky130_fd_sc_hd__tapvpwrvgnd_1$1
XFILLER_8_613 vssd1 vccd1 vccd1 vssd1 sky130_ef_sc_hd__decap_40_12$1
XFILLER_129_349 vssd1 vccd1 vccd1 vssd1 sky130_ef_sc_hd__decap_40_12$1
XFILLER_12_697 vssd1 vccd1 vccd1 vssd1 sky130_fd_sc_hd__fill_2$1
XFILLER_8_657 vssd1 vccd1 vccd1 vssd1 sky130_ef_sc_hd__decap_40_12$1
XFILLER_7_167 vccd1 vssd1 vccd1 vssd1 sky130_fd_sc_hd__fill_1$1
XFILLER_22_81 vssd1 vccd1 vccd1 vssd1 sky130_fd_sc_hd__fill_2$1
XFILLER_98_41 vssd1 vccd1 vccd1 vssd1 sky130_ef_sc_hd__decap_40_12$1
XFILLER_4_841 vccd1 vssd1 vccd1 vssd1 sky130_fd_sc_hd__fill_1$1
XFILLER_125_577 vssd1 vccd1 vccd1 vssd1 sky130_ef_sc_hd__decap_40_12$1
XFILLER_98_406 vssd1 vccd1 vccd1 vssd1 sky130_ef_sc_hd__decap_40_12$1
XFILLER_98_85 vssd1 vccd1 vccd1 vssd1 sky130_ef_sc_hd__decap_40_12$1
XFILLER_112_249 vssd1 vccd1 vccd1 vssd1 sky130_fd_sc_hd__fill_2$1
XFILLER_3_373 vssd1 vccd1 vccd1 vssd1 sky130_ef_sc_hd__decap_40_12$1
XFILLER_94_601 vssd1 vccd1 vccd1 vssd1 sky130_ef_sc_hd__decap_40_12$1
XFILLER_79_653 vssd1 vccd1 vccd1 vssd1 sky130_ef_sc_hd__decap_40_12$1
XFILLER_78_141 vssd1 vccd1 vccd1 vssd1 sky130_ef_sc_hd__decap_40_12$1
XFILLER_39_517 vssd1 vccd1 vccd1 vssd1 sky130_ef_sc_hd__decap_40_12$1
XFILLER_121_783 vccd1 vssd1 vccd1 vssd1 sky130_fd_sc_hd__fill_1$1
XFILLER_94_645 vssd1 vccd1 vccd1 vssd1 sky130_ef_sc_hd__decap_40_12$1
XFILLER_93_111 vccd1 vssd1 vccd1 vssd1 sky130_fd_sc_hd__fill_1$1
X_1012_ hold26/X _1012_/X _1012_/B vssd1 vccd1 vccd1 vssd1 sky130_fd_sc_hd__or2_1$1
XFILLER_81_317 vssd1 vccd1 vccd1 vssd1 sky130_ef_sc_hd__decap_40_12$1
XFILLER_47_561 vssd1 vccd1 vccd1 vssd1 sky130_fd_sc_hd__fill_4$1
XFILLER_47_572 vssd1 vccd1 vccd1 vssd1 sky130_ef_sc_hd__decap_40_12$1
XFILLER_34_233 vssd1 vccd1 vccd1 vssd1 sky130_ef_sc_hd__decap_40_12$1
XFILLER_47_594 vssd1 vccd1 vccd1 vssd1 sky130_ef_sc_hd__decap_40_12$1
XFILLER_22_417 vssd1 vccd1 vccd1 vssd1 sky130_fd_sc_hd__fill_2$1
XFILLER_34_277 vssd1 vccd1 vccd1 vssd1 sky130_ef_sc_hd__decap_40_12$1
XTAP_TAPCELL_ROW_20_607 vccd1 vssd1 sky130_fd_sc_hd__tapvpwrvgnd_1$1
X_1845_ _1845_/A _1845_/X vssd1 vccd1 vccd1 vssd1 sky130_fd_sc_hd__clkbuf_2$1
XFILLER_8_83 vccd1 vssd1 vccd1 vssd1 sky130_fd_sc_hd__fill_1$1
XFILLER_118_29 vssd1 vccd1 vccd1 vssd1 sky130_ef_sc_hd__decap_40_12$1
XTAP_TAPCELL_ROW_96_1742 vccd1 vssd1 sky130_fd_sc_hd__tapvpwrvgnd_1$1
X_1776_ vccd1 vssd1 _1776_/X _1776_/A vccd1 vssd1 sky130_fd_sc_hd__buf_1$1
XFILLER_116_533 vssd1 vccd1 vccd1 vssd1 sky130_ef_sc_hd__decap_40_12$1
XFILLER_103_205 vssd1 vccd1 vccd1 vssd1 sky130_ef_sc_hd__decap_40_12$1
XFILLER_103_249 vssd1 vccd1 vccd1 vssd1 sky130_ef_sc_hd__decap_40_12$1
XFILLER_111_293 vssd1 vccd1 vccd1 vssd1 sky130_ef_sc_hd__decap_40_12$1
XFILLER_84_133 vssd1 vccd1 vccd1 vssd1 sky130_fd_sc_hd__fill_4$1
XFILLER_27_15 vssd1 vccd1 vccd1 vssd1 sky130_ef_sc_hd__decap_40_12$1
XTAP_TAPCELL_ROW_123_2138 vccd1 vssd1 sky130_fd_sc_hd__tapvpwrvgnd_1$1
XFILLER_84_177 vssd1 vccd1 vccd1 vssd1 sky130_ef_sc_hd__decap_40_12$1
XTAP_TAPCELL_ROW_28_718 vccd1 vssd1 sky130_fd_sc_hd__tapvpwrvgnd_1$1
Xclkbuf_leaf_34_wb_clk_i _1579_/CLK clkload1/A vssd1 vccd1 vccd1 vssd1 sky130_fd_sc_hd__clkbuf_8$1
XTAP_TAPCELL_ROW_123_2149 vccd1 vssd1 sky130_fd_sc_hd__tapvpwrvgnd_1$1
XFILLER_65_391 vccd1 vssd1 vccd1 vssd1 sky130_fd_sc_hd__fill_1$1
XFILLER_26_734 vssd1 vccd1 vccd1 vssd1 sky130_fd_sc_hd__fill_8$1
XFILLER_80_361 vssd1 vccd1 vccd1 vssd1 sky130_fd_sc_hd__fill_2$1
XPHY_EDGE_ROW_40_Left_179 vccd1 vssd1 vccd1 vssd1 sky130_fd_sc_hd__decap_3$1
XTAP_TAPCELL_ROW_105_1882 vccd1 vssd1 sky130_fd_sc_hd__tapvpwrvgnd_1$1
XTAP_TAPCELL_ROW_105_1871 vccd1 vssd1 sky130_fd_sc_hd__tapvpwrvgnd_1$1
XFILLER_13_417 vssd1 vccd1 vccd1 vssd1 sky130_ef_sc_hd__decap_40_12$1
XFILLER_25_277 vssd1 vccd1 vccd1 vssd1 sky130_fd_sc_hd__fill_2$1
XFILLER_41_726 vssd1 vccd1 vccd1 vssd1 sky130_fd_sc_hd__fill_2$1
XFILLER_41_748 vssd1 vccd1 vccd1 vssd1 sky130_ef_sc_hd__decap_40_12$1
XFILLER_43_69 vssd1 vccd1 vccd1 vssd1 sky130_ef_sc_hd__decap_40_12$1
XFILLER_138_113 vssd1 vccd1 vccd1 vssd1 sky130_fd_sc_hd__fill_2$1
XFILLER_21_461 vssd1 vccd1 vccd1 vssd1 sky130_ef_sc_hd__decap_40_12$1
XTAP_TAPCELL_ROW_138_2392 vccd1 vssd1 sky130_fd_sc_hd__tapvpwrvgnd_1$1
XTAP_TAPCELL_ROW_138_2381 vccd1 vssd1 sky130_fd_sc_hd__tapvpwrvgnd_1$1
XTAP_TAPCELL_ROW_138_2370 vccd1 vssd1 sky130_fd_sc_hd__tapvpwrvgnd_1$1
XFILLER_107_500 vssd1 vccd1 vccd1 vssd1 sky130_fd_sc_hd__fill_4$1
XFILLER_119_393 vssd1 vccd1 vccd1 vssd1 sky130_ef_sc_hd__decap_40_12$1
XFILLER_104_3 vssd1 vccd1 vccd1 vssd1 sky130_ef_sc_hd__decap_40_12$1
XFILLER_4_137 vssd1 vccd1 vccd1 vssd1 sky130_fd_sc_hd__fill_2$1
XTAP_TAPCELL_ROW_8_421 vccd1 vssd1 sky130_fd_sc_hd__tapvpwrvgnd_1$1
XFILLER_122_525 vssd1 vccd1 vccd1 vssd1 sky130_fd_sc_hd__fill_4$1
XFILLER_0_321 vssd1 vccd1 vccd1 vssd1 sky130_ef_sc_hd__decap_40_12$1
XFILLER_1_833 vssd1 vccd1 vccd1 vssd1 sky130_fd_sc_hd__fill_4$1
XFILLER_68_77 vssd1 vccd1 vccd1 vssd1 sky130_fd_sc_hd__fill_4$1
XFILLER_76_612 vssd1 vccd1 vccd1 vssd1 sky130_ef_sc_hd__decap_40_12$1
XFILLER_75_111 vccd1 vssd1 vccd1 vssd1 sky130_fd_sc_hd__fill_1$1
XFILLER_0_365 vssd1 vccd1 vccd1 vssd1 sky130_ef_sc_hd__decap_40_12$1
XFILLER_124_83 vccd1 vssd1 vccd1 vssd1 sky130_fd_sc_hd__fill_1$1
XFILLER_64_807 vssd1 vccd1 vccd1 vssd1 sky130_fd_sc_hd__fill_4$1
XFILLER_84_65 vssd1 vccd1 vccd1 vssd1 sky130_ef_sc_hd__decap_40_12$1
XFILLER_76_689 vssd1 vccd1 vccd1 vssd1 sky130_fd_sc_hd__fill_8$1
XTAP_TAPCELL_ROW_67_1310 vccd1 vssd1 sky130_fd_sc_hd__tapvpwrvgnd_1$1
XFILLER_63_317 vssd1 vccd1 vccd1 vssd1 sky130_ef_sc_hd__decap_40_12$1
XFILLER_29_561 vssd1 vccd1 vccd1 vssd1 sky130_ef_sc_hd__decap_40_12$1
XFILLER_16_233 vssd1 vccd1 vccd1 vssd1 sky130_ef_sc_hd__decap_40_12$1
XFILLER_44_531 vccd1 vssd1 vccd1 vssd1 sky130_fd_sc_hd__fill_1$1
XFILLER_71_361 vssd1 vccd1 vccd1 vssd1 sky130_ef_sc_hd__decap_40_12$1
XFILLER_17_81 vssd1 vccd1 vccd1 vssd1 sky130_ef_sc_hd__decap_40_12$1
XFILLER_16_277 vssd1 vccd1 vccd1 vssd1 sky130_ef_sc_hd__decap_40_12$1
XFILLER_31_225 vssd1 vccd1 vccd1 vssd1 sky130_ef_sc_hd__decap_40_12$1
XFILLER_129_113 vssd1 vccd1 vccd1 vssd1 sky130_ef_sc_hd__decap_40_12$1
XFILLER_8_421 vssd1 vccd1 vccd1 vssd1 sky130_ef_sc_hd__decap_40_12$1
XFILLER_40_781 vssd1 vccd1 vccd1 vssd1 sky130_ef_sc_hd__decap_40_12$1
X_1630_ _1630_/Q _1759_/CLK _1630_/D vccd1 vssd1 vccd1 vssd1 sky130_fd_sc_hd__dfxtp_1$1
XTAP_TAPCELL_ROW_78_1472 vccd1 vssd1 sky130_fd_sc_hd__tapvpwrvgnd_1$1
XFILLER_113_503 vccd1 vssd1 vccd1 vssd1 sky130_fd_sc_hd__fill_1$1
X_1561_ _1561_/Q _1753_/CLK _1561_/D vccd1 vssd1 vccd1 vssd1 sky130_fd_sc_hd__dfxtp_1$1
XFILLER_125_385 vssd1 vccd1 vccd1 vssd1 sky130_fd_sc_hd__fill_4$1
X_1492_ _1492_/Q _1748_/CLK _1492_/D vccd1 vssd1 vccd1 vssd1 sky130_fd_sc_hd__dfxtp_1$1
XFILLER_4_693 vssd1 vccd1 vccd1 vssd1 sky130_fd_sc_hd__fill_4$1
XFILLER_3_181 vssd1 vccd1 vccd1 vssd1 sky130_ef_sc_hd__decap_40_12$1
XFILLER_113_569 vssd1 vccd1 vccd1 vssd1 sky130_ef_sc_hd__decap_40_12$1
XTAP_TAPCELL_ROW_91_1672 vccd1 vssd1 sky130_fd_sc_hd__tapvpwrvgnd_1$1
XTAP_TAPCELL_ROW_91_1661 vccd1 vssd1 sky130_fd_sc_hd__tapvpwrvgnd_1$1
XFILLER_79_472 vssd1 vccd1 vccd1 vssd1 sky130_ef_sc_hd__decap_40_12$1
XFILLER_67_645 vssd1 vccd1 vccd1 vssd1 sky130_fd_sc_hd__fill_2$1
XFILLER_66_133 vssd1 vccd1 vccd1 vssd1 sky130_fd_sc_hd__fill_4$1
XFILLER_94_475 vccd1 vssd1 vccd1 vssd1 sky130_fd_sc_hd__fill_1$1
XFILLER_66_177 vssd1 vccd1 vccd1 vssd1 sky130_ef_sc_hd__decap_40_12$1
XFILLER_81_125 vssd1 vccd1 vccd1 vssd1 sky130_ef_sc_hd__decap_40_12$1
XFILLER_47_391 vccd1 vssd1 vccd1 vssd1 sky130_fd_sc_hd__fill_1$1
XFILLER_81_169 vssd1 vccd1 vccd1 vssd1 sky130_ef_sc_hd__decap_40_12$1
XFILLER_50_501 vssd1 vccd1 vccd1 vssd1 sky130_ef_sc_hd__decap_40_12$1
XFILLER_35_553 vssd1 vccd1 vccd1 vssd1 sky130_fd_sc_hd__fill_4$1
XFILLER_62_361 vssd1 vccd1 vccd1 vssd1 sky130_fd_sc_hd__fill_2$1
XFILLER_35_597 vssd1 vccd1 vccd1 vssd1 sky130_ef_sc_hd__decap_40_12$1
XFILLER_50_545 vssd1 vccd1 vccd1 vssd1 sky130_ef_sc_hd__decap_40_12$1
XFILLER_50_589 vssd1 vccd1 vccd1 vssd1 sky130_ef_sc_hd__decap_40_12$1
XFILLER_13_39 vssd1 vccd1 vccd1 vssd1 sky130_ef_sc_hd__decap_40_12$1
XFILLER_31_781 vssd1 vccd1 vccd1 vssd1 sky130_fd_sc_hd__fill_2$1
XTAP_TAPCELL_ROW_33_798 vccd1 vssd1 sky130_fd_sc_hd__tapvpwrvgnd_1$1
XFILLER_129_39 vssd1 vccd1 vccd1 vssd1 sky130_ef_sc_hd__decap_40_12$1
XFILLER_135_105 vssd1 vccd1 vccd1 vssd1 sky130_fd_sc_hd__fill_4$1
X_1828_ vccd1 vssd1 _1828_/X _1828_/A vccd1 vssd1 sky130_fd_sc_hd__buf_1$1
XFILLER_135_149 vssd1 vccd1 vccd1 vssd1 sky130_ef_sc_hd__decap_40_12$1
XPHY_EDGE_ROW_111_Right_111 vccd1 vssd1 vccd1 vssd1 sky130_fd_sc_hd__decap_3$1
X_1759_ _1759_/Q _1759_/CLK _1759_/D vccd1 vssd1 vccd1 vssd1 sky130_fd_sc_hd__dfxtp_1$1
XFILLER_116_363 vccd1 vssd1 vccd1 vssd1 sky130_fd_sc_hd__fill_1$1
XFILLER_132_834 vssd1 vccd1 vccd1 vssd1 sky130_fd_sc_hd__fill_8$1
XFILLER_131_333 vssd1 vccd1 vccd1 vssd1 sky130_fd_sc_hd__fill_2$1
XFILLER_89_225 vssd1 vccd1 vccd1 vssd1 sky130_ef_sc_hd__decap_40_12$1
XFILLER_104_569 vssd1 vccd1 vccd1 vssd1 sky130_ef_sc_hd__decap_40_12$1
XFILLER_57_111 vccd1 vssd1 vccd1 vssd1 sky130_fd_sc_hd__fill_1$1
XFILLER_100_753 vssd1 vccd1 vccd1 vssd1 sky130_fd_sc_hd__fill_2$1
XFILLER_58_645 vssd1 vccd1 vccd1 vssd1 sky130_ef_sc_hd__decap_40_12$1
XFILLER_46_807 vssd1 vccd1 vccd1 vssd1 sky130_fd_sc_hd__fill_4$1
XTAP_TAPCELL_ROW_107_1911 vccd1 vssd1 sky130_fd_sc_hd__tapvpwrvgnd_1$1
XTAP_TAPCELL_ROW_107_1900 vccd1 vssd1 sky130_fd_sc_hd__tapvpwrvgnd_1$1
XFILLER_100_797 vssd1 vccd1 vccd1 vssd1 sky130_fd_sc_hd__fill_2$1
XFILLER_45_317 vssd1 vccd1 vccd1 vssd1 sky130_ef_sc_hd__decap_40_12$1
XFILLER_26_531 vccd1 vssd1 vccd1 vssd1 sky130_fd_sc_hd__fill_1$1
XFILLER_60_309 vssd1 vccd1 vccd1 vssd1 sky130_ef_sc_hd__decap_40_12$1
XTAP_TAPCELL_ROW_49_1040 vccd1 vssd1 sky130_fd_sc_hd__tapvpwrvgnd_1$1
XFILLER_53_361 vssd1 vccd1 vccd1 vssd1 sky130_ef_sc_hd__decap_40_12$1
XFILLER_13_225 vssd1 vccd1 vccd1 vssd1 sky130_ef_sc_hd__decap_40_12$1
XFILLER_14_737 vssd1 vccd1 vccd1 vssd1 sky130_ef_sc_hd__decap_40_12$1
XFILLER_41_501 vssd1 vccd1 vccd1 vssd1 sky130_fd_sc_hd__fill_2$1
XFILLER_110_41 vssd1 vccd1 vccd1 vssd1 sky130_ef_sc_hd__decap_40_12$1
XFILLER_110_85 vssd1 vccd1 vccd1 vssd1 sky130_ef_sc_hd__decap_40_12$1
XFILLER_22_781 vssd1 vccd1 vccd1 vssd1 sky130_ef_sc_hd__decap_40_12$1
XFILLER_127_606 vssd1 vccd1 vccd1 vssd1 sky130_fd_sc_hd__fill_8$1
XFILLER_127_617 vssd1 vccd1 vccd1 vssd1 sky130_fd_sc_hd__fill_8$1
XTAP_TAPCELL_ROW_11_459 vccd1 vssd1 sky130_fd_sc_hd__tapvpwrvgnd_1$1
XFILLER_123_823 vccd1 vssd1 vccd1 vssd1 sky130_fd_sc_hd__fill_1$1
XFILLER_122_333 vssd1 vccd1 vccd1 vssd1 sky130_ef_sc_hd__decap_40_12$1
XFILLER_107_385 vssd1 vccd1 vccd1 vssd1 sky130_fd_sc_hd__fill_4$1
XFILLER_134_193 vssd1 vccd1 vccd1 vssd1 sky130_fd_sc_hd__fill_2$1
XFILLER_1_641 vssd1 vccd1 vccd1 vssd1 sky130_ef_sc_hd__decap_40_12$1
XFILLER_95_217 vssd1 vccd1 vccd1 vssd1 sky130_fd_sc_hd__fill_4$1
XFILLER_89_781 vssd1 vccd1 vccd1 vssd1 sky130_fd_sc_hd__fill_2$1
XTAP_TAPCELL_ROW_73_1391 vccd1 vssd1 sky130_fd_sc_hd__tapvpwrvgnd_1$1
XFILLER_1_685 vssd1 vccd1 vccd1 vssd1 sky130_ef_sc_hd__decap_40_12$1
XFILLER_135_93 vssd1 vccd1 vccd1 vssd1 sky130_ef_sc_hd__decap_40_12$1
XFILLER_0_195 vccd1 vssd1 vccd1 vssd1 sky130_fd_sc_hd__fill_1$1
XFILLER_37_807 vccd1 vssd1 vccd1 vssd1 sky130_fd_sc_hd__fill_1$1
XFILLER_48_133 vssd1 vccd1 vccd1 vssd1 sky130_fd_sc_hd__fill_4$1
XFILLER_48_177 vssd1 vccd1 vccd1 vssd1 sky130_ef_sc_hd__decap_40_12$1
XFILLER_91_445 vssd1 vccd1 vccd1 vssd1 sky130_fd_sc_hd__fill_2$1
XFILLER_63_125 vssd1 vccd1 vccd1 vssd1 sky130_ef_sc_hd__decap_40_12$1
XFILLER_29_391 vccd1 vssd1 vccd1 vssd1 sky130_fd_sc_hd__fill_1$1
XFILLER_63_169 vssd1 vccd1 vccd1 vssd1 sky130_ef_sc_hd__decap_40_12$1
XFILLER_17_553 vssd1 vccd1 vccd1 vssd1 sky130_fd_sc_hd__fill_4$1
XFILLER_17_597 vssd1 vccd1 vccd1 vssd1 sky130_ef_sc_hd__decap_40_12$1
XFILLER_32_501 vssd1 vccd1 vccd1 vssd1 sky130_ef_sc_hd__decap_40_12$1
XFILLER_44_361 vssd1 vccd1 vccd1 vssd1 sky130_fd_sc_hd__fill_2$1
XFILLER_32_545 vssd1 vccd1 vccd1 vssd1 sky130_ef_sc_hd__decap_40_12$1
X_0992_ _0992_/A _0992_/X _1012_/B vssd1 vccd1 vccd1 vssd1 sky130_fd_sc_hd__or2_1$1
XFILLER_32_589 vssd1 vccd1 vccd1 vssd1 sky130_ef_sc_hd__decap_40_12$1
XFILLER_9_741 vssd1 vccd1 vccd1 vssd1 sky130_ef_sc_hd__decap_40_12$1
XFILLER_13_781 vssd1 vccd1 vccd1 vssd1 sky130_fd_sc_hd__fill_2$1
XTAP_TAPCELL_ROW_30_746 vccd1 vssd1 sky130_fd_sc_hd__tapvpwrvgnd_1$1
XFILLER_118_639 vssd1 vccd1 vccd1 vssd1 sky130_fd_sc_hd__fill_4$1
XFILLER_117_105 vssd1 vccd1 vccd1 vssd1 sky130_fd_sc_hd__fill_4$1
XFILLER_9_785 vssd1 vccd1 vccd1 vssd1 sky130_ef_sc_hd__decap_40_12$1
XFILLER_8_251 vccd1 vssd1 vccd1 vssd1 sky130_fd_sc_hd__fill_1$1
XTAP_TAPCELL_ROW_30_757 vccd1 vssd1 sky130_fd_sc_hd__tapvpwrvgnd_1$1
XFILLER_133_609 vssd1 vccd1 vccd1 vssd1 sky130_fd_sc_hd__fill_4$1
XFILLER_117_149 vssd1 vccd1 vccd1 vssd1 sky130_ef_sc_hd__decap_40_12$1
XTAP_TAPCELL_ROW_93_1701 vccd1 vssd1 sky130_fd_sc_hd__tapvpwrvgnd_1$1
XFILLER_67_3 vssd1 vccd1 vccd1 vssd1 sky130_ef_sc_hd__decap_40_12$1
XFILLER_126_661 vssd1 vccd1 vccd1 vssd1 sky130_fd_sc_hd__fill_8$1
XFILLER_99_501 vssd1 vccd1 vccd1 vssd1 sky130_fd_sc_hd__fill_2$1
X_1613_ _1817_/A clkload4/A _1613_/D vccd1 vssd1 vccd1 vssd1 sky130_fd_sc_hd__dfxtp_1$1
XFILLER_5_51 vssd1 vccd1 vccd1 vssd1 sky130_fd_sc_hd__fill_4$1
X_1544_ _1775_/A _1608_/CLK _1544_/D vccd1 vssd1 vccd1 vssd1 sky130_fd_sc_hd__dfxtp_1$1
Xfanout208 _1399_/A2 vccd1 vssd1 _1345_/Y vccd1 vssd1 sky130_fd_sc_hd__buf_6$1
XFILLER_125_193 vssd1 vccd1 vccd1 vssd1 sky130_ef_sc_hd__decap_40_12$1
XFILLER_113_333 vssd1 vccd1 vccd1 vssd1 sky130_fd_sc_hd__fill_2$1
XFILLER_87_729 vssd1 vccd1 vccd1 vssd1 sky130_fd_sc_hd__fill_8$1
Xfanout219 _1189_/A2 _1147_/Y vssd1 vccd1 vccd1 vssd1 sky130_fd_sc_hd__clkbuf_8$1
X_1475_ _1475_/C1 _1474_/X _1475_/A2 hold2/X _1764_/D vssd1 vccd1 vccd1 vssd1 sky130_fd_sc_hd__o211a_1$1
XFILLER_113_377 vssd1 vccd1 vccd1 vssd1 sky130_fd_sc_hd__fill_2$1
XFILLER_113_388 vssd1 vccd1 vccd1 vssd1 sky130_fd_sc_hd__fill_4$1
XFILLER_101_517 vssd1 vccd1 vccd1 vssd1 sky130_fd_sc_hd__fill_8$1
XPHY_EDGE_ROW_105_Left_244 vccd1 vssd1 vccd1 vssd1 sky130_fd_sc_hd__decap_3$1
XFILLER_67_442 vssd1 vccd1 vccd1 vssd1 sky130_fd_sc_hd__fill_4$1
XFILLER_39_111 vccd1 vssd1 vccd1 vssd1 sky130_fd_sc_hd__fill_1$1
XFILLER_27_317 vssd1 vccd1 vccd1 vssd1 sky130_ef_sc_hd__decap_40_12$1
XFILLER_82_445 vssd1 vccd1 vccd1 vssd1 sky130_ef_sc_hd__decap_40_12$1
XFILLER_67_497 vssd1 vccd1 vccd1 vssd1 sky130_fd_sc_hd__fill_4$1
XTAP_TAPCELL_ROW_38_868 vccd1 vssd1 sky130_fd_sc_hd__tapvpwrvgnd_1$1
XFILLER_42_309 vssd1 vccd1 vccd1 vssd1 sky130_ef_sc_hd__decap_40_12$1
XFILLER_82_489 vssd1 vccd1 vccd1 vssd1 sky130_ef_sc_hd__decap_40_12$1
XTAP_TAPCELL_ROW_18_570 vccd1 vssd1 sky130_fd_sc_hd__tapvpwrvgnd_1$1
XFILLER_23_501 vssd1 vccd1 vccd1 vssd1 sky130_fd_sc_hd__fill_2$1
XFILLER_35_361 vssd1 vccd1 vccd1 vssd1 sky130_ef_sc_hd__decap_40_12$1
XTAP_TAPCELL_ROW_102_1830 vccd1 vssd1 sky130_fd_sc_hd__tapvpwrvgnd_1$1
XFILLER_24_27 vccd1 vssd1 vccd1 vssd1 sky130_fd_sc_hd__fill_1$1
XPHY_EDGE_ROW_114_Left_253 vccd1 vssd1 vccd1 vssd1 sky130_fd_sc_hd__decap_3$1
XFILLER_11_729 vssd1 vccd1 vccd1 vssd1 sky130_ef_sc_hd__decap_40_12$1
XFILLER_109_617 vssd1 vccd1 vccd1 vssd1 sky130_fd_sc_hd__fill_8$1
XFILLER_40_15 vssd1 vccd1 vccd1 vssd1 sky130_ef_sc_hd__decap_40_12$1
XTAP_TAPCELL_ROW_131_2259 vccd1 vssd1 sky130_fd_sc_hd__tapvpwrvgnd_1$1
XFILLER_105_823 vccd1 vssd1 vccd1 vssd1 sky130_fd_sc_hd__fill_1$1
XFILLER_116_193 vssd1 vccd1 vccd1 vssd1 sky130_fd_sc_hd__fill_2$1
XFILLER_104_333 vssd1 vccd1 vccd1 vssd1 sky130_ef_sc_hd__decap_40_12$1
XFILLER_78_718 vssd1 vccd1 vccd1 vssd1 sky130_ef_sc_hd__decap_40_12$1
XPHY_EDGE_ROW_123_Left_262 vccd1 vssd1 vccd1 vssd1 sky130_fd_sc_hd__decap_3$1
XTAP_TAPCELL_ROW_113_1992 vccd1 vssd1 sky130_fd_sc_hd__tapvpwrvgnd_1$1
XFILLER_77_217 vssd1 vccd1 vccd1 vssd1 sky130_fd_sc_hd__fill_4$1
XFILLER_49_57 vssd1 vccd1 vccd1 vssd1 sky130_ef_sc_hd__decap_40_12$1
XFILLER_92_209 vssd1 vccd1 vccd1 vssd1 sky130_ef_sc_hd__decap_40_12$1
XFILLER_85_261 vssd1 vccd1 vccd1 vssd1 sky130_ef_sc_hd__decap_40_12$1
XFILLER_58_475 vccd1 vssd1 vccd1 vssd1 sky130_fd_sc_hd__fill_1$1
XFILLER_45_125 vssd1 vccd1 vccd1 vssd1 sky130_ef_sc_hd__decap_40_12$1
XFILLER_46_637 vssd1 vccd1 vccd1 vssd1 sky130_fd_sc_hd__fill_4$1
XFILLER_45_169 vssd1 vccd1 vccd1 vssd1 sky130_ef_sc_hd__decap_40_12$1
XFILLER_121_51 vssd1 vccd1 vccd1 vssd1 sky130_fd_sc_hd__fill_4$1
XFILLER_61_629 vssd1 vccd1 vccd1 vssd1 sky130_ef_sc_hd__decap_40_12$1
XFILLER_54_681 vssd1 vccd1 vccd1 vssd1 sky130_ef_sc_hd__decap_40_12$1
XFILLER_14_501 vssd1 vccd1 vccd1 vssd1 sky130_ef_sc_hd__decap_40_12$1
XFILLER_26_361 vssd1 vccd1 vccd1 vssd1 sky130_fd_sc_hd__fill_2$1
XPHY_EDGE_ROW_132_Left_271 vccd1 vssd1 vccd1 vssd1 sky130_fd_sc_hd__decap_3$1
XFILLER_60_139 vccd1 vssd1 vccd1 vssd1 sky130_fd_sc_hd__fill_1$1
XFILLER_14_545 vssd1 vccd1 vccd1 vssd1 sky130_ef_sc_hd__decap_40_12$1
XFILLER_81_55 vccd1 vssd1 vccd1 vssd1 sky130_fd_sc_hd__fill_1$1
XFILLER_14_589 vssd1 vccd1 vccd1 vssd1 sky130_ef_sc_hd__decap_40_12$1
XFILLER_127_425 vccd1 vssd1 vccd1 vssd1 sky130_fd_sc_hd__fill_1$1
XFILLER_127_447 vccd1 vssd1 vccd1 vssd1 sky130_fd_sc_hd__fill_1$1
XFILLER_10_773 vssd1 vccd1 vccd1 vssd1 sky130_ef_sc_hd__decap_40_12$1
XFILLER_5_221 vssd1 vccd1 vccd1 vssd1 sky130_fd_sc_hd__fill_2$1
XTAP_TAPCELL_ROW_75_1420 vccd1 vssd1 sky130_fd_sc_hd__tapvpwrvgnd_1$1
XFILLER_6_755 vccd1 vssd1 vccd1 vssd1 sky130_fd_sc_hd__fill_1$1
XTAP_TAPCELL_ROW_75_1431 vccd1 vssd1 sky130_fd_sc_hd__tapvpwrvgnd_1$1
XFILLER_30_81 vssd1 vccd1 vccd1 vssd1 sky130_fd_sc_hd__fill_2$1
XFILLER_122_141 vssd1 vccd1 vccd1 vssd1 sky130_ef_sc_hd__decap_40_12$1
XFILLER_107_193 vssd1 vccd1 vccd1 vssd1 sky130_ef_sc_hd__decap_40_12$1
XFILLER_123_697 vssd1 vccd1 vccd1 vssd1 sky130_ef_sc_hd__decap_40_12$1
XFILLER_69_729 vssd1 vccd1 vccd1 vssd1 sky130_fd_sc_hd__fill_8$1
X_1260_ _1660_/Q _1260_/X _1276_/B vssd1 vccd1 vccd1 vssd1 sky130_fd_sc_hd__or2_1$1
X_1191_ _1417_/C1 _1190_/X _1211_/A2 hold107/X _1626_/D vssd1 vccd1 vccd1 vssd1 sky130_fd_sc_hd__o211a_1$1
Xclkbuf_2_0__f_wb_clk_i clkload0/A clkbuf_0_wb_clk_i/X vssd1 vccd1 vccd1 vssd1 sky130_fd_sc_hd__clkbuf_16$1
Xinput8 adc_data[5] input8/X vssd1 vccd1 vccd1 vssd1 sky130_fd_sc_hd__clkbuf_2$1
XFILLER_37_615 vccd1 vssd1 vccd1 vssd1 sky130_fd_sc_hd__fill_1$1
XFILLER_24_309 vssd1 vccd1 vccd1 vssd1 sky130_ef_sc_hd__decap_40_12$1
XFILLER_64_489 vssd1 vccd1 vccd1 vssd1 sky130_ef_sc_hd__decap_40_12$1
XFILLER_17_361 vssd1 vccd1 vccd1 vssd1 sky130_ef_sc_hd__decap_40_12$1
XTAP_TAPCELL_ROW_35_827 vccd1 vssd1 sky130_fd_sc_hd__tapvpwrvgnd_1$1
XTAP_TAPCELL_ROW_86_1593 vccd1 vssd1 sky130_fd_sc_hd__tapvpwrvgnd_1$1
X_0975_ _1437_/C1 _0974_/X _1013_/A2 hold55/X _1521_/D vssd1 vccd1 vccd1 vssd1 sky130_fd_sc_hd__o211a_1$1
XFILLER_133_428 vssd1 vccd1 vccd1 vssd1 sky130_fd_sc_hd__fill_4$1
XFILLER_114_631 vssd1 vccd1 vccd1 vssd1 sky130_ef_sc_hd__decap_40_12$1
XFILLER_10_29 vssd1 vccd1 vccd1 vssd1 sky130_ef_sc_hd__decap_40_12$1
XFILLER_126_29 vssd1 vccd1 vccd1 vssd1 sky130_ef_sc_hd__decap_40_12$1
XFILLER_99_375 vccd1 vssd1 vccd1 vssd1 sky130_fd_sc_hd__fill_1$1
X_1527_ _1527_/Q _1716_/CLK _1527_/D vccd1 vssd1 vccd1 vssd1 sky130_fd_sc_hd__dfxtp_1$1
XFILLER_59_217 vssd1 vccd1 vccd1 vssd1 sky130_fd_sc_hd__fill_4$1
X_1458_ hold37/X _1458_/X _1464_/B vssd1 vccd1 vccd1 vssd1 sky130_fd_sc_hd__or2_1$1
XFILLER_87_548 vssd1 vccd1 vccd1 vssd1 sky130_ef_sc_hd__decap_40_12$1
XFILLER_19_27 vssd1 vccd1 vccd1 vssd1 sky130_ef_sc_hd__decap_40_12$1
XFILLER_74_209 vssd1 vccd1 vccd1 vssd1 sky130_ef_sc_hd__decap_40_12$1
XFILLER_67_261 vssd1 vccd1 vccd1 vssd1 sky130_ef_sc_hd__decap_40_12$1
XFILLER_55_401 vssd1 vccd1 vccd1 vssd1 sky130_ef_sc_hd__decap_40_12$1
X_1389_ _1437_/C1 _1388_/X _1409_/A2 hold107/X _1722_/D vssd1 vccd1 vccd1 vssd1 sky130_fd_sc_hd__o211a_1$1
XFILLER_83_743 vssd1 vccd1 vccd1 vssd1 sky130_ef_sc_hd__decap_40_12$1
XFILLER_27_125 vssd1 vccd1 vccd1 vssd1 sky130_ef_sc_hd__decap_40_12$1
XFILLER_28_637 vssd1 vccd1 vccd1 vssd1 sky130_fd_sc_hd__fill_4$1
XFILLER_82_253 vssd1 vccd1 vccd1 vssd1 sky130_ef_sc_hd__decap_40_12$1
XFILLER_55_445 vssd1 vccd1 vccd1 vssd1 sky130_fd_sc_hd__fill_2$1
XFILLER_28_659 vccd1 vssd1 vccd1 vssd1 sky130_fd_sc_hd__fill_1$1
XFILLER_35_15 vssd1 vccd1 vccd1 vssd1 sky130_ef_sc_hd__decap_40_12$1
XFILLER_27_169 vssd1 vccd1 vccd1 vssd1 sky130_ef_sc_hd__decap_40_12$1
XFILLER_36_681 vssd1 vccd1 vccd1 vssd1 sky130_ef_sc_hd__decap_40_12$1
XFILLER_42_139 vccd1 vssd1 vccd1 vssd1 sky130_fd_sc_hd__fill_1$1
XFILLER_51_673 vssd1 vccd1 vccd1 vssd1 sky130_fd_sc_hd__fill_4$1
XFILLER_109_403 vssd1 vccd1 vccd1 vssd1 sky130_ef_sc_hd__decap_40_12$1
XFILLER_51_69 vssd1 vccd1 vccd1 vssd1 sky130_ef_sc_hd__decap_40_12$1
XFILLER_11_559 vccd1 vssd1 vccd1 vssd1 sky130_fd_sc_hd__fill_1$1
XFILLER_136_233 vssd1 vccd1 vccd1 vssd1 sky130_ef_sc_hd__decap_40_12$1
XFILLER_109_447 vccd1 vssd1 vccd1 vssd1 sky130_fd_sc_hd__fill_1$1
XFILLER_137_767 vssd1 vccd1 vccd1 vssd1 sky130_ef_sc_hd__decap_40_12$1
XFILLER_136_277 vssd1 vccd1 vccd1 vssd1 sky130_fd_sc_hd__fill_8$1
XFILLER_124_417 vssd1 vccd1 vccd1 vssd1 sky130_fd_sc_hd__fill_2$1
XFILLER_3_725 vssd1 vccd1 vccd1 vssd1 sky130_fd_sc_hd__fill_2$1
XFILLER_105_653 vssd1 vccd1 vccd1 vssd1 sky130_ef_sc_hd__decap_40_12$1
XTAP_TAPCELL_ROW_57_1161 vccd1 vssd1 sky130_fd_sc_hd__tapvpwrvgnd_1$1
XTAP_TAPCELL_ROW_57_1150 vccd1 vssd1 sky130_fd_sc_hd__tapvpwrvgnd_1$1
XFILLER_132_461 vssd1 vccd1 vccd1 vssd1 sky130_ef_sc_hd__decap_40_12$1
XFILLER_120_601 vssd1 vccd1 vccd1 vssd1 sky130_ef_sc_hd__decap_40_12$1
XFILLER_105_697 vssd1 vccd1 vccd1 vssd1 sky130_fd_sc_hd__fill_8$1
XFILLER_104_141 vssd1 vccd1 vccd1 vssd1 sky130_ef_sc_hd__decap_40_12$1
XTAP_TAPCELL_ROW_70_1350 vccd1 vssd1 sky130_fd_sc_hd__tapvpwrvgnd_1$1
XFILLER_59_773 vssd1 vccd1 vccd1 vssd1 sky130_fd_sc_hd__fill_8$1
XFILLER_19_615 vccd1 vssd1 vccd1 vssd1 sky130_fd_sc_hd__fill_1$1
XFILLER_86_581 vssd1 vccd1 vccd1 vssd1 sky130_fd_sc_hd__fill_4$1
XFILLER_76_77 vssd1 vccd1 vccd1 vssd1 sky130_fd_sc_hd__fill_4$1
XFILLER_46_401 vssd1 vccd1 vccd1 vssd1 sky130_ef_sc_hd__decap_40_12$1
XFILLER_46_445 vssd1 vccd1 vccd1 vssd1 sky130_ef_sc_hd__decap_40_12$1
XFILLER_132_83 vccd1 vssd1 vccd1 vssd1 sky130_fd_sc_hd__fill_1$1
XFILLER_61_426 vssd1 vccd1 vccd1 vssd1 sky130_fd_sc_hd__fill_2$1
XFILLER_27_670 vssd1 vccd1 vccd1 vssd1 sky130_fd_sc_hd__fill_2$1
XFILLER_46_489 vssd1 vccd1 vccd1 vssd1 sky130_ef_sc_hd__decap_40_12$1
XFILLER_92_65 vssd1 vccd1 vccd1 vssd1 sky130_ef_sc_hd__decap_40_12$1
XFILLER_25_81 vssd1 vccd1 vccd1 vssd1 sky130_ef_sc_hd__decap_40_12$1
XFILLER_30_813 vssd1 vccd1 vccd1 vssd1 sky130_ef_sc_hd__decap_40_12$1
XFILLER_42_662 vssd1 vccd1 vccd1 vssd1 sky130_fd_sc_hd__fill_4$1
XFILLER_41_161 vssd1 vccd1 vccd1 vssd1 sky130_fd_sc_hd__fill_4$1
XFILLER_128_701 vssd1 vccd1 vccd1 vssd1 sky130_ef_sc_hd__decap_40_12$1
X_0760_ _1842_/A _0881_/B1 _0760_/X _1638_/Q _1213_/A vccd1 vssd1 vccd1 vssd1 sky130_fd_sc_hd__a22o_1$1
XFILLER_10_581 vssd1 vccd1 vccd1 vssd1 sky130_fd_sc_hd__fill_4$1
XTAP_TAPCELL_ROW_40_896 vccd1 vssd1 sky130_fd_sc_hd__tapvpwrvgnd_1$1
XFILLER_128_778 vssd1 vccd1 vccd1 vssd1 sky130_ef_sc_hd__decap_40_12$1
XFILLER_127_277 vssd1 vccd1 vccd1 vssd1 sky130_fd_sc_hd__fill_2$1
XFILLER_115_417 vssd1 vccd1 vccd1 vssd1 sky130_ef_sc_hd__decap_40_12$1
XFILLER_6_585 vssd1 vccd1 vccd1 vssd1 sky130_fd_sc_hd__fill_2$1
XFILLER_123_461 vssd1 vccd1 vccd1 vssd1 sky130_ef_sc_hd__decap_40_12$1
XFILLER_97_813 vssd1 vccd1 vccd1 vssd1 sky130_fd_sc_hd__fill_8$1
XFILLER_96_301 vssd1 vccd1 vccd1 vssd1 sky130_fd_sc_hd__fill_4$1
X_1312_ hold34/X _1312_/X _1330_/B vssd1 vccd1 vccd1 vssd1 sky130_fd_sc_hd__or2_1$1
XFILLER_96_345 vssd1 vccd1 vccd1 vssd1 sky130_ef_sc_hd__decap_40_12$1
XFILLER_69_559 vccd1 vssd1 vccd1 vssd1 sky130_fd_sc_hd__fill_1$1
XFILLER_69_537 vssd1 vccd1 vccd1 vssd1 sky130_fd_sc_hd__fill_2$1
XFILLER_110_133 vssd1 vccd1 vccd1 vssd1 sky130_fd_sc_hd__fill_4$1
X_1243_ _1441_/C1 _1242_/X _1273_/A2 hold172/X _1651_/D vssd1 vccd1 vccd1 vssd1 sky130_fd_sc_hd__o211a_1$1
XFILLER_84_529 vssd1 vccd1 vccd1 vssd1 sky130_fd_sc_hd__fill_2$1
XFILLER_56_209 vssd1 vccd1 vccd1 vssd1 sky130_ef_sc_hd__decap_40_12$1
XFILLER_2_41 vssd1 vccd1 vccd1 vssd1 sky130_ef_sc_hd__decap_40_12$1
XFILLER_110_177 vssd1 vccd1 vccd1 vssd1 sky130_ef_sc_hd__decap_40_12$1
XTAP_TAPCELL_ROW_88_1622 vccd1 vssd1 sky130_fd_sc_hd__tapvpwrvgnd_1$1
XFILLER_65_721 vssd1 vccd1 vccd1 vssd1 sky130_fd_sc_hd__fill_4$1
XFILLER_2_85 vssd1 vccd1 vccd1 vssd1 sky130_ef_sc_hd__decap_40_12$1
XFILLER_49_261 vssd1 vccd1 vccd1 vssd1 sky130_ef_sc_hd__decap_40_12$1
X_1174_ _1822_/A _1174_/X _1188_/B vssd1 vccd1 vccd1 vssd1 sky130_fd_sc_hd__or2_1$1
XFILLER_65_765 vssd1 vccd1 vccd1 vssd1 sky130_ef_sc_hd__decap_40_12$1
XFILLER_37_445 vssd1 vccd1 vccd1 vssd1 sky130_fd_sc_hd__fill_2$1
XFILLER_80_713 vssd1 vccd1 vccd1 vssd1 sky130_ef_sc_hd__decap_40_12$1
XFILLER_64_253 vssd1 vccd1 vccd1 vssd1 sky130_ef_sc_hd__decap_40_12$1
XFILLER_18_681 vssd1 vccd1 vccd1 vssd1 sky130_ef_sc_hd__decap_40_12$1
XFILLER_25_629 vssd1 vccd1 vccd1 vssd1 sky130_ef_sc_hd__decap_40_12$1
XFILLER_80_757 vssd1 vccd1 vccd1 vssd1 sky130_ef_sc_hd__decap_40_12$1
XFILLER_24_139 vccd1 vssd1 vccd1 vssd1 sky130_fd_sc_hd__fill_1$1
XANTENNA_13 hold61/A vssd1 vccd1 vccd1 vssd1 sky130_fd_sc_hd__diode_2$1
XFILLER_60_470 vssd1 vccd1 vccd1 vssd1 sky130_fd_sc_hd__fill_4$1
XFILLER_20_301 vssd1 vccd1 vccd1 vssd1 sky130_fd_sc_hd__fill_4$1
XFILLER_119_723 vssd1 vccd1 vccd1 vssd1 sky130_fd_sc_hd__fill_4$1
XANTENNA_24 _0747_/X vssd1 vccd1 vccd1 vssd1 sky130_fd_sc_hd__diode_2$1
XFILLER_20_345 vssd1 vccd1 vccd1 vssd1 sky130_ef_sc_hd__decap_40_12$1
XTAP_TAPCELL_ROW_115_2018 vccd1 vssd1 sky130_fd_sc_hd__tapvpwrvgnd_1$1
XFILLER_20_389 vssd1 vccd1 vccd1 vssd1 sky130_ef_sc_hd__decap_40_12$1
X_0958_ _1786_/A _0958_/X _0990_/B vssd1 vccd1 vccd1 vssd1 sky130_fd_sc_hd__or2_1$1
XFILLER_118_233 vssd1 vccd1 vccd1 vssd1 sky130_ef_sc_hd__decap_40_12$1
XTAP_TAPCELL_ROW_115_2029 vccd1 vssd1 sky130_fd_sc_hd__tapvpwrvgnd_1$1
XTAP_TAPCELL_ROW_99_1784 vccd1 vssd1 sky130_fd_sc_hd__tapvpwrvgnd_1$1
XFILLER_21_39 vssd1 vccd1 vccd1 vssd1 sky130_ef_sc_hd__decap_40_12$1
XFILLER_134_737 vccd1 vssd1 vccd1 vssd1 sky130_fd_sc_hd__fill_1$1
XFILLER_133_225 vssd1 vccd1 vccd1 vssd1 sky130_ef_sc_hd__decap_40_12$1
X_0889_ hold95/A _0949_/A _0891_/B _1691_/Q _1279_/A vccd1 vssd1 vccd1 vssd1 sky130_fd_sc_hd__a22o_1$1
XFILLER_118_277 vssd1 vccd1 vccd1 vssd1 sky130_ef_sc_hd__decap_40_12$1
Xoutput142 _1645_/Q analog_ctrl[72] vssd1 vccd1 vccd1 vssd1 sky130_fd_sc_hd__buf_12$1
Xoutput131 _1833_/X analog_ctrl[62] vssd1 vccd1 vccd1 vssd1 sky130_fd_sc_hd__buf_12$1
Xoutput120 _1823_/X analog_ctrl[52] vssd1 vccd1 vccd1 vssd1 sky130_fd_sc_hd__buf_12$1
Xoutput186 _1500_/Q wbs_dat_o[23] vssd1 vccd1 vccd1 vssd1 sky130_fd_sc_hd__buf_12$1
Xoutput175 _1490_/Q wbs_dat_o[13] vssd1 vccd1 vccd1 vssd1 sky130_fd_sc_hd__buf_12$1
XFILLER_102_601 vssd1 vccd1 vccd1 vssd1 sky130_ef_sc_hd__decap_40_12$1
Xoutput164 _1666_/Q analog_ctrl[93] vssd1 vccd1 vccd1 vssd1 sky130_fd_sc_hd__buf_12$1
XFILLER_99_161 vssd1 vccd1 vccd1 vssd1 sky130_fd_sc_hd__fill_4$1
Xoutput153 _1656_/Q analog_ctrl[83] vssd1 vccd1 vccd1 vssd1 sky130_fd_sc_hd__buf_12$1
XFILLER_88_813 vssd1 vccd1 vccd1 vssd1 sky130_ef_sc_hd__decap_40_12$1
Xoutput197 _1481_/Q wbs_dat_o[4] vssd1 vccd1 vccd1 vssd1 sky130_fd_sc_hd__buf_12$1
XTAP_TAPCELL_ROW_110_1951 vccd1 vssd1 sky130_fd_sc_hd__tapvpwrvgnd_1$1
XFILLER_102_645 vssd1 vccd1 vccd1 vssd1 sky130_ef_sc_hd__decap_40_12$1
XFILLER_101_111 vccd1 vssd1 vccd1 vssd1 sky130_fd_sc_hd__fill_1$1
XFILLER_75_529 vssd1 vccd1 vccd1 vssd1 sky130_ef_sc_hd__decap_40_12$1
XTAP_TAPCELL_ROW_52_1080 vccd1 vssd1 sky130_fd_sc_hd__tapvpwrvgnd_1$1
XFILLER_28_401 vssd1 vccd1 vccd1 vssd1 sky130_ef_sc_hd__decap_40_12$1
XFILLER_56_776 vssd1 vccd1 vccd1 vssd1 sky130_fd_sc_hd__fill_2$1
XFILLER_28_445 vssd1 vccd1 vccd1 vssd1 sky130_ef_sc_hd__decap_40_12$1
XFILLER_71_713 vssd1 vccd1 vccd1 vssd1 sky130_ef_sc_hd__decap_40_12$1
XFILLER_28_489 vssd1 vccd1 vccd1 vssd1 sky130_ef_sc_hd__decap_40_12$1
XFILLER_102_53 vssd1 vccd1 vccd1 vssd1 sky130_ef_sc_hd__decap_40_12$1
XFILLER_70_245 vssd1 vccd1 vccd1 vssd1 sky130_fd_sc_hd__fill_4$1
XFILLER_102_97 vssd1 vccd1 vccd1 vssd1 sky130_ef_sc_hd__decap_40_12$1
XFILLER_12_813 vssd1 vccd1 vccd1 vssd1 sky130_fd_sc_hd__fill_8$1
XFILLER_30_109 vssd1 vccd1 vccd1 vssd1 sky130_ef_sc_hd__decap_40_12$1
XFILLER_70_289 vssd1 vccd1 vccd1 vssd1 sky130_ef_sc_hd__decap_40_12$1
XFILLER_51_481 vccd1 vssd1 vccd1 vssd1 sky130_fd_sc_hd__fill_1$1
XFILLER_23_161 vssd1 vccd1 vccd1 vssd1 sky130_fd_sc_hd__fill_4$1
XFILLER_134_3 vssd1 vccd1 vccd1 vssd1 sky130_ef_sc_hd__decap_40_12$1
XFILLER_7_305 vssd1 vccd1 vccd1 vssd1 sky130_ef_sc_hd__decap_40_12$1
XFILLER_11_389 vssd1 vccd1 vccd1 vssd1 sky130_fd_sc_hd__fill_2$1
XFILLER_137_553 vssd1 vccd1 vccd1 vssd1 sky130_fd_sc_hd__fill_4$1
XFILLER_7_349 vssd1 vccd1 vccd1 vssd1 sky130_ef_sc_hd__decap_40_12$1
XFILLER_109_277 vssd1 vccd1 vccd1 vssd1 sky130_fd_sc_hd__fill_2$1
XFILLER_133_781 vssd1 vccd1 vccd1 vssd1 sky130_fd_sc_hd__fill_2$1
XFILLER_105_461 vssd1 vccd1 vccd1 vssd1 sky130_ef_sc_hd__decap_40_12$1
XFILLER_97_109 vssd1 vccd1 vccd1 vssd1 sky130_fd_sc_hd__fill_2$1
XFILLER_78_301 vssd1 vccd1 vccd1 vssd1 sky130_fd_sc_hd__fill_4$1
XFILLER_105_494 vssd1 vccd1 vccd1 vssd1 sky130_fd_sc_hd__fill_8$1
XFILLER_78_345 vssd1 vccd1 vccd1 vssd1 sky130_ef_sc_hd__decap_40_12$1
XFILLER_94_805 vssd1 vccd1 vccd1 vssd1 sky130_fd_sc_hd__fill_4$1
XFILLER_38_209 vssd1 vccd1 vccd1 vssd1 sky130_ef_sc_hd__decap_40_12$1
XFILLER_93_337 vssd1 vccd1 vccd1 vssd1 sky130_ef_sc_hd__decap_40_12$1
XTAP_TAPCELL_ROW_6_393 vccd1 vssd1 sky130_fd_sc_hd__tapvpwrvgnd_1$1
XFILLER_19_445 vssd1 vccd1 vccd1 vssd1 sky130_fd_sc_hd__fill_2$1
XFILLER_74_562 vssd1 vccd1 vccd1 vssd1 sky130_ef_sc_hd__decap_40_12$1
Xafe_wb_280 analog_ctrl[7] afe_wb_280/HI vssd1 vccd1 vccd1 vssd1 sky130_fd_sc_hd__conb_1$1
XFILLER_46_253 vssd1 vccd1 vccd1 vssd1 sky130_ef_sc_hd__decap_40_12$1
XFILLER_62_757 vssd1 vccd1 vccd1 vssd1 sky130_ef_sc_hd__decap_40_12$1
XFILLER_61_223 vccd1 vssd1 vccd1 vssd1 sky130_fd_sc_hd__fill_1$1
XTAP_TAPCELL_ROW_83_1552 vccd1 vssd1 sky130_fd_sc_hd__tapvpwrvgnd_1$1
XTAP_TAPCELL_ROW_83_1541 vccd1 vssd1 sky130_fd_sc_hd__tapvpwrvgnd_1$1
XFILLER_15_673 vssd1 vccd1 vccd1 vssd1 sky130_ef_sc_hd__decap_40_12$1
XFILLER_21_109 vssd1 vccd1 vccd1 vssd1 sky130_fd_sc_hd__fill_2$1
XTAP_TAPCELL_ROW_45_977 vccd1 vssd1 sky130_fd_sc_hd__tapvpwrvgnd_1$1
XFILLER_30_643 vccd1 vssd1 vccd1 vssd1 sky130_fd_sc_hd__fill_1$1
Xinput22 input22/X vccd1 vssd1 input22/A vccd1 vssd1 sky130_fd_sc_hd__buf_4$1
XFILLER_128_531 vccd1 vssd1 vccd1 vssd1 sky130_fd_sc_hd__fill_1$1
X_0812_ _0879_/B1 _0812_/X _0811_/X _1833_/A _0878_/B1 _0810_/X vssd1 vccd1 vccd1
+ vssd1 sky130_fd_sc_hd__a2111o_1$1
Xinput11 vccd1 vssd1 input11/X adc_data[8] vccd1 vssd1 sky130_fd_sc_hd__buf_1$1
Xinput44 vccd1 vssd1 hold2/A hold1/X vccd1 vssd1 sky130_fd_sc_hd__buf_2$1
Xinput33 vccd1 vssd1 input33/X input33/A vccd1 vssd1 sky130_fd_sc_hd__buf_2$1
X_1792_ vccd1 vssd1 _1792_/X _1792_/A vccd1 vssd1 sky130_fd_sc_hd__buf_1$1
X_0743_ _1787_/A _0879_/A2 _0758_/A _1781_/A _0875_/A2 vccd1 vssd1 vccd1 vssd1 sky130_fd_sc_hd__a22o_1$1
XFILLER_115_225 vssd1 vccd1 vccd1 vssd1 sky130_ef_sc_hd__decap_40_12$1
XFILLER_131_729 vssd1 vccd1 vccd1 vssd1 sky130_fd_sc_hd__fill_8$1
XFILLER_88_109 vssd1 vccd1 vccd1 vssd1 sky130_ef_sc_hd__decap_40_12$1
XFILLER_97_665 vssd1 vccd1 vccd1 vssd1 sky130_fd_sc_hd__fill_4$1
XFILLER_96_153 vssd1 vccd1 vccd1 vssd1 sky130_ef_sc_hd__decap_40_12$1
XFILLER_111_486 vssd1 vccd1 vccd1 vssd1 sky130_ef_sc_hd__decap_40_12$1
XFILLER_96_197 vssd1 vccd1 vccd1 vssd1 sky130_ef_sc_hd__decap_40_12$1
XFILLER_69_389 vssd1 vccd1 vccd1 vssd1 sky130_fd_sc_hd__fill_2$1
X_1226_ _1643_/Q _1226_/X _1270_/B vssd1 vccd1 vccd1 vssd1 sky130_fd_sc_hd__or2_1$1
X_1157_ _1289_/C1 _1156_/X _1189_/A2 hold61/X _1609_/D vssd1 vccd1 vccd1 vssd1 sky130_fd_sc_hd__o211a_1$1
XTAP_TAPCELL_ROW_125_2180 vccd1 vssd1 sky130_fd_sc_hd__tapvpwrvgnd_1$1
XFILLER_52_245 vssd1 vccd1 vccd1 vssd1 sky130_fd_sc_hd__fill_4$1
XFILLER_12_109 vssd1 vccd1 vccd1 vssd1 sky130_ef_sc_hd__decap_40_12$1
X_1088_ _1790_/A _1088_/X _1122_/B vssd1 vccd1 vccd1 vssd1 sky130_fd_sc_hd__or2_1$1
XFILLER_52_289 vssd1 vccd1 vccd1 vssd1 sky130_ef_sc_hd__decap_40_12$1
XTAP_TAPCELL_ROW_23_638 vccd1 vssd1 sky130_fd_sc_hd__tapvpwrvgnd_1$1
XFILLER_21_665 vssd1 vccd1 vccd1 vssd1 sky130_fd_sc_hd__fill_4$1
XTAP_TAPCELL_ROW_23_649 vccd1 vssd1 sky130_fd_sc_hd__tapvpwrvgnd_1$1
XFILLER_32_27 vccd1 vssd1 vccd1 vssd1 sky130_fd_sc_hd__fill_1$1
XFILLER_119_520 vssd1 vccd1 vccd1 vssd1 sky130_ef_sc_hd__decap_40_12$1
XFILLER_20_153 vssd1 vccd1 vccd1 vssd1 sky130_ef_sc_hd__decap_40_12$1
XFILLER_5_809 vssd1 vccd1 vccd1 vssd1 sky130_ef_sc_hd__decap_40_12$1
XFILLER_20_197 vssd1 vccd1 vccd1 vssd1 sky130_ef_sc_hd__decap_40_12$1
XFILLER_119_597 vssd1 vccd1 vccd1 vssd1 sky130_ef_sc_hd__decap_40_12$1
XFILLER_134_589 vssd1 vccd1 vccd1 vssd1 sky130_fd_sc_hd__fill_2$1
XFILLER_121_217 vssd1 vccd1 vccd1 vssd1 sky130_fd_sc_hd__fill_4$1
XFILLER_79_109 vssd1 vccd1 vccd1 vssd1 sky130_fd_sc_hd__fill_2$1
XFILLER_115_781 vssd1 vccd1 vccd1 vssd1 sky130_fd_sc_hd__fill_2$1
XFILLER_88_643 vccd1 vssd1 vccd1 vssd1 sky130_fd_sc_hd__fill_1$1
XFILLER_0_558 vssd1 vccd1 vccd1 vssd1 sky130_fd_sc_hd__fill_2$1
XFILLER_102_475 vccd1 vssd1 vccd1 vssd1 sky130_fd_sc_hd__fill_1$1
XFILLER_75_337 vssd1 vccd1 vccd1 vssd1 sky130_ef_sc_hd__decap_40_12$1
XFILLER_57_57 vssd1 vccd1 vccd1 vssd1 sky130_ef_sc_hd__decap_40_12$1
XFILLER_29_721 vssd1 vccd1 vccd1 vssd1 sky130_fd_sc_hd__fill_4$1
XTAP_TAPCELL_ROW_3_352 vccd1 vssd1 sky130_fd_sc_hd__tapvpwrvgnd_1$1
XTAP_TAPCELL_ROW_3_341 vccd1 vssd1 sky130_fd_sc_hd__tapvpwrvgnd_1$1
XFILLER_29_765 vssd1 vccd1 vccd1 vssd1 sky130_ef_sc_hd__decap_40_12$1
XFILLER_90_307 vccd1 vssd1 vccd1 vssd1 sky130_fd_sc_hd__fill_1$1
XFILLER_28_253 vssd1 vccd1 vccd1 vssd1 sky130_ef_sc_hd__decap_40_12$1
XFILLER_44_713 vssd1 vccd1 vccd1 vssd1 sky130_ef_sc_hd__decap_40_12$1
XFILLER_71_521 vssd1 vccd1 vccd1 vssd1 sky130_ef_sc_hd__decap_40_12$1
XFILLER_43_223 vccd1 vssd1 vccd1 vssd1 sky130_fd_sc_hd__fill_1$1
XFILLER_44_757 vssd1 vccd1 vccd1 vssd1 sky130_ef_sc_hd__decap_40_12$1
XPHY_EDGE_ROW_125_Right_125 vccd1 vssd1 vccd1 vssd1 sky130_fd_sc_hd__decap_3$1
XTAP_TAPCELL_ROW_65_1282 vccd1 vssd1 sky130_fd_sc_hd__tapvpwrvgnd_1$1
XTAP_TAPCELL_ROW_65_1271 vccd1 vssd1 sky130_fd_sc_hd__tapvpwrvgnd_1$1
XFILLER_31_429 vssd1 vccd1 vccd1 vssd1 sky130_ef_sc_hd__decap_40_12$1
XTAP_TAPCELL_ROW_42_925 vccd1 vssd1 sky130_fd_sc_hd__tapvpwrvgnd_1$1
XTAP_TAPCELL_ROW_42_936 vccd1 vssd1 sky130_fd_sc_hd__tapvpwrvgnd_1$1
XFILLER_12_643 vccd1 vssd1 vccd1 vssd1 sky130_fd_sc_hd__fill_1$1
XFILLER_8_625 vssd1 vccd1 vccd1 vssd1 sky130_ef_sc_hd__decap_40_12$1
XFILLER_7_113 vssd1 vccd1 vccd1 vssd1 sky130_ef_sc_hd__decap_40_12$1
XFILLER_8_669 vssd1 vccd1 vccd1 vssd1 sky130_ef_sc_hd__decap_40_12$1
XFILLER_137_361 vssd1 vccd1 vccd1 vssd1 sky130_ef_sc_hd__decap_40_12$1
Xclkbuf_leaf_4_wb_clk_i _1748_/CLK clkbuf_leaf_9_wb_clk_i/A vssd1 vccd1 vccd1 vssd1
+ sky130_fd_sc_hd__clkbuf_8$1
XFILLER_98_53 vssd1 vccd1 vccd1 vssd1 sky130_ef_sc_hd__decap_40_12$1
XFILLER_125_589 vssd1 vccd1 vccd1 vssd1 sky130_fd_sc_hd__fill_8$1
XFILLER_113_729 vssd1 vccd1 vccd1 vssd1 sky130_ef_sc_hd__decap_40_12$1
XFILLER_98_418 vssd1 vccd1 vccd1 vssd1 sky130_fd_sc_hd__fill_2$1
XFILLER_106_781 vssd1 vccd1 vccd1 vssd1 sky130_ef_sc_hd__decap_40_12$1
XFILLER_98_97 vssd1 vccd1 vccd1 vssd1 sky130_ef_sc_hd__decap_40_12$1
XFILLER_3_385 vssd1 vccd1 vccd1 vssd1 sky130_fd_sc_hd__fill_4$1
XFILLER_79_665 vssd1 vccd1 vccd1 vssd1 sky130_fd_sc_hd__fill_4$1
XFILLER_78_153 vssd1 vccd1 vccd1 vssd1 sky130_ef_sc_hd__decap_40_12$1
XFILLER_94_613 vssd1 vccd1 vccd1 vssd1 sky130_ef_sc_hd__decap_40_12$1
XFILLER_39_529 vssd1 vccd1 vccd1 vssd1 sky130_ef_sc_hd__decap_40_12$1
XFILLER_94_657 vssd1 vccd1 vccd1 vssd1 sky130_ef_sc_hd__decap_40_12$1
XFILLER_78_197 vssd1 vccd1 vccd1 vssd1 sky130_ef_sc_hd__decap_40_12$1
X_1011_ _1475_/C1 _1010_/X _1013_/A2 hold64/X _1539_/D vssd1 vccd1 vccd1 vssd1 sky130_fd_sc_hd__o211a_1$1
XFILLER_93_167 vccd1 vssd1 vccd1 vssd1 sky130_fd_sc_hd__fill_1$1
XFILLER_81_329 vssd1 vccd1 vccd1 vssd1 sky130_fd_sc_hd__fill_4$1
XFILLER_90_841 vccd1 vssd1 vccd1 vssd1 sky130_fd_sc_hd__fill_1$1
XFILLER_74_392 vssd1 vccd1 vccd1 vssd1 sky130_fd_sc_hd__fill_8$1
XFILLER_62_521 vssd1 vccd1 vccd1 vssd1 sky130_fd_sc_hd__fill_2$1
XFILLER_47_584 vssd1 vccd1 vccd1 vssd1 sky130_fd_sc_hd__fill_4$1
XFILLER_62_576 vssd1 vccd1 vccd1 vssd1 sky130_fd_sc_hd__fill_2$1
XFILLER_34_245 vssd1 vccd1 vccd1 vssd1 sky130_fd_sc_hd__fill_4$1
XFILLER_97_3 vssd1 vccd1 vccd1 vssd1 sky130_ef_sc_hd__decap_40_12$1
XFILLER_62_587 vccd1 vssd1 vccd1 vssd1 sky130_fd_sc_hd__fill_1$1
XFILLER_34_289 vssd1 vccd1 vccd1 vssd1 sky130_ef_sc_hd__decap_40_12$1
XFILLER_30_473 vssd1 vccd1 vccd1 vssd1 sky130_fd_sc_hd__fill_2$1
X_1844_ _1844_/A _1844_/X vssd1 vccd1 vccd1 vssd1 sky130_fd_sc_hd__clkbuf_2$1
XFILLER_128_361 vssd1 vccd1 vccd1 vssd1 sky130_fd_sc_hd__fill_2$1
XFILLER_116_501 vssd1 vccd1 vccd1 vssd1 sky130_fd_sc_hd__fill_4$1
XTAP_TAPCELL_ROW_96_1743 vccd1 vssd1 sky130_fd_sc_hd__tapvpwrvgnd_1$1
X_1775_ vccd1 vssd1 _1775_/X _1775_/A vccd1 vssd1 sky130_fd_sc_hd__buf_1$1
XFILLER_116_545 vssd1 vccd1 vccd1 vssd1 sky130_ef_sc_hd__decap_40_12$1
XFILLER_116_589 vssd1 vccd1 vccd1 vssd1 sky130_ef_sc_hd__decap_40_12$1
XFILLER_103_217 vssd1 vccd1 vccd1 vssd1 sky130_fd_sc_hd__fill_4$1
XFILLER_134_29 vssd1 vccd1 vccd1 vssd1 sky130_ef_sc_hd__decap_40_12$1
XFILLER_131_559 vccd1 vssd1 vccd1 vssd1 sky130_fd_sc_hd__fill_1$1
XFILLER_111_261 vssd1 vccd1 vccd1 vssd1 sky130_ef_sc_hd__decap_40_12$1
XFILLER_85_613 vssd1 vccd1 vccd1 vssd1 sky130_fd_sc_hd__fill_2$1
XFILLER_57_337 vssd1 vccd1 vccd1 vssd1 sky130_ef_sc_hd__decap_40_12$1
XFILLER_27_27 vssd1 vccd1 vccd1 vssd1 sky130_ef_sc_hd__decap_40_12$1
X_1209_ _1409_/C1 _1208_/X _1211_/A2 hold64/X hold65/A vssd1 vccd1 vccd1 vssd1 sky130_fd_sc_hd__o211a_1$1
XFILLER_72_307 vccd1 vssd1 vccd1 vssd1 sky130_fd_sc_hd__fill_1$1
XTAP_TAPCELL_ROW_0_300 vccd1 vssd1 sky130_fd_sc_hd__tapvpwrvgnd_1$1
XTAP_TAPCELL_ROW_28_719 vccd1 vssd1 sky130_fd_sc_hd__tapvpwrvgnd_1$1
XTAP_TAPCELL_ROW_123_2139 vccd1 vssd1 sky130_fd_sc_hd__tapvpwrvgnd_1$1
XFILLER_84_189 vssd1 vccd1 vccd1 vssd1 sky130_fd_sc_hd__fill_4$1
XFILLER_81_841 vccd1 vssd1 vccd1 vssd1 sky130_fd_sc_hd__fill_1$1
XFILLER_25_223 vccd1 vssd1 vccd1 vssd1 sky130_fd_sc_hd__fill_1$1
XTAP_TAPCELL_ROW_105_1872 vccd1 vssd1 sky130_fd_sc_hd__tapvpwrvgnd_1$1
XFILLER_13_429 vssd1 vccd1 vccd1 vssd1 sky130_ef_sc_hd__decap_40_12$1
XFILLER_43_15 vssd1 vccd1 vccd1 vssd1 sky130_ef_sc_hd__decap_40_12$1
XFILLER_21_473 vssd1 vccd1 vccd1 vssd1 sky130_ef_sc_hd__decap_40_12$1
XTAP_TAPCELL_ROW_138_2382 vccd1 vssd1 sky130_fd_sc_hd__tapvpwrvgnd_1$1
XTAP_TAPCELL_ROW_138_2371 vccd1 vssd1 sky130_fd_sc_hd__tapvpwrvgnd_1$1
XFILLER_126_309 vssd1 vccd1 vccd1 vssd1 sky130_ef_sc_hd__decap_40_12$1
XFILLER_119_361 vssd1 vccd1 vccd1 vssd1 sky130_ef_sc_hd__decap_40_12$1
XFILLER_5_617 vssd1 vccd1 vccd1 vssd1 sky130_ef_sc_hd__decap_40_12$1
XFILLER_108_41 vssd1 vccd1 vccd1 vssd1 sky130_ef_sc_hd__decap_40_12$1
XFILLER_108_85 vssd1 vccd1 vccd1 vssd1 sky130_ef_sc_hd__decap_40_12$1
XTAP_TAPCELL_ROW_8_422 vccd1 vssd1 sky130_fd_sc_hd__tapvpwrvgnd_1$1
XFILLER_0_333 vssd1 vccd1 vccd1 vssd1 sky130_fd_sc_hd__fill_2$1
XFILLER_76_624 vssd1 vccd1 vccd1 vssd1 sky130_ef_sc_hd__decap_40_12$1
XFILLER_0_377 vssd1 vccd1 vccd1 vssd1 sky130_ef_sc_hd__decap_40_12$1
XFILLER_75_167 vccd1 vssd1 vccd1 vssd1 sky130_fd_sc_hd__fill_1$1
XTAP_TAPCELL_ROW_67_1300 vccd1 vssd1 sky130_fd_sc_hd__tapvpwrvgnd_1$1
XFILLER_64_819 vccd1 vssd1 vccd1 vssd1 sky130_fd_sc_hd__fill_1$1
XFILLER_29_573 vssd1 vccd1 vccd1 vssd1 sky130_ef_sc_hd__decap_40_12$1
XFILLER_90_137 vssd1 vccd1 vccd1 vssd1 sky130_fd_sc_hd__fill_2$1
XFILLER_84_77 vssd1 vccd1 vccd1 vssd1 sky130_fd_sc_hd__fill_4$1
XTAP_TAPCELL_ROW_67_1311 vccd1 vssd1 sky130_fd_sc_hd__tapvpwrvgnd_1$1
XFILLER_63_329 vssd1 vccd1 vccd1 vssd1 sky130_fd_sc_hd__fill_4$1
XFILLER_56_381 vccd1 vssd1 vccd1 vssd1 sky130_fd_sc_hd__fill_1$1
XFILLER_16_245 vssd1 vccd1 vccd1 vssd1 sky130_fd_sc_hd__fill_4$1
XTAP_TAPCELL_ROW_80_1500 vccd1 vssd1 sky130_fd_sc_hd__tapvpwrvgnd_1$1
XFILLER_71_373 vssd1 vccd1 vccd1 vssd1 sky130_ef_sc_hd__decap_40_12$1
XFILLER_16_289 vssd1 vccd1 vccd1 vssd1 sky130_ef_sc_hd__decap_40_12$1
XFILLER_17_93 vssd1 vccd1 vccd1 vssd1 sky130_ef_sc_hd__decap_40_12$1
XFILLER_32_738 vccd1 vssd1 vccd1 vssd1 sky130_fd_sc_hd__fill_1$1
XFILLER_44_587 vccd1 vssd1 vccd1 vssd1 sky130_fd_sc_hd__fill_1$1
XFILLER_71_395 vccd1 vssd1 vccd1 vssd1 sky130_fd_sc_hd__fill_1$1
XFILLER_31_237 vssd1 vccd1 vccd1 vssd1 sky130_ef_sc_hd__decap_40_12$1
XFILLER_129_125 vssd1 vccd1 vccd1 vssd1 sky130_ef_sc_hd__decap_40_12$1
XFILLER_12_473 vssd1 vccd1 vccd1 vssd1 sky130_fd_sc_hd__fill_2$1
XFILLER_8_433 vssd1 vccd1 vccd1 vssd1 sky130_ef_sc_hd__decap_40_12$1
XFILLER_33_81 vssd1 vccd1 vccd1 vssd1 sky130_ef_sc_hd__decap_40_12$1
XFILLER_40_793 vssd1 vccd1 vccd1 vssd1 sky130_fd_sc_hd__fill_8$1
XFILLER_129_169 vssd1 vccd1 vccd1 vssd1 sky130_ef_sc_hd__decap_40_12$1
XFILLER_126_810 vssd1 vccd1 vccd1 vssd1 sky130_fd_sc_hd__fill_2$1
XFILLER_8_477 vssd1 vccd1 vccd1 vssd1 sky130_ef_sc_hd__decap_40_12$1
X_1560_ _1560_/Q _1752_/CLK _1560_/D vccd1 vssd1 vccd1 vssd1 sky130_fd_sc_hd__dfxtp_1$1
XTAP_TAPCELL_ROW_78_1473 vccd1 vssd1 sky130_fd_sc_hd__tapvpwrvgnd_1$1
XFILLER_99_727 vccd1 vssd1 vccd1 vssd1 sky130_fd_sc_hd__fill_1$1
X_1491_ _1491_/Q _1720_/CLK _1491_/D vccd1 vssd1 vccd1 vssd1 sky130_fd_sc_hd__dfxtp_1$1
XFILLER_113_559 vccd1 vssd1 vccd1 vssd1 sky130_fd_sc_hd__fill_1$1
XTAP_TAPCELL_ROW_91_1662 vccd1 vssd1 sky130_fd_sc_hd__tapvpwrvgnd_1$1
XFILLER_3_193 vssd1 vccd1 vccd1 vssd1 sky130_ef_sc_hd__decap_40_12$1
XFILLER_100_209 vssd1 vccd1 vccd1 vssd1 sky130_ef_sc_hd__decap_40_12$1
XFILLER_79_484 vccd1 vssd1 vccd1 vssd1 sky130_fd_sc_hd__fill_1$1
XFILLER_67_613 vssd1 vccd1 vccd1 vssd1 sky130_fd_sc_hd__fill_2$1
XFILLER_12_3 vssd1 vccd1 vccd1 vssd1 sky130_ef_sc_hd__decap_40_12$1
XFILLER_39_337 vssd1 vccd1 vccd1 vssd1 sky130_ef_sc_hd__decap_40_12$1
XFILLER_94_487 vccd1 vssd1 vccd1 vssd1 sky130_fd_sc_hd__fill_1$1
XFILLER_54_307 vccd1 vssd1 vccd1 vssd1 sky130_fd_sc_hd__fill_1$1
XFILLER_81_137 vssd1 vccd1 vccd1 vssd1 sky130_ef_sc_hd__decap_40_12$1
XFILLER_66_189 vssd1 vccd1 vccd1 vssd1 sky130_fd_sc_hd__fill_4$1
XFILLER_63_841 vccd1 vssd1 vccd1 vssd1 sky130_fd_sc_hd__fill_1$1
XFILLER_50_513 vssd1 vccd1 vccd1 vssd1 sky130_fd_sc_hd__fill_8$1
XFILLER_23_727 vccd1 vssd1 vccd1 vssd1 sky130_fd_sc_hd__fill_1$1
XFILLER_50_557 vssd1 vccd1 vccd1 vssd1 sky130_ef_sc_hd__decap_40_12$1
XTAP_TAPCELL_ROW_33_788 vccd1 vssd1 sky130_fd_sc_hd__tapvpwrvgnd_1$1
XTAP_TAPCELL_ROW_33_799 vccd1 vssd1 sky130_fd_sc_hd__tapvpwrvgnd_1$1
XFILLER_108_309 vssd1 vccd1 vccd1 vssd1 sky130_ef_sc_hd__decap_40_12$1
X_1827_ vccd1 vssd1 _1827_/X _1827_/A vccd1 vssd1 sky130_fd_sc_hd__buf_1$1
XTAP_TAPCELL_ROW_13_490 vccd1 vssd1 sky130_fd_sc_hd__tapvpwrvgnd_1$1
XFILLER_132_813 vssd1 vccd1 vccd1 vssd1 sky130_fd_sc_hd__fill_4$1
XTAP_TAPCELL_ROW_133_2290 vccd1 vssd1 sky130_fd_sc_hd__tapvpwrvgnd_1$1
X_1758_ _1758_/Q _1759_/CLK _1758_/D vccd1 vssd1 vccd1 vssd1 sky130_fd_sc_hd__dfxtp_1$1
XFILLER_104_504 vssd1 vccd1 vccd1 vssd1 sky130_ef_sc_hd__decap_40_12$1
XFILLER_89_237 vssd1 vccd1 vccd1 vssd1 sky130_ef_sc_hd__decap_40_12$1
X_1689_ _1689_/Q _1721_/CLK _1689_/D vccd1 vssd1 vccd1 vssd1 sky130_fd_sc_hd__dfxtp_1$1
XFILLER_131_389 vssd1 vccd1 vccd1 vssd1 sky130_fd_sc_hd__fill_2$1
XFILLER_38_15 vssd1 vccd1 vccd1 vssd1 sky130_ef_sc_hd__decap_40_12$1
XFILLER_112_581 vssd1 vccd1 vccd1 vssd1 sky130_fd_sc_hd__fill_4$1
XFILLER_97_281 vssd1 vccd1 vccd1 vssd1 sky130_ef_sc_hd__decap_40_12$1
XFILLER_58_657 vssd1 vccd1 vccd1 vssd1 sky130_ef_sc_hd__decap_40_12$1
XTAP_TAPCELL_ROW_107_1901 vccd1 vssd1 sky130_fd_sc_hd__tapvpwrvgnd_1$1
XFILLER_57_167 vccd1 vssd1 vccd1 vssd1 sky130_fd_sc_hd__fill_1$1
XTAP_TAPCELL_ROW_107_1912 vccd1 vssd1 sky130_fd_sc_hd__tapvpwrvgnd_1$1
XFILLER_72_137 vssd1 vccd1 vccd1 vssd1 sky130_fd_sc_hd__fill_2$1
XFILLER_45_329 vssd1 vccd1 vccd1 vssd1 sky130_fd_sc_hd__fill_4$1
XTAP_TAPCELL_ROW_49_1041 vccd1 vssd1 sky130_fd_sc_hd__tapvpwrvgnd_1$1
XTAP_TAPCELL_ROW_49_1030 vccd1 vssd1 sky130_fd_sc_hd__tapvpwrvgnd_1$1
XFILLER_81_671 vccd1 vssd1 vccd1 vssd1 sky130_fd_sc_hd__fill_1$1
XFILLER_53_373 vssd1 vccd1 vccd1 vssd1 sky130_fd_sc_hd__fill_8$1
XFILLER_26_587 vccd1 vssd1 vccd1 vssd1 sky130_fd_sc_hd__fill_1$1
XFILLER_110_53 vssd1 vccd1 vccd1 vssd1 sky130_ef_sc_hd__decap_40_12$1
XTAP_TAPCELL_ROW_62_1230 vccd1 vssd1 sky130_fd_sc_hd__tapvpwrvgnd_1$1
XFILLER_13_237 vssd1 vccd1 vccd1 vssd1 sky130_ef_sc_hd__decap_40_12$1
XFILLER_14_749 vssd1 vccd1 vccd1 vssd1 sky130_fd_sc_hd__fill_4$1
XFILLER_110_97 vssd1 vccd1 vccd1 vssd1 sky130_ef_sc_hd__decap_40_12$1
XFILLER_21_281 vssd1 vccd1 vccd1 vssd1 sky130_ef_sc_hd__decap_40_12$1
XFILLER_22_793 vssd1 vccd1 vccd1 vssd1 sky130_ef_sc_hd__decap_40_12$1
XFILLER_126_139 vccd1 vssd1 vccd1 vssd1 sky130_fd_sc_hd__fill_1$1
XFILLER_119_51 vssd1 vccd1 vccd1 vssd1 sky130_fd_sc_hd__fill_4$1
XFILLER_5_447 vccd1 vssd1 vccd1 vssd1 sky130_fd_sc_hd__fill_1$1
XFILLER_122_301 vssd1 vccd1 vccd1 vssd1 sky130_fd_sc_hd__fill_4$1
XFILLER_79_55 vccd1 vssd1 vccd1 vssd1 sky130_fd_sc_hd__fill_1$1
XFILLER_122_345 vssd1 vccd1 vccd1 vssd1 sky130_ef_sc_hd__decap_40_12$1
XFILLER_1_653 vssd1 vccd1 vccd1 vssd1 sky130_ef_sc_hd__decap_40_12$1
XFILLER_122_389 vssd1 vccd1 vccd1 vssd1 sky130_fd_sc_hd__fill_2$1
XTAP_TAPCELL_ROW_73_1392 vccd1 vssd1 sky130_fd_sc_hd__tapvpwrvgnd_1$1
XFILLER_49_613 vssd1 vccd1 vccd1 vssd1 sky130_fd_sc_hd__fill_2$1
XFILLER_0_141 vssd1 vccd1 vccd1 vssd1 sky130_ef_sc_hd__decap_40_12$1
XFILLER_76_421 vssd1 vccd1 vccd1 vssd1 sky130_ef_sc_hd__decap_40_12$1
XFILLER_1_697 vssd1 vccd1 vccd1 vssd1 sky130_ef_sc_hd__decap_40_12$1
XFILLER_64_605 vssd1 vccd1 vccd1 vssd1 sky130_ef_sc_hd__decap_40_12$1
XFILLER_36_307 vccd1 vssd1 vccd1 vssd1 sky130_fd_sc_hd__fill_1$1
XFILLER_64_649 vccd1 vssd1 vccd1 vssd1 sky130_fd_sc_hd__fill_1$1
XFILLER_63_137 vssd1 vccd1 vccd1 vssd1 sky130_ef_sc_hd__decap_40_12$1
XFILLER_28_81 vssd1 vccd1 vccd1 vssd1 sky130_fd_sc_hd__fill_2$1
XFILLER_48_189 vssd1 vccd1 vccd1 vssd1 sky130_fd_sc_hd__fill_4$1
XFILLER_45_841 vccd1 vssd1 vccd1 vssd1 sky130_fd_sc_hd__fill_1$1
XFILLER_72_671 vssd1 vccd1 vccd1 vssd1 sky130_ef_sc_hd__decap_40_12$1
XFILLER_60_811 vccd1 vssd1 vccd1 vssd1 sky130_fd_sc_hd__fill_1$1
XFILLER_32_513 vssd1 vccd1 vccd1 vssd1 sky130_ef_sc_hd__decap_40_12$1
XFILLER_71_181 vssd1 vccd1 vccd1 vssd1 sky130_ef_sc_hd__decap_40_12$1
XFILLER_32_557 vssd1 vccd1 vccd1 vssd1 sky130_ef_sc_hd__decap_40_12$1
X_0991_ _1387_/C1 _0990_/X _0991_/A2 hold125/X _1529_/D vssd1 vccd1 vccd1 vssd1 sky130_fd_sc_hd__o211a_1$1
XFILLER_9_753 vssd1 vccd1 vccd1 vssd1 sky130_ef_sc_hd__decap_40_12$1
XTAP_TAPCELL_ROW_30_747 vccd1 vssd1 sky130_fd_sc_hd__tapvpwrvgnd_1$1
XTAP_TAPCELL_ROW_93_1702 vccd1 vssd1 sky130_fd_sc_hd__tapvpwrvgnd_1$1
XFILLER_9_797 vssd1 vccd1 vccd1 vssd1 sky130_ef_sc_hd__decap_40_12$1
X_1612_ _1816_/A _1679_/CLK _1612_/D vccd1 vssd1 vccd1 vssd1 sky130_fd_sc_hd__dfxtp_1$1
XFILLER_132_109 vssd1 vccd1 vccd1 vssd1 sky130_ef_sc_hd__decap_40_12$1
XFILLER_114_813 vssd1 vccd1 vccd1 vssd1 sky130_ef_sc_hd__decap_40_12$1
XFILLER_125_161 vssd1 vccd1 vccd1 vssd1 sky130_fd_sc_hd__fill_4$1
XFILLER_99_513 vssd1 vccd1 vccd1 vssd1 sky130_fd_sc_hd__fill_2$1
X_1543_ _1774_/A _1608_/CLK _1543_/D vccd1 vssd1 vccd1 vssd1 sky130_fd_sc_hd__dfxtp_1$1
X_1474_ hold12/X _1474_/X _1474_/B vssd1 vccd1 vccd1 vssd1 sky130_fd_sc_hd__or2_1$1
Xfanout209 _1408_/B vccd1 vssd1 _1398_/B vccd1 vssd1 sky130_fd_sc_hd__buf_4$1
XFILLER_99_568 vssd1 vccd1 vccd1 vssd1 sky130_fd_sc_hd__fill_2$1
XFILLER_95_741 vssd1 vccd1 vccd1 vssd1 sky130_fd_sc_hd__fill_2$1
XFILLER_79_281 vssd1 vccd1 vccd1 vssd1 sky130_ef_sc_hd__decap_40_12$1
XFILLER_95_785 vssd1 vccd1 vccd1 vssd1 sky130_fd_sc_hd__fill_8$1
XFILLER_95_763 vssd1 vccd1 vccd1 vssd1 sky130_ef_sc_hd__decap_40_12$1
XFILLER_94_251 vccd1 vssd1 vccd1 vssd1 sky130_fd_sc_hd__fill_1$1
XFILLER_39_167 vccd1 vssd1 vccd1 vssd1 sky130_fd_sc_hd__fill_1$1
XFILLER_27_329 vssd1 vccd1 vccd1 vssd1 sky130_fd_sc_hd__fill_4$1
XFILLER_82_457 vssd1 vccd1 vccd1 vssd1 sky130_ef_sc_hd__decap_40_12$1
XFILLER_54_137 vssd1 vccd1 vccd1 vssd1 sky130_fd_sc_hd__fill_2$1
XTAP_TAPCELL_ROW_38_869 vccd1 vssd1 sky130_fd_sc_hd__tapvpwrvgnd_1$1
XFILLER_63_671 vccd1 vssd1 vccd1 vssd1 sky130_fd_sc_hd__fill_1$1
XTAP_TAPCELL_ROW_18_571 vccd1 vssd1 sky130_fd_sc_hd__tapvpwrvgnd_1$1
XFILLER_35_373 vssd1 vccd1 vccd1 vssd1 sky130_ef_sc_hd__decap_40_12$1
XTAP_TAPCELL_ROW_102_1831 vccd1 vssd1 sky130_fd_sc_hd__tapvpwrvgnd_1$1
XFILLER_50_321 vssd1 vccd1 vccd1 vssd1 sky130_ef_sc_hd__decap_40_12$1
XFILLER_23_557 vssd1 vccd1 vccd1 vssd1 sky130_fd_sc_hd__fill_2$1
XFILLER_50_365 vssd1 vccd1 vccd1 vssd1 sky130_ef_sc_hd__decap_40_12$1
XTAP_TAPCELL_ROW_135_2330 vccd1 vssd1 sky130_fd_sc_hd__tapvpwrvgnd_1$1
XFILLER_109_607 vccd1 vssd1 vccd1 vssd1 sky130_fd_sc_hd__fill_1$1
XFILLER_40_27 vccd1 vssd1 vccd1 vssd1 sky130_fd_sc_hd__fill_1$1
XFILLER_108_139 vccd1 vssd1 vccd1 vssd1 sky130_fd_sc_hd__fill_1$1
XFILLER_123_109 vssd1 vccd1 vccd1 vssd1 sky130_fd_sc_hd__fill_2$1
XFILLER_104_301 vssd1 vccd1 vccd1 vssd1 sky130_fd_sc_hd__fill_4$1
XFILLER_2_417 vssd1 vccd1 vccd1 vssd1 sky130_fd_sc_hd__fill_2$1
XFILLER_132_643 vccd1 vssd1 vccd1 vssd1 sky130_fd_sc_hd__fill_1$1
XFILLER_104_345 vssd1 vccd1 vccd1 vssd1 sky130_ef_sc_hd__decap_40_12$1
XFILLER_132_698 vssd1 vccd1 vccd1 vssd1 sky130_fd_sc_hd__fill_2$1
XTAP_TAPCELL_ROW_113_1993 vccd1 vssd1 sky130_fd_sc_hd__tapvpwrvgnd_1$1
XFILLER_49_69 vssd1 vccd1 vccd1 vssd1 sky130_ef_sc_hd__decap_40_12$1
XFILLER_58_421 vssd1 vccd1 vccd1 vssd1 sky130_ef_sc_hd__decap_40_12$1
XFILLER_18_307 vccd1 vssd1 vccd1 vssd1 sky130_fd_sc_hd__fill_1$1
XFILLER_19_808 vssd1 vccd1 vccd1 vssd1 sky130_ef_sc_hd__decap_40_12$1
XFILLER_100_573 vccd1 vssd1 vccd1 vssd1 sky130_fd_sc_hd__fill_1$1
XFILLER_100_584 vssd1 vccd1 vccd1 vssd1 sky130_fd_sc_hd__fill_4$1
XFILLER_85_273 vssd1 vccd1 vccd1 vssd1 sky130_fd_sc_hd__fill_4$1
XFILLER_65_57 vssd1 vccd1 vccd1 vssd1 sky130_ef_sc_hd__decap_40_12$1
XFILLER_27_841 vccd1 vssd1 vccd1 vssd1 sky130_fd_sc_hd__fill_1$1
XFILLER_45_137 vssd1 vccd1 vccd1 vssd1 sky130_ef_sc_hd__decap_40_12$1
XFILLER_14_513 vssd1 vccd1 vccd1 vssd1 sky130_ef_sc_hd__decap_40_12$1
XFILLER_54_693 vssd1 vccd1 vccd1 vssd1 sky130_fd_sc_hd__fill_4$1
XFILLER_53_181 vssd1 vccd1 vccd1 vssd1 sky130_ef_sc_hd__decap_40_12$1
XFILLER_14_557 vssd1 vccd1 vccd1 vssd1 sky130_ef_sc_hd__decap_40_12$1
XFILLER_6_701 vssd1 vccd1 vccd1 vssd1 sky130_ef_sc_hd__decap_40_12$1
XFILLER_14_83 vccd1 vssd1 vccd1 vssd1 sky130_fd_sc_hd__fill_1$1
XFILLER_10_785 vssd1 vccd1 vccd1 vssd1 sky130_ef_sc_hd__decap_40_12$1
XFILLER_114_109 vssd1 vccd1 vccd1 vssd1 sky130_ef_sc_hd__decap_40_12$1
XFILLER_107_161 vssd1 vccd1 vccd1 vssd1 sky130_fd_sc_hd__fill_4$1
XTAP_TAPCELL_ROW_75_1432 vccd1 vssd1 sky130_fd_sc_hd__tapvpwrvgnd_1$1
XTAP_TAPCELL_ROW_75_1421 vccd1 vssd1 sky130_fd_sc_hd__tapvpwrvgnd_1$1
XFILLER_5_277 vssd1 vccd1 vccd1 vssd1 sky130_fd_sc_hd__fill_2$1
XFILLER_122_153 vssd1 vccd1 vccd1 vssd1 sky130_ef_sc_hd__decap_40_12$1
XFILLER_1_461 vssd1 vccd1 vccd1 vssd1 sky130_ef_sc_hd__decap_40_12$1
XFILLER_122_197 vssd1 vccd1 vccd1 vssd1 sky130_ef_sc_hd__decap_40_12$1
XFILLER_77_741 vssd1 vccd1 vccd1 vssd1 sky130_ef_sc_hd__decap_40_12$1
X_1190_ _1190_/A _1190_/X _1210_/B vssd1 vccd1 vccd1 vssd1 sky130_fd_sc_hd__or2_1$1
XFILLER_77_785 vssd1 vccd1 vccd1 vssd1 sky130_ef_sc_hd__decap_40_12$1
XFILLER_76_251 vccd1 vssd1 vccd1 vssd1 sky130_fd_sc_hd__fill_1$1
XFILLER_49_487 vccd1 vssd1 vccd1 vssd1 sky130_fd_sc_hd__fill_1$1
Xinput9 adc_data[6] input9/X vssd1 vccd1 vccd1 vssd1 sky130_fd_sc_hd__clkbuf_2$1
XFILLER_91_221 vssd1 vccd1 vccd1 vssd1 sky130_fd_sc_hd__fill_2$1
XFILLER_36_137 vssd1 vccd1 vccd1 vssd1 sky130_fd_sc_hd__fill_2$1
XTAP_TAPCELL_ROW_86_1583 vccd1 vssd1 sky130_fd_sc_hd__tapvpwrvgnd_1$1
XFILLER_17_373 vssd1 vccd1 vccd1 vssd1 sky130_ef_sc_hd__decap_40_12$1
XTAP_TAPCELL_ROW_35_828 vccd1 vssd1 sky130_fd_sc_hd__tapvpwrvgnd_1$1
XFILLER_45_682 vssd1 vccd1 vccd1 vssd1 sky130_ef_sc_hd__decap_40_12$1
XTAP_TAPCELL_ROW_86_1594 vccd1 vssd1 sky130_fd_sc_hd__tapvpwrvgnd_1$1
XFILLER_60_641 vssd1 vccd1 vccd1 vssd1 sky130_fd_sc_hd__fill_2$1
XFILLER_32_321 vssd1 vccd1 vccd1 vssd1 sky130_ef_sc_hd__decap_40_12$1
XTAP_TAPCELL_ROW_15_530 vccd1 vssd1 sky130_fd_sc_hd__tapvpwrvgnd_1$1
XFILLER_32_365 vssd1 vccd1 vccd1 vssd1 sky130_ef_sc_hd__decap_40_12$1
X_0974_ _0974_/A _0974_/X _1012_/B vssd1 vccd1 vccd1 vssd1 sky130_fd_sc_hd__or2_1$1
XFILLER_9_561 vssd1 vccd1 vccd1 vssd1 sky130_ef_sc_hd__decap_40_12$1
XTAP_TAPCELL_ROW_117_2060 vccd1 vssd1 sky130_fd_sc_hd__tapvpwrvgnd_1$1
XFILLER_105_109 vssd1 vccd1 vccd1 vssd1 sky130_fd_sc_hd__fill_2$1
XFILLER_114_654 vssd1 vccd1 vccd1 vssd1 sky130_ef_sc_hd__decap_40_12$1
XFILLER_114_643 vccd1 vssd1 vccd1 vssd1 sky130_fd_sc_hd__fill_1$1
X_1526_ _1526_/Q clkload7/A _1526_/D vccd1 vssd1 vccd1 vssd1 sky130_fd_sc_hd__dfxtp_1$1
XFILLER_114_698 vssd1 vccd1 vccd1 vssd1 sky130_fd_sc_hd__fill_2$1
XFILLER_87_505 vssd1 vccd1 vccd1 vssd1 sky130_ef_sc_hd__decap_40_12$1
X_1457_ _1463_/C1 _1456_/X _1465_/A2 hold59/X _1755_/D vssd1 vccd1 vccd1 vssd1 sky130_fd_sc_hd__o211a_1$1
XFILLER_101_337 vssd1 vccd1 vccd1 vssd1 sky130_ef_sc_hd__decap_40_12$1
XFILLER_99_398 vssd1 vccd1 vccd1 vssd1 sky130_ef_sc_hd__decap_40_12$1
X_1388_ _1388_/A _1388_/X _1408_/B vssd1 vccd1 vccd1 vssd1 sky130_fd_sc_hd__or2_1$1
XFILLER_19_39 vssd1 vccd1 vccd1 vssd1 sky130_ef_sc_hd__decap_40_12$1
XFILLER_67_273 vssd1 vccd1 vccd1 vssd1 sky130_fd_sc_hd__fill_4$1
XFILLER_55_413 vssd1 vccd1 vccd1 vssd1 sky130_ef_sc_hd__decap_40_12$1
XFILLER_83_755 vssd1 vccd1 vccd1 vssd1 sky130_ef_sc_hd__decap_40_12$1
XFILLER_82_221 vssd1 vccd1 vccd1 vssd1 sky130_ef_sc_hd__decap_40_12$1
XFILLER_27_137 vssd1 vccd1 vccd1 vssd1 sky130_ef_sc_hd__decap_40_12$1
XFILLER_82_265 vssd1 vccd1 vccd1 vssd1 sky130_ef_sc_hd__decap_40_12$1
XFILLER_24_811 vccd1 vssd1 vccd1 vssd1 sky130_fd_sc_hd__fill_1$1
XFILLER_35_27 vssd1 vccd1 vccd1 vssd1 sky130_ef_sc_hd__decap_40_12$1
XFILLER_35_181 vssd1 vccd1 vccd1 vssd1 sky130_ef_sc_hd__decap_40_12$1
XFILLER_36_693 vssd1 vccd1 vccd1 vssd1 sky130_fd_sc_hd__fill_4$1
XFILLER_11_505 vssd1 vccd1 vccd1 vssd1 sky130_ef_sc_hd__decap_40_12$1
XFILLER_51_15 vssd1 vccd1 vccd1 vssd1 sky130_ef_sc_hd__decap_40_12$1
XFILLER_109_415 vssd1 vccd1 vccd1 vssd1 sky130_ef_sc_hd__decap_40_12$1
XFILLER_50_195 vccd1 vssd1 vccd1 vssd1 sky130_fd_sc_hd__fill_1$1
XFILLER_136_201 vssd1 vccd1 vccd1 vssd1 sky130_fd_sc_hd__fill_2$1
XFILLER_137_779 vssd1 vccd1 vccd1 vssd1 sky130_fd_sc_hd__fill_4$1
XFILLER_136_245 vssd1 vccd1 vccd1 vssd1 sky130_fd_sc_hd__fill_4$1
XFILLER_109_459 vccd1 vssd1 vccd1 vssd1 sky130_fd_sc_hd__fill_1$1
XFILLER_132_440 vccd1 vssd1 vccd1 vssd1 sky130_fd_sc_hd__fill_1$1
XTAP_TAPCELL_ROW_57_1162 vccd1 vssd1 sky130_fd_sc_hd__tapvpwrvgnd_1$1
XTAP_TAPCELL_ROW_57_1151 vccd1 vssd1 sky130_fd_sc_hd__tapvpwrvgnd_1$1
XFILLER_132_473 vssd1 vccd1 vccd1 vssd1 sky130_fd_sc_hd__fill_2$1
XFILLER_120_613 vssd1 vccd1 vccd1 vssd1 sky130_fd_sc_hd__fill_2$1
XFILLER_116_41 vssd1 vccd1 vccd1 vssd1 sky130_ef_sc_hd__decap_40_12$1
XFILLER_105_665 vssd1 vccd1 vccd1 vssd1 sky130_fd_sc_hd__fill_4$1
XFILLER_104_153 vssd1 vccd1 vccd1 vssd1 sky130_ef_sc_hd__decap_40_12$1
XFILLER_116_85 vssd1 vccd1 vccd1 vssd1 sky130_ef_sc_hd__decap_40_12$1
XFILLER_104_197 vssd1 vccd1 vccd1 vssd1 sky130_ef_sc_hd__decap_40_12$1
XTAP_TAPCELL_ROW_70_1351 vccd1 vssd1 sky130_fd_sc_hd__tapvpwrvgnd_1$1
XFILLER_58_251 vccd1 vssd1 vccd1 vssd1 sky130_fd_sc_hd__fill_1$1
XFILLER_59_785 vssd1 vccd1 vccd1 vssd1 sky130_ef_sc_hd__decap_40_12$1
XFILLER_46_413 vssd1 vccd1 vccd1 vssd1 sky130_fd_sc_hd__fill_4$1
XFILLER_74_744 vssd1 vccd1 vccd1 vssd1 sky130_ef_sc_hd__decap_40_12$1
XFILLER_73_221 vssd1 vccd1 vccd1 vssd1 sky130_fd_sc_hd__fill_2$1
XFILLER_18_137 vssd1 vccd1 vccd1 vssd1 sky130_fd_sc_hd__fill_2$1
XFILLER_46_457 vssd1 vccd1 vccd1 vssd1 sky130_fd_sc_hd__fill_2$1
XFILLER_61_405 vssd1 vccd1 vccd1 vssd1 sky130_fd_sc_hd__fill_8$1
XFILLER_92_77 vssd1 vccd1 vccd1 vssd1 sky130_fd_sc_hd__fill_4$1
XFILLER_61_449 vssd1 vccd1 vccd1 vssd1 sky130_ef_sc_hd__decap_40_12$1
XFILLER_14_321 vssd1 vccd1 vccd1 vssd1 sky130_ef_sc_hd__decap_40_12$1
XFILLER_27_682 vssd1 vccd1 vccd1 vssd1 sky130_ef_sc_hd__decap_40_12$1
XFILLER_14_365 vssd1 vccd1 vccd1 vssd1 sky130_ef_sc_hd__decap_40_12$1
XFILLER_25_93 vssd1 vccd1 vccd1 vssd1 sky130_ef_sc_hd__decap_40_12$1
XFILLER_30_825 vccd1 vssd1 vccd1 vssd1 sky130_fd_sc_hd__fill_1$1
XFILLER_128_713 vssd1 vccd1 vccd1 vssd1 sky130_ef_sc_hd__decap_40_12$1
XFILLER_127_223 vccd1 vssd1 vccd1 vssd1 sky130_fd_sc_hd__fill_1$1
XTAP_TAPCELL_ROW_40_897 vccd1 vssd1 sky130_fd_sc_hd__tapvpwrvgnd_1$1
XFILLER_6_531 vccd1 vssd1 vccd1 vssd1 sky130_fd_sc_hd__fill_1$1
XFILLER_41_81 vssd1 vccd1 vccd1 vssd1 sky130_ef_sc_hd__decap_40_12$1
XFILLER_115_429 vssd1 vccd1 vccd1 vssd1 sky130_fd_sc_hd__fill_4$1
XFILLER_123_473 vssd1 vccd1 vccd1 vssd1 sky130_ef_sc_hd__decap_40_12$1
XFILLER_111_613 vssd1 vccd1 vccd1 vssd1 sky130_fd_sc_hd__fill_2$1
XFILLER_69_505 vssd1 vccd1 vccd1 vssd1 sky130_ef_sc_hd__decap_40_12$1
X_1311_ _1449_/C1 _1310_/X _1331_/A2 hold90/X _1684_/D vssd1 vccd1 vccd1 vssd1 sky130_fd_sc_hd__o211a_1$1
XFILLER_2_781 vssd1 vccd1 vccd1 vssd1 sky130_ef_sc_hd__decap_40_12$1
XFILLER_96_357 vssd1 vccd1 vccd1 vssd1 sky130_fd_sc_hd__fill_4$1
X_1242_ _1651_/Q _1242_/X _1270_/B vssd1 vccd1 vccd1 vssd1 sky130_fd_sc_hd__or2_1$1
XPHY_EDGE_ROW_10_Right_10 vccd1 vssd1 vccd1 vssd1 sky130_fd_sc_hd__decap_3$1
XFILLER_2_53 vssd1 vccd1 vccd1 vssd1 sky130_ef_sc_hd__decap_40_12$1
XFILLER_110_189 vssd1 vccd1 vccd1 vssd1 sky130_fd_sc_hd__fill_4$1
XTAP_TAPCELL_ROW_88_1623 vccd1 vssd1 sky130_fd_sc_hd__tapvpwrvgnd_1$1
XFILLER_49_273 vssd1 vccd1 vccd1 vssd1 sky130_fd_sc_hd__fill_4$1
XFILLER_64_221 vssd1 vccd1 vccd1 vssd1 sky130_ef_sc_hd__decap_40_12$1
X_1173_ _1305_/C1 _1172_/X _1189_/A2 hold55/X _1617_/D vssd1 vccd1 vccd1 vssd1 sky130_fd_sc_hd__o211a_1$1
XFILLER_2_97 vssd1 vccd1 vccd1 vssd1 sky130_ef_sc_hd__decap_40_12$1
XFILLER_80_725 vssd1 vccd1 vccd1 vssd1 sky130_ef_sc_hd__decap_40_12$1
XFILLER_65_777 vssd1 vccd1 vccd1 vssd1 sky130_fd_sc_hd__fill_4$1
XFILLER_64_265 vssd1 vccd1 vccd1 vssd1 sky130_ef_sc_hd__decap_40_12$1
XFILLER_80_769 vssd1 vccd1 vccd1 vssd1 sky130_ef_sc_hd__decap_40_12$1
XFILLER_17_181 vssd1 vccd1 vccd1 vssd1 sky130_ef_sc_hd__decap_40_12$1
XFILLER_18_693 vssd1 vccd1 vccd1 vssd1 sky130_fd_sc_hd__fill_4$1
XFILLER_33_641 vssd1 vccd1 vccd1 vssd1 sky130_fd_sc_hd__fill_4$1
XANTENNA_14 hold30/A vssd1 vccd1 vccd1 vssd1 sky130_fd_sc_hd__diode_2$1
XANTENNA_25 _1480_/Q vssd1 vccd1 vccd1 vssd1 sky130_fd_sc_hd__diode_2$1
XFILLER_20_357 vssd1 vccd1 vccd1 vssd1 sky130_fd_sc_hd__fill_4$1
XFILLER_32_195 vccd1 vssd1 vccd1 vssd1 sky130_fd_sc_hd__fill_1$1
XTAP_TAPCELL_ROW_115_2019 vccd1 vssd1 sky130_fd_sc_hd__tapvpwrvgnd_1$1
X_0957_ _1091_/C1 _0956_/X _0991_/A2 hold67/X _1512_/D vssd1 vccd1 vccd1 vssd1 sky130_fd_sc_hd__o211a_1$1
XFILLER_119_757 vssd1 vccd1 vccd1 vssd1 sky130_fd_sc_hd__fill_2$1
XFILLER_118_245 vssd1 vccd1 vccd1 vssd1 sky130_fd_sc_hd__fill_4$1
XTAP_TAPCELL_ROW_99_1785 vccd1 vssd1 sky130_fd_sc_hd__tapvpwrvgnd_1$1
XFILLER_9_391 vccd1 vssd1 vccd1 vssd1 sky130_fd_sc_hd__fill_1$1
X_0888_ _0888_/X _1015_/A _1595_/Q hold79/A hold10/A vssd1 vccd1 _0887_/X vccd1 vssd1
+ sky130_fd_sc_hd__a221o_1$1
XFILLER_118_289 vssd1 vccd1 vccd1 vssd1 sky130_ef_sc_hd__decap_40_12$1
XFILLER_106_418 vssd1 vccd1 vccd1 vssd1 sky130_fd_sc_hd__fill_2$1
Xoutput110 _1814_/X analog_ctrl[43] vssd1 vccd1 vccd1 vssd1 sky130_fd_sc_hd__buf_12$1
XFILLER_133_237 vssd1 vccd1 vccd1 vssd1 sky130_ef_sc_hd__decap_40_12$1
Xoutput143 _1646_/Q analog_ctrl[73] vssd1 vccd1 vccd1 vssd1 sky130_fd_sc_hd__buf_12$1
Xoutput132 _1834_/X analog_ctrl[63] vssd1 vccd1 vccd1 vssd1 sky130_fd_sc_hd__buf_12$1
Xclkbuf_leaf_28_wb_clk_i clkload9/A clkload1/A vssd1 vccd1 vccd1 vssd1 sky130_fd_sc_hd__clkbuf_8$1
Xoutput121 _1824_/X analog_ctrl[53] vssd1 vccd1 vccd1 vssd1 sky130_fd_sc_hd__buf_12$1
Xoutput176 _1491_/Q wbs_dat_o[14] vssd1 vccd1 vccd1 vssd1 sky130_fd_sc_hd__buf_12$1
XFILLER_114_473 vssd1 vccd1 vccd1 vssd1 sky130_fd_sc_hd__fill_2$1
Xoutput165 _1667_/Q analog_ctrl[94] vssd1 vccd1 vccd1 vssd1 sky130_fd_sc_hd__buf_12$1
XFILLER_102_613 vssd1 vccd1 vccd1 vssd1 sky130_ef_sc_hd__decap_40_12$1
Xoutput154 _1657_/Q analog_ctrl[84] vssd1 vccd1 vccd1 vssd1 sky130_fd_sc_hd__buf_12$1
XFILLER_88_825 vccd1 vssd1 vccd1 vssd1 sky130_fd_sc_hd__fill_1$1
XFILLER_0_729 vssd1 vccd1 vccd1 vssd1 sky130_ef_sc_hd__decap_40_12$1
Xoutput187 _1501_/Q wbs_dat_o[24] vssd1 vccd1 vccd1 vssd1 sky130_fd_sc_hd__buf_12$1
Xoutput198 _1482_/Q wbs_dat_o[5] vssd1 vccd1 vccd1 vssd1 sky130_fd_sc_hd__buf_12$1
XFILLER_102_635 vccd1 vssd1 vccd1 vssd1 sky130_fd_sc_hd__fill_1$1
XFILLER_87_335 vccd1 vssd1 vccd1 vssd1 sky130_fd_sc_hd__fill_1$1
X_1509_ _1781_/A _1579_/CLK _1509_/D vccd1 vssd1 vccd1 vssd1 sky130_fd_sc_hd__dfxtp_1$1
XTAP_TAPCELL_ROW_110_1952 vccd1 vssd1 sky130_fd_sc_hd__tapvpwrvgnd_1$1
XFILLER_102_657 vssd1 vccd1 vccd1 vssd1 sky130_ef_sc_hd__decap_40_12$1
XFILLER_101_167 vccd1 vssd1 vccd1 vssd1 sky130_fd_sc_hd__fill_1$1
XTAP_TAPCELL_ROW_52_1081 vccd1 vssd1 sky130_fd_sc_hd__tapvpwrvgnd_1$1
XFILLER_28_413 vssd1 vccd1 vccd1 vssd1 sky130_fd_sc_hd__fill_4$1
XFILLER_46_15 vssd1 vccd1 vccd1 vssd1 sky130_ef_sc_hd__decap_40_12$1
XPHY_EDGE_ROW_106_Right_106 vccd1 vssd1 vccd1 vssd1 sky130_fd_sc_hd__decap_3$1
XFILLER_56_755 vccd1 vssd1 vccd1 vssd1 sky130_fd_sc_hd__fill_1$1
XFILLER_55_221 vssd1 vccd1 vccd1 vssd1 sky130_fd_sc_hd__fill_2$1
XFILLER_28_457 vssd1 vccd1 vccd1 vssd1 sky130_ef_sc_hd__decap_40_12$1
XFILLER_71_725 vssd1 vccd1 vccd1 vssd1 sky130_fd_sc_hd__fill_2$1
XFILLER_43_405 vssd1 vccd1 vccd1 vssd1 sky130_ef_sc_hd__decap_40_12$1
XFILLER_43_449 vccd1 vssd1 vccd1 vssd1 sky130_fd_sc_hd__fill_1$1
XFILLER_102_65 vssd1 vccd1 vccd1 vssd1 sky130_ef_sc_hd__decap_40_12$1
XFILLER_24_641 vssd1 vccd1 vccd1 vssd1 sky130_fd_sc_hd__fill_2$1
XFILLER_11_335 vccd1 vssd1 vccd1 vssd1 sky130_fd_sc_hd__fill_1$1
XFILLER_127_3 vssd1 vccd1 vccd1 vssd1 sky130_ef_sc_hd__decap_40_12$1
XFILLER_109_223 vccd1 vssd1 vccd1 vssd1 sky130_fd_sc_hd__fill_1$1
XFILLER_7_317 vssd1 vccd1 vccd1 vssd1 sky130_ef_sc_hd__decap_40_12$1
XFILLER_125_727 vccd1 vssd1 vccd1 vssd1 sky130_fd_sc_hd__fill_1$1
XFILLER_11_51 vssd1 vccd1 vccd1 vssd1 sky130_fd_sc_hd__fill_4$1
XFILLER_3_501 vssd1 vccd1 vccd1 vssd1 sky130_fd_sc_hd__fill_2$1
XFILLER_127_51 vssd1 vccd1 vccd1 vssd1 sky130_fd_sc_hd__fill_4$1
XFILLER_105_473 vssd1 vccd1 vccd1 vssd1 sky130_fd_sc_hd__fill_4$1
XFILLER_87_55 vccd1 vssd1 vccd1 vssd1 sky130_fd_sc_hd__fill_1$1
XFILLER_120_454 vssd1 vccd1 vccd1 vssd1 sky130_fd_sc_hd__fill_4$1
XFILLER_78_357 vssd1 vccd1 vccd1 vssd1 sky130_fd_sc_hd__fill_4$1
XFILLER_93_305 vssd1 vccd1 vccd1 vssd1 sky130_ef_sc_hd__decap_40_12$1
XTAP_TAPCELL_ROW_6_394 vccd1 vssd1 sky130_fd_sc_hd__tapvpwrvgnd_1$1
XTAP_TAPCELL_ROW_6_383 vccd1 vssd1 sky130_fd_sc_hd__tapvpwrvgnd_1$1
XFILLER_93_349 vssd1 vccd1 vccd1 vssd1 sky130_ef_sc_hd__decap_40_12$1
XFILLER_46_221 vssd1 vccd1 vccd1 vssd1 sky130_ef_sc_hd__decap_40_12$1
XFILLER_47_766 vssd1 vccd1 vccd1 vssd1 sky130_fd_sc_hd__fill_4$1
XFILLER_74_574 vssd1 vccd1 vccd1 vssd1 sky130_ef_sc_hd__decap_40_12$1
XFILLER_46_265 vssd1 vccd1 vccd1 vssd1 sky130_ef_sc_hd__decap_40_12$1
Xafe_wb_281 analog_ctrl[98] afe_wb_281/HI vssd1 vccd1 vccd1 vssd1 sky130_fd_sc_hd__conb_1$1
XFILLER_62_736 vssd1 vccd1 vccd1 vssd1 sky130_ef_sc_hd__decap_40_12$1
XFILLER_36_81 vssd1 vccd1 vccd1 vssd1 sky130_fd_sc_hd__fill_2$1
XTAP_TAPCELL_ROW_83_1542 vccd1 vssd1 sky130_fd_sc_hd__tapvpwrvgnd_1$1
XFILLER_62_769 vssd1 vccd1 vccd1 vssd1 sky130_fd_sc_hd__fill_4$1
XFILLER_15_641 vssd1 vccd1 vccd1 vssd1 sky130_ef_sc_hd__decap_40_12$1
XTAP_TAPCELL_ROW_45_978 vccd1 vssd1 sky130_fd_sc_hd__tapvpwrvgnd_1$1
XFILLER_61_279 vccd1 vssd1 vccd1 vssd1 sky130_fd_sc_hd__fill_1$1
XFILLER_15_685 vssd1 vccd1 vccd1 vssd1 sky130_ef_sc_hd__decap_40_12$1
XFILLER_14_195 vccd1 vssd1 vccd1 vssd1 sky130_fd_sc_hd__fill_1$1
XTAP_TAPCELL_ROW_25_680 vccd1 vssd1 sky130_fd_sc_hd__tapvpwrvgnd_1$1
X_0811_ _1518_/Q _0875_/A2 _0811_/X _1678_/Q _0875_/B1 vccd1 vssd1 vccd1 vssd1 sky130_fd_sc_hd__a22o_1$1
Xinput12 adc_data[9] input12/X vccd1 vssd1 vccd1 vssd1 sky130_fd_sc_hd__dlymetal6s2s_1$1
X_1791_ _1791_/A _1791_/X vssd1 vccd1 vccd1 vssd1 sky130_fd_sc_hd__clkbuf_2$1
XFILLER_30_699 vccd1 vssd1 vccd1 vssd1 sky130_fd_sc_hd__fill_1$1
Xinput45 hold67/A hold66/X vssd1 vccd1 vccd1 vssd1 sky130_fd_sc_hd__clkbuf_8$1
Xinput34 vccd1 vssd1 hold59/A hold58/X vccd1 vssd1 sky130_fd_sc_hd__buf_2$1
Xinput23 hold55/A vccd1 vssd1 hold54/X vccd1 vssd1 sky130_fd_sc_hd__buf_4$1
X_0742_ hold17/A _0742_/Y hold24/A hold8/A hold5/A vssd1 vccd1 vccd1 vssd1 sky130_fd_sc_hd__nor4b_2$1
XFILLER_116_727 vssd1 vccd1 vccd1 vssd1 sky130_ef_sc_hd__decap_40_12$1
XFILLER_6_361 vssd1 vccd1 vccd1 vssd1 sky130_fd_sc_hd__fill_2$1
XFILLER_116_749 vssd1 vccd1 vccd1 vssd1 sky130_fd_sc_hd__fill_4$1
XFILLER_115_237 vssd1 vccd1 vccd1 vssd1 sky130_ef_sc_hd__decap_40_12$1
XFILLER_97_611 vssd1 vccd1 vccd1 vssd1 sky130_fd_sc_hd__fill_4$1
XFILLER_42_3 vssd1 vccd1 vccd1 vssd1 sky130_ef_sc_hd__decap_40_12$1
XFILLER_123_281 vssd1 vccd1 vccd1 vssd1 sky130_ef_sc_hd__decap_40_12$1
XFILLER_96_121 vssd1 vccd1 vccd1 vssd1 sky130_ef_sc_hd__decap_40_12$1
XFILLER_69_335 vccd1 vssd1 vccd1 vssd1 sky130_fd_sc_hd__fill_1$1
XFILLER_111_498 vssd1 vccd1 vccd1 vssd1 sky130_fd_sc_hd__fill_4$1
XFILLER_97_699 vssd1 vccd1 vccd1 vssd1 sky130_ef_sc_hd__decap_40_12$1
XFILLER_97_688 vssd1 vccd1 vccd1 vssd1 sky130_fd_sc_hd__fill_4$1
XFILLER_96_165 vssd1 vccd1 vccd1 vssd1 sky130_ef_sc_hd__decap_40_12$1
XFILLER_84_305 vssd1 vccd1 vccd1 vssd1 sky130_fd_sc_hd__fill_2$1
X_1225_ _1421_/C1 _1224_/X _1273_/A2 hold30/X _1642_/D vssd1 vccd1 vccd1 vssd1 sky130_fd_sc_hd__o211a_1$1
XFILLER_65_541 vssd1 vccd1 vccd1 vssd1 sky130_ef_sc_hd__decap_40_12$1
XFILLER_37_221 vssd1 vccd1 vccd1 vssd1 sky130_fd_sc_hd__fill_2$1
XFILLER_38_755 vccd1 vssd1 vccd1 vssd1 sky130_fd_sc_hd__fill_1$1
XTAP_TAPCELL_ROW_125_2170 vccd1 vssd1 sky130_fd_sc_hd__tapvpwrvgnd_1$1
XFILLER_53_725 vssd1 vccd1 vccd1 vssd1 sky130_fd_sc_hd__fill_2$1
XFILLER_25_405 vssd1 vccd1 vccd1 vssd1 sky130_ef_sc_hd__decap_40_12$1
XFILLER_38_799 vccd1 vssd1 vccd1 vssd1 sky130_fd_sc_hd__fill_1$1
X_1156_ _1813_/A _1156_/X _1188_/B vssd1 vccd1 vccd1 vssd1 sky130_fd_sc_hd__or2_1$1
XTAP_TAPCELL_ROW_125_2181 vccd1 vssd1 sky130_fd_sc_hd__tapvpwrvgnd_1$1
XFILLER_80_533 vssd1 vccd1 vccd1 vssd1 sky130_ef_sc_hd__decap_40_12$1
XFILLER_16_29 vssd1 vccd1 vccd1 vssd1 sky130_ef_sc_hd__decap_40_12$1
XFILLER_25_449 vssd1 vccd1 vccd1 vssd1 sky130_ef_sc_hd__decap_40_12$1
X_1087_ _1091_/C1 _1086_/X _1123_/A2 hold71/X _1575_/D vssd1 vccd1 vccd1 vssd1 sky130_fd_sc_hd__o211a_1$1
XTAP_TAPCELL_ROW_23_639 vccd1 vssd1 sky130_fd_sc_hd__tapvpwrvgnd_1$1
XFILLER_40_419 vccd1 vssd1 vccd1 vssd1 sky130_fd_sc_hd__fill_1$1
XFILLER_138_307 vccd1 vssd1 vccd1 vssd1 sky130_fd_sc_hd__fill_1$1
XFILLER_20_121 vssd1 vccd1 vccd1 vssd1 sky130_ef_sc_hd__decap_40_12$1
XFILLER_20_165 vssd1 vccd1 vccd1 vssd1 sky130_ef_sc_hd__decap_40_12$1
XFILLER_119_532 vssd1 vccd1 vccd1 vssd1 sky130_fd_sc_hd__fill_4$1
XFILLER_134_502 vssd1 vccd1 vccd1 vssd1 sky130_ef_sc_hd__decap_40_12$1
XFILLER_107_727 vccd1 vssd1 vccd1 vssd1 sky130_fd_sc_hd__fill_1$1
XFILLER_4_309 vssd1 vccd1 vccd1 vssd1 sky130_ef_sc_hd__decap_40_12$1
XTAP_TAPCELL_ROW_54_1110 vccd1 vssd1 sky130_fd_sc_hd__tapvpwrvgnd_1$1
XFILLER_102_421 vssd1 vccd1 vccd1 vssd1 sky130_ef_sc_hd__decap_40_12$1
XFILLER_130_741 vccd1 vssd1 vccd1 vssd1 sky130_fd_sc_hd__fill_1$1
XFILLER_88_699 vccd1 vssd1 vccd1 vssd1 sky130_fd_sc_hd__fill_1$1
XFILLER_87_165 vssd1 vccd1 vccd1 vssd1 sky130_fd_sc_hd__fill_2$1
XFILLER_75_305 vssd1 vccd1 vccd1 vssd1 sky130_ef_sc_hd__decap_40_12$1
XFILLER_57_69 vssd1 vccd1 vccd1 vssd1 sky130_ef_sc_hd__decap_40_12$1
XFILLER_75_349 vssd1 vccd1 vccd1 vssd1 sky130_ef_sc_hd__decap_40_12$1
XFILLER_56_530 vssd1 vccd1 vccd1 vssd1 sky130_fd_sc_hd__fill_2$1
XTAP_TAPCELL_ROW_3_342 vccd1 vssd1 sky130_fd_sc_hd__tapvpwrvgnd_1$1
XFILLER_28_221 vssd1 vccd1 vccd1 vssd1 sky130_ef_sc_hd__decap_40_12$1
XFILLER_28_265 vssd1 vccd1 vccd1 vssd1 sky130_ef_sc_hd__decap_40_12$1
XFILLER_29_777 vssd1 vccd1 vccd1 vssd1 sky130_fd_sc_hd__fill_4$1
XFILLER_83_393 vssd1 vccd1 vccd1 vssd1 sky130_fd_sc_hd__fill_4$1
XFILLER_71_533 vssd1 vccd1 vccd1 vssd1 sky130_ef_sc_hd__decap_40_12$1
XFILLER_44_725 vssd1 vccd1 vccd1 vssd1 sky130_ef_sc_hd__decap_40_12$1
XFILLER_73_57 vssd1 vccd1 vccd1 vssd1 sky130_ef_sc_hd__decap_40_12$1
XFILLER_44_769 vssd1 vccd1 vccd1 vssd1 sky130_ef_sc_hd__decap_40_12$1
XTAP_TAPCELL_ROW_65_1272 vccd1 vssd1 sky130_fd_sc_hd__tapvpwrvgnd_1$1
XTAP_TAPCELL_ROW_42_926 vccd1 vssd1 sky130_fd_sc_hd__tapvpwrvgnd_1$1
XTAP_TAPCELL_ROW_42_937 vccd1 vssd1 sky130_fd_sc_hd__tapvpwrvgnd_1$1
XFILLER_43_279 vccd1 vssd1 vccd1 vssd1 sky130_fd_sc_hd__fill_1$1
XFILLER_11_165 vssd1 vccd1 vccd1 vssd1 sky130_fd_sc_hd__fill_2$1
XFILLER_8_637 vssd1 vccd1 vccd1 vssd1 sky130_fd_sc_hd__fill_4$1
XFILLER_138_841 vccd1 vssd1 vccd1 vssd1 sky130_fd_sc_hd__fill_1$1
XFILLER_7_125 vssd1 vccd1 vccd1 vssd1 sky130_ef_sc_hd__decap_40_12$1
XFILLER_12_699 vccd1 vssd1 vccd1 vssd1 sky130_fd_sc_hd__fill_1$1
XFILLER_137_373 vssd1 vccd1 vccd1 vssd1 sky130_fd_sc_hd__fill_2$1
XFILLER_137_351 vssd1 vccd1 vccd1 vssd1 sky130_fd_sc_hd__fill_4$1
XFILLER_7_169 vssd1 vccd1 vccd1 vssd1 sky130_ef_sc_hd__decap_40_12$1
XFILLER_22_83 vccd1 vssd1 vccd1 vssd1 sky130_fd_sc_hd__fill_1$1
XFILLER_138_83 vccd1 vssd1 vccd1 vssd1 sky130_fd_sc_hd__fill_1$1
XFILLER_125_557 vssd1 vccd1 vccd1 vssd1 sky130_fd_sc_hd__fill_2$1
XFILLER_98_65 vssd1 vccd1 vccd1 vssd1 sky130_ef_sc_hd__decap_40_12$1
XFILLER_106_793 vssd1 vccd1 vccd1 vssd1 sky130_ef_sc_hd__decap_40_12$1
XFILLER_121_741 vssd1 vccd1 vccd1 vssd1 sky130_ef_sc_hd__decap_40_12$1
XFILLER_105_281 vssd1 vccd1 vccd1 vssd1 sky130_ef_sc_hd__decap_40_12$1
XFILLER_78_121 vssd1 vccd1 vccd1 vssd1 sky130_ef_sc_hd__decap_40_12$1
XFILLER_121_785 vssd1 vccd1 vccd1 vssd1 sky130_ef_sc_hd__decap_40_12$1
XFILLER_120_251 vccd1 vssd1 vccd1 vssd1 sky130_fd_sc_hd__fill_1$1
XFILLER_94_625 vccd1 vssd1 vccd1 vssd1 sky130_fd_sc_hd__fill_1$1
XFILLER_93_113 vssd1 vccd1 vccd1 vssd1 sky130_ef_sc_hd__decap_40_12$1
XFILLER_78_165 vssd1 vccd1 vccd1 vssd1 sky130_ef_sc_hd__decap_40_12$1
XFILLER_66_305 vssd1 vccd1 vccd1 vssd1 sky130_fd_sc_hd__fill_2$1
XFILLER_94_669 vssd1 vccd1 vccd1 vssd1 sky130_ef_sc_hd__decap_40_12$1
XFILLER_19_221 vssd1 vccd1 vccd1 vssd1 sky130_fd_sc_hd__fill_2$1
X_1010_ hold69/X _1010_/X _1012_/B vssd1 vccd1 vccd1 vssd1 sky130_fd_sc_hd__or2_1$1
XFILLER_22_419 vccd1 vssd1 vccd1 vssd1 sky130_fd_sc_hd__fill_1$1
XFILLER_43_780 vssd1 vccd1 vccd1 vssd1 sky130_fd_sc_hd__fill_4$1
XFILLER_8_41 vssd1 vccd1 vccd1 vssd1 sky130_ef_sc_hd__decap_40_12$1
XFILLER_129_841 vccd1 vssd1 vccd1 vssd1 sky130_fd_sc_hd__fill_1$1
X_1843_ vccd1 vssd1 _1843_/X _1843_/A vccd1 vssd1 sky130_fd_sc_hd__buf_1$1
XFILLER_8_85 vssd1 vccd1 vccd1 vssd1 sky130_ef_sc_hd__decap_40_12$1
XTAP_TAPCELL_ROW_96_1744 vccd1 vssd1 sky130_fd_sc_hd__tapvpwrvgnd_1$1
XTAP_TAPCELL_ROW_96_1733 vccd1 vssd1 sky130_fd_sc_hd__tapvpwrvgnd_1$1
X_1774_ vccd1 vssd1 _1774_/X _1774_/A vccd1 vssd1 sky130_fd_sc_hd__buf_1$1
XFILLER_131_505 vssd1 vccd1 vccd1 vssd1 sky130_fd_sc_hd__fill_4$1
XFILLER_116_557 vssd1 vccd1 vccd1 vssd1 sky130_fd_sc_hd__fill_2$1
XTAP_TAPCELL_ROW_127_2210 vccd1 vssd1 sky130_fd_sc_hd__tapvpwrvgnd_1$1
XFILLER_111_273 vssd1 vccd1 vccd1 vssd1 sky130_fd_sc_hd__fill_4$1
XFILLER_69_165 vssd1 vccd1 vccd1 vssd1 sky130_fd_sc_hd__fill_2$1
XFILLER_57_305 vssd1 vccd1 vccd1 vssd1 sky130_ef_sc_hd__decap_40_12$1
XFILLER_73_809 vssd1 vccd1 vccd1 vssd1 sky130_ef_sc_hd__decap_40_12$1
XFILLER_57_349 vssd1 vccd1 vccd1 vssd1 sky130_ef_sc_hd__decap_40_12$1
X_1208_ _1635_/Q _1208_/X _1210_/B vssd1 vccd1 vccd1 vssd1 sky130_fd_sc_hd__or2_1$1
XTAP_TAPCELL_ROW_0_301 vccd1 vssd1 sky130_fd_sc_hd__tapvpwrvgnd_1$1
XFILLER_27_39 vssd1 vccd1 vccd1 vssd1 sky130_ef_sc_hd__decap_40_12$1
XFILLER_65_393 vccd1 vssd1 vccd1 vssd1 sky130_fd_sc_hd__fill_1$1
XFILLER_38_585 vssd1 vccd1 vccd1 vssd1 sky130_fd_sc_hd__fill_2$1
X_1139_ _1475_/C1 _1138_/X _1145_/A2 hold49/X _1601_/D vssd1 vccd1 vccd1 vssd1 sky130_fd_sc_hd__o211a_1$1
XTAP_TAPCELL_ROW_105_1873 vccd1 vssd1 sky130_fd_sc_hd__tapvpwrvgnd_1$1
XFILLER_80_363 vccd1 vssd1 vccd1 vssd1 sky130_fd_sc_hd__fill_1$1
XFILLER_53_577 vssd1 vccd1 vccd1 vssd1 sky130_fd_sc_hd__fill_2$1
XFILLER_25_279 vccd1 vssd1 vccd1 vssd1 sky130_fd_sc_hd__fill_1$1
XFILLER_43_27 vssd1 vccd1 vccd1 vssd1 sky130_ef_sc_hd__decap_40_12$1
XFILLER_40_249 vssd1 vccd1 vccd1 vssd1 sky130_fd_sc_hd__fill_2$1
XFILLER_21_441 vssd1 vccd1 vccd1 vssd1 sky130_fd_sc_hd__fill_4$1
XTAP_TAPCELL_ROW_138_2383 vccd1 vssd1 sky130_fd_sc_hd__tapvpwrvgnd_1$1
XTAP_TAPCELL_ROW_138_2372 vccd1 vssd1 sky130_fd_sc_hd__tapvpwrvgnd_1$1
Xclkbuf_leaf_43_wb_clk_i clkload6/A clkload0/A vssd1 vccd1 vccd1 vssd1 sky130_fd_sc_hd__clkbuf_8$1
XFILLER_21_485 vssd1 vccd1 vccd1 vssd1 sky130_ef_sc_hd__decap_40_12$1
XFILLER_119_373 vssd1 vccd1 vccd1 vssd1 sky130_fd_sc_hd__fill_8$1
XFILLER_5_629 vssd1 vccd1 vccd1 vssd1 sky130_ef_sc_hd__decap_40_12$1
XFILLER_134_321 vccd1 vssd1 vccd1 vssd1 sky130_fd_sc_hd__fill_1$1
XFILLER_107_546 vssd1 vccd1 vccd1 vssd1 sky130_ef_sc_hd__decap_40_12$1
XFILLER_4_139 vccd1 vssd1 vccd1 vssd1 sky130_fd_sc_hd__fill_1$1
XFILLER_134_343 vssd1 vccd1 vccd1 vssd1 sky130_ef_sc_hd__decap_40_12$1
XFILLER_108_53 vssd1 vccd1 vccd1 vssd1 sky130_ef_sc_hd__decap_40_12$1
XFILLER_134_376 vssd1 vccd1 vccd1 vssd1 sky130_fd_sc_hd__fill_2$1
XTAP_TAPCELL_ROW_8_423 vccd1 vssd1 sky130_fd_sc_hd__tapvpwrvgnd_1$1
XFILLER_108_97 vssd1 vccd1 vccd1 vssd1 sky130_ef_sc_hd__decap_40_12$1
XFILLER_88_441 vssd1 vccd1 vccd1 vssd1 sky130_ef_sc_hd__decap_40_12$1
XFILLER_103_785 vssd1 vccd1 vccd1 vssd1 sky130_ef_sc_hd__decap_40_12$1
XFILLER_102_251 vccd1 vssd1 vccd1 vssd1 sky130_fd_sc_hd__fill_1$1
XFILLER_0_389 vssd1 vccd1 vccd1 vssd1 sky130_fd_sc_hd__fill_2$1
XFILLER_48_305 vssd1 vccd1 vccd1 vssd1 sky130_fd_sc_hd__fill_2$1
XFILLER_124_41 vssd1 vccd1 vccd1 vssd1 sky130_ef_sc_hd__decap_40_12$1
XFILLER_76_636 vssd1 vccd1 vccd1 vssd1 sky130_fd_sc_hd__fill_8$1
XFILLER_75_113 vssd1 vccd1 vccd1 vssd1 sky130_ef_sc_hd__decap_40_12$1
XFILLER_124_85 vssd1 vccd1 vccd1 vssd1 sky130_ef_sc_hd__decap_40_12$1
XFILLER_91_617 vssd1 vccd1 vccd1 vssd1 sky130_ef_sc_hd__decap_40_12$1
XTAP_TAPCELL_ROW_67_1301 vccd1 vssd1 sky130_fd_sc_hd__tapvpwrvgnd_1$1
XFILLER_29_541 vssd1 vccd1 vccd1 vssd1 sky130_ef_sc_hd__decap_40_12$1
XTAP_TAPCELL_ROW_67_1312 vccd1 vssd1 sky130_fd_sc_hd__tapvpwrvgnd_1$1
XFILLER_17_725 vssd1 vccd1 vccd1 vssd1 sky130_fd_sc_hd__fill_2$1
XFILLER_29_585 vssd1 vccd1 vccd1 vssd1 sky130_ef_sc_hd__decap_40_12$1
XFILLER_44_533 vssd1 vccd1 vccd1 vssd1 sky130_ef_sc_hd__decap_40_12$1
XTAP_TAPCELL_ROW_80_1501 vccd1 vssd1 sky130_fd_sc_hd__tapvpwrvgnd_1$1
XFILLER_71_385 vssd1 vccd1 vccd1 vssd1 sky130_fd_sc_hd__fill_4$1
XFILLER_31_205 vssd1 vccd1 vccd1 vssd1 sky130_ef_sc_hd__decap_40_12$1
XFILLER_25_791 vccd1 vssd1 vccd1 vssd1 sky130_fd_sc_hd__fill_1$1
XFILLER_31_249 vssd1 vccd1 vccd1 vssd1 sky130_ef_sc_hd__decap_40_12$1
XFILLER_8_401 vssd1 vccd1 vccd1 vssd1 sky130_ef_sc_hd__decap_40_12$1
XFILLER_129_137 vssd1 vccd1 vccd1 vssd1 sky130_ef_sc_hd__decap_40_12$1
XFILLER_8_445 vssd1 vccd1 vccd1 vssd1 sky130_ef_sc_hd__decap_40_12$1
XFILLER_33_93 vssd1 vccd1 vccd1 vssd1 sky130_ef_sc_hd__decap_40_12$1
XFILLER_138_671 vccd1 vssd1 vccd1 vssd1 sky130_fd_sc_hd__fill_1$1
XFILLER_8_489 vssd1 vccd1 vccd1 vssd1 sky130_ef_sc_hd__decap_40_12$1
XTAP_TAPCELL_ROW_78_1463 vccd1 vssd1 sky130_fd_sc_hd__tapvpwrvgnd_1$1
XFILLER_113_505 vssd1 vccd1 vccd1 vssd1 sky130_ef_sc_hd__decap_40_12$1
XTAP_TAPCELL_ROW_78_1474 vccd1 vssd1 sky130_fd_sc_hd__tapvpwrvgnd_1$1
X_1490_ _1490_/Q _1719_/CLK _1490_/D vccd1 vssd1 vccd1 vssd1 sky130_fd_sc_hd__dfxtp_2$1
XFILLER_3_161 vssd1 vccd1 vccd1 vssd1 sky130_fd_sc_hd__fill_4$1
XFILLER_98_249 vssd1 vccd1 vccd1 vssd1 sky130_fd_sc_hd__fill_2$1
XTAP_TAPCELL_ROW_91_1663 vccd1 vssd1 sky130_fd_sc_hd__tapvpwrvgnd_1$1
XFILLER_79_430 vccd1 vssd1 vccd1 vssd1 sky130_fd_sc_hd__fill_1$1
XFILLER_39_305 vssd1 vccd1 vccd1 vssd1 sky130_ef_sc_hd__decap_40_12$1
Xhold1 wbs_dat_i[31] hold1/X vssd1 vccd1 vccd1 vssd1 sky130_fd_sc_hd__dlygate4sd3_1$1
XFILLER_67_647 vccd1 vssd1 vccd1 vssd1 sky130_fd_sc_hd__fill_1$1
XFILLER_39_349 vssd1 vccd1 vccd1 vssd1 sky130_ef_sc_hd__decap_40_12$1
XFILLER_81_105 vssd1 vccd1 vccd1 vssd1 sky130_fd_sc_hd__fill_4$1
XFILLER_81_149 vssd1 vccd1 vccd1 vssd1 sky130_ef_sc_hd__decap_40_12$1
XFILLER_47_393 vssd1 vccd1 vccd1 vssd1 sky130_ef_sc_hd__decap_40_12$1
XFILLER_62_385 vssd1 vccd1 vccd1 vssd1 sky130_fd_sc_hd__fill_2$1
XFILLER_62_363 vccd1 vssd1 vccd1 vssd1 sky130_fd_sc_hd__fill_1$1
XPHY_EDGE_ROW_8_Right_8 vccd1 vssd1 vccd1 vssd1 sky130_fd_sc_hd__decap_3$1
XFILLER_22_249 vssd1 vccd1 vccd1 vssd1 sky130_fd_sc_hd__fill_2$1
XFILLER_50_569 vssd1 vccd1 vccd1 vssd1 sky130_ef_sc_hd__decap_40_12$1
XTAP_TAPCELL_ROW_33_789 vccd1 vssd1 sky130_fd_sc_hd__tapvpwrvgnd_1$1
XFILLER_136_608 vssd1 vccd1 vccd1 vssd1 sky130_ef_sc_hd__decap_40_12$1
XFILLER_31_783 vccd1 vssd1 vccd1 vssd1 sky130_fd_sc_hd__fill_1$1
XFILLER_129_671 vccd1 vssd1 vccd1 vssd1 sky130_fd_sc_hd__fill_1$1
X_1826_ vccd1 vssd1 _1826_/X _1826_/A vccd1 vssd1 sky130_fd_sc_hd__buf_1$1
XTAP_TAPCELL_ROW_13_491 vccd1 vssd1 sky130_fd_sc_hd__tapvpwrvgnd_1$1
XFILLER_116_321 vssd1 vccd1 vccd1 vssd1 sky130_ef_sc_hd__decap_40_12$1
X_1757_ _1757_/Q _1757_/CLK _1757_/D vccd1 vssd1 vccd1 vssd1 sky130_fd_sc_hd__dfxtp_1$1
XFILLER_116_365 vssd1 vccd1 vccd1 vssd1 sky130_ef_sc_hd__decap_40_12$1
XTAP_TAPCELL_ROW_133_2291 vccd1 vssd1 sky130_fd_sc_hd__tapvpwrvgnd_1$1
XFILLER_104_516 vssd1 vccd1 vccd1 vssd1 sky130_ef_sc_hd__decap_40_12$1
X_1688_ _1688_/Q _1720_/CLK _1688_/D vccd1 vssd1 vccd1 vssd1 sky130_fd_sc_hd__dfxtp_1$1
XFILLER_89_205 vssd1 vccd1 vccd1 vssd1 sky130_ef_sc_hd__decap_40_12$1
XFILLER_1_109 vssd1 vccd1 vccd1 vssd1 sky130_fd_sc_hd__fill_2$1
XFILLER_131_335 vccd1 vssd1 vccd1 vssd1 sky130_fd_sc_hd__fill_1$1
XFILLER_89_249 vssd1 vccd1 vccd1 vssd1 sky130_ef_sc_hd__decap_40_12$1
XPHY_EDGE_ROW_39_Right_39 vccd1 vssd1 vccd1 vssd1 sky130_fd_sc_hd__decap_3$1
XFILLER_38_27 vccd1 vssd1 vccd1 vssd1 sky130_fd_sc_hd__fill_1$1
XFILLER_97_293 vssd1 vccd1 vccd1 vssd1 sky130_ef_sc_hd__decap_40_12$1
XFILLER_57_113 vssd1 vccd1 vccd1 vssd1 sky130_ef_sc_hd__decap_40_12$1
XTAP_TAPCELL_ROW_107_1902 vccd1 vssd1 sky130_fd_sc_hd__tapvpwrvgnd_1$1
XFILLER_100_755 vccd1 vssd1 vccd1 vssd1 sky130_fd_sc_hd__fill_1$1
XFILLER_85_466 vssd1 vccd1 vccd1 vssd1 sky130_ef_sc_hd__decap_40_12$1
XFILLER_73_617 vssd1 vccd1 vccd1 vssd1 sky130_ef_sc_hd__decap_40_12$1
XFILLER_58_669 vssd1 vccd1 vccd1 vssd1 sky130_ef_sc_hd__decap_40_12$1
XFILLER_66_680 vssd1 vccd1 vccd1 vssd1 sky130_ef_sc_hd__decap_40_12$1
XFILLER_54_15 vssd1 vccd1 vccd1 vssd1 sky130_ef_sc_hd__decap_40_12$1
XTAP_TAPCELL_ROW_49_1042 vccd1 vssd1 sky130_fd_sc_hd__tapvpwrvgnd_1$1
XFILLER_26_533 vssd1 vccd1 vccd1 vssd1 sky130_ef_sc_hd__decap_40_12$1
XTAP_TAPCELL_ROW_49_1031 vccd1 vssd1 sky130_fd_sc_hd__tapvpwrvgnd_1$1
XFILLER_13_205 vssd1 vccd1 vccd1 vssd1 sky130_ef_sc_hd__decap_40_12$1
XFILLER_41_503 vccd1 vssd1 vccd1 vssd1 sky130_fd_sc_hd__fill_1$1
XFILLER_80_193 vssd1 vccd1 vccd1 vssd1 sky130_fd_sc_hd__fill_2$1
XTAP_TAPCELL_ROW_62_1231 vccd1 vssd1 sky130_fd_sc_hd__tapvpwrvgnd_1$1
XFILLER_13_249 vssd1 vccd1 vccd1 vssd1 sky130_ef_sc_hd__decap_40_12$1
XFILLER_41_558 vssd1 vccd1 vccd1 vssd1 sky130_fd_sc_hd__fill_2$1
XPHY_EDGE_ROW_48_Right_48 vccd1 vssd1 vccd1 vssd1 sky130_fd_sc_hd__decap_3$1
XFILLER_110_65 vssd1 vccd1 vccd1 vssd1 sky130_ef_sc_hd__decap_40_12$1
XFILLER_108_811 vccd1 vssd1 vccd1 vssd1 sky130_fd_sc_hd__fill_1$1
XFILLER_21_293 vssd1 vccd1 vccd1 vssd1 sky130_ef_sc_hd__decap_40_12$1
XFILLER_119_181 vssd1 vccd1 vccd1 vssd1 sky130_ef_sc_hd__decap_40_12$1
XPHY_EDGE_ROW_57_Right_57 vccd1 vssd1 vccd1 vssd1 sky130_fd_sc_hd__decap_3$1
XFILLER_134_195 vccd1 vssd1 vccd1 vssd1 sky130_fd_sc_hd__fill_1$1
XFILLER_122_357 vssd1 vccd1 vccd1 vssd1 sky130_fd_sc_hd__fill_4$1
XFILLER_135_51 vssd1 vccd1 vccd1 vssd1 sky130_fd_sc_hd__fill_4$1
XFILLER_89_783 vccd1 vssd1 vccd1 vssd1 sky130_fd_sc_hd__fill_1$1
XTAP_TAPCELL_ROW_73_1393 vccd1 vssd1 sky130_fd_sc_hd__tapvpwrvgnd_1$1
XFILLER_0_153 vssd1 vccd1 vccd1 vssd1 sky130_fd_sc_hd__fill_4$1
XFILLER_1_665 vssd1 vccd1 vccd1 vssd1 sky130_fd_sc_hd__fill_4$1
XFILLER_95_55 vccd1 vssd1 vccd1 vssd1 sky130_fd_sc_hd__fill_1$1
XFILLER_0_197 vssd1 vccd1 vccd1 vssd1 sky130_ef_sc_hd__decap_40_12$1
XFILLER_76_477 vssd1 vccd1 vccd1 vssd1 sky130_fd_sc_hd__fill_4$1
XFILLER_63_105 vssd1 vccd1 vccd1 vssd1 sky130_fd_sc_hd__fill_4$1
XFILLER_91_447 vccd1 vssd1 vccd1 vssd1 sky130_fd_sc_hd__fill_1$1
XFILLER_63_149 vssd1 vccd1 vccd1 vssd1 sky130_ef_sc_hd__decap_40_12$1
XFILLER_29_393 vssd1 vccd1 vccd1 vssd1 sky130_ef_sc_hd__decap_40_12$1
XFILLER_72_683 vssd1 vccd1 vccd1 vssd1 sky130_ef_sc_hd__decap_40_12$1
XPHY_EDGE_ROW_66_Right_66 vccd1 vssd1 vccd1 vssd1 sky130_fd_sc_hd__decap_3$1
XFILLER_44_363 vccd1 vssd1 vccd1 vssd1 sky130_fd_sc_hd__fill_1$1
XFILLER_71_193 vssd1 vccd1 vccd1 vssd1 sky130_ef_sc_hd__decap_40_12$1
XFILLER_32_525 vssd1 vccd1 vccd1 vssd1 sky130_fd_sc_hd__fill_4$1
XFILLER_32_569 vssd1 vccd1 vccd1 vssd1 sky130_ef_sc_hd__decap_40_12$1
XFILLER_44_81 vssd1 vccd1 vccd1 vssd1 sky130_fd_sc_hd__fill_2$1
X_0990_ _0990_/A _0990_/X _0990_/B vssd1 vccd1 vccd1 vssd1 sky130_fd_sc_hd__or2_1$1
XFILLER_9_721 vssd1 vccd1 vccd1 vssd1 sky130_fd_sc_hd__fill_4$1
XFILLER_13_783 vccd1 vssd1 vccd1 vssd1 sky130_fd_sc_hd__fill_1$1
XFILLER_9_765 vssd1 vccd1 vccd1 vssd1 sky130_ef_sc_hd__decap_40_12$1
XFILLER_8_253 vssd1 vccd1 vccd1 vssd1 sky130_ef_sc_hd__decap_40_12$1
XTAP_TAPCELL_ROW_30_748 vccd1 vssd1 sky130_fd_sc_hd__tapvpwrvgnd_1$1
X_1611_ _1815_/A clkload9/A _1611_/D vccd1 vssd1 vccd1 vssd1 sky130_fd_sc_hd__dfxtp_1$1
XTAP_TAPCELL_ROW_10_450 vccd1 vssd1 sky130_fd_sc_hd__tapvpwrvgnd_1$1
XFILLER_99_503 vccd1 vssd1 vccd1 vssd1 sky130_fd_sc_hd__fill_1$1
XPHY_EDGE_ROW_75_Right_75 vccd1 vssd1 vccd1 vssd1 sky130_fd_sc_hd__decap_3$1
XFILLER_114_825 vccd1 vssd1 vccd1 vssd1 sky130_fd_sc_hd__fill_1$1
X_1542_ _1773_/A _1575_/CLK _1542_/D vccd1 vssd1 vccd1 vssd1 sky130_fd_sc_hd__dfxtp_1$1
XFILLER_113_335 vccd1 vssd1 vccd1 vssd1 sky130_fd_sc_hd__fill_1$1
X_1473_ _1475_/C1 _1472_/X _1475_/A2 hold64/X _1763_/D vssd1 vccd1 vccd1 vssd1 sky130_fd_sc_hd__o211a_1$1
XFILLER_87_709 vssd1 vccd1 vccd1 vssd1 sky130_ef_sc_hd__decap_40_12$1
XFILLER_79_293 vssd1 vccd1 vccd1 vssd1 sky130_ef_sc_hd__decap_40_12$1
XFILLER_67_433 vccd1 vssd1 vccd1 vssd1 sky130_fd_sc_hd__fill_1$1
XFILLER_39_113 vssd1 vccd1 vccd1 vssd1 sky130_ef_sc_hd__decap_40_12$1
XFILLER_95_775 vssd1 vccd1 vccd1 vssd1 sky130_fd_sc_hd__fill_8$1
XFILLER_28_809 vssd1 vccd1 vccd1 vssd1 sky130_fd_sc_hd__fill_2$1
XPHY_EDGE_ROW_84_Right_84 vccd1 vssd1 vccd1 vssd1 sky130_fd_sc_hd__decap_3$1
XPHY_EDGE_ROW_19_Left_158 vccd1 vssd1 vccd1 vssd1 sky130_fd_sc_hd__decap_3$1
XFILLER_82_469 vssd1 vccd1 vccd1 vssd1 sky130_fd_sc_hd__fill_4$1
XFILLER_48_691 vccd1 vssd1 vccd1 vssd1 sky130_fd_sc_hd__fill_1$1
XFILLER_63_661 vssd1 vccd1 vccd1 vssd1 sky130_fd_sc_hd__fill_8$1
XFILLER_23_503 vccd1 vssd1 vccd1 vssd1 sky130_fd_sc_hd__fill_1$1
XTAP_TAPCELL_ROW_102_1832 vccd1 vssd1 sky130_fd_sc_hd__tapvpwrvgnd_1$1
XFILLER_62_193 vssd1 vccd1 vccd1 vssd1 sky130_fd_sc_hd__fill_2$1
XFILLER_50_333 vssd1 vccd1 vccd1 vssd1 sky130_ef_sc_hd__decap_40_12$1
XTAP_TAPCELL_ROW_18_572 vccd1 vssd1 sky130_fd_sc_hd__tapvpwrvgnd_1$1
XFILLER_24_29 vssd1 vccd1 vccd1 vssd1 sky130_ef_sc_hd__decap_40_12$1
XFILLER_35_385 vssd1 vccd1 vccd1 vssd1 sky130_fd_sc_hd__fill_4$1
XFILLER_11_709 vssd1 vccd1 vccd1 vssd1 sky130_ef_sc_hd__decap_40_12$1
XFILLER_50_377 vssd1 vccd1 vccd1 vssd1 sky130_ef_sc_hd__decap_40_12$1
XTAP_TAPCELL_ROW_135_2331 vccd1 vssd1 sky130_fd_sc_hd__tapvpwrvgnd_1$1
XTAP_TAPCELL_ROW_135_2320 vccd1 vssd1 sky130_fd_sc_hd__tapvpwrvgnd_1$1
XPHY_EDGE_ROW_93_Right_93 vccd1 vssd1 vccd1 vssd1 sky130_fd_sc_hd__decap_3$1
XPHY_EDGE_ROW_28_Left_167 vccd1 vssd1 vccd1 vssd1 sky130_fd_sc_hd__decap_3$1
X_1809_ _1809_/A _1809_/X vssd1 vccd1 vccd1 vssd1 sky130_fd_sc_hd__clkbuf_2$1
XFILLER_117_696 vssd1 vccd1 vccd1 vssd1 sky130_fd_sc_hd__fill_8$1
XFILLER_116_195 vccd1 vssd1 vccd1 vssd1 sky130_fd_sc_hd__fill_1$1
XFILLER_49_15 vssd1 vccd1 vccd1 vssd1 sky130_ef_sc_hd__decap_40_12$1
XFILLER_131_165 vssd1 vccd1 vccd1 vssd1 sky130_fd_sc_hd__fill_2$1
XTAP_TAPCELL_ROW_113_1994 vccd1 vssd1 sky130_fd_sc_hd__tapvpwrvgnd_1$1
XFILLER_104_357 vssd1 vccd1 vccd1 vssd1 sky130_fd_sc_hd__fill_4$1
XFILLER_58_433 vssd1 vccd1 vccd1 vssd1 sky130_ef_sc_hd__decap_40_12$1
XFILLER_100_541 vssd1 vccd1 vccd1 vssd1 sky130_ef_sc_hd__decap_40_12$1
XPHY_EDGE_ROW_37_Left_176 vccd1 vssd1 vccd1 vssd1 sky130_fd_sc_hd__decap_3$1
XFILLER_58_477 vssd1 vccd1 vccd1 vssd1 sky130_fd_sc_hd__fill_2$1
XFILLER_45_105 vssd1 vccd1 vccd1 vssd1 sky130_fd_sc_hd__fill_4$1
XFILLER_73_447 vccd1 vssd1 vccd1 vssd1 sky130_fd_sc_hd__fill_1$1
XFILLER_65_69 vssd1 vccd1 vccd1 vssd1 sky130_ef_sc_hd__decap_40_12$1
XFILLER_61_609 vssd1 vccd1 vccd1 vssd1 sky130_fd_sc_hd__fill_4$1
XFILLER_45_149 vssd1 vccd1 vccd1 vssd1 sky130_ef_sc_hd__decap_40_12$1
XFILLER_54_661 vssd1 vccd1 vccd1 vssd1 sky130_fd_sc_hd__fill_2$1
XFILLER_26_363 vccd1 vssd1 vccd1 vssd1 sky130_fd_sc_hd__fill_1$1
XFILLER_42_801 vssd1 vccd1 vccd1 vssd1 sky130_fd_sc_hd__fill_2$1
XFILLER_53_193 vssd1 vccd1 vccd1 vssd1 sky130_ef_sc_hd__decap_40_12$1
XFILLER_14_525 vssd1 vccd1 vccd1 vssd1 sky130_fd_sc_hd__fill_4$1
XFILLER_41_333 vssd1 vccd1 vccd1 vssd1 sky130_fd_sc_hd__fill_2$1
XFILLER_81_57 vssd1 vccd1 vccd1 vssd1 sky130_ef_sc_hd__decap_40_12$1
XFILLER_14_569 vssd1 vccd1 vccd1 vssd1 sky130_ef_sc_hd__decap_40_12$1
XFILLER_10_753 vssd1 vccd1 vccd1 vssd1 sky130_fd_sc_hd__fill_2$1
XPHY_EDGE_ROW_46_Left_185 vccd1 vssd1 vccd1 vssd1 sky130_fd_sc_hd__decap_3$1
XFILLER_127_449 vssd1 vccd1 vccd1 vssd1 sky130_ef_sc_hd__decap_40_12$1
XFILLER_10_797 vssd1 vccd1 vccd1 vssd1 sky130_ef_sc_hd__decap_40_12$1
XFILLER_6_713 vssd1 vccd1 vccd1 vssd1 sky130_ef_sc_hd__decap_40_12$1
XFILLER_108_652 vssd1 vccd1 vccd1 vssd1 sky130_ef_sc_hd__decap_40_12$1
XFILLER_6_757 vssd1 vccd1 vccd1 vssd1 sky130_ef_sc_hd__decap_40_12$1
XFILLER_5_223 vccd1 vssd1 vccd1 vssd1 sky130_fd_sc_hd__fill_1$1
XFILLER_135_482 vccd1 vssd1 vccd1 vssd1 sky130_fd_sc_hd__fill_1$1
XTAP_TAPCELL_ROW_75_1422 vccd1 vssd1 sky130_fd_sc_hd__tapvpwrvgnd_1$1
XFILLER_30_83 vccd1 vssd1 vccd1 vssd1 sky130_fd_sc_hd__fill_1$1
XFILLER_122_121 vssd1 vccd1 vccd1 vssd1 sky130_ef_sc_hd__decap_40_12$1
XFILLER_122_165 vssd1 vccd1 vccd1 vssd1 sky130_ef_sc_hd__decap_40_12$1
XFILLER_110_305 vssd1 vccd1 vccd1 vssd1 sky130_fd_sc_hd__fill_2$1
XPHY_EDGE_ROW_55_Left_194 vccd1 vssd1 vccd1 vssd1 sky130_fd_sc_hd__decap_3$1
XFILLER_1_473 vssd1 vccd1 vccd1 vssd1 sky130_ef_sc_hd__decap_40_12$1
XFILLER_103_390 vssd1 vccd1 vccd1 vssd1 sky130_fd_sc_hd__fill_2$1
XFILLER_92_701 vssd1 vccd1 vccd1 vssd1 sky130_fd_sc_hd__fill_2$1
XFILLER_77_753 vssd1 vccd1 vccd1 vssd1 sky130_ef_sc_hd__decap_40_12$1
XFILLER_39_81 vssd1 vccd1 vccd1 vssd1 sky130_ef_sc_hd__decap_40_12$1
XFILLER_92_712 vssd1 vccd1 vccd1 vssd1 sky130_ef_sc_hd__decap_40_12$1
XFILLER_37_617 vssd1 vccd1 vccd1 vssd1 sky130_ef_sc_hd__decap_40_12$1
XFILLER_91_277 vssd1 vccd1 vccd1 vssd1 sky130_fd_sc_hd__fill_2$1
XTAP_TAPCELL_ROW_35_818 vccd1 vssd1 sky130_fd_sc_hd__tapvpwrvgnd_1$1
XTAP_TAPCELL_ROW_35_829 vccd1 vssd1 sky130_fd_sc_hd__tapvpwrvgnd_1$1
XTAP_TAPCELL_ROW_86_1595 vccd1 vssd1 sky130_fd_sc_hd__tapvpwrvgnd_1$1
XTAP_TAPCELL_ROW_86_1584 vccd1 vssd1 sky130_fd_sc_hd__tapvpwrvgnd_1$1
XTAP_TAPCELL_ROW_15_520 vccd1 vssd1 sky130_fd_sc_hd__tapvpwrvgnd_1$1
XFILLER_17_385 vssd1 vccd1 vccd1 vssd1 sky130_fd_sc_hd__fill_4$1
XFILLER_45_694 vssd1 vccd1 vccd1 vssd1 sky130_ef_sc_hd__decap_40_12$1
XTAP_TAPCELL_ROW_15_531 vccd1 vssd1 sky130_fd_sc_hd__tapvpwrvgnd_1$1
XFILLER_32_333 vssd1 vccd1 vccd1 vssd1 sky130_ef_sc_hd__decap_40_12$1
XFILLER_44_193 vssd1 vccd1 vccd1 vssd1 sky130_fd_sc_hd__fill_2$1
XFILLER_32_377 vssd1 vccd1 vccd1 vssd1 sky130_ef_sc_hd__decap_40_12$1
X_0973_ _1387_/C1 _0972_/X _0991_/A2 hold210/X _1520_/D vssd1 vccd1 vccd1 vssd1 sky130_fd_sc_hd__o211a_1$1
XTAP_TAPCELL_ROW_117_2050 vccd1 vssd1 sky130_fd_sc_hd__tapvpwrvgnd_1$1
XFILLER_72_3 vssd1 vccd1 vccd1 vssd1 sky130_ef_sc_hd__decap_40_12$1
XFILLER_9_573 vssd1 vccd1 vccd1 vssd1 sky130_ef_sc_hd__decap_40_12$1
XTAP_TAPCELL_ROW_117_2061 vccd1 vssd1 sky130_fd_sc_hd__tapvpwrvgnd_1$1
XFILLER_133_419 vssd1 vccd1 vccd1 vssd1 sky130_fd_sc_hd__fill_2$1
XTAP_TAPCELL_ROW_130_2250 vccd1 vssd1 sky130_fd_sc_hd__tapvpwrvgnd_1$1
X_1525_ hold43/A _1749_/CLK _1525_/D vccd1 vssd1 vccd1 vssd1 sky130_fd_sc_hd__dfxtp_1$1
XFILLER_99_333 vssd1 vccd1 vccd1 vssd1 sky130_fd_sc_hd__fill_2$1
XFILLER_114_666 vssd1 vccd1 vccd1 vssd1 sky130_ef_sc_hd__decap_40_12$1
XFILLER_113_165 vssd1 vccd1 vccd1 vssd1 sky130_fd_sc_hd__fill_2$1
XFILLER_101_305 vssd1 vccd1 vccd1 vssd1 sky130_ef_sc_hd__decap_40_12$1
XFILLER_87_517 vssd1 vccd1 vccd1 vssd1 sky130_ef_sc_hd__decap_40_12$1
X_1456_ hold92/X _1456_/X _1464_/B vssd1 vccd1 vccd1 vssd1 sky130_fd_sc_hd__or2_1$1
XFILLER_101_349 vssd1 vccd1 vccd1 vssd1 sky130_ef_sc_hd__decap_40_12$1
XFILLER_95_561 vssd1 vccd1 vccd1 vssd1 sky130_ef_sc_hd__decap_40_12$1
XFILLER_83_701 vssd1 vccd1 vccd1 vssd1 sky130_fd_sc_hd__fill_2$1
X_1387_ _1387_/C1 _1386_/X _1399_/A2 hold125/X _1721_/D vssd1 vccd1 vccd1 vssd1 sky130_fd_sc_hd__o211a_1$1
XFILLER_55_425 vssd1 vccd1 vccd1 vssd1 sky130_ef_sc_hd__decap_40_12$1
XFILLER_27_105 vssd1 vccd1 vccd1 vssd1 sky130_fd_sc_hd__fill_4$1
XFILLER_83_767 vssd1 vccd1 vccd1 vssd1 sky130_ef_sc_hd__decap_40_12$1
XFILLER_82_233 vssd1 vccd1 vccd1 vssd1 sky130_ef_sc_hd__decap_40_12$1
XFILLER_55_447 vccd1 vssd1 vccd1 vssd1 sky130_fd_sc_hd__fill_1$1
XFILLER_27_149 vssd1 vccd1 vccd1 vssd1 sky130_ef_sc_hd__decap_40_12$1
XFILLER_82_277 vssd1 vccd1 vccd1 vssd1 sky130_ef_sc_hd__decap_40_12$1
XFILLER_35_39 vssd1 vccd1 vccd1 vssd1 sky130_ef_sc_hd__decap_40_12$1
XFILLER_50_141 vssd1 vccd1 vccd1 vssd1 sky130_ef_sc_hd__decap_40_12$1
XFILLER_23_333 vssd1 vccd1 vccd1 vssd1 sky130_fd_sc_hd__fill_2$1
XFILLER_35_193 vssd1 vccd1 vccd1 vssd1 sky130_ef_sc_hd__decap_40_12$1
XFILLER_51_27 vssd1 vccd1 vccd1 vssd1 sky130_ef_sc_hd__decap_40_12$1
XFILLER_11_517 vssd1 vccd1 vccd1 vssd1 sky130_ef_sc_hd__decap_40_12$1
XFILLER_137_725 vssd1 vccd1 vccd1 vssd1 sky130_fd_sc_hd__fill_2$1
XFILLER_109_427 vssd1 vccd1 vccd1 vssd1 sky130_ef_sc_hd__decap_40_12$1
XFILLER_109_449 vssd1 vccd1 vccd1 vssd1 sky130_fd_sc_hd__fill_8$1
XFILLER_124_419 vccd1 vssd1 vccd1 vssd1 sky130_fd_sc_hd__fill_1$1
XFILLER_105_600 vssd1 vccd1 vccd1 vssd1 sky130_ef_sc_hd__decap_40_12$1
XFILLER_3_727 vccd1 vssd1 vccd1 vssd1 sky130_fd_sc_hd__fill_1$1
XFILLER_104_121 vssd1 vccd1 vccd1 vssd1 sky130_ef_sc_hd__decap_40_12$1
XTAP_TAPCELL_ROW_57_1152 vccd1 vssd1 sky130_fd_sc_hd__tapvpwrvgnd_1$1
XFILLER_104_165 vssd1 vccd1 vccd1 vssd1 sky130_ef_sc_hd__decap_40_12$1
XFILLER_116_53 vssd1 vccd1 vccd1 vssd1 sky130_ef_sc_hd__decap_40_12$1
XFILLER_116_97 vssd1 vccd1 vccd1 vssd1 sky130_ef_sc_hd__decap_40_12$1
XTAP_TAPCELL_ROW_70_1352 vccd1 vssd1 sky130_fd_sc_hd__tapvpwrvgnd_1$1
XFILLER_74_734 vssd1 vccd1 vccd1 vssd1 sky130_fd_sc_hd__fill_2$1
XFILLER_59_797 vssd1 vccd1 vccd1 vssd1 sky130_fd_sc_hd__fill_8$1
XFILLER_19_617 vssd1 vccd1 vccd1 vssd1 sky130_ef_sc_hd__decap_40_12$1
XFILLER_132_41 vssd1 vccd1 vccd1 vssd1 sky130_ef_sc_hd__decap_40_12$1
XFILLER_132_85 vssd1 vccd1 vccd1 vssd1 sky130_ef_sc_hd__decap_40_12$1
XFILLER_73_277 vssd1 vccd1 vccd1 vssd1 sky130_fd_sc_hd__fill_2$1
XFILLER_46_469 vssd1 vccd1 vccd1 vssd1 sky130_fd_sc_hd__fill_4$1
XFILLER_27_694 vssd1 vccd1 vccd1 vssd1 sky130_fd_sc_hd__fill_4$1
XFILLER_14_333 vssd1 vccd1 vccd1 vssd1 sky130_ef_sc_hd__decap_40_12$1
XFILLER_26_193 vssd1 vccd1 vccd1 vssd1 sky130_fd_sc_hd__fill_2$1
XFILLER_14_377 vssd1 vccd1 vccd1 vssd1 sky130_ef_sc_hd__decap_40_12$1
XFILLER_128_725 vssd1 vccd1 vccd1 vssd1 sky130_ef_sc_hd__decap_40_12$1
XTAP_TAPCELL_ROW_40_898 vccd1 vssd1 sky130_fd_sc_hd__tapvpwrvgnd_1$1
XFILLER_41_93 vssd1 vccd1 vccd1 vssd1 sky130_ef_sc_hd__decap_40_12$1
XFILLER_127_279 vccd1 vssd1 vccd1 vssd1 sky130_fd_sc_hd__fill_1$1
XFILLER_6_587 vccd1 vssd1 vccd1 vssd1 sky130_fd_sc_hd__fill_1$1
XFILLER_69_517 vssd1 vccd1 vccd1 vssd1 sky130_ef_sc_hd__decap_40_12$1
XPHY_EDGE_ROW_63_Left_202 vccd1 vssd1 vccd1 vssd1 sky130_fd_sc_hd__decap_3$1
XFILLER_123_485 vssd1 vccd1 vccd1 vssd1 sky130_ef_sc_hd__decap_40_12$1
XFILLER_69_539 vccd1 vssd1 vccd1 vssd1 sky130_fd_sc_hd__fill_1$1
X_1310_ _1310_/A _1310_/X _1330_/B vssd1 vccd1 vccd1 vssd1 sky130_fd_sc_hd__or2_1$1
XFILLER_2_793 vssd1 vccd1 vccd1 vssd1 sky130_ef_sc_hd__decap_40_12$1
XFILLER_111_669 vssd1 vccd1 vccd1 vssd1 sky130_fd_sc_hd__fill_2$1
XFILLER_84_509 vssd1 vccd1 vccd1 vssd1 sky130_ef_sc_hd__decap_40_12$1
X_1241_ _1449_/C1 _1240_/X _1277_/A2 hold21/X _1650_/D vssd1 vccd1 vccd1 vssd1 sky130_fd_sc_hd__o211a_1$1
XFILLER_1_281 vssd1 vccd1 vccd1 vssd1 sky130_ef_sc_hd__decap_40_12$1
XTAP_TAPCELL_ROW_88_1624 vccd1 vssd1 sky130_fd_sc_hd__tapvpwrvgnd_1$1
XTAP_TAPCELL_ROW_88_1613 vccd1 vssd1 sky130_fd_sc_hd__tapvpwrvgnd_1$1
XFILLER_77_561 vssd1 vccd1 vccd1 vssd1 sky130_ef_sc_hd__decap_40_12$1
X_1172_ _1821_/A _1172_/X _1188_/B vssd1 vccd1 vccd1 vssd1 sky130_fd_sc_hd__or2_1$1
XFILLER_2_65 vssd1 vccd1 vccd1 vssd1 sky130_ef_sc_hd__decap_40_12$1
XFILLER_64_233 vssd1 vccd1 vccd1 vssd1 sky130_ef_sc_hd__decap_40_12$1
XFILLER_37_447 vccd1 vssd1 vccd1 vssd1 sky130_fd_sc_hd__fill_1$1
XFILLER_64_277 vssd1 vccd1 vccd1 vssd1 sky130_ef_sc_hd__decap_40_12$1
XFILLER_52_417 vssd1 vccd1 vccd1 vssd1 sky130_fd_sc_hd__fill_2$1
XFILLER_25_609 vssd1 vccd1 vccd1 vssd1 sky130_fd_sc_hd__fill_4$1
XFILLER_80_737 vssd1 vccd1 vccd1 vssd1 sky130_fd_sc_hd__fill_8$1
XPHY_EDGE_ROW_72_Left_211 vccd1 vssd1 vccd1 vssd1 sky130_fd_sc_hd__decap_3$1
XFILLER_17_193 vssd1 vccd1 vccd1 vssd1 sky130_ef_sc_hd__decap_40_12$1
XFILLER_32_141 vssd1 vccd1 vccd1 vssd1 sky130_ef_sc_hd__decap_40_12$1
XANTENNA_15 input48/X vssd1 vccd1 vccd1 vssd1 sky130_fd_sc_hd__diode_2$1
XANTENNA_26 _1408_/B vssd1 vccd1 vccd1 vssd1 sky130_fd_sc_hd__diode_2$1
X_0956_ _1780_/A _0956_/X _0990_/B vssd1 vccd1 vccd1 vssd1 sky130_fd_sc_hd__or2_1$1
XTAP_TAPCELL_ROW_99_1786 vccd1 vssd1 sky130_fd_sc_hd__tapvpwrvgnd_1$1
XFILLER_134_717 vssd1 vccd1 vccd1 vssd1 sky130_ef_sc_hd__decap_40_12$1
XFILLER_133_205 vssd1 vccd1 vccd1 vssd1 sky130_ef_sc_hd__decap_40_12$1
X_0887_ hold62/A _1147_/A _0887_/X _1659_/Q _1213_/A vccd1 vssd1 vccd1 vssd1 sky130_fd_sc_hd__a22o_1$1
Xoutput100 _1805_/X analog_ctrl[34] vssd1 vccd1 vccd1 vssd1 sky130_fd_sc_hd__buf_12$1
XFILLER_133_249 vssd1 vccd1 vccd1 vssd1 sky130_ef_sc_hd__decap_40_12$1
XFILLER_127_791 vccd1 vssd1 vccd1 vssd1 sky130_fd_sc_hd__fill_1$1
XPHY_EDGE_ROW_81_Left_220 vccd1 vssd1 vccd1 vssd1 sky130_fd_sc_hd__decap_3$1
Xoutput133 _1637_/Q analog_ctrl[64] vssd1 vccd1 vccd1 vssd1 sky130_fd_sc_hd__buf_12$1
Xoutput122 _1825_/X analog_ctrl[54] vssd1 vccd1 vccd1 vssd1 sky130_fd_sc_hd__buf_12$1
Xoutput111 _1815_/X analog_ctrl[44] vssd1 vccd1 vccd1 vssd1 sky130_fd_sc_hd__buf_12$1
Xoutput177 _1492_/Q wbs_dat_o[15] vssd1 vccd1 vccd1 vssd1 sky130_fd_sc_hd__buf_12$1
Xoutput166 _1668_/Q analog_ctrl[95] vssd1 vccd1 vccd1 vssd1 sky130_fd_sc_hd__buf_12$1
Xoutput155 _1658_/Q analog_ctrl[85] vssd1 vccd1 vccd1 vssd1 sky130_fd_sc_hd__buf_12$1
Xoutput144 _1647_/Q analog_ctrl[74] vssd1 vccd1 vccd1 vssd1 sky130_fd_sc_hd__buf_12$1
Xoutput188 _1502_/Q wbs_dat_o[25] vssd1 vccd1 vccd1 vssd1 sky130_fd_sc_hd__buf_12$1
Xoutput199 _1483_/Q wbs_dat_o[6] vssd1 vccd1 vccd1 vssd1 sky130_fd_sc_hd__buf_12$1
X_1508_ _1508_/Q _1764_/CLK _1508_/D vccd1 vssd1 vccd1 vssd1 sky130_fd_sc_hd__dfxtp_1$1
XFILLER_102_625 vssd1 vccd1 vccd1 vssd1 sky130_fd_sc_hd__fill_8$1
XFILLER_101_113 vssd1 vccd1 vccd1 vssd1 sky130_ef_sc_hd__decap_40_12$1
XTAP_TAPCELL_ROW_110_1953 vccd1 vssd1 sky130_fd_sc_hd__tapvpwrvgnd_1$1
XFILLER_102_669 vssd1 vccd1 vccd1 vssd1 sky130_ef_sc_hd__decap_40_12$1
X_1439_ _1443_/C1 _1438_/X _1465_/A2 hold21/X _1746_/D vssd1 vccd1 vccd1 vssd1 sky130_fd_sc_hd__o211a_1$1
XFILLER_56_701 vssd1 vccd1 vccd1 vssd1 sky130_ef_sc_hd__decap_40_12$1
XTAP_TAPCELL_ROW_52_1082 vccd1 vssd1 sky130_fd_sc_hd__tapvpwrvgnd_1$1
XFILLER_95_391 vccd1 vssd1 vccd1 vssd1 sky130_fd_sc_hd__fill_1$1
XFILLER_46_27 vccd1 vssd1 vccd1 vssd1 sky130_fd_sc_hd__fill_1$1
XFILLER_56_778 vccd1 vssd1 vccd1 vssd1 sky130_fd_sc_hd__fill_1$1
XFILLER_55_277 vssd1 vccd1 vccd1 vssd1 sky130_fd_sc_hd__fill_2$1
XFILLER_28_469 vssd1 vccd1 vccd1 vssd1 sky130_fd_sc_hd__fill_4$1
XFILLER_43_417 vssd1 vccd1 vccd1 vssd1 sky130_ef_sc_hd__decap_40_12$1
XFILLER_102_77 vssd1 vccd1 vccd1 vssd1 sky130_fd_sc_hd__fill_4$1
XFILLER_62_15 vssd1 vccd1 vccd1 vssd1 sky130_ef_sc_hd__decap_40_12$1
XFILLER_51_461 vssd1 vccd1 vccd1 vssd1 sky130_ef_sc_hd__decap_40_12$1
XFILLER_24_697 vssd1 vccd1 vccd1 vssd1 sky130_fd_sc_hd__fill_2$1
XFILLER_7_329 vssd1 vccd1 vccd1 vssd1 sky130_fd_sc_hd__fill_4$1
XFILLER_137_599 vssd1 vccd1 vccd1 vssd1 sky130_ef_sc_hd__decap_40_12$1
XFILLER_109_279 vccd1 vssd1 vccd1 vssd1 sky130_fd_sc_hd__fill_1$1
XFILLER_124_249 vssd1 vccd1 vccd1 vssd1 sky130_fd_sc_hd__fill_2$1
XFILLER_3_557 vssd1 vccd1 vccd1 vssd1 sky130_fd_sc_hd__fill_2$1
XFILLER_2_3 vssd1 vccd1 vccd1 vssd1 sky130_ef_sc_hd__decap_40_12$1
XFILLER_133_783 vccd1 vssd1 vccd1 vssd1 sky130_fd_sc_hd__fill_1$1
XFILLER_93_317 vssd1 vccd1 vccd1 vssd1 sky130_ef_sc_hd__decap_40_12$1
XFILLER_59_561 vssd1 vccd1 vccd1 vssd1 sky130_ef_sc_hd__decap_40_12$1
XTAP_TAPCELL_ROW_6_395 vccd1 vssd1 sky130_fd_sc_hd__tapvpwrvgnd_1$1
XTAP_TAPCELL_ROW_6_384 vccd1 vssd1 sky130_fd_sc_hd__tapvpwrvgnd_1$1
XFILLER_74_520 vssd1 vccd1 vccd1 vssd1 sky130_ef_sc_hd__decap_40_12$1
XFILLER_19_447 vccd1 vssd1 vccd1 vssd1 sky130_fd_sc_hd__fill_1$1
XFILLER_46_233 vssd1 vccd1 vccd1 vssd1 sky130_ef_sc_hd__decap_40_12$1
Xafe_wb_282 analog_ctrl[99] afe_wb_282/HI vssd1 vccd1 vccd1 vssd1 sky130_fd_sc_hd__conb_1$1
XFILLER_74_586 vssd1 vccd1 vccd1 vssd1 sky130_fd_sc_hd__fill_2$1
XFILLER_62_748 vssd1 vccd1 vccd1 vssd1 sky130_fd_sc_hd__fill_8$1
XFILLER_61_225 vssd1 vccd1 vccd1 vssd1 sky130_ef_sc_hd__decap_40_12$1
XFILLER_34_417 vssd1 vccd1 vccd1 vssd1 sky130_fd_sc_hd__fill_2$1
XFILLER_46_277 vssd1 vccd1 vccd1 vssd1 sky130_ef_sc_hd__decap_40_12$1
XTAP_TAPCELL_ROW_83_1543 vccd1 vssd1 sky130_fd_sc_hd__tapvpwrvgnd_1$1
XFILLER_15_653 vssd1 vccd1 vccd1 vssd1 sky130_ef_sc_hd__decap_40_12$1
XTAP_TAPCELL_ROW_45_968 vccd1 vssd1 sky130_fd_sc_hd__tapvpwrvgnd_1$1
XTAP_TAPCELL_ROW_45_979 vccd1 vssd1 sky130_fd_sc_hd__tapvpwrvgnd_1$1
XFILLER_70_781 vssd1 vccd1 vccd1 vssd1 sky130_ef_sc_hd__decap_40_12$1
XFILLER_14_141 vssd1 vccd1 vccd1 vssd1 sky130_ef_sc_hd__decap_40_12$1
XFILLER_15_697 vssd1 vccd1 vccd1 vssd1 sky130_ef_sc_hd__decap_40_12$1
XTAP_TAPCELL_ROW_25_670 vccd1 vssd1 sky130_fd_sc_hd__tapvpwrvgnd_1$1
XFILLER_30_601 vssd1 vccd1 vccd1 vssd1 sky130_ef_sc_hd__decap_40_12$1
XTAP_TAPCELL_ROW_25_681 vccd1 vssd1 sky130_fd_sc_hd__tapvpwrvgnd_1$1
XFILLER_30_645 vssd1 vccd1 vccd1 vssd1 sky130_ef_sc_hd__decap_40_12$1
X_0810_ _1818_/A _0878_/A2 _0810_/X _1550_/Q _0866_/B1 vccd1 vssd1 vccd1 vssd1 sky130_fd_sc_hd__a22o_1$1
XFILLER_52_81 vssd1 vccd1 vccd1 vssd1 sky130_fd_sc_hd__fill_2$1
Xinput13 adc_eof input13/X vssd1 vccd1 vccd1 vssd1 sky130_fd_sc_hd__clkbuf_2$1
X_1790_ _1790_/A _1790_/X vssd1 vccd1 vccd1 vssd1 sky130_fd_sc_hd__clkbuf_2$1
Xinput35 hold14/A hold13/X vssd1 vccd1 vccd1 vssd1 sky130_fd_sc_hd__clkbuf_4$1
Xinput46 hold61/A hold60/X vssd1 vccd1 vccd1 vssd1 sky130_fd_sc_hd__clkbuf_8$1
Xinput24 hold21/A hold20/X vssd1 vccd1 vccd1 vssd1 sky130_fd_sc_hd__clkbuf_4$1
X_0741_ hold24/A hold17/A hold8/X hold5/X hold9/A vssd1 vccd1 vccd1 vssd1 sky130_fd_sc_hd__nor4b_1$1
XFILLER_128_533 vssd1 vccd1 vccd1 vssd1 sky130_ef_sc_hd__decap_40_12$1
XFILLER_7_841 vccd1 vssd1 vccd1 vssd1 sky130_fd_sc_hd__fill_1$1
XFILLER_116_739 vccd1 vssd1 vccd1 vssd1 sky130_fd_sc_hd__fill_1$1
XFILLER_115_205 vssd1 vccd1 vccd1 vssd1 sky130_ef_sc_hd__decap_40_12$1
XFILLER_115_249 vssd1 vccd1 vccd1 vssd1 sky130_ef_sc_hd__decap_40_12$1
XFILLER_131_709 vssd1 vccd1 vccd1 vssd1 sky130_ef_sc_hd__decap_40_12$1
XFILLER_35_3 vssd1 vccd1 vccd1 vssd1 sky130_ef_sc_hd__decap_40_12$1
XFILLER_123_293 vssd1 vccd1 vccd1 vssd1 sky130_ef_sc_hd__decap_40_12$1
XFILLER_96_133 vssd1 vccd1 vccd1 vssd1 sky130_fd_sc_hd__fill_4$1
XFILLER_96_177 vssd1 vccd1 vccd1 vssd1 sky130_ef_sc_hd__decap_40_12$1
XFILLER_38_701 vssd1 vccd1 vccd1 vssd1 sky130_ef_sc_hd__decap_40_12$1
XFILLER_77_391 vccd1 vssd1 vccd1 vssd1 sky130_fd_sc_hd__fill_1$1
X_1224_ _1642_/Q _1224_/X _1270_/B vssd1 vccd1 vccd1 vssd1 sky130_fd_sc_hd__or2_1$1
XFILLER_92_361 vssd1 vccd1 vccd1 vssd1 sky130_fd_sc_hd__fill_2$1
XFILLER_80_501 vssd1 vccd1 vccd1 vssd1 sky130_ef_sc_hd__decap_40_12$1
XFILLER_65_553 vssd1 vccd1 vccd1 vssd1 sky130_fd_sc_hd__fill_2$1
X_1155_ _1289_/C1 _1154_/X _1189_/A2 hold67/X _1608_/D vssd1 vccd1 vccd1 vssd1 sky130_fd_sc_hd__o211a_1$1
XTAP_TAPCELL_ROW_125_2182 vccd1 vssd1 sky130_fd_sc_hd__tapvpwrvgnd_1$1
XTAP_TAPCELL_ROW_125_2171 vccd1 vssd1 sky130_fd_sc_hd__tapvpwrvgnd_1$1
XFILLER_25_417 vssd1 vccd1 vccd1 vssd1 sky130_ef_sc_hd__decap_40_12$1
X_1086_ _1789_/A _1086_/X _1122_/B vssd1 vccd1 vccd1 vssd1 sky130_fd_sc_hd__or2_1$1
XFILLER_37_277 vssd1 vccd1 vccd1 vssd1 sky130_fd_sc_hd__fill_2$1
XFILLER_80_556 vssd1 vccd1 vccd1 vssd1 sky130_ef_sc_hd__decap_40_12$1
XFILLER_80_545 vssd1 vccd1 vccd1 vssd1 sky130_fd_sc_hd__fill_2$1
XFILLER_80_589 vssd1 vccd1 vccd1 vssd1 sky130_ef_sc_hd__decap_40_12$1
XFILLER_61_781 vssd1 vccd1 vccd1 vssd1 sky130_fd_sc_hd__fill_2$1
XFILLER_33_461 vssd1 vccd1 vccd1 vssd1 sky130_ef_sc_hd__decap_40_12$1
XFILLER_32_29 vssd1 vccd1 vccd1 vssd1 sky130_ef_sc_hd__decap_40_12$1
XFILLER_119_511 vccd1 vssd1 vccd1 vssd1 sky130_fd_sc_hd__fill_1$1
XFILLER_20_133 vssd1 vccd1 vccd1 vssd1 sky130_fd_sc_hd__fill_4$1
XFILLER_20_177 vssd1 vccd1 vccd1 vssd1 sky130_ef_sc_hd__decap_40_12$1
X_0939_ _0750_/X _0939_/X _0938_/X _1635_/Q _1147_/A _0937_/X vssd1 vccd1 vccd1 vssd1
+ sky130_fd_sc_hd__a2111o_1$1
XFILLER_134_525 vccd1 vssd1 vccd1 vssd1 sky130_fd_sc_hd__fill_1$1
XFILLER_106_249 vssd1 vccd1 vccd1 vssd1 sky130_fd_sc_hd__fill_2$1
XTAP_TAPCELL_ROW_54_1111 vccd1 vssd1 sky130_fd_sc_hd__tapvpwrvgnd_1$1
XFILLER_115_783 vccd1 vssd1 vccd1 vssd1 sky130_fd_sc_hd__fill_1$1
XFILLER_87_111 vccd1 vssd1 vccd1 vssd1 sky130_fd_sc_hd__fill_1$1
XFILLER_0_505 vssd1 vccd1 vccd1 vssd1 sky130_ef_sc_hd__decap_40_12$1
XFILLER_102_433 vssd1 vccd1 vccd1 vssd1 sky130_ef_sc_hd__decap_40_12$1
XFILLER_88_645 vssd1 vccd1 vccd1 vssd1 sky130_ef_sc_hd__decap_40_12$1
XFILLER_57_15 vssd1 vccd1 vccd1 vssd1 sky130_ef_sc_hd__decap_40_12$1
XFILLER_75_317 vssd1 vccd1 vccd1 vssd1 sky130_ef_sc_hd__decap_40_12$1
XTAP_TAPCELL_ROW_3_343 vccd1 vssd1 sky130_fd_sc_hd__tapvpwrvgnd_1$1
XFILLER_90_309 vssd1 vccd1 vccd1 vssd1 sky130_ef_sc_hd__decap_40_12$1
XFILLER_28_233 vssd1 vccd1 vccd1 vssd1 sky130_ef_sc_hd__decap_40_12$1
XFILLER_83_361 vssd1 vccd1 vccd1 vssd1 sky130_ef_sc_hd__decap_40_12$1
XFILLER_16_417 vssd1 vccd1 vccd1 vssd1 sky130_fd_sc_hd__fill_2$1
XFILLER_28_277 vssd1 vccd1 vccd1 vssd1 sky130_ef_sc_hd__decap_40_12$1
XFILLER_43_225 vssd1 vccd1 vccd1 vssd1 sky130_ef_sc_hd__decap_40_12$1
XFILLER_44_737 vssd1 vccd1 vccd1 vssd1 sky130_fd_sc_hd__fill_4$1
XFILLER_73_69 vssd1 vccd1 vccd1 vssd1 sky130_ef_sc_hd__decap_40_12$1
XFILLER_71_545 vssd1 vccd1 vccd1 vssd1 sky130_fd_sc_hd__fill_2$1
XTAP_TAPCELL_ROW_65_1273 vccd1 vssd1 sky130_fd_sc_hd__tapvpwrvgnd_1$1
XFILLER_52_781 vssd1 vccd1 vccd1 vssd1 sky130_ef_sc_hd__decap_40_12$1
XFILLER_12_601 vssd1 vccd1 vccd1 vssd1 sky130_ef_sc_hd__decap_40_12$1
XTAP_TAPCELL_ROW_42_927 vccd1 vssd1 sky130_fd_sc_hd__tapvpwrvgnd_1$1
XFILLER_11_111 vccd1 vssd1 vccd1 vssd1 sky130_fd_sc_hd__fill_1$1
XFILLER_12_645 vssd1 vccd1 vccd1 vssd1 sky130_ef_sc_hd__decap_40_12$1
XFILLER_7_137 vssd1 vccd1 vccd1 vssd1 sky130_ef_sc_hd__decap_40_12$1
XFILLER_4_811 vccd1 vssd1 vccd1 vssd1 sky130_fd_sc_hd__fill_1$1
XFILLER_125_569 vssd1 vccd1 vccd1 vssd1 sky130_fd_sc_hd__fill_2$1
XFILLER_113_709 vssd1 vccd1 vccd1 vssd1 sky130_ef_sc_hd__decap_40_12$1
XFILLER_98_77 vssd1 vccd1 vccd1 vssd1 sky130_fd_sc_hd__fill_4$1
XFILLER_121_753 vssd1 vccd1 vccd1 vssd1 sky130_ef_sc_hd__decap_40_12$1
XFILLER_105_293 vssd1 vccd1 vccd1 vssd1 sky130_ef_sc_hd__decap_40_12$1
XFILLER_78_133 vssd1 vccd1 vccd1 vssd1 sky130_fd_sc_hd__fill_4$1
XFILLER_121_797 vssd1 vccd1 vccd1 vssd1 sky130_fd_sc_hd__fill_8$1
XFILLER_78_177 vssd1 vccd1 vccd1 vssd1 sky130_ef_sc_hd__decap_40_12$1
XFILLER_93_125 vssd1 vccd1 vccd1 vssd1 sky130_ef_sc_hd__decap_40_12$1
XFILLER_59_391 vccd1 vssd1 vccd1 vssd1 sky130_fd_sc_hd__fill_1$1
XFILLER_93_169 vssd1 vccd1 vccd1 vssd1 sky130_ef_sc_hd__decap_40_12$1
XFILLER_35_715 vssd1 vccd1 vccd1 vssd1 sky130_ef_sc_hd__decap_40_12$1
XFILLER_47_81 vssd1 vccd1 vccd1 vssd1 sky130_ef_sc_hd__decap_40_12$1
XFILLER_47_542 vssd1 vccd1 vccd1 vssd1 sky130_ef_sc_hd__decap_40_12$1
XFILLER_74_361 vssd1 vccd1 vccd1 vssd1 sky130_fd_sc_hd__fill_2$1
XFILLER_62_523 vccd1 vssd1 vccd1 vssd1 sky130_fd_sc_hd__fill_1$1
XFILLER_62_501 vssd1 vccd1 vccd1 vssd1 sky130_ef_sc_hd__decap_40_12$1
XFILLER_19_277 vssd1 vccd1 vccd1 vssd1 sky130_fd_sc_hd__fill_2$1
XFILLER_62_556 vssd1 vccd1 vccd1 vssd1 sky130_ef_sc_hd__decap_40_12$1
XFILLER_62_589 vssd1 vccd1 vccd1 vssd1 sky130_ef_sc_hd__decap_40_12$1
XFILLER_15_461 vssd1 vccd1 vccd1 vssd1 sky130_ef_sc_hd__decap_40_12$1
X_1842_ _1842_/A _1842_/X vssd1 vccd1 vccd1 vssd1 sky130_fd_sc_hd__clkbuf_2$1
XFILLER_8_53 vssd1 vccd1 vccd1 vssd1 sky130_ef_sc_hd__decap_40_12$1
XFILLER_30_475 vccd1 vssd1 vccd1 vssd1 sky130_fd_sc_hd__fill_1$1
XFILLER_128_363 vccd1 vssd1 vccd1 vssd1 sky130_fd_sc_hd__fill_1$1
XTAP_TAPCELL_ROW_96_1745 vccd1 vssd1 sky130_fd_sc_hd__tapvpwrvgnd_1$1
XTAP_TAPCELL_ROW_96_1734 vccd1 vssd1 sky130_fd_sc_hd__tapvpwrvgnd_1$1
X_1773_ vccd1 vssd1 _1773_/X _1773_/A vccd1 vssd1 sky130_fd_sc_hd__buf_1$1
XFILLER_8_97 vssd1 vccd1 vccd1 vssd1 sky130_ef_sc_hd__decap_40_12$1
XFILLER_7_671 vccd1 vssd1 vccd1 vssd1 sky130_fd_sc_hd__fill_1$1
XFILLER_131_517 vssd1 vccd1 vccd1 vssd1 sky130_ef_sc_hd__decap_40_12$1
XFILLER_97_453 vccd1 vssd1 vccd1 vssd1 sky130_fd_sc_hd__fill_1$1
XFILLER_69_111 vccd1 vssd1 vccd1 vssd1 sky130_fd_sc_hd__fill_1$1
XTAP_TAPCELL_ROW_127_2211 vccd1 vssd1 sky130_fd_sc_hd__tapvpwrvgnd_1$1
XTAP_TAPCELL_ROW_127_2200 vccd1 vssd1 sky130_fd_sc_hd__tapvpwrvgnd_1$1
XFILLER_85_615 vccd1 vssd1 vccd1 vssd1 sky130_fd_sc_hd__fill_1$1
XFILLER_57_317 vssd1 vccd1 vccd1 vssd1 sky130_ef_sc_hd__decap_40_12$1
XFILLER_38_531 vccd1 vssd1 vccd1 vssd1 sky130_fd_sc_hd__fill_1$1
X_1207_ _1417_/C1 _1206_/X _1211_/A2 hold109/X _1207_/X vssd1 vccd1 vccd1 vssd1 sky130_fd_sc_hd__o211a_1$1
XFILLER_72_309 vssd1 vccd1 vccd1 vssd1 sky130_ef_sc_hd__decap_40_12$1
XTAP_TAPCELL_ROW_0_302 vccd1 vssd1 sky130_fd_sc_hd__tapvpwrvgnd_1$1
XFILLER_38_553 vssd1 vccd1 vccd1 vssd1 sky130_fd_sc_hd__fill_2$1
XFILLER_81_821 vssd1 vccd1 vccd1 vssd1 sky130_fd_sc_hd__fill_2$1
XFILLER_65_361 vssd1 vccd1 vccd1 vssd1 sky130_ef_sc_hd__decap_40_12$1
X_1138_ hold53/X _1138_/X _1144_/B vssd1 vccd1 vccd1 vssd1 sky130_fd_sc_hd__or2_1$1
XFILLER_25_225 vssd1 vccd1 vccd1 vssd1 sky130_ef_sc_hd__decap_40_12$1
X_1069_ _1471_/C1 _1068_/X _1079_/A2 hold83/X _1567_/D vssd1 vccd1 vccd1 vssd1 sky130_fd_sc_hd__o211a_1$1
XTAP_TAPCELL_ROW_105_1874 vccd1 vssd1 sky130_fd_sc_hd__tapvpwrvgnd_1$1
XFILLER_80_386 vssd1 vccd1 vccd1 vssd1 sky130_fd_sc_hd__fill_2$1
XFILLER_43_39 vssd1 vccd1 vccd1 vssd1 sky130_ef_sc_hd__decap_40_12$1
XTAP_TAPCELL_ROW_138_2384 vccd1 vssd1 sky130_fd_sc_hd__tapvpwrvgnd_1$1
XTAP_TAPCELL_ROW_138_2373 vccd1 vssd1 sky130_fd_sc_hd__tapvpwrvgnd_1$1
XFILLER_138_138 vssd1 vccd1 vccd1 vssd1 sky130_fd_sc_hd__fill_2$1
XFILLER_21_497 vssd1 vccd1 vccd1 vssd1 sky130_fd_sc_hd__fill_4$1
XFILLER_135_801 vssd1 vccd1 vccd1 vssd1 sky130_ef_sc_hd__decap_40_12$1
XFILLER_134_355 vssd1 vccd1 vccd1 vssd1 sky130_fd_sc_hd__fill_2$1
XFILLER_107_558 vssd1 vccd1 vccd1 vssd1 sky130_fd_sc_hd__fill_2$1
XFILLER_108_65 vssd1 vccd1 vccd1 vssd1 sky130_ef_sc_hd__decap_40_12$1
Xclkbuf_leaf_12_wb_clk_i _1690_/CLK clkbuf_leaf_9_wb_clk_i/A vssd1 vccd1 vccd1 vssd1
+ sky130_fd_sc_hd__clkbuf_8$1
XTAP_TAPCELL_ROW_8_424 vccd1 vssd1 sky130_fd_sc_hd__tapvpwrvgnd_1$1
XTAP_TAPCELL_ROW_8_413 vccd1 vssd1 sky130_fd_sc_hd__tapvpwrvgnd_1$1
XFILLER_115_591 vssd1 vccd1 vccd1 vssd1 sky130_fd_sc_hd__fill_8$1
XFILLER_0_335 vccd1 vssd1 vccd1 vssd1 sky130_fd_sc_hd__fill_1$1
XFILLER_88_453 vccd1 vssd1 vccd1 vssd1 sky130_fd_sc_hd__fill_1$1
XFILLER_124_53 vssd1 vccd1 vccd1 vssd1 sky130_ef_sc_hd__decap_40_12$1
XFILLER_103_797 vssd1 vccd1 vccd1 vssd1 sky130_fd_sc_hd__fill_8$1
XFILLER_75_125 vssd1 vccd1 vccd1 vssd1 sky130_ef_sc_hd__decap_40_12$1
XFILLER_124_97 vssd1 vccd1 vccd1 vssd1 sky130_ef_sc_hd__decap_40_12$1
XFILLER_75_169 vssd1 vccd1 vccd1 vssd1 sky130_ef_sc_hd__decap_40_12$1
XFILLER_29_553 vssd1 vccd1 vccd1 vssd1 sky130_fd_sc_hd__fill_4$1
XFILLER_91_629 vssd1 vccd1 vccd1 vssd1 sky130_ef_sc_hd__decap_40_12$1
XTAP_TAPCELL_ROW_67_1302 vccd1 vssd1 sky130_fd_sc_hd__tapvpwrvgnd_1$1
XFILLER_56_361 vssd1 vccd1 vccd1 vssd1 sky130_fd_sc_hd__fill_2$1
XTAP_TAPCELL_ROW_27_710 vccd1 vssd1 sky130_fd_sc_hd__tapvpwrvgnd_1$1
XFILLER_29_597 vssd1 vccd1 vccd1 vssd1 sky130_ef_sc_hd__decap_40_12$1
XFILLER_44_501 vssd1 vccd1 vccd1 vssd1 sky130_ef_sc_hd__decap_40_12$1
XFILLER_90_139 vccd1 vssd1 vccd1 vssd1 sky130_fd_sc_hd__fill_1$1
XFILLER_17_51 vssd1 vccd1 vccd1 vssd1 sky130_fd_sc_hd__fill_4$1
XFILLER_44_545 vssd1 vccd1 vccd1 vssd1 sky130_fd_sc_hd__fill_4$1
XTAP_TAPCELL_ROW_80_1502 vccd1 vssd1 sky130_fd_sc_hd__tapvpwrvgnd_1$1
XFILLER_31_217 vssd1 vccd1 vccd1 vssd1 sky130_fd_sc_hd__fill_4$1
XFILLER_44_589 vssd1 vccd1 vccd1 vssd1 sky130_ef_sc_hd__decap_40_12$1
XFILLER_129_105 vssd1 vccd1 vccd1 vssd1 sky130_fd_sc_hd__fill_4$1
XFILLER_8_413 vssd1 vccd1 vccd1 vssd1 sky130_fd_sc_hd__fill_4$1
XFILLER_129_149 vssd1 vccd1 vccd1 vssd1 sky130_ef_sc_hd__decap_40_12$1
XFILLER_12_475 vccd1 vssd1 vccd1 vssd1 sky130_fd_sc_hd__fill_1$1
XFILLER_8_457 vssd1 vccd1 vccd1 vssd1 sky130_ef_sc_hd__decap_40_12$1
XTAP_TAPCELL_ROW_78_1464 vccd1 vssd1 sky130_fd_sc_hd__tapvpwrvgnd_1$1
XFILLER_125_333 vssd1 vccd1 vccd1 vssd1 sky130_fd_sc_hd__fill_2$1
XTAP_TAPCELL_ROW_78_1475 vccd1 vssd1 sky130_fd_sc_hd__tapvpwrvgnd_1$1
XFILLER_4_641 vssd1 vccd1 vccd1 vssd1 sky130_fd_sc_hd__fill_2$1
XFILLER_113_517 vssd1 vccd1 vccd1 vssd1 sky130_ef_sc_hd__decap_40_12$1
XFILLER_99_729 vssd1 vccd1 vccd1 vssd1 sky130_ef_sc_hd__decap_40_12$1
XTAP_TAPCELL_ROW_91_1664 vccd1 vssd1 sky130_fd_sc_hd__tapvpwrvgnd_1$1
XFILLER_121_561 vssd1 vccd1 vccd1 vssd1 sky130_ef_sc_hd__decap_40_12$1
XFILLER_67_615 vccd1 vssd1 vccd1 vssd1 sky130_fd_sc_hd__fill_1$1
XFILLER_39_317 vssd1 vccd1 vccd1 vssd1 sky130_ef_sc_hd__decap_40_12$1
Xhold2 hold2/A hold2/X vssd1 vccd1 vccd1 vssd1 sky130_fd_sc_hd__dlygate4sd3_1$1
XFILLER_94_434 vssd1 vccd1 vccd1 vssd1 sky130_fd_sc_hd__fill_2$1
XFILLER_54_309 vssd1 vccd1 vccd1 vssd1 sky130_ef_sc_hd__decap_40_12$1
XFILLER_48_840 vssd1 vccd1 vccd1 vssd1 sky130_fd_sc_hd__fill_2$1
XFILLER_82_629 vssd1 vccd1 vccd1 vssd1 sky130_ef_sc_hd__decap_40_12$1
XFILLER_75_681 vssd1 vccd1 vccd1 vssd1 sky130_ef_sc_hd__decap_40_12$1
XFILLER_35_501 vssd1 vccd1 vccd1 vssd1 sky130_fd_sc_hd__fill_2$1
XFILLER_47_361 vssd1 vccd1 vccd1 vssd1 sky130_ef_sc_hd__decap_40_12$1
XTAP_TAPCELL_ROW_122_2130 vccd1 vssd1 sky130_fd_sc_hd__tapvpwrvgnd_1$1
XFILLER_23_729 vssd1 vccd1 vccd1 vssd1 sky130_ef_sc_hd__decap_40_12$1
XFILLER_16_781 vssd1 vccd1 vccd1 vssd1 sky130_ef_sc_hd__decap_40_12$1
XTAP_TAPCELL_ROW_100_1793 vccd1 vssd1 sky130_fd_sc_hd__tapvpwrvgnd_1$1
X_1825_ _1825_/A _1825_/X vssd1 vccd1 vccd1 vssd1 sky130_fd_sc_hd__clkbuf_2$1
XTAP_TAPCELL_ROW_13_492 vccd1 vssd1 sky130_fd_sc_hd__tapvpwrvgnd_1$1
X_1756_ hold37/A _1756_/CLK _1756_/D vccd1 vssd1 vccd1 vssd1 sky130_fd_sc_hd__dfxtp_1$1
XFILLER_117_834 vssd1 vccd1 vccd1 vssd1 sky130_fd_sc_hd__fill_4$1
XFILLER_128_193 vssd1 vccd1 vccd1 vssd1 sky130_fd_sc_hd__fill_2$1
XFILLER_116_333 vssd1 vccd1 vccd1 vssd1 sky130_ef_sc_hd__decap_40_12$1
XTAP_TAPCELL_ROW_133_2292 vccd1 vssd1 sky130_fd_sc_hd__tapvpwrvgnd_1$1
XFILLER_116_377 vssd1 vccd1 vccd1 vssd1 sky130_fd_sc_hd__fill_4$1
XFILLER_104_528 vssd1 vccd1 vccd1 vssd1 sky130_fd_sc_hd__fill_4$1
XFILLER_89_217 vssd1 vccd1 vccd1 vssd1 sky130_fd_sc_hd__fill_4$1
X_1687_ _1687_/Q _1716_/CLK _1687_/D vccd1 vssd1 vccd1 vssd1 sky130_fd_sc_hd__dfxtp_1$1
XFILLER_100_701 vssd1 vccd1 vccd1 vssd1 sky130_ef_sc_hd__decap_40_12$1
XFILLER_98_773 vccd1 vssd1 vccd1 vssd1 sky130_fd_sc_hd__fill_1$1
XFILLER_97_261 vssd1 vccd1 vccd1 vssd1 sky130_ef_sc_hd__decap_40_12$1
XFILLER_57_125 vssd1 vccd1 vccd1 vssd1 sky130_ef_sc_hd__decap_40_12$1
XFILLER_85_478 vssd1 vccd1 vccd1 vssd1 sky130_fd_sc_hd__fill_4$1
XFILLER_57_169 vssd1 vccd1 vccd1 vssd1 sky130_ef_sc_hd__decap_40_12$1
XTAP_TAPCELL_ROW_107_1903 vccd1 vssd1 sky130_fd_sc_hd__tapvpwrvgnd_1$1
XFILLER_73_629 vssd1 vccd1 vccd1 vssd1 sky130_fd_sc_hd__fill_2$1
XFILLER_54_821 vccd1 vssd1 vccd1 vssd1 sky130_fd_sc_hd__fill_1$1
XFILLER_26_501 vssd1 vccd1 vccd1 vssd1 sky130_ef_sc_hd__decap_40_12$1
XFILLER_38_361 vssd1 vccd1 vccd1 vssd1 sky130_fd_sc_hd__fill_2$1
XFILLER_72_139 vccd1 vssd1 vccd1 vssd1 sky130_fd_sc_hd__fill_1$1
XFILLER_66_692 vssd1 vccd1 vccd1 vssd1 sky130_fd_sc_hd__fill_8$1
XFILLER_54_27 vccd1 vssd1 vccd1 vssd1 sky130_fd_sc_hd__fill_1$1
XFILLER_26_545 vssd1 vccd1 vccd1 vssd1 sky130_ef_sc_hd__decap_40_12$1
XTAP_TAPCELL_ROW_49_1032 vccd1 vssd1 sky130_fd_sc_hd__tapvpwrvgnd_1$1
XFILLER_81_673 vssd1 vccd1 vccd1 vssd1 sky130_ef_sc_hd__decap_40_12$1
XFILLER_26_589 vssd1 vccd1 vccd1 vssd1 sky130_ef_sc_hd__decap_40_12$1
XFILLER_13_217 vssd1 vccd1 vccd1 vssd1 sky130_fd_sc_hd__fill_4$1
XFILLER_41_537 vccd1 vssd1 vccd1 vssd1 sky130_fd_sc_hd__fill_1$1
XFILLER_110_77 vssd1 vccd1 vccd1 vssd1 sky130_fd_sc_hd__fill_4$1
XFILLER_70_15 vssd1 vccd1 vccd1 vssd1 sky130_ef_sc_hd__decap_40_12$1
XTAP_TAPCELL_ROW_62_1232 vccd1 vssd1 sky130_fd_sc_hd__tapvpwrvgnd_1$1
XFILLER_21_261 vssd1 vccd1 vccd1 vssd1 sky130_ef_sc_hd__decap_40_12$1
XFILLER_108_834 vssd1 vccd1 vccd1 vssd1 sky130_fd_sc_hd__fill_2$1
XFILLER_5_405 vssd1 vccd1 vccd1 vssd1 sky130_ef_sc_hd__decap_40_12$1
XFILLER_134_141 vssd1 vccd1 vccd1 vssd1 sky130_ef_sc_hd__decap_40_12$1
XFILLER_119_193 vssd1 vccd1 vccd1 vssd1 sky130_ef_sc_hd__decap_40_12$1
XFILLER_107_333 vssd1 vccd1 vccd1 vssd1 sky130_fd_sc_hd__fill_2$1
XFILLER_5_449 vssd1 vccd1 vccd1 vssd1 sky130_ef_sc_hd__decap_40_12$1
XFILLER_135_697 vssd1 vccd1 vccd1 vssd1 sky130_fd_sc_hd__fill_4$1
XFILLER_102_3 vssd1 vccd1 vccd1 vssd1 sky130_ef_sc_hd__decap_40_12$1
XFILLER_79_57 vssd1 vccd1 vccd1 vssd1 sky130_ef_sc_hd__decap_40_12$1
XFILLER_103_561 vssd1 vccd1 vccd1 vssd1 sky130_ef_sc_hd__decap_40_12$1
XFILLER_76_401 vssd1 vccd1 vccd1 vssd1 sky130_ef_sc_hd__decap_40_12$1
XTAP_TAPCELL_ROW_73_1394 vccd1 vssd1 sky130_fd_sc_hd__tapvpwrvgnd_1$1
XFILLER_49_615 vccd1 vssd1 vccd1 vssd1 sky130_fd_sc_hd__fill_1$1
XFILLER_0_165 vssd1 vccd1 vccd1 vssd1 sky130_fd_sc_hd__fill_2$1
XFILLER_76_456 vssd1 vccd1 vccd1 vssd1 sky130_ef_sc_hd__decap_40_12$1
XFILLER_36_309 vssd1 vccd1 vccd1 vssd1 sky130_ef_sc_hd__decap_40_12$1
XFILLER_57_681 vssd1 vccd1 vccd1 vssd1 sky130_fd_sc_hd__fill_2$1
XFILLER_17_501 vssd1 vccd1 vccd1 vssd1 sky130_fd_sc_hd__fill_2$1
XFILLER_28_83 vccd1 vssd1 vccd1 vssd1 sky130_fd_sc_hd__fill_1$1
XFILLER_29_361 vssd1 vccd1 vccd1 vssd1 sky130_ef_sc_hd__decap_40_12$1
XFILLER_72_640 vssd1 vccd1 vccd1 vssd1 sky130_fd_sc_hd__fill_4$1
XFILLER_60_813 vssd1 vccd1 vccd1 vssd1 sky130_fd_sc_hd__fill_2$1
XFILLER_72_695 vssd1 vccd1 vccd1 vssd1 sky130_fd_sc_hd__fill_4$1
XFILLER_71_161 vssd1 vccd1 vccd1 vssd1 sky130_fd_sc_hd__fill_4$1
XFILLER_8_221 vssd1 vccd1 vccd1 vssd1 sky130_ef_sc_hd__decap_40_12$1
XFILLER_9_777 vssd1 vccd1 vccd1 vssd1 sky130_fd_sc_hd__fill_4$1
XTAP_TAPCELL_ROW_30_749 vccd1 vssd1 sky130_fd_sc_hd__tapvpwrvgnd_1$1
XFILLER_60_81 vssd1 vccd1 vccd1 vssd1 sky130_fd_sc_hd__fill_2$1
X_1610_ _1814_/A _1704_/CLK _1610_/D vccd1 vssd1 vccd1 vssd1 sky130_fd_sc_hd__dfxtp_1$1
XTAP_TAPCELL_ROW_10_451 vccd1 vssd1 sky130_fd_sc_hd__tapvpwrvgnd_1$1
XFILLER_8_265 vssd1 vccd1 vccd1 vssd1 sky130_ef_sc_hd__decap_40_12$1
XFILLER_99_515 vccd1 vssd1 vccd1 vssd1 sky130_fd_sc_hd__fill_1$1
X_1541_ _1772_/A _1575_/CLK _1541_/D vccd1 vssd1 vccd1 vssd1 sky130_fd_sc_hd__dfxtp_1$1
X_1472_ hold74/X _1472_/X _1474_/B vssd1 vccd1 vccd1 vssd1 sky130_fd_sc_hd__or2_1$1
XFILLER_99_559 vccd1 vssd1 vccd1 vssd1 sky130_fd_sc_hd__fill_1$1
XFILLER_86_209 vssd1 vccd1 vccd1 vssd1 sky130_ef_sc_hd__decap_40_12$1
XFILLER_95_743 vccd1 vssd1 vccd1 vssd1 sky130_fd_sc_hd__fill_1$1
XFILLER_79_261 vssd1 vccd1 vccd1 vssd1 sky130_ef_sc_hd__decap_40_12$1
XFILLER_39_125 vssd1 vccd1 vccd1 vssd1 sky130_ef_sc_hd__decap_40_12$1
XFILLER_94_253 vssd1 vccd1 vccd1 vssd1 sky130_ef_sc_hd__decap_40_12$1
XFILLER_82_404 vssd1 vccd1 vccd1 vssd1 sky130_ef_sc_hd__decap_40_12$1
XFILLER_36_810 vssd1 vccd1 vccd1 vssd1 sky130_fd_sc_hd__fill_2$1
XFILLER_39_169 vssd1 vccd1 vccd1 vssd1 sky130_ef_sc_hd__decap_40_12$1
XFILLER_48_681 vssd1 vccd1 vccd1 vssd1 sky130_fd_sc_hd__fill_8$1
XFILLER_54_139 vccd1 vssd1 vccd1 vssd1 sky130_fd_sc_hd__fill_1$1
XFILLER_63_673 vssd1 vccd1 vccd1 vssd1 sky130_ef_sc_hd__decap_40_12$1
XFILLER_50_301 vssd1 vccd1 vccd1 vssd1 sky130_fd_sc_hd__fill_4$1
XTAP_TAPCELL_ROW_18_573 vccd1 vssd1 sky130_fd_sc_hd__tapvpwrvgnd_1$1
XTAP_TAPCELL_ROW_102_1833 vccd1 vssd1 sky130_fd_sc_hd__tapvpwrvgnd_1$1
XFILLER_50_345 vssd1 vccd1 vccd1 vssd1 sky130_ef_sc_hd__decap_40_12$1
XFILLER_23_559 vccd1 vssd1 vccd1 vssd1 sky130_fd_sc_hd__fill_1$1
XFILLER_50_389 vssd1 vccd1 vccd1 vssd1 sky130_ef_sc_hd__decap_40_12$1
XFILLER_10_209 vssd1 vccd1 vccd1 vssd1 sky130_ef_sc_hd__decap_40_12$1
XTAP_TAPCELL_ROW_135_2332 vccd1 vssd1 sky130_fd_sc_hd__tapvpwrvgnd_1$1
XTAP_TAPCELL_ROW_135_2321 vccd1 vssd1 sky130_fd_sc_hd__tapvpwrvgnd_1$1
XFILLER_40_29 vssd1 vccd1 vccd1 vssd1 sky130_ef_sc_hd__decap_40_12$1
X_1808_ _1808_/A _1808_/X vssd1 vccd1 vccd1 vssd1 sky130_fd_sc_hd__clkbuf_2$1
Xhold210 input22/X hold210/X vssd1 vccd1 vccd1 vssd1 sky130_fd_sc_hd__dlygate4sd3_1$1
XFILLER_132_601 vssd1 vccd1 vccd1 vssd1 sky130_ef_sc_hd__decap_40_12$1
XFILLER_116_141 vssd1 vccd1 vccd1 vssd1 sky130_ef_sc_hd__decap_40_12$1
X_1739_ _1847_/A _1739_/CLK _1739_/D vccd1 vssd1 vccd1 vssd1 sky130_fd_sc_hd__dfxtp_1$1
XFILLER_2_419 vccd1 vssd1 vccd1 vssd1 sky130_fd_sc_hd__fill_1$1
XFILLER_132_645 vssd1 vccd1 vccd1 vssd1 sky130_ef_sc_hd__decap_40_12$1
XFILLER_131_111 vccd1 vssd1 vccd1 vssd1 sky130_fd_sc_hd__fill_1$1
XFILLER_49_27 vssd1 vccd1 vccd1 vssd1 sky130_ef_sc_hd__decap_40_12$1
XFILLER_132_689 vccd1 vssd1 vccd1 vssd1 sky130_fd_sc_hd__fill_1$1
XFILLER_120_818 vssd1 vccd1 vccd1 vssd1 sky130_fd_sc_hd__fill_8$1
XTAP_TAPCELL_ROW_113_1995 vccd1 vssd1 sky130_fd_sc_hd__tapvpwrvgnd_1$1
XFILLER_58_401 vssd1 vccd1 vccd1 vssd1 sky130_ef_sc_hd__decap_40_12$1
XFILLER_105_55 vccd1 vssd1 vccd1 vssd1 sky130_fd_sc_hd__fill_1$1
XFILLER_100_553 vssd1 vccd1 vccd1 vssd1 sky130_ef_sc_hd__decap_40_12$1
XFILLER_86_754 vssd1 vccd1 vccd1 vssd1 sky130_fd_sc_hd__fill_2$1
XFILLER_65_15 vssd1 vccd1 vccd1 vssd1 sky130_ef_sc_hd__decap_40_12$1
XFILLER_58_445 vccd1 vssd1 vccd1 vssd1 sky130_fd_sc_hd__fill_1$1
XFILLER_18_309 vssd1 vccd1 vccd1 vssd1 sky130_ef_sc_hd__decap_40_12$1
XFILLER_27_821 vssd1 vccd1 vccd1 vssd1 sky130_fd_sc_hd__fill_2$1
XFILLER_100_597 vssd1 vccd1 vccd1 vssd1 sky130_ef_sc_hd__decap_40_12$1
XFILLER_60_109 vssd1 vccd1 vccd1 vssd1 sky130_ef_sc_hd__decap_40_12$1
XTAP_TAPCELL_ROW_37_860 vccd1 vssd1 sky130_fd_sc_hd__tapvpwrvgnd_1$1
XFILLER_42_813 vssd1 vccd1 vccd1 vssd1 sky130_ef_sc_hd__decap_40_12$1
XFILLER_53_161 vssd1 vccd1 vccd1 vssd1 sky130_fd_sc_hd__fill_4$1
XFILLER_81_69 vssd1 vccd1 vccd1 vssd1 sky130_ef_sc_hd__decap_40_12$1
XFILLER_14_41 vssd1 vccd1 vccd1 vssd1 sky130_ef_sc_hd__decap_40_12$1
XFILLER_41_389 vssd1 vccd1 vccd1 vssd1 sky130_fd_sc_hd__fill_2$1
XPHY_EDGE_ROW_101_Left_240 vccd1 vssd1 vccd1 vssd1 sky130_fd_sc_hd__decap_3$1
XFILLER_14_85 vssd1 vccd1 vccd1 vssd1 sky130_ef_sc_hd__decap_40_12$1
XFILLER_22_581 vssd1 vccd1 vccd1 vssd1 sky130_fd_sc_hd__fill_4$1
XFILLER_6_725 vssd1 vccd1 vccd1 vssd1 sky130_ef_sc_hd__decap_40_12$1
XFILLER_6_769 vssd1 vccd1 vccd1 vssd1 sky130_ef_sc_hd__decap_40_12$1
XFILLER_108_664 vssd1 vccd1 vccd1 vssd1 sky130_ef_sc_hd__decap_40_12$1
XTAP_TAPCELL_ROW_75_1423 vccd1 vssd1 sky130_fd_sc_hd__tapvpwrvgnd_1$1
XFILLER_5_279 vccd1 vssd1 vccd1 vssd1 sky130_fd_sc_hd__fill_1$1
XFILLER_122_133 vssd1 vccd1 vccd1 vssd1 sky130_fd_sc_hd__fill_4$1
XFILLER_68_209 vssd1 vccd1 vccd1 vssd1 sky130_ef_sc_hd__decap_40_12$1
XFILLER_1_441 vssd1 vccd1 vccd1 vssd1 sky130_fd_sc_hd__fill_4$1
XFILLER_122_177 vssd1 vccd1 vccd1 vssd1 sky130_ef_sc_hd__decap_40_12$1
XFILLER_77_721 vssd1 vccd1 vccd1 vssd1 sky130_fd_sc_hd__fill_4$1
XFILLER_1_485 vssd1 vccd1 vccd1 vssd1 sky130_ef_sc_hd__decap_40_12$1
XFILLER_77_765 vssd1 vccd1 vccd1 vssd1 sky130_ef_sc_hd__decap_40_12$1
XFILLER_39_93 vssd1 vccd1 vccd1 vssd1 sky130_ef_sc_hd__decap_40_12$1
XFILLER_49_445 vssd1 vccd1 vccd1 vssd1 sky130_fd_sc_hd__fill_2$1
XFILLER_92_724 vssd1 vccd1 vccd1 vssd1 sky130_ef_sc_hd__decap_40_12$1
XFILLER_76_253 vssd1 vccd1 vccd1 vssd1 sky130_ef_sc_hd__decap_40_12$1
XFILLER_64_415 vssd1 vccd1 vccd1 vssd1 sky130_fd_sc_hd__fill_4$1
XFILLER_18_821 vssd1 vccd1 vccd1 vssd1 sky130_fd_sc_hd__fill_2$1
XFILLER_37_629 vssd1 vccd1 vccd1 vssd1 sky130_ef_sc_hd__decap_40_12$1
XFILLER_92_757 vssd1 vccd1 vccd1 vssd1 sky130_ef_sc_hd__decap_40_12$1
XFILLER_91_223 vccd1 vssd1 vccd1 vssd1 sky130_fd_sc_hd__fill_1$1
XFILLER_36_139 vccd1 vssd1 vccd1 vssd1 sky130_fd_sc_hd__fill_1$1
XFILLER_55_81 vssd1 vccd1 vccd1 vssd1 sky130_ef_sc_hd__decap_40_12$1
XFILLER_51_109 vssd1 vccd1 vccd1 vssd1 sky130_fd_sc_hd__fill_2$1
XTAP_TAPCELL_ROW_35_819 vccd1 vssd1 sky130_fd_sc_hd__tapvpwrvgnd_1$1
XTAP_TAPCELL_ROW_86_1596 vccd1 vssd1 sky130_fd_sc_hd__tapvpwrvgnd_1$1
XTAP_TAPCELL_ROW_86_1585 vccd1 vssd1 sky130_fd_sc_hd__tapvpwrvgnd_1$1
XFILLER_32_301 vssd1 vccd1 vccd1 vssd1 sky130_fd_sc_hd__fill_4$1
XFILLER_60_643 vccd1 vssd1 vccd1 vssd1 sky130_fd_sc_hd__fill_1$1
XTAP_TAPCELL_ROW_15_521 vccd1 vssd1 sky130_fd_sc_hd__tapvpwrvgnd_1$1
XTAP_TAPCELL_ROW_15_532 vccd1 vssd1 sky130_fd_sc_hd__tapvpwrvgnd_1$1
XFILLER_32_345 vssd1 vccd1 vccd1 vssd1 sky130_ef_sc_hd__decap_40_12$1
XFILLER_20_529 vssd1 vccd1 vccd1 vssd1 sky130_fd_sc_hd__fill_2$1
XFILLER_32_389 vssd1 vccd1 vccd1 vssd1 sky130_ef_sc_hd__decap_40_12$1
X_0972_ _0972_/A _0972_/X _0990_/B vssd1 vccd1 vccd1 vssd1 sky130_fd_sc_hd__or2_1$1
XFILLER_9_541 vssd1 vccd1 vccd1 vssd1 sky130_ef_sc_hd__decap_40_12$1
XTAP_TAPCELL_ROW_117_2051 vccd1 vssd1 sky130_fd_sc_hd__tapvpwrvgnd_1$1
XFILLER_9_585 vssd1 vccd1 vccd1 vssd1 sky130_ef_sc_hd__decap_40_12$1
XTAP_TAPCELL_ROW_117_2062 vccd1 vssd1 sky130_fd_sc_hd__tapvpwrvgnd_1$1
XFILLER_65_3 vssd1 vccd1 vccd1 vssd1 sky130_ef_sc_hd__decap_40_12$1
XFILLER_114_601 vssd1 vccd1 vccd1 vssd1 sky130_fd_sc_hd__fill_4$1
XTAP_TAPCELL_ROW_130_2251 vccd1 vssd1 sky130_fd_sc_hd__tapvpwrvgnd_1$1
XFILLER_114_623 vssd1 vccd1 vccd1 vssd1 sky130_fd_sc_hd__fill_2$1
XFILLER_114_645 vccd1 vssd1 vccd1 vssd1 sky130_fd_sc_hd__fill_1$1
XFILLER_113_111 vccd1 vssd1 vccd1 vssd1 sky130_fd_sc_hd__fill_1$1
X_1524_ _1524_/Q _1748_/CLK _1524_/D vccd1 vssd1 vccd1 vssd1 sky130_fd_sc_hd__dfxtp_1$1
XFILLER_114_678 vssd1 vccd1 vccd1 vssd1 sky130_ef_sc_hd__decap_40_12$1
XFILLER_101_317 vssd1 vccd1 vccd1 vssd1 sky130_ef_sc_hd__decap_40_12$1
X_1455_ _1455_/C1 _1454_/X _1465_/A2 hold107/X _1754_/D vssd1 vccd1 vccd1 vssd1 sky130_fd_sc_hd__o211a_1$1
XFILLER_87_529 vssd1 vccd1 vccd1 vssd1 sky130_fd_sc_hd__fill_2$1
XFILLER_68_721 vccd1 vssd1 vccd1 vssd1 sky130_fd_sc_hd__fill_1$1
X_1386_ _1386_/A _1386_/X _1398_/B vssd1 vccd1 vccd1 vssd1 sky130_fd_sc_hd__or2_1$1
XFILLER_95_573 vssd1 vccd1 vccd1 vssd1 sky130_ef_sc_hd__decap_40_12$1
XFILLER_83_724 vssd1 vccd1 vccd1 vssd1 sky130_fd_sc_hd__fill_4$1
XFILLER_55_437 vssd1 vccd1 vccd1 vssd1 sky130_fd_sc_hd__fill_8$1
XFILLER_83_779 vssd1 vccd1 vccd1 vssd1 sky130_fd_sc_hd__fill_4$1
XFILLER_82_245 vssd1 vccd1 vccd1 vssd1 sky130_fd_sc_hd__fill_4$1
XFILLER_24_813 vssd1 vccd1 vccd1 vssd1 sky130_fd_sc_hd__fill_4$1
XFILLER_42_109 vssd1 vccd1 vccd1 vssd1 sky130_ef_sc_hd__decap_40_12$1
XFILLER_82_289 vssd1 vccd1 vccd1 vssd1 sky130_ef_sc_hd__decap_40_12$1
XFILLER_63_481 vssd1 vccd1 vccd1 vssd1 sky130_fd_sc_hd__fill_2$1
XFILLER_35_161 vssd1 vccd1 vccd1 vssd1 sky130_fd_sc_hd__fill_4$1
XFILLER_50_153 vssd1 vccd1 vccd1 vssd1 sky130_ef_sc_hd__decap_40_12$1
XFILLER_11_529 vssd1 vccd1 vccd1 vssd1 sky130_ef_sc_hd__decap_40_12$1
XFILLER_23_389 vssd1 vccd1 vccd1 vssd1 sky130_fd_sc_hd__fill_2$1
XFILLER_137_715 vssd1 vccd1 vccd1 vssd1 sky130_fd_sc_hd__fill_2$1
XFILLER_51_39 vssd1 vccd1 vccd1 vssd1 sky130_ef_sc_hd__decap_40_12$1
XFILLER_50_197 vssd1 vccd1 vccd1 vssd1 sky130_ef_sc_hd__decap_40_12$1
XFILLER_109_439 vssd1 vccd1 vccd1 vssd1 sky130_fd_sc_hd__fill_8$1
XFILLER_105_612 vssd1 vccd1 vccd1 vssd1 sky130_fd_sc_hd__fill_4$1
XTAP_TAPCELL_ROW_57_1153 vccd1 vssd1 sky130_fd_sc_hd__tapvpwrvgnd_1$1
XFILLER_104_133 vssd1 vccd1 vccd1 vssd1 sky130_fd_sc_hd__fill_4$1
XFILLER_2_249 vssd1 vccd1 vccd1 vssd1 sky130_fd_sc_hd__fill_2$1
XFILLER_132_475 vccd1 vssd1 vccd1 vssd1 sky130_fd_sc_hd__fill_1$1
XFILLER_120_615 vccd1 vssd1 vccd1 vssd1 sky130_fd_sc_hd__fill_1$1
XFILLER_116_65 vssd1 vccd1 vccd1 vssd1 sky130_ef_sc_hd__decap_40_12$1
XFILLER_104_177 vssd1 vccd1 vccd1 vssd1 sky130_ef_sc_hd__decap_40_12$1
XFILLER_78_529 vssd1 vccd1 vccd1 vssd1 sky130_fd_sc_hd__fill_2$1
XTAP_TAPCELL_ROW_70_1353 vccd1 vssd1 sky130_fd_sc_hd__tapvpwrvgnd_1$1
XFILLER_100_361 vssd1 vccd1 vccd1 vssd1 sky130_fd_sc_hd__fill_2$1
XFILLER_58_253 vssd1 vccd1 vccd1 vssd1 sky130_ef_sc_hd__decap_40_12$1
XFILLER_19_629 vssd1 vccd1 vccd1 vssd1 sky130_ef_sc_hd__decap_40_12$1
XFILLER_132_53 vssd1 vccd1 vccd1 vssd1 sky130_ef_sc_hd__decap_40_12$1
XFILLER_74_757 vssd1 vccd1 vccd1 vssd1 sky130_ef_sc_hd__decap_40_12$1
XFILLER_73_223 vccd1 vssd1 vccd1 vssd1 sky130_fd_sc_hd__fill_1$1
XFILLER_18_139 vccd1 vssd1 vccd1 vssd1 sky130_fd_sc_hd__fill_1$1
XFILLER_46_459 vccd1 vssd1 vccd1 vssd1 sky130_fd_sc_hd__fill_1$1
XFILLER_61_418 vssd1 vccd1 vccd1 vssd1 sky130_fd_sc_hd__fill_8$1
XFILLER_33_109 vssd1 vccd1 vccd1 vssd1 sky130_fd_sc_hd__fill_2$1
XFILLER_132_97 vssd1 vccd1 vccd1 vssd1 sky130_ef_sc_hd__decap_40_12$1
XFILLER_54_470 vssd1 vccd1 vccd1 vssd1 sky130_fd_sc_hd__fill_4$1
XFILLER_14_301 vssd1 vccd1 vccd1 vssd1 sky130_fd_sc_hd__fill_4$1
XFILLER_27_673 vssd1 vccd1 vccd1 vssd1 sky130_fd_sc_hd__fill_4$1
XFILLER_14_345 vssd1 vccd1 vccd1 vssd1 sky130_ef_sc_hd__decap_40_12$1
XFILLER_25_51 vssd1 vccd1 vccd1 vssd1 sky130_fd_sc_hd__fill_4$1
XFILLER_30_805 vssd1 vccd1 vccd1 vssd1 sky130_fd_sc_hd__fill_4$1
XFILLER_14_389 vssd1 vccd1 vccd1 vssd1 sky130_ef_sc_hd__decap_40_12$1
XFILLER_42_698 vssd1 vccd1 vccd1 vssd1 sky130_fd_sc_hd__fill_2$1
XFILLER_128_737 vssd1 vccd1 vccd1 vssd1 sky130_ef_sc_hd__decap_40_12$1
XFILLER_127_225 vssd1 vccd1 vccd1 vssd1 sky130_ef_sc_hd__decap_40_12$1
XFILLER_6_533 vssd1 vccd1 vccd1 vssd1 sky130_ef_sc_hd__decap_40_12$1
XTAP_TAPCELL_ROW_40_899 vccd1 vssd1 sky130_fd_sc_hd__tapvpwrvgnd_1$1
XFILLER_136_781 vssd1 vccd1 vccd1 vssd1 sky130_fd_sc_hd__fill_4$1
XFILLER_136_792 vssd1 vccd1 vccd1 vssd1 sky130_fd_sc_hd__fill_2$1
XFILLER_123_431 vssd1 vccd1 vccd1 vssd1 sky130_ef_sc_hd__decap_40_12$1
XFILLER_123_497 vssd1 vccd1 vccd1 vssd1 sky130_fd_sc_hd__fill_4$1
XFILLER_111_615 vccd1 vssd1 vccd1 vssd1 sky130_fd_sc_hd__fill_1$1
XFILLER_69_529 vssd1 vccd1 vccd1 vssd1 sky130_fd_sc_hd__fill_8$1
X_1240_ _1650_/Q _1240_/X _1276_/B vssd1 vccd1 vccd1 vssd1 sky130_fd_sc_hd__or2_1$1
XFILLER_1_293 vssd1 vccd1 vccd1 vssd1 sky130_ef_sc_hd__decap_40_12$1
XTAP_TAPCELL_ROW_88_1625 vccd1 vssd1 sky130_fd_sc_hd__tapvpwrvgnd_1$1
XTAP_TAPCELL_ROW_88_1614 vccd1 vssd1 sky130_fd_sc_hd__tapvpwrvgnd_1$1
XFILLER_77_573 vssd1 vccd1 vccd1 vssd1 sky130_ef_sc_hd__decap_40_12$1
X_1171_ _1431_/C1 _1170_/X _1189_/A2 hold210/X _1616_/D vssd1 vccd1 vccd1 vssd1 sky130_fd_sc_hd__o211a_1$1
XFILLER_2_77 vssd1 vccd1 vccd1 vssd1 sky130_fd_sc_hd__fill_4$1
XFILLER_92_521 vssd1 vccd1 vccd1 vssd1 sky130_fd_sc_hd__fill_2$1
XFILLER_64_245 vssd1 vccd1 vccd1 vssd1 sky130_fd_sc_hd__fill_4$1
XFILLER_92_587 vccd1 vssd1 vccd1 vssd1 sky130_fd_sc_hd__fill_1$1
XFILLER_64_289 vssd1 vccd1 vccd1 vssd1 sky130_ef_sc_hd__decap_40_12$1
XFILLER_17_161 vssd1 vccd1 vccd1 vssd1 sky130_fd_sc_hd__fill_4$1
XFILLER_24_109 vssd1 vccd1 vccd1 vssd1 sky130_ef_sc_hd__decap_40_12$1
XFILLER_32_153 vssd1 vccd1 vccd1 vssd1 sky130_ef_sc_hd__decap_40_12$1
XPHY_EDGE_ROW_120_Right_120 vccd1 vssd1 vccd1 vssd1 sky130_fd_sc_hd__decap_3$1
XANTENNA_16 input49/X vssd1 vccd1 vccd1 vssd1 sky130_fd_sc_hd__diode_2$1
XANTENNA_27 _1144_/B vssd1 vccd1 vccd1 vssd1 sky130_fd_sc_hd__diode_2$1
XFILLER_32_197 vssd1 vccd1 vccd1 vssd1 sky130_ef_sc_hd__decap_40_12$1
X_0955_ _1091_/C1 _0954_/X _0991_/A2 hold71/X _1511_/D vssd1 vccd1 vccd1 vssd1 sky130_fd_sc_hd__o211a_1$1
XTAP_TAPCELL_ROW_99_1787 vccd1 vssd1 sky130_fd_sc_hd__tapvpwrvgnd_1$1
X_0886_ _0749_/X _1498_/D _0882_/X _1417_/C1 _1498_/Q _0885_/X vssd1 vccd1 vccd1 vssd1
+ sky130_fd_sc_hd__o221a_1$1
XFILLER_9_393 vssd1 vccd1 vccd1 vssd1 sky130_ef_sc_hd__decap_40_12$1
XFILLER_134_729 vssd1 vccd1 vccd1 vssd1 sky130_fd_sc_hd__fill_8$1
Xoutput101 _1806_/X analog_ctrl[35] vssd1 vccd1 vccd1 vssd1 sky130_fd_sc_hd__buf_12$1
XFILLER_133_217 vssd1 vccd1 vccd1 vssd1 sky130_fd_sc_hd__fill_4$1
Xoutput134 _1638_/Q analog_ctrl[65] vssd1 vccd1 vccd1 vssd1 sky130_fd_sc_hd__buf_12$1
Xoutput123 _1826_/X analog_ctrl[55] vssd1 vccd1 vccd1 vssd1 sky130_fd_sc_hd__buf_12$1
Xoutput112 _1816_/X analog_ctrl[45] vssd1 vccd1 vccd1 vssd1 sky130_fd_sc_hd__buf_12$1
Xoutput167 _1835_/X analog_ctrl[96] vssd1 vccd1 vccd1 vssd1 sky130_fd_sc_hd__buf_12$1
Xoutput156 _1659_/Q analog_ctrl[86] vssd1 vccd1 vccd1 vssd1 sky130_fd_sc_hd__buf_12$1
Xoutput145 _1648_/Q analog_ctrl[75] vssd1 vccd1 vccd1 vssd1 sky130_fd_sc_hd__buf_12$1
Xoutput189 _1503_/Q wbs_dat_o[26] vssd1 vccd1 vccd1 vssd1 sky130_fd_sc_hd__buf_12$1
Xoutput178 _1493_/Q wbs_dat_o[16] vssd1 vccd1 vccd1 vssd1 sky130_fd_sc_hd__buf_12$1
X_1507_ _1507_/Q _1764_/CLK _1507_/D vccd1 vssd1 vccd1 vssd1 sky130_fd_sc_hd__dfxtp_1$1
XFILLER_114_475 vccd1 vssd1 vccd1 vssd1 sky130_fd_sc_hd__fill_1$1
XTAP_TAPCELL_ROW_110_1954 vccd1 vssd1 sky130_fd_sc_hd__tapvpwrvgnd_1$1
XTAP_TAPCELL_ROW_110_1943 vccd1 vssd1 sky130_fd_sc_hd__tapvpwrvgnd_1$1
XFILLER_101_125 vssd1 vccd1 vccd1 vssd1 sky130_ef_sc_hd__decap_40_12$1
X_1438_ _1854_/A _1438_/X _1464_/B vssd1 vccd1 vccd1 vssd1 sky130_fd_sc_hd__or2_1$1
XFILLER_87_337 vssd1 vccd1 vccd1 vssd1 sky130_ef_sc_hd__decap_40_12$1
XFILLER_101_169 vssd1 vccd1 vccd1 vssd1 sky130_ef_sc_hd__decap_40_12$1
XFILLER_68_562 vccd1 vssd1 vccd1 vssd1 sky130_fd_sc_hd__fill_1$1
XFILLER_56_713 vssd1 vccd1 vccd1 vssd1 sky130_ef_sc_hd__decap_40_12$1
XTAP_TAPCELL_ROW_52_1083 vccd1 vssd1 sky130_fd_sc_hd__tapvpwrvgnd_1$1
XFILLER_83_521 vssd1 vccd1 vccd1 vssd1 sky130_fd_sc_hd__fill_2$1
X_1369_ _1449_/C1 _1368_/X _1399_/A2 hold210/X _1712_/D vssd1 vccd1 vccd1 vssd1 sky130_fd_sc_hd__o211a_1$1
XFILLER_55_223 vccd1 vssd1 vccd1 vssd1 sky130_fd_sc_hd__fill_1$1
XFILLER_71_727 vccd1 vssd1 vccd1 vssd1 sky130_fd_sc_hd__fill_1$1
Xclkbuf_leaf_37_wb_clk_i _1679_/CLK clkload1/A vssd1 vccd1 vccd1 vssd1 sky130_fd_sc_hd__clkbuf_8$1
XFILLER_15_109 vssd1 vccd1 vccd1 vssd1 sky130_fd_sc_hd__fill_2$1
XFILLER_43_429 vssd1 vccd1 vccd1 vssd1 sky130_ef_sc_hd__decap_40_12$1
XFILLER_62_27 vccd1 vssd1 vccd1 vssd1 sky130_fd_sc_hd__fill_1$1
XFILLER_24_643 vccd1 vssd1 vccd1 vssd1 sky130_fd_sc_hd__fill_1$1
XFILLER_51_473 vssd1 vccd1 vccd1 vssd1 sky130_fd_sc_hd__fill_8$1
XFILLER_12_805 vssd1 vccd1 vccd1 vssd1 sky130_fd_sc_hd__fill_4$1
XFILLER_11_337 vssd1 vccd1 vccd1 vssd1 sky130_ef_sc_hd__decap_40_12$1
XFILLER_8_809 vssd1 vccd1 vccd1 vssd1 sky130_fd_sc_hd__fill_2$1
XFILLER_109_225 vssd1 vccd1 vccd1 vssd1 sky130_ef_sc_hd__decap_40_12$1
XFILLER_125_729 vssd1 vccd1 vccd1 vssd1 sky130_fd_sc_hd__fill_2$1
XFILLER_3_503 vccd1 vssd1 vccd1 vssd1 sky130_fd_sc_hd__fill_1$1
XFILLER_87_57 vssd1 vccd1 vccd1 vssd1 sky130_ef_sc_hd__decap_40_12$1
XFILLER_120_434 vssd1 vccd1 vccd1 vssd1 sky130_fd_sc_hd__fill_4$1
XFILLER_93_329 vssd1 vccd1 vccd1 vssd1 sky130_fd_sc_hd__fill_4$1
XFILLER_59_573 vssd1 vccd1 vccd1 vssd1 sky130_ef_sc_hd__decap_40_12$1
XTAP_TAPCELL_ROW_6_385 vccd1 vssd1 sky130_fd_sc_hd__tapvpwrvgnd_1$1
XTAP_TAPCELL_ROW_6_396 vccd1 vssd1 sky130_fd_sc_hd__tapvpwrvgnd_1$1
XFILLER_47_757 vccd1 vssd1 vccd1 vssd1 sky130_fd_sc_hd__fill_1$1
XFILLER_46_245 vssd1 vccd1 vccd1 vssd1 sky130_fd_sc_hd__fill_4$1
Xafe_wb_283 analog_ctrl[100] afe_wb_283/HI vssd1 vccd1 vccd1 vssd1 sky130_fd_sc_hd__conb_1$1
XFILLER_46_289 vssd1 vccd1 vccd1 vssd1 sky130_ef_sc_hd__decap_40_12$1
XTAP_TAPCELL_ROW_83_1544 vccd1 vssd1 sky130_fd_sc_hd__tapvpwrvgnd_1$1
XFILLER_61_237 vssd1 vccd1 vccd1 vssd1 sky130_ef_sc_hd__decap_40_12$1
XFILLER_36_83 vccd1 vssd1 vccd1 vssd1 sky130_fd_sc_hd__fill_1$1
XTAP_TAPCELL_ROW_45_969 vccd1 vssd1 sky130_fd_sc_hd__tapvpwrvgnd_1$1
XFILLER_14_153 vssd1 vccd1 vccd1 vssd1 sky130_ef_sc_hd__decap_40_12$1
XFILLER_15_665 vssd1 vccd1 vccd1 vssd1 sky130_fd_sc_hd__fill_4$1
XFILLER_30_613 vssd1 vccd1 vccd1 vssd1 sky130_ef_sc_hd__decap_40_12$1
XFILLER_42_473 vssd1 vccd1 vccd1 vssd1 sky130_fd_sc_hd__fill_2$1
XFILLER_70_793 vssd1 vccd1 vccd1 vssd1 sky130_ef_sc_hd__decap_40_12$1
XFILLER_14_197 vssd1 vccd1 vccd1 vssd1 sky130_ef_sc_hd__decap_40_12$1
XTAP_TAPCELL_ROW_25_671 vccd1 vssd1 sky130_fd_sc_hd__tapvpwrvgnd_1$1
XTAP_TAPCELL_ROW_25_682 vccd1 vssd1 sky130_fd_sc_hd__tapvpwrvgnd_1$1
XFILLER_128_501 vssd1 vccd1 vccd1 vssd1 sky130_fd_sc_hd__fill_8$1
XFILLER_30_657 vssd1 vccd1 vccd1 vssd1 sky130_ef_sc_hd__decap_40_12$1
Xinput36 vccd1 vssd1 hold86/A hold85/X vccd1 vssd1 sky130_fd_sc_hd__buf_2$1
Xinput14 wb_rst_i _0738_/A vccd1 vssd1 vccd1 vssd1 sky130_fd_sc_hd__dlymetal6s2s_1$1
Xinput25 input25/X input25/A vssd1 vccd1 vccd1 vssd1 sky130_fd_sc_hd__clkbuf_4$1
XFILLER_128_545 vssd1 vccd1 vccd1 vssd1 sky130_ef_sc_hd__decap_40_12$1
X_0740_ hold5/A hold8/A hold17/A _0740_/X hold24/A vssd1 vccd1 vccd1 vssd1 sky130_fd_sc_hd__and4bb_4$1
Xinput47 hold30/A hold29/X vssd1 vccd1 vccd1 vssd1 sky130_fd_sc_hd__clkbuf_8$1
XFILLER_128_589 vssd1 vccd1 vccd1 vssd1 sky130_fd_sc_hd__fill_2$1
XTAP_TAPCELL_ROW_114_2010 vccd1 vssd1 sky130_fd_sc_hd__tapvpwrvgnd_1$1
XFILLER_109_770 vssd1 vccd1 vccd1 vssd1 sky130_ef_sc_hd__decap_40_12$1
XFILLER_115_217 vssd1 vccd1 vccd1 vssd1 sky130_fd_sc_hd__fill_4$1
XFILLER_6_363 vccd1 vssd1 vccd1 vssd1 sky130_fd_sc_hd__fill_1$1
XFILLER_124_762 vssd1 vccd1 vccd1 vssd1 sky130_ef_sc_hd__decap_40_12$1
XFILLER_130_209 vssd1 vccd1 vccd1 vssd1 sky130_ef_sc_hd__decap_40_12$1
XFILLER_123_261 vssd1 vccd1 vccd1 vssd1 sky130_ef_sc_hd__decap_40_12$1
XFILLER_111_401 vssd1 vccd1 vccd1 vssd1 sky130_ef_sc_hd__decap_40_12$1
XFILLER_69_337 vssd1 vccd1 vccd1 vssd1 sky130_ef_sc_hd__decap_40_12$1
XFILLER_85_819 vccd1 vssd1 vccd1 vssd1 sky130_fd_sc_hd__fill_1$1
XFILLER_84_307 vccd1 vssd1 vccd1 vssd1 sky130_fd_sc_hd__fill_1$1
X_1223_ _1435_/C1 _1222_/X _1273_/A2 hold61/X _1641_/D vssd1 vccd1 vccd1 vssd1 sky130_fd_sc_hd__o211a_1$1
XFILLER_28_3 vssd1 vccd1 vccd1 vssd1 sky130_ef_sc_hd__decap_40_12$1
XFILLER_38_713 vssd1 vccd1 vccd1 vssd1 sky130_ef_sc_hd__decap_40_12$1
XFILLER_96_189 vssd1 vccd1 vccd1 vssd1 sky130_fd_sc_hd__fill_4$1
XFILLER_93_841 vccd1 vssd1 vccd1 vssd1 sky130_fd_sc_hd__fill_1$1
XFILLER_37_223 vccd1 vssd1 vccd1 vssd1 sky130_fd_sc_hd__fill_1$1
XFILLER_38_757 vssd1 vccd1 vccd1 vssd1 sky130_ef_sc_hd__decap_40_12$1
X_1154_ _1795_/A _1154_/X _1188_/B vssd1 vccd1 vccd1 vssd1 sky130_fd_sc_hd__or2_1$1
XTAP_TAPCELL_ROW_125_2172 vccd1 vssd1 sky130_fd_sc_hd__tapvpwrvgnd_1$1
XFILLER_80_513 vssd1 vccd1 vccd1 vssd1 sky130_ef_sc_hd__decap_40_12$1
XFILLER_53_727 vccd1 vssd1 vccd1 vssd1 sky130_fd_sc_hd__fill_1$1
XFILLER_25_429 vssd1 vccd1 vccd1 vssd1 sky130_ef_sc_hd__decap_40_12$1
X_1085_ _1091_/C1 _1084_/X _1123_/A2 hold73/X _1574_/D vssd1 vccd1 vccd1 vssd1 sky130_fd_sc_hd__o211a_1$1
XFILLER_80_568 vssd1 vccd1 vccd1 vssd1 sky130_ef_sc_hd__decap_40_12$1
XFILLER_21_613 vssd1 vccd1 vccd1 vssd1 sky130_fd_sc_hd__fill_2$1
XFILLER_33_473 vssd1 vccd1 vccd1 vssd1 sky130_ef_sc_hd__decap_40_12$1
X_0938_ hold69/A _0949_/A _0938_/X hold68/A _0753_/X vccd1 vssd1 vccd1 vssd1 sky130_fd_sc_hd__a22o_1$1
XFILLER_20_189 vssd1 vccd1 vccd1 vssd1 sky130_fd_sc_hd__fill_4$1
XFILLER_107_729 vssd1 vccd1 vccd1 vssd1 sky130_ef_sc_hd__decap_40_12$1
XFILLER_134_537 vssd1 vccd1 vccd1 vssd1 sky130_fd_sc_hd__fill_2$1
X_0869_ _1624_/Q _1147_/A _0869_/X _1656_/Q _1213_/A vccd1 vssd1 vccd1 vssd1 sky130_fd_sc_hd__a22o_1$1
XFILLER_102_401 vssd1 vccd1 vccd1 vssd1 sky130_fd_sc_hd__fill_4$1
XFILLER_102_412 vssd1 vccd1 vccd1 vssd1 sky130_fd_sc_hd__fill_8$1
XTAP_TAPCELL_ROW_54_1112 vccd1 vssd1 sky130_fd_sc_hd__tapvpwrvgnd_1$1
XFILLER_0_517 vssd1 vccd1 vccd1 vssd1 sky130_ef_sc_hd__decap_40_12$1
XFILLER_102_445 vssd1 vccd1 vccd1 vssd1 sky130_ef_sc_hd__decap_40_12$1
XFILLER_88_657 vssd1 vccd1 vccd1 vssd1 sky130_ef_sc_hd__decap_40_12$1
XFILLER_87_167 vccd1 vssd1 vccd1 vssd1 sky130_fd_sc_hd__fill_1$1
XFILLER_57_27 vssd1 vccd1 vccd1 vssd1 sky130_ef_sc_hd__decap_40_12$1
XFILLER_130_798 vccd1 vssd1 vccd1 vssd1 sky130_fd_sc_hd__fill_1$1
XFILLER_75_329 vssd1 vccd1 vccd1 vssd1 sky130_fd_sc_hd__fill_4$1
XTAP_TAPCELL_ROW_3_344 vccd1 vssd1 sky130_fd_sc_hd__tapvpwrvgnd_1$1
XFILLER_113_55 vccd1 vssd1 vccd1 vssd1 sky130_fd_sc_hd__fill_1$1
XFILLER_28_245 vssd1 vccd1 vccd1 vssd1 sky130_fd_sc_hd__fill_4$1
XFILLER_83_373 vssd1 vccd1 vccd1 vssd1 sky130_fd_sc_hd__fill_8$1
XFILLER_73_15 vssd1 vccd1 vccd1 vssd1 sky130_ef_sc_hd__decap_40_12$1
XFILLER_28_289 vssd1 vccd1 vccd1 vssd1 sky130_ef_sc_hd__decap_40_12$1
XFILLER_71_568 vssd1 vccd1 vccd1 vssd1 sky130_ef_sc_hd__decap_40_12$1
XFILLER_71_557 vssd1 vccd1 vccd1 vssd1 sky130_fd_sc_hd__fill_2$1
XFILLER_43_237 vssd1 vccd1 vccd1 vssd1 sky130_ef_sc_hd__decap_40_12$1
XTAP_TAPCELL_ROW_65_1274 vccd1 vssd1 sky130_fd_sc_hd__tapvpwrvgnd_1$1
XFILLER_12_613 vssd1 vccd1 vccd1 vssd1 sky130_ef_sc_hd__decap_40_12$1
XTAP_TAPCELL_ROW_42_928 vccd1 vssd1 sky130_fd_sc_hd__tapvpwrvgnd_1$1
XFILLER_52_793 vssd1 vccd1 vccd1 vssd1 sky130_ef_sc_hd__decap_40_12$1
XFILLER_51_281 vssd1 vccd1 vccd1 vssd1 sky130_ef_sc_hd__decap_40_12$1
XFILLER_24_473 vssd1 vccd1 vccd1 vssd1 sky130_fd_sc_hd__fill_2$1
XFILLER_132_3 vssd1 vccd1 vccd1 vssd1 sky130_ef_sc_hd__decap_40_12$1
XFILLER_7_105 vssd1 vccd1 vccd1 vssd1 sky130_fd_sc_hd__fill_4$1
XFILLER_12_657 vssd1 vccd1 vccd1 vssd1 sky130_ef_sc_hd__decap_40_12$1
XTAP_TAPCELL_ROW_22_630 vccd1 vssd1 sky130_fd_sc_hd__tapvpwrvgnd_1$1
XFILLER_11_167 vccd1 vssd1 vccd1 vssd1 sky130_fd_sc_hd__fill_1$1
XFILLER_22_41 vssd1 vccd1 vccd1 vssd1 sky130_ef_sc_hd__decap_40_12$1
XFILLER_7_149 vssd1 vccd1 vccd1 vssd1 sky130_ef_sc_hd__decap_40_12$1
XFILLER_22_85 vssd1 vccd1 vccd1 vssd1 sky130_ef_sc_hd__decap_40_12$1
XFILLER_138_85 vssd1 vccd1 vccd1 vssd1 sky130_fd_sc_hd__fill_2$1
XFILLER_137_375 vccd1 vssd1 vccd1 vssd1 sky130_fd_sc_hd__fill_1$1
XFILLER_125_559 vccd1 vssd1 vccd1 vssd1 sky130_fd_sc_hd__fill_1$1
XFILLER_3_333 vssd1 vccd1 vccd1 vssd1 sky130_fd_sc_hd__fill_2$1
XFILLER_121_721 vssd1 vccd1 vccd1 vssd1 sky130_fd_sc_hd__fill_4$1
XFILLER_112_209 vssd1 vccd1 vccd1 vssd1 sky130_ef_sc_hd__decap_40_12$1
XFILLER_105_261 vssd1 vccd1 vccd1 vssd1 sky130_ef_sc_hd__decap_40_12$1
XFILLER_79_613 vssd1 vccd1 vccd1 vssd1 sky130_fd_sc_hd__fill_2$1
XFILLER_121_765 vssd1 vccd1 vccd1 vssd1 sky130_ef_sc_hd__decap_40_12$1
XFILLER_120_253 vssd1 vccd1 vccd1 vssd1 sky130_ef_sc_hd__decap_40_12$1
XFILLER_66_307 vccd1 vssd1 vccd1 vssd1 sky130_fd_sc_hd__fill_1$1
XFILLER_93_137 vssd1 vccd1 vccd1 vssd1 sky130_ef_sc_hd__decap_40_12$1
XFILLER_78_189 vssd1 vccd1 vccd1 vssd1 sky130_fd_sc_hd__fill_4$1
XFILLER_75_841 vccd1 vssd1 vccd1 vssd1 sky130_fd_sc_hd__fill_1$1
XFILLER_19_223 vccd1 vssd1 vccd1 vssd1 sky130_fd_sc_hd__fill_1$1
XFILLER_47_554 vssd1 vccd1 vccd1 vssd1 sky130_fd_sc_hd__fill_4$1
XFILLER_47_565 vssd1 vccd1 vccd1 vssd1 sky130_fd_sc_hd__fill_2$1
XFILLER_90_833 vssd1 vccd1 vccd1 vssd1 sky130_fd_sc_hd__fill_8$1
XFILLER_90_811 vccd1 vssd1 vccd1 vssd1 sky130_fd_sc_hd__fill_1$1
XFILLER_62_513 vssd1 vccd1 vccd1 vssd1 sky130_fd_sc_hd__fill_8$1
XFILLER_35_727 vccd1 vssd1 vccd1 vssd1 sky130_fd_sc_hd__fill_1$1
XFILLER_47_93 vssd1 vccd1 vccd1 vssd1 sky130_ef_sc_hd__decap_40_12$1
XFILLER_62_568 vssd1 vccd1 vccd1 vssd1 sky130_fd_sc_hd__fill_8$1
XFILLER_43_771 vssd1 vccd1 vccd1 vssd1 sky130_fd_sc_hd__fill_4$1
XFILLER_63_81 vssd1 vccd1 vccd1 vssd1 sky130_ef_sc_hd__decap_40_12$1
XFILLER_15_473 vssd1 vccd1 vccd1 vssd1 sky130_ef_sc_hd__decap_40_12$1
XFILLER_30_421 vssd1 vccd1 vccd1 vssd1 sky130_ef_sc_hd__decap_40_12$1
X_1841_ _1841_/A _1841_/X vssd1 vccd1 vccd1 vssd1 sky130_fd_sc_hd__clkbuf_2$1
XFILLER_8_65 vssd1 vccd1 vccd1 vssd1 sky130_ef_sc_hd__decap_40_12$1
XTAP_TAPCELL_ROW_96_1735 vccd1 vssd1 sky130_fd_sc_hd__tapvpwrvgnd_1$1
X_1772_ vccd1 vssd1 _1772_/X _1772_/A vccd1 vssd1 sky130_fd_sc_hd__buf_1$1
XTAP_TAPCELL_ROW_96_1746 vccd1 vssd1 sky130_fd_sc_hd__tapvpwrvgnd_1$1
XFILLER_6_193 vssd1 vccd1 vccd1 vssd1 sky130_fd_sc_hd__fill_2$1
XFILLER_131_529 vssd1 vccd1 vccd1 vssd1 sky130_ef_sc_hd__decap_40_12$1
XTAP_TAPCELL_ROW_127_2212 vccd1 vssd1 sky130_fd_sc_hd__tapvpwrvgnd_1$1
XTAP_TAPCELL_ROW_127_2201 vccd1 vssd1 sky130_fd_sc_hd__tapvpwrvgnd_1$1
XFILLER_97_465 vssd1 vccd1 vccd1 vssd1 sky130_ef_sc_hd__decap_40_12$1
XFILLER_69_167 vccd1 vssd1 vccd1 vssd1 sky130_fd_sc_hd__fill_1$1
XFILLER_84_137 vssd1 vccd1 vccd1 vssd1 sky130_fd_sc_hd__fill_2$1
XFILLER_57_329 vssd1 vccd1 vccd1 vssd1 sky130_fd_sc_hd__fill_4$1
X_1206_ _1634_/Q _1206_/X _1210_/B vssd1 vccd1 vccd1 vssd1 sky130_fd_sc_hd__or2_1$1
XTAP_TAPCELL_ROW_0_303 vccd1 vssd1 sky130_fd_sc_hd__tapvpwrvgnd_1$1
X_1137_ _1465_/C1 _1136_/X _1145_/A2 hold146/X _1600_/D vssd1 vccd1 vccd1 vssd1 sky130_fd_sc_hd__o211a_1$1
XFILLER_93_671 vccd1 vssd1 vccd1 vssd1 sky130_fd_sc_hd__fill_1$1
XFILLER_65_373 vssd1 vccd1 vccd1 vssd1 sky130_ef_sc_hd__decap_40_12$1
XFILLER_53_502 vssd1 vccd1 vccd1 vssd1 sky130_fd_sc_hd__fill_2$1
XFILLER_38_587 vccd1 vssd1 vccd1 vssd1 sky130_fd_sc_hd__fill_1$1
XFILLER_80_321 vssd1 vccd1 vccd1 vssd1 sky130_ef_sc_hd__decap_40_12$1
XFILLER_25_237 vssd1 vccd1 vccd1 vssd1 sky130_ef_sc_hd__decap_40_12$1
X_1068_ _1068_/A _1068_/X _1078_/B vssd1 vccd1 vccd1 vssd1 sky130_fd_sc_hd__or2_1$1
XTAP_TAPCELL_ROW_105_1875 vccd1 vssd1 sky130_fd_sc_hd__tapvpwrvgnd_1$1
XFILLER_80_365 vssd1 vccd1 vccd1 vssd1 sky130_fd_sc_hd__fill_4$1
XFILLER_53_579 vccd1 vssd1 vccd1 vssd1 sky130_fd_sc_hd__fill_1$1
XFILLER_33_281 vssd1 vccd1 vccd1 vssd1 sky130_ef_sc_hd__decap_40_12$1
XTAP_TAPCELL_ROW_138_2374 vccd1 vssd1 sky130_fd_sc_hd__tapvpwrvgnd_1$1
XTAP_TAPCELL_ROW_138_2363 vccd1 vssd1 sky130_fd_sc_hd__tapvpwrvgnd_1$1
XTAP_TAPCELL_ROW_138_2385 vccd1 vssd1 sky130_fd_sc_hd__tapvpwrvgnd_1$1
XFILLER_135_813 vssd1 vccd1 vccd1 vssd1 sky130_ef_sc_hd__decap_40_12$1
XTAP_TAPCELL_ROW_60_1193 vccd1 vssd1 sky130_fd_sc_hd__tapvpwrvgnd_1$1
XFILLER_5_609 vssd1 vccd1 vccd1 vssd1 sky130_fd_sc_hd__fill_4$1
XFILLER_134_301 vssd1 vccd1 vccd1 vssd1 sky130_fd_sc_hd__fill_4$1
XFILLER_107_515 vssd1 vccd1 vccd1 vssd1 sky130_fd_sc_hd__fill_4$1
XFILLER_134_378 vccd1 vssd1 vccd1 vssd1 sky130_fd_sc_hd__fill_1$1
XFILLER_122_529 vssd1 vccd1 vccd1 vssd1 sky130_fd_sc_hd__fill_2$1
XFILLER_122_507 vssd1 vccd1 vccd1 vssd1 sky130_fd_sc_hd__fill_2$1
XFILLER_108_77 vssd1 vccd1 vccd1 vssd1 sky130_fd_sc_hd__fill_4$1
XFILLER_68_15 vssd1 vccd1 vccd1 vssd1 sky130_ef_sc_hd__decap_40_12$1
XTAP_TAPCELL_ROW_8_425 vccd1 vssd1 sky130_fd_sc_hd__tapvpwrvgnd_1$1
XTAP_TAPCELL_ROW_8_414 vccd1 vssd1 sky130_fd_sc_hd__tapvpwrvgnd_1$1
XFILLER_1_837 vssd1 vccd1 vccd1 vssd1 sky130_fd_sc_hd__fill_2$1
XFILLER_130_540 vssd1 vccd1 vccd1 vssd1 sky130_ef_sc_hd__decap_40_12$1
XFILLER_102_253 vssd1 vccd1 vccd1 vssd1 sky130_ef_sc_hd__decap_40_12$1
XFILLER_48_307 vccd1 vssd1 vccd1 vssd1 sky130_fd_sc_hd__fill_1$1
XFILLER_124_65 vssd1 vccd1 vccd1 vssd1 sky130_ef_sc_hd__decap_40_12$1
XFILLER_75_137 vssd1 vccd1 vccd1 vssd1 sky130_ef_sc_hd__decap_40_12$1
XFILLER_57_841 vccd1 vssd1 vccd1 vssd1 sky130_fd_sc_hd__fill_1$1
XTAP_TAPCELL_ROW_67_1303 vccd1 vssd1 sky130_fd_sc_hd__tapvpwrvgnd_1$1
XFILLER_17_727 vccd1 vssd1 vccd1 vssd1 sky130_fd_sc_hd__fill_1$1
XTAP_TAPCELL_ROW_27_700 vccd1 vssd1 sky130_fd_sc_hd__tapvpwrvgnd_1$1
XTAP_TAPCELL_ROW_27_711 vccd1 vssd1 sky130_fd_sc_hd__tapvpwrvgnd_1$1
XFILLER_44_513 vssd1 vccd1 vccd1 vssd1 sky130_ef_sc_hd__decap_40_12$1
XFILLER_83_181 vssd1 vccd1 vccd1 vssd1 sky130_ef_sc_hd__decap_40_12$1
XTAP_TAPCELL_ROW_80_1503 vccd1 vssd1 sky130_fd_sc_hd__tapvpwrvgnd_1$1
XFILLER_25_771 vssd1 vccd1 vccd1 vssd1 sky130_ef_sc_hd__decap_40_12$1
XFILLER_12_421 vssd1 vccd1 vccd1 vssd1 sky130_ef_sc_hd__decap_40_12$1
XFILLER_33_51 vssd1 vccd1 vccd1 vssd1 sky130_fd_sc_hd__fill_4$1
XFILLER_126_813 vssd1 vccd1 vccd1 vssd1 sky130_fd_sc_hd__fill_4$1
XFILLER_8_469 vssd1 vccd1 vccd1 vssd1 sky130_fd_sc_hd__fill_4$1
XFILLER_138_673 vssd1 vccd1 vccd1 vssd1 sky130_fd_sc_hd__fill_2$1
XFILLER_137_194 vssd1 vccd1 vccd1 vssd1 sky130_fd_sc_hd__fill_8$1
XTAP_TAPCELL_ROW_78_1476 vccd1 vssd1 sky130_fd_sc_hd__tapvpwrvgnd_1$1
XTAP_TAPCELL_ROW_78_1465 vccd1 vssd1 sky130_fd_sc_hd__tapvpwrvgnd_1$1
XFILLER_125_389 vssd1 vccd1 vccd1 vssd1 sky130_fd_sc_hd__fill_2$1
XFILLER_113_529 vssd1 vccd1 vccd1 vssd1 sky130_ef_sc_hd__decap_40_12$1
XTAP_TAPCELL_ROW_91_1665 vccd1 vssd1 sky130_fd_sc_hd__tapvpwrvgnd_1$1
XFILLER_79_410 vssd1 vccd1 vccd1 vssd1 sky130_ef_sc_hd__decap_40_12$1
XFILLER_4_697 vssd1 vccd1 vccd1 vssd1 sky130_fd_sc_hd__fill_2$1
Xhold3 hold3/A hold3/X vssd1 vccd1 vccd1 vssd1 sky130_fd_sc_hd__dlygate4sd3_1$1
XFILLER_121_573 vssd1 vccd1 vccd1 vssd1 sky130_ef_sc_hd__decap_40_12$1
XFILLER_58_81 vssd1 vccd1 vccd1 vssd1 sky130_fd_sc_hd__fill_2$1
XFILLER_39_329 vssd1 vccd1 vccd1 vssd1 sky130_fd_sc_hd__fill_4$1
XFILLER_82_619 vssd1 vccd1 vccd1 vssd1 sky130_fd_sc_hd__fill_2$1
XFILLER_66_137 vssd1 vccd1 vccd1 vssd1 sky130_fd_sc_hd__fill_2$1
XFILLER_75_671 vccd1 vssd1 vccd1 vssd1 sky130_fd_sc_hd__fill_1$1
XFILLER_47_373 vssd1 vccd1 vccd1 vssd1 sky130_ef_sc_hd__decap_40_12$1
XTAP_TAPCELL_ROW_122_2131 vccd1 vssd1 sky130_fd_sc_hd__tapvpwrvgnd_1$1
XFILLER_90_641 vssd1 vccd1 vccd1 vssd1 sky130_fd_sc_hd__fill_2$1
XFILLER_75_693 vssd1 vccd1 vccd1 vssd1 sky130_fd_sc_hd__fill_8$1
XFILLER_62_321 vssd1 vccd1 vccd1 vssd1 sky130_ef_sc_hd__decap_40_12$1
XFILLER_35_557 vssd1 vccd1 vccd1 vssd1 sky130_fd_sc_hd__fill_2$1
XFILLER_62_365 vssd1 vccd1 vccd1 vssd1 sky130_ef_sc_hd__decap_40_12$1
XFILLER_95_3 vssd1 vccd1 vccd1 vssd1 sky130_ef_sc_hd__decap_40_12$1
XFILLER_16_793 vssd1 vccd1 vccd1 vssd1 sky130_ef_sc_hd__decap_40_12$1
XFILLER_15_281 vssd1 vccd1 vccd1 vssd1 sky130_ef_sc_hd__decap_40_12$1
XFILLER_31_741 vssd1 vccd1 vccd1 vssd1 sky130_ef_sc_hd__decap_40_12$1
XFILLER_30_251 vccd1 vssd1 vccd1 vssd1 sky130_fd_sc_hd__fill_1$1
XFILLER_31_785 vssd1 vccd1 vccd1 vssd1 sky130_ef_sc_hd__decap_40_12$1
XFILLER_135_109 vssd1 vccd1 vccd1 vssd1 sky130_fd_sc_hd__fill_2$1
XTAP_TAPCELL_ROW_100_1794 vccd1 vssd1 sky130_fd_sc_hd__tapvpwrvgnd_1$1
X_1824_ vccd1 vssd1 _1824_/X _1824_/A vccd1 vssd1 sky130_fd_sc_hd__buf_1$1
XTAP_TAPCELL_ROW_13_493 vccd1 vssd1 sky130_fd_sc_hd__tapvpwrvgnd_1$1
XFILLER_129_673 vssd1 vccd1 vccd1 vssd1 sky130_ef_sc_hd__decap_40_12$1
X_1755_ hold92/A _1755_/CLK _1755_/D vccd1 vssd1 vccd1 vssd1 sky130_fd_sc_hd__dfxtp_1$1
XFILLER_116_301 vssd1 vccd1 vccd1 vssd1 sky130_fd_sc_hd__fill_4$1
XFILLER_116_345 vssd1 vccd1 vccd1 vssd1 sky130_ef_sc_hd__decap_40_12$1
XTAP_TAPCELL_ROW_133_2293 vccd1 vssd1 sky130_fd_sc_hd__tapvpwrvgnd_1$1
X_1686_ _1686_/Q _1721_/CLK _1686_/D vccd1 vssd1 vccd1 vssd1 sky130_fd_sc_hd__dfxtp_1$1
XFILLER_131_337 vssd1 vccd1 vccd1 vssd1 sky130_ef_sc_hd__decap_40_12$1
XFILLER_58_616 vssd1 vccd1 vccd1 vssd1 sky130_ef_sc_hd__decap_40_12$1
XFILLER_100_713 vssd1 vccd1 vccd1 vssd1 sky130_ef_sc_hd__decap_40_12$1
XFILLER_97_273 vssd1 vccd1 vccd1 vssd1 sky130_fd_sc_hd__fill_4$1
XFILLER_38_29 vssd1 vccd1 vccd1 vssd1 sky130_ef_sc_hd__decap_40_12$1
XFILLER_100_757 vssd1 vccd1 vccd1 vssd1 sky130_ef_sc_hd__decap_40_12$1
XFILLER_57_137 vssd1 vccd1 vccd1 vssd1 sky130_ef_sc_hd__decap_40_12$1
XFILLER_39_841 vccd1 vssd1 vccd1 vssd1 sky130_fd_sc_hd__fill_1$1
XTAP_TAPCELL_ROW_107_1904 vccd1 vssd1 sky130_fd_sc_hd__tapvpwrvgnd_1$1
XFILLER_26_513 vssd1 vccd1 vccd1 vssd1 sky130_ef_sc_hd__decap_40_12$1
XFILLER_65_181 vssd1 vccd1 vccd1 vssd1 sky130_ef_sc_hd__decap_40_12$1
XTAP_TAPCELL_ROW_49_1033 vccd1 vssd1 sky130_fd_sc_hd__tapvpwrvgnd_1$1
XFILLER_26_557 vssd1 vccd1 vccd1 vssd1 sky130_ef_sc_hd__decap_40_12$1
XFILLER_41_505 vssd1 vccd1 vccd1 vssd1 sky130_ef_sc_hd__decap_40_12$1
XFILLER_81_685 vssd1 vccd1 vccd1 vssd1 sky130_ef_sc_hd__decap_40_12$1
XFILLER_80_195 vccd1 vssd1 vccd1 vssd1 sky130_fd_sc_hd__fill_1$1
XTAP_TAPCELL_ROW_62_1233 vccd1 vssd1 sky130_fd_sc_hd__tapvpwrvgnd_1$1
XFILLER_70_27 vccd1 vssd1 vccd1 vssd1 sky130_fd_sc_hd__fill_1$1
XFILLER_21_273 vssd1 vccd1 vccd1 vssd1 sky130_fd_sc_hd__fill_4$1
XTAP_TAPCELL_ROW_32_780 vccd1 vssd1 sky130_fd_sc_hd__tapvpwrvgnd_1$1
XFILLER_126_109 vssd1 vccd1 vccd1 vssd1 sky130_ef_sc_hd__decap_40_12$1
XFILLER_119_161 vssd1 vccd1 vccd1 vssd1 sky130_fd_sc_hd__fill_4$1
XFILLER_5_417 vssd1 vccd1 vccd1 vssd1 sky130_ef_sc_hd__decap_40_12$1
XFILLER_134_153 vssd1 vccd1 vccd1 vssd1 sky130_ef_sc_hd__decap_40_12$1
XFILLER_107_389 vssd1 vccd1 vccd1 vssd1 sky130_fd_sc_hd__fill_2$1
XFILLER_79_69 vssd1 vccd1 vccd1 vssd1 sky130_ef_sc_hd__decap_40_12$1
XFILLER_134_197 vssd1 vccd1 vccd1 vssd1 sky130_ef_sc_hd__decap_40_12$1
XFILLER_89_741 vssd1 vccd1 vccd1 vssd1 sky130_ef_sc_hd__decap_40_12$1
XFILLER_0_111 vccd1 vssd1 vccd1 vssd1 sky130_fd_sc_hd__fill_1$1
XFILLER_88_251 vccd1 vssd1 vccd1 vssd1 sky130_fd_sc_hd__fill_1$1
XFILLER_103_573 vssd1 vccd1 vccd1 vssd1 sky130_ef_sc_hd__decap_40_12$1
XFILLER_95_57 vssd1 vccd1 vccd1 vssd1 sky130_ef_sc_hd__decap_40_12$1
XFILLER_89_785 vssd1 vccd1 vccd1 vssd1 sky130_ef_sc_hd__decap_40_12$1
XFILLER_76_413 vssd1 vccd1 vccd1 vssd1 sky130_fd_sc_hd__fill_4$1
XTAP_TAPCELL_ROW_73_1395 vccd1 vssd1 sky130_fd_sc_hd__tapvpwrvgnd_1$1
XFILLER_49_649 vssd1 vccd1 vccd1 vssd1 sky130_ef_sc_hd__decap_40_12$1
XFILLER_76_468 vssd1 vccd1 vccd1 vssd1 sky130_fd_sc_hd__fill_8$1
XFILLER_48_137 vssd1 vccd1 vccd1 vssd1 sky130_fd_sc_hd__fill_2$1
XFILLER_91_405 vssd1 vccd1 vccd1 vssd1 sky130_ef_sc_hd__decap_40_12$1
XFILLER_57_671 vccd1 vssd1 vccd1 vssd1 sky130_fd_sc_hd__fill_1$1
XFILLER_29_373 vssd1 vccd1 vccd1 vssd1 sky130_ef_sc_hd__decap_40_12$1
XFILLER_91_449 vssd1 vccd1 vccd1 vssd1 sky130_ef_sc_hd__decap_40_12$1
XFILLER_44_321 vssd1 vccd1 vccd1 vssd1 sky130_ef_sc_hd__decap_40_12$1
XFILLER_17_557 vssd1 vccd1 vccd1 vssd1 sky130_fd_sc_hd__fill_2$1
XFILLER_44_365 vssd1 vccd1 vccd1 vssd1 sky130_ef_sc_hd__decap_40_12$1
XFILLER_13_741 vssd1 vccd1 vccd1 vssd1 sky130_ef_sc_hd__decap_40_12$1
XFILLER_44_83 vccd1 vssd1 vccd1 vssd1 sky130_fd_sc_hd__fill_1$1
XFILLER_12_251 vccd1 vssd1 vccd1 vssd1 sky130_fd_sc_hd__fill_1$1
XFILLER_13_785 vssd1 vccd1 vccd1 vssd1 sky130_ef_sc_hd__decap_40_12$1
XFILLER_40_560 vssd1 vccd1 vccd1 vssd1 sky130_fd_sc_hd__fill_4$1
XFILLER_40_571 vssd1 vccd1 vccd1 vssd1 sky130_ef_sc_hd__decap_40_12$1
XFILLER_8_233 vssd1 vccd1 vccd1 vssd1 sky130_ef_sc_hd__decap_40_12$1
XFILLER_40_593 vccd1 vssd1 vccd1 vssd1 sky130_fd_sc_hd__fill_1$1
XFILLER_117_109 vssd1 vccd1 vccd1 vssd1 sky130_fd_sc_hd__fill_2$1
XTAP_TAPCELL_ROW_10_452 vccd1 vssd1 sky130_fd_sc_hd__tapvpwrvgnd_1$1
XFILLER_8_277 vssd1 vccd1 vccd1 vssd1 sky130_ef_sc_hd__decap_40_12$1
X_1540_ hold26/A _1764_/CLK _1540_/D vccd1 vssd1 vccd1 vssd1 sky130_fd_sc_hd__dfxtp_1$1
XFILLER_114_805 vssd1 vccd1 vccd1 vssd1 sky130_fd_sc_hd__fill_4$1
XFILLER_99_505 vssd1 vccd1 vccd1 vssd1 sky130_fd_sc_hd__fill_8$1
XFILLER_5_55 vccd1 vssd1 vccd1 vssd1 sky130_fd_sc_hd__fill_1$1
X_1471_ _1471_/C1 _1470_/X _1475_/A2 hold109/X _1762_/D vssd1 vccd1 vccd1 vssd1 sky130_fd_sc_hd__o211a_1$1
XFILLER_126_698 vssd1 vccd1 vccd1 vssd1 sky130_fd_sc_hd__fill_2$1
XFILLER_113_337 vssd1 vccd1 vccd1 vssd1 sky130_ef_sc_hd__decap_40_12$1
XFILLER_95_722 vssd1 vccd1 vccd1 vssd1 sky130_fd_sc_hd__fill_4$1
XFILLER_79_273 vssd1 vccd1 vccd1 vssd1 sky130_fd_sc_hd__fill_4$1
XFILLER_94_221 vssd1 vccd1 vccd1 vssd1 sky130_ef_sc_hd__decap_40_12$1
XFILLER_67_446 vssd1 vccd1 vccd1 vssd1 sky130_fd_sc_hd__fill_2$1
XFILLER_55_608 vssd1 vccd1 vccd1 vssd1 sky130_fd_sc_hd__fill_8$1
XFILLER_10_3 vssd1 vccd1 vccd1 vssd1 sky130_ef_sc_hd__decap_40_12$1
XFILLER_39_137 vssd1 vccd1 vccd1 vssd1 sky130_ef_sc_hd__decap_40_12$1
XFILLER_94_265 vssd1 vccd1 vccd1 vssd1 sky130_ef_sc_hd__decap_40_12$1
XFILLER_82_416 vssd1 vccd1 vccd1 vssd1 sky130_fd_sc_hd__fill_4$1
XFILLER_47_181 vssd1 vccd1 vccd1 vssd1 sky130_ef_sc_hd__decap_40_12$1
XFILLER_23_505 vssd1 vccd1 vccd1 vssd1 sky130_ef_sc_hd__decap_40_12$1
XTAP_TAPCELL_ROW_102_1823 vccd1 vssd1 sky130_fd_sc_hd__tapvpwrvgnd_1$1
XFILLER_63_685 vssd1 vccd1 vccd1 vssd1 sky130_fd_sc_hd__fill_4$1
XTAP_TAPCELL_ROW_18_563 vccd1 vssd1 sky130_fd_sc_hd__tapvpwrvgnd_1$1
XTAP_TAPCELL_ROW_18_574 vccd1 vssd1 sky130_fd_sc_hd__tapvpwrvgnd_1$1
XTAP_TAPCELL_ROW_102_1834 vccd1 vssd1 sky130_fd_sc_hd__tapvpwrvgnd_1$1
XFILLER_62_195 vccd1 vssd1 vccd1 vssd1 sky130_fd_sc_hd__fill_1$1
XFILLER_50_357 vssd1 vccd1 vccd1 vssd1 sky130_fd_sc_hd__fill_4$1
XTAP_TAPCELL_ROW_135_2322 vccd1 vssd1 sky130_fd_sc_hd__tapvpwrvgnd_1$1
XFILLER_108_109 vssd1 vccd1 vccd1 vssd1 sky130_ef_sc_hd__decap_40_12$1
X_1807_ vccd1 vssd1 _1807_/X _1807_/A vccd1 vssd1 sky130_fd_sc_hd__buf_2$1
Xhold211 _1751_/Q _1448_/A vssd1 vccd1 vccd1 vssd1 sky130_fd_sc_hd__dlygate4sd3_1$1
Xhold200 _1625_/Q _1188_/A vssd1 vccd1 vccd1 vssd1 sky130_fd_sc_hd__dlygate4sd3_1$1
XFILLER_132_613 vssd1 vccd1 vccd1 vssd1 sky130_fd_sc_hd__fill_4$1
XFILLER_116_153 vssd1 vccd1 vccd1 vssd1 sky130_ef_sc_hd__decap_40_12$1
X_1738_ _1846_/A _1738_/CLK _1738_/D vccd1 vssd1 vccd1 vssd1 sky130_fd_sc_hd__dfxtp_1$1
XFILLER_116_197 vssd1 vccd1 vccd1 vssd1 sky130_ef_sc_hd__decap_40_12$1
X_1669_ _1837_/A _1704_/CLK _1669_/D vccd1 vssd1 vccd1 vssd1 sky130_fd_sc_hd__dfxtp_1$1
XFILLER_132_657 vssd1 vccd1 vccd1 vssd1 sky130_ef_sc_hd__decap_40_12$1
XFILLER_49_39 vssd1 vccd1 vccd1 vssd1 sky130_ef_sc_hd__decap_40_12$1
XFILLER_131_167 vccd1 vssd1 vccd1 vssd1 sky130_fd_sc_hd__fill_1$1
XTAP_TAPCELL_ROW_113_1996 vccd1 vssd1 sky130_fd_sc_hd__tapvpwrvgnd_1$1
XFILLER_98_571 vccd1 vssd1 vccd1 vssd1 sky130_fd_sc_hd__fill_1$1
XFILLER_58_413 vssd1 vccd1 vccd1 vssd1 sky130_fd_sc_hd__fill_4$1
XFILLER_100_521 vssd1 vccd1 vccd1 vssd1 sky130_fd_sc_hd__fill_2$1
XFILLER_85_221 vssd1 vccd1 vccd1 vssd1 sky130_fd_sc_hd__fill_2$1
XFILLER_100_565 vssd1 vccd1 vccd1 vssd1 sky130_fd_sc_hd__fill_8$1
XFILLER_65_27 vssd1 vccd1 vccd1 vssd1 sky130_ef_sc_hd__decap_40_12$1
XFILLER_58_479 vccd1 vssd1 vccd1 vssd1 sky130_fd_sc_hd__fill_1$1
XPHY_EDGE_ROW_134_Right_134 vccd1 vssd1 vccd1 vssd1 sky130_fd_sc_hd__decap_3$1
XFILLER_73_449 vssd1 vccd1 vccd1 vssd1 sky130_ef_sc_hd__decap_40_12$1
XFILLER_54_630 vssd1 vccd1 vccd1 vssd1 sky130_ef_sc_hd__decap_40_12$1
XFILLER_26_321 vssd1 vccd1 vccd1 vssd1 sky130_ef_sc_hd__decap_40_12$1
XFILLER_54_663 vccd1 vssd1 vccd1 vssd1 sky130_fd_sc_hd__fill_1$1
XFILLER_26_365 vssd1 vccd1 vccd1 vssd1 sky130_ef_sc_hd__decap_40_12$1
XTAP_TAPCELL_ROW_37_850 vccd1 vssd1 sky130_fd_sc_hd__tapvpwrvgnd_1$1
XTAP_TAPCELL_ROW_37_861 vccd1 vssd1 sky130_fd_sc_hd__tapvpwrvgnd_1$1
XFILLER_121_55 vccd1 vssd1 vccd1 vssd1 sky130_fd_sc_hd__fill_1$1
XFILLER_81_15 vssd1 vccd1 vccd1 vssd1 sky130_ef_sc_hd__decap_40_12$1
XFILLER_42_825 vccd1 vssd1 vccd1 vssd1 sky130_fd_sc_hd__fill_1$1
XFILLER_41_335 vccd1 vssd1 vccd1 vssd1 sky130_fd_sc_hd__fill_1$1
XFILLER_14_53 vssd1 vccd1 vccd1 vssd1 sky130_ef_sc_hd__decap_40_12$1
XFILLER_10_755 vccd1 vssd1 vccd1 vssd1 sky130_fd_sc_hd__fill_1$1
XFILLER_14_97 vssd1 vccd1 vccd1 vssd1 sky130_ef_sc_hd__decap_40_12$1
XFILLER_6_737 vssd1 vccd1 vccd1 vssd1 sky130_ef_sc_hd__decap_40_12$1
XFILLER_5_225 vssd1 vccd1 vccd1 vssd1 sky130_ef_sc_hd__decap_40_12$1
XFILLER_30_41 vssd1 vccd1 vccd1 vssd1 sky130_ef_sc_hd__decap_40_12$1
XFILLER_135_440 vssd1 vccd1 vccd1 vssd1 sky130_fd_sc_hd__fill_8$1
XFILLER_123_602 vssd1 vccd1 vccd1 vssd1 sky130_ef_sc_hd__decap_40_12$1
XFILLER_108_676 vssd1 vccd1 vccd1 vssd1 sky130_ef_sc_hd__decap_40_12$1
XTAP_TAPCELL_ROW_75_1424 vccd1 vssd1 sky130_fd_sc_hd__tapvpwrvgnd_1$1
XFILLER_30_85 vssd1 vccd1 vccd1 vssd1 sky130_ef_sc_hd__decap_40_12$1
XFILLER_111_808 vssd1 vccd1 vccd1 vssd1 sky130_ef_sc_hd__decap_40_12$1
XFILLER_122_189 vssd1 vccd1 vccd1 vssd1 sky130_fd_sc_hd__fill_4$1
XFILLER_110_307 vccd1 vssd1 vccd1 vssd1 sky130_fd_sc_hd__fill_1$1
XFILLER_76_221 vssd1 vccd1 vccd1 vssd1 sky130_ef_sc_hd__decap_40_12$1
XFILLER_1_497 vssd1 vccd1 vccd1 vssd1 sky130_fd_sc_hd__fill_4$1
XFILLER_92_703 vccd1 vssd1 vccd1 vssd1 sky130_fd_sc_hd__fill_1$1
XFILLER_77_777 vssd1 vccd1 vccd1 vssd1 sky130_fd_sc_hd__fill_4$1
XFILLER_76_265 vssd1 vccd1 vccd1 vssd1 sky130_ef_sc_hd__decap_40_12$1
XFILLER_18_811 vccd1 vssd1 vccd1 vssd1 sky130_fd_sc_hd__fill_1$1
XPHY_EDGE_ROW_101_Right_101 vccd1 vssd1 vccd1 vssd1 sky130_fd_sc_hd__decap_3$1
XFILLER_92_769 vssd1 vccd1 vccd1 vssd1 sky130_fd_sc_hd__fill_8$1
XFILLER_92_736 vssd1 vccd1 vccd1 vssd1 sky130_ef_sc_hd__decap_40_12$1
XFILLER_29_181 vssd1 vccd1 vccd1 vssd1 sky130_ef_sc_hd__decap_40_12$1
XFILLER_91_279 vccd1 vssd1 vccd1 vssd1 sky130_fd_sc_hd__fill_1$1
XFILLER_45_641 vssd1 vccd1 vccd1 vssd1 sky130_ef_sc_hd__decap_40_12$1
XTAP_TAPCELL_ROW_86_1597 vccd1 vssd1 sky130_fd_sc_hd__tapvpwrvgnd_1$1
XTAP_TAPCELL_ROW_86_1586 vccd1 vssd1 sky130_fd_sc_hd__tapvpwrvgnd_1$1
XFILLER_72_482 vssd1 vccd1 vccd1 vssd1 sky130_ef_sc_hd__decap_40_12$1
XFILLER_55_93 vssd1 vccd1 vccd1 vssd1 sky130_ef_sc_hd__decap_40_12$1
XFILLER_60_633 vssd1 vccd1 vccd1 vssd1 sky130_fd_sc_hd__fill_2$1
XTAP_TAPCELL_ROW_15_522 vccd1 vssd1 sky130_fd_sc_hd__tapvpwrvgnd_1$1
XFILLER_32_357 vssd1 vccd1 vccd1 vssd1 sky130_fd_sc_hd__fill_4$1
XFILLER_44_195 vccd1 vssd1 vccd1 vssd1 sky130_fd_sc_hd__fill_1$1
X_0971_ _1305_/C1 _0970_/X _0991_/A2 hold142/X _1519_/D vssd1 vccd1 vccd1 vssd1 sky130_fd_sc_hd__o211a_1$1
XFILLER_71_81 vssd1 vccd1 vccd1 vssd1 sky130_ef_sc_hd__decap_40_12$1
XFILLER_9_553 vssd1 vccd1 vccd1 vssd1 sky130_fd_sc_hd__fill_4$1
XTAP_TAPCELL_ROW_117_2052 vccd1 vssd1 sky130_fd_sc_hd__tapvpwrvgnd_1$1
XFILLER_9_597 vssd1 vccd1 vccd1 vssd1 sky130_ef_sc_hd__decap_40_12$1
XFILLER_58_3 vssd1 vccd1 vccd1 vssd1 sky130_ef_sc_hd__decap_40_12$1
XTAP_TAPCELL_ROW_130_2252 vccd1 vssd1 sky130_fd_sc_hd__tapvpwrvgnd_1$1
XFILLER_99_335 vccd1 vssd1 vccd1 vssd1 sky130_fd_sc_hd__fill_1$1
X_1523_ _1523_/Q _1747_/CLK _1523_/D vccd1 vssd1 vccd1 vssd1 sky130_fd_sc_hd__dfxtp_1$1
XFILLER_5_781 vssd1 vccd1 vccd1 vssd1 sky130_fd_sc_hd__fill_2$1
X_1454_ _1454_/A _1454_/X _1464_/B vssd1 vccd1 vccd1 vssd1 sky130_fd_sc_hd__or2_1$1
XFILLER_113_167 vccd1 vssd1 vccd1 vssd1 sky130_fd_sc_hd__fill_1$1
XFILLER_101_329 vssd1 vccd1 vccd1 vssd1 sky130_fd_sc_hd__fill_4$1
X_1385_ _1455_/C1 _1384_/X _1399_/A2 hold120/X _1720_/D vssd1 vccd1 vccd1 vssd1 sky130_fd_sc_hd__o211a_1$1
XFILLER_68_755 vccd1 vssd1 vccd1 vssd1 sky130_fd_sc_hd__fill_1$1
XFILLER_67_221 vssd1 vccd1 vccd1 vssd1 sky130_fd_sc_hd__fill_2$1
XFILLER_95_585 vssd1 vccd1 vccd1 vssd1 sky130_ef_sc_hd__decap_40_12$1
XFILLER_55_449 vssd1 vccd1 vccd1 vssd1 sky130_ef_sc_hd__decap_40_12$1
XFILLER_36_641 vssd1 vccd1 vccd1 vssd1 sky130_fd_sc_hd__fill_2$1
XFILLER_63_493 vssd1 vccd1 vccd1 vssd1 sky130_fd_sc_hd__fill_8$1
XFILLER_50_121 vssd1 vccd1 vccd1 vssd1 sky130_ef_sc_hd__decap_40_12$1
XFILLER_23_335 vccd1 vssd1 vccd1 vssd1 sky130_fd_sc_hd__fill_1$1
XFILLER_51_677 vssd1 vccd1 vccd1 vssd1 sky130_fd_sc_hd__fill_2$1
XFILLER_50_165 vssd1 vccd1 vccd1 vssd1 sky130_ef_sc_hd__decap_40_12$1
XFILLER_137_727 vccd1 vssd1 vccd1 vssd1 sky130_fd_sc_hd__fill_1$1
XFILLER_132_421 vssd1 vccd1 vccd1 vssd1 sky130_ef_sc_hd__decap_40_12$1
XTAP_TAPCELL_ROW_57_1154 vccd1 vssd1 sky130_fd_sc_hd__tapvpwrvgnd_1$1
XFILLER_3_729 vssd1 vccd1 vccd1 vssd1 sky130_ef_sc_hd__decap_40_12$1
XFILLER_104_189 vssd1 vccd1 vccd1 vssd1 sky130_fd_sc_hd__fill_4$1
XFILLER_76_15 vssd1 vccd1 vccd1 vssd1 sky130_ef_sc_hd__decap_40_12$1
XFILLER_116_77 vssd1 vccd1 vccd1 vssd1 sky130_fd_sc_hd__fill_4$1
XFILLER_101_841 vccd1 vssd1 vccd1 vssd1 sky130_fd_sc_hd__fill_1$1
XFILLER_86_530 vssd1 vccd1 vccd1 vssd1 sky130_fd_sc_hd__fill_2$1
XTAP_TAPCELL_ROW_70_1354 vccd1 vssd1 sky130_fd_sc_hd__tapvpwrvgnd_1$1
XTAP_TAPCELL_ROW_70_1343 vccd1 vssd1 sky130_fd_sc_hd__tapvpwrvgnd_1$1
XFILLER_58_221 vssd1 vccd1 vccd1 vssd1 sky130_ef_sc_hd__decap_40_12$1
XFILLER_86_585 vssd1 vccd1 vccd1 vssd1 sky130_fd_sc_hd__fill_2$1
XFILLER_58_265 vssd1 vccd1 vccd1 vssd1 sky130_ef_sc_hd__decap_40_12$1
XFILLER_132_65 vssd1 vccd1 vccd1 vssd1 sky130_ef_sc_hd__decap_40_12$1
XFILLER_74_769 vssd1 vccd1 vccd1 vssd1 sky130_ef_sc_hd__decap_40_12$1
XFILLER_27_641 vssd1 vccd1 vccd1 vssd1 sky130_ef_sc_hd__decap_40_12$1
XFILLER_82_791 vccd1 vssd1 vccd1 vssd1 sky130_fd_sc_hd__fill_1$1
XFILLER_73_279 vccd1 vssd1 vccd1 vssd1 sky130_fd_sc_hd__fill_1$1
XFILLER_26_195 vccd1 vssd1 vccd1 vssd1 sky130_fd_sc_hd__fill_1$1
XFILLER_14_357 vssd1 vccd1 vccd1 vssd1 sky130_fd_sc_hd__fill_4$1
XFILLER_41_165 vssd1 vccd1 vccd1 vssd1 sky130_fd_sc_hd__fill_2$1
XFILLER_6_501 vssd1 vccd1 vccd1 vssd1 sky130_ef_sc_hd__decap_40_12$1
XFILLER_128_749 vssd1 vccd1 vccd1 vssd1 sky130_fd_sc_hd__fill_4$1
XFILLER_127_237 vssd1 vccd1 vccd1 vssd1 sky130_ef_sc_hd__decap_40_12$1
XFILLER_10_585 vssd1 vccd1 vccd1 vssd1 sky130_fd_sc_hd__fill_2$1
XFILLER_6_545 vssd1 vccd1 vccd1 vssd1 sky130_ef_sc_hd__decap_40_12$1
XFILLER_41_51 vssd1 vccd1 vccd1 vssd1 sky130_fd_sc_hd__fill_4$1
XFILLER_135_281 vssd1 vccd1 vccd1 vssd1 sky130_ef_sc_hd__decap_40_12$1
XFILLER_108_473 vssd1 vccd1 vccd1 vssd1 sky130_fd_sc_hd__fill_2$1
XFILLER_6_589 vssd1 vccd1 vccd1 vssd1 sky130_ef_sc_hd__decap_40_12$1
Xclkbuf_leaf_7_wb_clk_i _1756_/CLK clkbuf_leaf_9_wb_clk_i/A vssd1 vccd1 vccd1 vssd1
+ sky130_fd_sc_hd__clkbuf_8$1
XFILLER_123_443 vssd1 vccd1 vccd1 vssd1 sky130_fd_sc_hd__fill_4$1
XFILLER_96_305 vssd1 vccd1 vccd1 vssd1 sky130_fd_sc_hd__fill_2$1
XFILLER_1_261 vssd1 vccd1 vccd1 vssd1 sky130_ef_sc_hd__decap_40_12$1
XFILLER_110_137 vssd1 vccd1 vccd1 vssd1 sky130_fd_sc_hd__fill_2$1
XFILLER_89_390 vssd1 vccd1 vccd1 vssd1 sky130_fd_sc_hd__fill_2$1
XFILLER_49_221 vssd1 vccd1 vccd1 vssd1 sky130_fd_sc_hd__fill_2$1
XTAP_TAPCELL_ROW_88_1615 vccd1 vssd1 sky130_fd_sc_hd__tapvpwrvgnd_1$1
X_1170_ _1820_/A _1170_/X _1188_/B vssd1 vccd1 vccd1 vssd1 sky130_fd_sc_hd__or2_1$1
XFILLER_37_405 vssd1 vccd1 vccd1 vssd1 sky130_ef_sc_hd__decap_40_12$1
XFILLER_92_533 vssd1 vccd1 vccd1 vssd1 sky130_ef_sc_hd__decap_40_12$1
XTAP_TAPCELL_ROW_88_1626 vccd1 vssd1 sky130_fd_sc_hd__tapvpwrvgnd_1$1
XFILLER_77_585 vssd1 vccd1 vccd1 vssd1 sky130_ef_sc_hd__decap_40_12$1
XFILLER_66_81 vssd1 vccd1 vccd1 vssd1 sky130_fd_sc_hd__fill_2$1
XFILLER_65_725 vssd1 vccd1 vccd1 vssd1 sky130_fd_sc_hd__fill_2$1
XFILLER_37_449 vssd1 vccd1 vccd1 vssd1 sky130_ef_sc_hd__decap_40_12$1
XFILLER_18_641 vssd1 vccd1 vccd1 vssd1 sky130_fd_sc_hd__fill_2$1
XFILLER_52_419 vccd1 vssd1 vccd1 vssd1 sky130_fd_sc_hd__fill_1$1
XFILLER_45_460 vccd1 vssd1 vccd1 vssd1 sky130_fd_sc_hd__fill_1$1
XFILLER_32_121 vssd1 vccd1 vccd1 vssd1 sky130_ef_sc_hd__decap_40_12$1
XFILLER_60_474 vssd1 vccd1 vccd1 vssd1 sky130_fd_sc_hd__fill_2$1
XFILLER_20_305 vssd1 vccd1 vccd1 vssd1 sky130_fd_sc_hd__fill_2$1
XFILLER_32_165 vssd1 vccd1 vccd1 vssd1 sky130_ef_sc_hd__decap_40_12$1
XFILLER_33_677 vssd1 vccd1 vccd1 vssd1 sky130_ef_sc_hd__decap_40_12$1
XANTENNA_17 input51/X vssd1 vccd1 vccd1 vssd1 sky130_fd_sc_hd__diode_2$1
XANTENNA_28 hold10/A vssd1 vccd1 vccd1 vssd1 sky130_fd_sc_hd__diode_2$1
XFILLER_119_727 vccd1 vssd1 vccd1 vssd1 sky130_fd_sc_hd__fill_1$1
XFILLER_9_361 vssd1 vccd1 vccd1 vssd1 sky130_ef_sc_hd__decap_40_12$1
X_0954_ _1779_/A _0954_/X _0990_/B vssd1 vccd1 vccd1 vssd1 sky130_fd_sc_hd__or2_1$1
XTAP_TAPCELL_ROW_99_1788 vccd1 vssd1 sky130_fd_sc_hd__tapvpwrvgnd_1$1
X_0885_ _0945_/A _0885_/X _0885_/B _0885_/C vccd1 vssd1 vccd1 vssd1 sky130_fd_sc_hd__or3_1$1
XFILLER_127_771 vssd1 vccd1 vccd1 vssd1 sky130_ef_sc_hd__decap_40_12$1
XFILLER_114_421 vssd1 vccd1 vccd1 vssd1 sky130_ef_sc_hd__decap_40_12$1
Xoutput124 _1827_/X analog_ctrl[56] vssd1 vccd1 vccd1 vssd1 sky130_fd_sc_hd__buf_12$1
Xoutput113 _1817_/X analog_ctrl[46] vssd1 vccd1 vccd1 vssd1 sky130_fd_sc_hd__buf_12$1
Xoutput102 _1807_/X analog_ctrl[36] vssd1 vccd1 vccd1 vssd1 sky130_fd_sc_hd__buf_12$1
XPHY_EDGE_ROW_120_Left_259 vccd1 vssd1 vccd1 vssd1 sky130_fd_sc_hd__decap_3$1
Xoutput168 _1836_/X analog_ctrl[97] vssd1 vccd1 vccd1 vssd1 sky130_fd_sc_hd__buf_12$1
Xoutput157 _1660_/Q analog_ctrl[87] vssd1 vccd1 vccd1 vssd1 sky130_fd_sc_hd__buf_12$1
Xoutput146 _1649_/Q analog_ctrl[76] vssd1 vccd1 vccd1 vssd1 sky130_fd_sc_hd__buf_12$1
Xoutput135 _1639_/Q analog_ctrl[66] vssd1 vccd1 vccd1 vssd1 sky130_fd_sc_hd__buf_12$1
Xoutput179 _1494_/Q wbs_dat_o[17] vssd1 vccd1 vccd1 vssd1 sky130_fd_sc_hd__buf_12$1
X_1506_ _1506_/Q _1761_/CLK _1506_/D vccd1 vssd1 vccd1 vssd1 sky130_fd_sc_hd__dfxtp_1$1
XFILLER_99_165 vssd1 vccd1 vccd1 vssd1 sky130_fd_sc_hd__fill_2$1
XFILLER_87_305 vssd1 vccd1 vccd1 vssd1 sky130_ef_sc_hd__decap_40_12$1
XTAP_TAPCELL_ROW_110_1955 vccd1 vssd1 sky130_fd_sc_hd__tapvpwrvgnd_1$1
XTAP_TAPCELL_ROW_110_1944 vccd1 vssd1 sky130_fd_sc_hd__tapvpwrvgnd_1$1
XFILLER_101_137 vssd1 vccd1 vccd1 vssd1 sky130_ef_sc_hd__decap_40_12$1
X_1437_ _1437_/C1 _1436_/X _1475_/A2 hold55/X _1745_/D vssd1 vccd1 vccd1 vssd1 sky130_fd_sc_hd__o211a_1$1
XFILLER_87_349 vssd1 vccd1 vccd1 vssd1 sky130_ef_sc_hd__decap_40_12$1
X_1368_ _1368_/A _1368_/X _1398_/B vssd1 vccd1 vccd1 vssd1 sky130_fd_sc_hd__or2_1$1
XTAP_TAPCELL_ROW_52_1084 vccd1 vssd1 sky130_fd_sc_hd__tapvpwrvgnd_1$1
XTAP_TAPCELL_ROW_52_1073 vccd1 vssd1 sky130_fd_sc_hd__tapvpwrvgnd_1$1
XFILLER_110_671 vccd1 vssd1 vccd1 vssd1 sky130_fd_sc_hd__fill_1$1
XFILLER_95_393 vssd1 vccd1 vccd1 vssd1 sky130_ef_sc_hd__decap_40_12$1
XFILLER_56_725 vssd1 vccd1 vccd1 vssd1 sky130_ef_sc_hd__decap_40_12$1
XFILLER_46_29 vssd1 vccd1 vccd1 vssd1 sky130_ef_sc_hd__decap_40_12$1
XFILLER_83_566 vssd1 vccd1 vccd1 vssd1 sky130_ef_sc_hd__decap_40_12$1
X_1299_ _1387_/C1 _1298_/X _1331_/A2 hold155/X _1678_/D vssd1 vccd1 vccd1 vssd1 sky130_fd_sc_hd__o211a_1$1
XFILLER_55_279 vccd1 vssd1 vccd1 vssd1 sky130_fd_sc_hd__fill_1$1
XFILLER_70_249 vssd1 vccd1 vccd1 vssd1 sky130_fd_sc_hd__fill_2$1
XFILLER_11_305 vssd1 vccd1 vccd1 vssd1 sky130_ef_sc_hd__decap_40_12$1
XFILLER_23_165 vssd1 vccd1 vccd1 vssd1 sky130_fd_sc_hd__fill_2$1
XFILLER_24_699 vccd1 vssd1 vccd1 vssd1 sky130_fd_sc_hd__fill_1$1
XFILLER_11_349 vssd1 vccd1 vccd1 vssd1 sky130_ef_sc_hd__decap_40_12$1
XFILLER_137_557 vssd1 vccd1 vccd1 vssd1 sky130_fd_sc_hd__fill_2$1
XFILLER_109_237 vssd1 vccd1 vccd1 vssd1 sky130_ef_sc_hd__decap_40_12$1
XFILLER_133_741 vssd1 vccd1 vccd1 vssd1 sky130_ef_sc_hd__decap_40_12$1
XFILLER_117_281 vssd1 vccd1 vccd1 vssd1 sky130_ef_sc_hd__decap_40_12$1
XFILLER_3_559 vccd1 vssd1 vccd1 vssd1 sky130_fd_sc_hd__fill_1$1
XFILLER_133_785 vssd1 vccd1 vccd1 vssd1 sky130_ef_sc_hd__decap_40_12$1
XFILLER_132_251 vccd1 vssd1 vccd1 vssd1 sky130_fd_sc_hd__fill_1$1
XFILLER_78_305 vssd1 vccd1 vccd1 vssd1 sky130_fd_sc_hd__fill_2$1
XFILLER_94_809 vssd1 vccd1 vccd1 vssd1 sky130_fd_sc_hd__fill_2$1
XFILLER_87_69 vssd1 vccd1 vccd1 vssd1 sky130_ef_sc_hd__decap_40_12$1
XFILLER_59_541 vssd1 vccd1 vccd1 vssd1 sky130_ef_sc_hd__decap_40_12$1
XTAP_TAPCELL_ROW_6_386 vccd1 vssd1 sky130_fd_sc_hd__tapvpwrvgnd_1$1
XFILLER_19_405 vssd1 vccd1 vccd1 vssd1 sky130_ef_sc_hd__decap_40_12$1
XFILLER_101_671 vccd1 vssd1 vccd1 vssd1 sky130_fd_sc_hd__fill_1$1
XFILLER_59_585 vssd1 vccd1 vccd1 vssd1 sky130_ef_sc_hd__decap_40_12$1
XTAP_TAPCELL_ROW_6_397 vccd1 vssd1 sky130_fd_sc_hd__tapvpwrvgnd_1$1
XFILLER_47_725 vssd1 vccd1 vccd1 vssd1 sky130_fd_sc_hd__fill_2$1
XFILLER_19_449 vssd1 vccd1 vccd1 vssd1 sky130_ef_sc_hd__decap_40_12$1
Xafe_wb_284 analog_ctrl[101] afe_wb_284/HI vssd1 vccd1 vccd1 vssd1 sky130_fd_sc_hd__conb_1$1
XFILLER_61_205 vssd1 vccd1 vccd1 vssd1 sky130_ef_sc_hd__decap_40_12$1
XFILLER_34_419 vccd1 vssd1 vccd1 vssd1 sky130_fd_sc_hd__fill_1$1
XTAP_TAPCELL_ROW_83_1545 vccd1 vssd1 sky130_fd_sc_hd__tapvpwrvgnd_1$1
XFILLER_61_249 vssd1 vccd1 vccd1 vssd1 sky130_ef_sc_hd__decap_40_12$1
XFILLER_55_791 vccd1 vssd1 vccd1 vssd1 sky130_fd_sc_hd__fill_1$1
XFILLER_14_121 vssd1 vccd1 vccd1 vssd1 sky130_ef_sc_hd__decap_40_12$1
XFILLER_14_165 vssd1 vccd1 vccd1 vssd1 sky130_ef_sc_hd__decap_40_12$1
XTAP_TAPCELL_ROW_25_672 vccd1 vssd1 sky130_fd_sc_hd__tapvpwrvgnd_1$1
XFILLER_30_625 vssd1 vccd1 vccd1 vssd1 sky130_ef_sc_hd__decap_40_12$1
XFILLER_52_83 vccd1 vssd1 vccd1 vssd1 sky130_fd_sc_hd__fill_1$1
XFILLER_30_669 vssd1 vccd1 vccd1 vssd1 sky130_ef_sc_hd__decap_40_12$1
Xinput37 vccd1 vssd1 hold81/A hold80/X vccd1 vssd1 sky130_fd_sc_hd__buf_2$1
Xinput26 hold90/A hold89/X vssd1 vccd1 vccd1 vssd1 sky130_fd_sc_hd__clkbuf_4$1
Xinput15 hold17/A vccd1 vssd1 hold16/X vccd1 vssd1 sky130_fd_sc_hd__buf_4$1
XFILLER_7_821 vssd1 vccd1 vccd1 vssd1 sky130_fd_sc_hd__fill_2$1
Xinput48 input48/X vccd1 vssd1 input48/A vccd1 vssd1 sky130_fd_sc_hd__buf_4$1
XFILLER_128_557 vssd1 vccd1 vccd1 vssd1 sky130_ef_sc_hd__decap_40_12$1
XTAP_TAPCELL_ROW_114_2011 vccd1 vssd1 sky130_fd_sc_hd__tapvpwrvgnd_1$1
XFILLER_109_782 vssd1 vccd1 vccd1 vssd1 sky130_fd_sc_hd__fill_2$1
XFILLER_124_774 vssd1 vccd1 vccd1 vssd1 sky130_ef_sc_hd__decap_40_12$1
XFILLER_111_413 vssd1 vccd1 vccd1 vssd1 sky130_fd_sc_hd__fill_2$1
XFILLER_69_305 vssd1 vccd1 vccd1 vssd1 sky130_ef_sc_hd__decap_40_12$1
XFILLER_123_273 vssd1 vccd1 vccd1 vssd1 sky130_fd_sc_hd__fill_4$1
XFILLER_97_669 vssd1 vccd1 vccd1 vssd1 sky130_fd_sc_hd__fill_2$1
XFILLER_69_349 vssd1 vccd1 vccd1 vssd1 sky130_ef_sc_hd__decap_40_12$1
XFILLER_2_581 vssd1 vccd1 vccd1 vssd1 sky130_fd_sc_hd__fill_4$1
X_1222_ _1641_/Q _1222_/X _1270_/B vssd1 vccd1 vccd1 vssd1 sky130_fd_sc_hd__or2_1$1
XFILLER_77_393 vssd1 vccd1 vccd1 vssd1 sky130_ef_sc_hd__decap_40_12$1
XFILLER_38_725 vssd1 vccd1 vccd1 vssd1 sky130_ef_sc_hd__decap_40_12$1
XFILLER_65_555 vccd1 vssd1 vccd1 vssd1 sky130_fd_sc_hd__fill_1$1
XFILLER_38_769 vssd1 vccd1 vccd1 vssd1 sky130_ef_sc_hd__decap_40_12$1
X_1153_ _1289_/C1 _1152_/X _1189_/A2 hold71/X _1607_/D vssd1 vccd1 vccd1 vssd1 sky130_fd_sc_hd__o211a_1$1
XTAP_TAPCELL_ROW_125_2173 vccd1 vssd1 sky130_fd_sc_hd__tapvpwrvgnd_1$1
XFILLER_92_363 vccd1 vssd1 vccd1 vssd1 sky130_fd_sc_hd__fill_1$1
XFILLER_80_525 vssd1 vccd1 vccd1 vssd1 sky130_fd_sc_hd__fill_4$1
XFILLER_53_717 vssd1 vccd1 vccd1 vssd1 sky130_fd_sc_hd__fill_8$1
X_1084_ _1788_/A _1084_/X _1122_/B vssd1 vccd1 vccd1 vssd1 sky130_fd_sc_hd__or2_1$1
XFILLER_37_279 vccd1 vssd1 vccd1 vssd1 sky130_fd_sc_hd__fill_1$1
XFILLER_80_547 vccd1 vssd1 vccd1 vssd1 sky130_fd_sc_hd__fill_1$1
XFILLER_52_249 vssd1 vccd1 vccd1 vssd1 sky130_fd_sc_hd__fill_2$1
XFILLER_33_441 vssd1 vccd1 vccd1 vssd1 sky130_fd_sc_hd__fill_4$1
XFILLER_61_783 vccd1 vssd1 vccd1 vssd1 sky130_fd_sc_hd__fill_1$1
XFILLER_33_485 vssd1 vccd1 vccd1 vssd1 sky130_ef_sc_hd__decap_40_12$1
XFILLER_119_502 vssd1 vccd1 vccd1 vssd1 sky130_fd_sc_hd__fill_2$1
XFILLER_21_669 vssd1 vccd1 vccd1 vssd1 sky130_fd_sc_hd__fill_2$1
X_0937_ hold93/A _0944_/A2 _0937_/X hold75/A _1344_/A vccd1 vssd1 vccd1 vssd1 sky130_fd_sc_hd__a22o_1$1
X_0868_ _0880_/A2 _1495_/D _0865_/X _1443_/C1 _1495_/Q _0867_/X vssd1 vccd1 vccd1
+ vssd1 sky130_fd_sc_hd__o221a_1$1
X_0799_ _1831_/A _1344_/A _0799_/X _1676_/Q _0875_/B1 vccd1 vssd1 vccd1 vssd1 sky130_fd_sc_hd__a22o_1$1
XFILLER_115_785 vssd1 vccd1 vccd1 vssd1 sky130_ef_sc_hd__decap_40_12$1
XFILLER_114_251 vccd1 vssd1 vccd1 vssd1 sky130_fd_sc_hd__fill_1$1
XTAP_TAPCELL_ROW_54_1113 vccd1 vssd1 sky130_fd_sc_hd__tapvpwrvgnd_1$1
XFILLER_0_529 vssd1 vccd1 vccd1 vssd1 sky130_fd_sc_hd__fill_2$1
XFILLER_130_755 vccd1 vssd1 vccd1 vssd1 sky130_fd_sc_hd__fill_1$1
XFILLER_87_113 vssd1 vccd1 vccd1 vssd1 sky130_ef_sc_hd__decap_40_12$1
XFILLER_102_457 vssd1 vccd1 vccd1 vssd1 sky130_fd_sc_hd__fill_2$1
XFILLER_88_669 vssd1 vccd1 vccd1 vssd1 sky130_ef_sc_hd__decap_40_12$1
XFILLER_57_39 vssd1 vccd1 vccd1 vssd1 sky130_ef_sc_hd__decap_40_12$1
XTAP_TAPCELL_ROW_3_345 vccd1 vssd1 sky130_fd_sc_hd__tapvpwrvgnd_1$1
XFILLER_29_725 vssd1 vccd1 vccd1 vssd1 sky130_fd_sc_hd__fill_2$1
XFILLER_73_27 vssd1 vccd1 vccd1 vssd1 sky130_ef_sc_hd__decap_40_12$1
XFILLER_16_419 vccd1 vssd1 vccd1 vssd1 sky130_fd_sc_hd__fill_1$1
XFILLER_43_205 vssd1 vccd1 vccd1 vssd1 sky130_ef_sc_hd__decap_40_12$1
XFILLER_71_547 vccd1 vssd1 vccd1 vssd1 sky130_fd_sc_hd__fill_1$1
XFILLER_43_249 vssd1 vccd1 vccd1 vssd1 sky130_ef_sc_hd__decap_40_12$1
XTAP_TAPCELL_ROW_42_929 vccd1 vssd1 sky130_fd_sc_hd__tapvpwrvgnd_1$1
XTAP_TAPCELL_ROW_65_1275 vccd1 vssd1 sky130_fd_sc_hd__tapvpwrvgnd_1$1
XFILLER_11_113 vssd1 vccd1 vccd1 vssd1 sky130_ef_sc_hd__decap_40_12$1
XFILLER_12_625 vssd1 vccd1 vccd1 vssd1 sky130_ef_sc_hd__decap_40_12$1
XFILLER_138_811 vccd1 vssd1 vccd1 vssd1 sky130_fd_sc_hd__fill_1$1
XFILLER_51_293 vssd1 vccd1 vccd1 vssd1 sky130_ef_sc_hd__decap_40_12$1
XFILLER_12_669 vssd1 vccd1 vccd1 vssd1 sky130_ef_sc_hd__decap_40_12$1
XTAP_TAPCELL_ROW_22_631 vccd1 vssd1 sky130_fd_sc_hd__tapvpwrvgnd_1$1
XFILLER_125_3 vssd1 vccd1 vccd1 vssd1 sky130_ef_sc_hd__decap_40_12$1
XFILLER_22_53 vssd1 vccd1 vccd1 vssd1 sky130_ef_sc_hd__decap_40_12$1
XFILLER_137_387 vssd1 vccd1 vccd1 vssd1 sky130_fd_sc_hd__fill_4$1
XFILLER_4_813 vssd1 vccd1 vccd1 vssd1 sky130_ef_sc_hd__decap_40_12$1
XFILLER_22_97 vssd1 vccd1 vccd1 vssd1 sky130_ef_sc_hd__decap_40_12$1
XFILLER_120_221 vssd1 vccd1 vccd1 vssd1 sky130_ef_sc_hd__decap_40_12$1
XFILLER_105_273 vssd1 vccd1 vccd1 vssd1 sky130_fd_sc_hd__fill_4$1
XFILLER_3_389 vssd1 vccd1 vccd1 vssd1 sky130_fd_sc_hd__fill_2$1
XFILLER_121_777 vssd1 vccd1 vccd1 vssd1 sky130_fd_sc_hd__fill_4$1
XFILLER_79_669 vssd1 vccd1 vccd1 vssd1 sky130_fd_sc_hd__fill_2$1
XFILLER_120_265 vssd1 vccd1 vccd1 vssd1 sky130_ef_sc_hd__decap_40_12$1
XFILLER_93_105 vssd1 vccd1 vccd1 vssd1 sky130_fd_sc_hd__fill_4$1
XFILLER_101_490 vccd1 vssd1 vccd1 vssd1 sky130_fd_sc_hd__fill_1$1
XFILLER_93_149 vssd1 vccd1 vccd1 vssd1 sky130_ef_sc_hd__decap_40_12$1
XFILLER_74_363 vccd1 vssd1 vccd1 vssd1 sky130_fd_sc_hd__fill_1$1
XFILLER_19_279 vccd1 vssd1 vccd1 vssd1 sky130_fd_sc_hd__fill_1$1
XFILLER_47_588 vssd1 vccd1 vccd1 vssd1 sky130_fd_sc_hd__fill_2$1
XFILLER_34_249 vssd1 vccd1 vccd1 vssd1 sky130_fd_sc_hd__fill_2$1
XFILLER_15_441 vssd1 vccd1 vccd1 vssd1 sky130_fd_sc_hd__fill_4$1
XFILLER_63_93 vssd1 vccd1 vccd1 vssd1 sky130_ef_sc_hd__decap_40_12$1
XFILLER_15_485 vssd1 vccd1 vccd1 vssd1 sky130_ef_sc_hd__decap_40_12$1
X_1840_ _1840_/A _1840_/X vssd1 vccd1 vccd1 vssd1 sky130_fd_sc_hd__clkbuf_2$1
XFILLER_30_433 vssd1 vccd1 vccd1 vssd1 sky130_ef_sc_hd__decap_40_12$1
XFILLER_128_321 vssd1 vccd1 vccd1 vssd1 sky130_ef_sc_hd__decap_40_12$1
XFILLER_30_477 vssd1 vccd1 vccd1 vssd1 sky130_ef_sc_hd__decap_40_12$1
XTAP_TAPCELL_ROW_96_1736 vccd1 vssd1 sky130_fd_sc_hd__tapvpwrvgnd_1$1
XFILLER_8_77 vssd1 vccd1 vccd1 vssd1 sky130_fd_sc_hd__fill_4$1
XTAP_TAPCELL_ROW_96_1747 vccd1 vssd1 sky130_fd_sc_hd__tapvpwrvgnd_1$1
XFILLER_7_673 vssd1 vccd1 vccd1 vssd1 sky130_ef_sc_hd__decap_40_12$1
XFILLER_109_590 vssd1 vccd1 vccd1 vssd1 sky130_fd_sc_hd__fill_8$1
XFILLER_97_400 vssd1 vccd1 vccd1 vssd1 sky130_ef_sc_hd__decap_40_12$1
XFILLER_40_3 vssd1 vccd1 vccd1 vssd1 sky130_ef_sc_hd__decap_40_12$1
XFILLER_111_221 vssd1 vccd1 vccd1 vssd1 sky130_fd_sc_hd__fill_2$1
XFILLER_69_113 vssd1 vccd1 vccd1 vssd1 sky130_ef_sc_hd__decap_40_12$1
XTAP_TAPCELL_ROW_127_2202 vccd1 vssd1 sky130_fd_sc_hd__tapvpwrvgnd_1$1
XFILLER_112_777 vssd1 vccd1 vccd1 vssd1 sky130_fd_sc_hd__fill_2$1
XFILLER_97_477 vssd1 vccd1 vccd1 vssd1 sky130_ef_sc_hd__decap_40_12$1
XFILLER_85_617 vssd1 vccd1 vccd1 vssd1 sky130_ef_sc_hd__decap_40_12$1
X_1205_ _1471_/C1 _1204_/X _1211_/A2 hold49/X _1633_/D vssd1 vccd1 vccd1 vssd1 sky130_fd_sc_hd__o211a_1$1
XFILLER_38_533 vssd1 vccd1 vccd1 vssd1 sky130_ef_sc_hd__decap_40_12$1
XFILLER_38_555 vccd1 vssd1 vccd1 vssd1 sky130_fd_sc_hd__fill_1$1
X_1136_ _1136_/A _1136_/X _1144_/B vssd1 vccd1 vccd1 vssd1 sky130_fd_sc_hd__or2_1$1
XFILLER_81_823 vccd1 vssd1 vccd1 vssd1 sky130_fd_sc_hd__fill_1$1
XTAP_TAPCELL_ROW_0_304 vccd1 vssd1 sky130_fd_sc_hd__tapvpwrvgnd_1$1
XFILLER_25_205 vssd1 vccd1 vccd1 vssd1 sky130_ef_sc_hd__decap_40_12$1
XFILLER_38_577 vssd1 vccd1 vccd1 vssd1 sky130_fd_sc_hd__fill_8$1
XFILLER_92_193 vssd1 vccd1 vccd1 vssd1 sky130_fd_sc_hd__fill_2$1
XFILLER_80_333 vssd1 vccd1 vccd1 vssd1 sky130_ef_sc_hd__decap_40_12$1
XFILLER_65_385 vssd1 vccd1 vccd1 vssd1 sky130_fd_sc_hd__fill_4$1
XFILLER_53_558 vssd1 vccd1 vccd1 vssd1 sky130_fd_sc_hd__fill_2$1
XFILLER_19_791 vccd1 vssd1 vccd1 vssd1 sky130_fd_sc_hd__fill_1$1
XFILLER_25_249 vssd1 vccd1 vccd1 vssd1 sky130_ef_sc_hd__decap_40_12$1
X_1067_ _1471_/C1 _1066_/X _1015_/Y hold81/X _1566_/D vssd1 vccd1 vccd1 vssd1 sky130_fd_sc_hd__o211a_1$1
XFILLER_41_709 vssd1 vccd1 vccd1 vssd1 sky130_fd_sc_hd__fill_4$1
XTAP_TAPCELL_ROW_105_1876 vccd1 vssd1 sky130_fd_sc_hd__tapvpwrvgnd_1$1
XFILLER_33_293 vssd1 vccd1 vccd1 vssd1 sky130_ef_sc_hd__decap_40_12$1
XTAP_TAPCELL_ROW_138_2375 vccd1 vssd1 sky130_fd_sc_hd__tapvpwrvgnd_1$1
XTAP_TAPCELL_ROW_138_2364 vccd1 vssd1 sky130_fd_sc_hd__tapvpwrvgnd_1$1
XTAP_TAPCELL_ROW_138_2386 vccd1 vssd1 sky130_fd_sc_hd__tapvpwrvgnd_1$1
XTAP_TAPCELL_ROW_60_1194 vccd1 vssd1 sky130_fd_sc_hd__tapvpwrvgnd_1$1
XFILLER_135_825 vssd1 vccd1 vccd1 vssd1 sky130_ef_sc_hd__decap_40_12$1
XFILLER_4_109 vssd1 vccd1 vccd1 vssd1 sky130_ef_sc_hd__decap_40_12$1
XTAP_TAPCELL_ROW_8_426 vccd1 vssd1 sky130_fd_sc_hd__tapvpwrvgnd_1$1
XTAP_TAPCELL_ROW_8_415 vccd1 vssd1 sky130_fd_sc_hd__tapvpwrvgnd_1$1
XFILLER_103_744 vssd1 vccd1 vccd1 vssd1 sky130_fd_sc_hd__fill_2$1
XFILLER_102_221 vssd1 vccd1 vccd1 vssd1 sky130_ef_sc_hd__decap_40_12$1
XFILLER_68_27 vccd1 vssd1 vccd1 vssd1 sky130_fd_sc_hd__fill_1$1
XFILLER_0_337 vssd1 vccd1 vccd1 vssd1 sky130_ef_sc_hd__decap_40_12$1
XFILLER_130_552 vssd1 vccd1 vccd1 vssd1 sky130_ef_sc_hd__decap_40_12$1
XFILLER_88_477 vssd1 vccd1 vccd1 vssd1 sky130_ef_sc_hd__decap_40_12$1
XFILLER_102_265 vssd1 vccd1 vccd1 vssd1 sky130_ef_sc_hd__decap_40_12$1
XFILLER_75_105 vssd1 vccd1 vccd1 vssd1 sky130_fd_sc_hd__fill_4$1
XFILLER_124_77 vssd1 vccd1 vccd1 vssd1 sky130_fd_sc_hd__fill_4$1
XFILLER_84_15 vssd1 vccd1 vccd1 vssd1 sky130_ef_sc_hd__decap_40_12$1
XFILLER_75_149 vssd1 vccd1 vccd1 vssd1 sky130_ef_sc_hd__decap_40_12$1
XTAP_TAPCELL_ROW_67_1304 vccd1 vssd1 sky130_fd_sc_hd__tapvpwrvgnd_1$1
XFILLER_56_363 vccd1 vssd1 vccd1 vssd1 sky130_fd_sc_hd__fill_1$1
XTAP_TAPCELL_ROW_27_701 vccd1 vssd1 sky130_fd_sc_hd__tapvpwrvgnd_1$1
XFILLER_83_193 vssd1 vccd1 vccd1 vssd1 sky130_ef_sc_hd__decap_40_12$1
XFILLER_72_834 vssd1 vccd1 vccd1 vssd1 sky130_fd_sc_hd__fill_8$1
XFILLER_71_333 vssd1 vccd1 vccd1 vssd1 sky130_fd_sc_hd__fill_2$1
XTAP_TAPCELL_ROW_27_712 vccd1 vssd1 sky130_fd_sc_hd__tapvpwrvgnd_1$1
XFILLER_44_525 vssd1 vccd1 vccd1 vssd1 sky130_fd_sc_hd__fill_4$1
Xclkbuf_leaf_21_wb_clk_i _1763_/CLK clkbuf_2_3__f_wb_clk_i/X vssd1 vccd1 vccd1 vssd1
+ sky130_fd_sc_hd__clkbuf_8$1
XFILLER_16_249 vssd1 vccd1 vccd1 vssd1 sky130_fd_sc_hd__fill_2$1
XTAP_TAPCELL_ROW_80_1504 vccd1 vssd1 sky130_fd_sc_hd__tapvpwrvgnd_1$1
XFILLER_25_783 vccd1 vssd1 vccd1 vssd1 sky130_fd_sc_hd__fill_1$1
XFILLER_12_433 vssd1 vccd1 vccd1 vssd1 sky130_ef_sc_hd__decap_40_12$1
XFILLER_12_477 vssd1 vccd1 vccd1 vssd1 sky130_ef_sc_hd__decap_40_12$1
XFILLER_125_335 vccd1 vssd1 vccd1 vssd1 sky130_fd_sc_hd__fill_1$1
XTAP_TAPCELL_ROW_78_1477 vccd1 vssd1 sky130_fd_sc_hd__tapvpwrvgnd_1$1
XTAP_TAPCELL_ROW_78_1466 vccd1 vssd1 sky130_fd_sc_hd__tapvpwrvgnd_1$1
XFILLER_4_643 vccd1 vssd1 vccd1 vssd1 sky130_fd_sc_hd__fill_1$1
XTAP_TAPCELL_ROW_91_1666 vccd1 vssd1 sky130_fd_sc_hd__tapvpwrvgnd_1$1
XFILLER_79_422 vssd1 vccd1 vccd1 vssd1 sky130_fd_sc_hd__fill_8$1
Xhold4 wbs_adr_i[4] hold4/X vssd1 vccd1 vccd1 vssd1 sky130_fd_sc_hd__dlygate4sd3_1$1
XFILLER_121_585 vssd1 vccd1 vccd1 vssd1 sky130_ef_sc_hd__decap_40_12$1
XFILLER_35_503 vccd1 vssd1 vccd1 vssd1 sky130_fd_sc_hd__fill_1$1
XTAP_TAPCELL_ROW_122_2132 vccd1 vssd1 sky130_fd_sc_hd__tapvpwrvgnd_1$1
XFILLER_74_193 vssd1 vccd1 vccd1 vssd1 sky130_fd_sc_hd__fill_2$1
XFILLER_62_333 vssd1 vccd1 vccd1 vssd1 sky130_ef_sc_hd__decap_40_12$1
XFILLER_47_385 vssd1 vccd1 vccd1 vssd1 sky130_fd_sc_hd__fill_4$1
XFILLER_74_81 vssd1 vccd1 vccd1 vssd1 sky130_fd_sc_hd__fill_2$1
XFILLER_23_709 vssd1 vccd1 vccd1 vssd1 sky130_ef_sc_hd__decap_40_12$1
XFILLER_62_377 vssd1 vccd1 vccd1 vssd1 sky130_fd_sc_hd__fill_8$1
XFILLER_15_293 vssd1 vccd1 vccd1 vssd1 sky130_ef_sc_hd__decap_40_12$1
XFILLER_31_753 vssd1 vccd1 vccd1 vssd1 sky130_ef_sc_hd__decap_40_12$1
XFILLER_43_591 vssd1 vccd1 vccd1 vssd1 sky130_ef_sc_hd__decap_40_12$1
XFILLER_88_3 vssd1 vccd1 vccd1 vssd1 sky130_ef_sc_hd__decap_40_12$1
XFILLER_31_797 vssd1 vccd1 vccd1 vssd1 sky130_ef_sc_hd__decap_40_12$1
XFILLER_129_641 vssd1 vccd1 vccd1 vssd1 sky130_ef_sc_hd__decap_40_12$1
XTAP_TAPCELL_ROW_100_1795 vccd1 vssd1 sky130_fd_sc_hd__tapvpwrvgnd_1$1
X_1823_ _1823_/A _1823_/X vssd1 vccd1 vccd1 vssd1 sky130_fd_sc_hd__clkbuf_2$1
XTAP_TAPCELL_ROW_13_494 vccd1 vssd1 sky130_fd_sc_hd__tapvpwrvgnd_1$1
XFILLER_129_685 vssd1 vccd1 vccd1 vssd1 sky130_fd_sc_hd__fill_4$1
X_1754_ _1754_/Q _1754_/CLK _1754_/D vccd1 vssd1 vccd1 vssd1 sky130_fd_sc_hd__dfxtp_1$1
XFILLER_128_195 vccd1 vssd1 vccd1 vssd1 sky130_fd_sc_hd__fill_1$1
XFILLER_132_817 vccd1 vssd1 vccd1 vssd1 sky130_fd_sc_hd__fill_1$1
XTAP_TAPCELL_ROW_133_2294 vccd1 vssd1 sky130_fd_sc_hd__tapvpwrvgnd_1$1
XFILLER_131_305 vssd1 vccd1 vccd1 vssd1 sky130_ef_sc_hd__decap_40_12$1
XFILLER_116_357 vssd1 vccd1 vccd1 vssd1 sky130_fd_sc_hd__fill_4$1
X_1685_ hold34/A _1749_/CLK _1685_/D vccd1 vssd1 vccd1 vssd1 sky130_fd_sc_hd__dfxtp_1$1
XFILLER_131_349 vssd1 vccd1 vccd1 vssd1 sky130_ef_sc_hd__decap_40_12$1
XPHY_EDGE_ROW_115_Right_115 vccd1 vssd1 vccd1 vssd1 sky130_fd_sc_hd__decap_3$1
XFILLER_112_585 vssd1 vccd1 vccd1 vssd1 sky130_fd_sc_hd__fill_2$1
XFILLER_100_725 vssd1 vccd1 vccd1 vssd1 sky130_ef_sc_hd__decap_40_12$1
XFILLER_58_628 vssd1 vccd1 vccd1 vssd1 sky130_fd_sc_hd__fill_2$1
XFILLER_58_639 vssd1 vccd1 vccd1 vssd1 sky130_fd_sc_hd__fill_4$1
XFILLER_57_105 vssd1 vccd1 vccd1 vssd1 sky130_fd_sc_hd__fill_4$1
XFILLER_100_769 vssd1 vccd1 vccd1 vssd1 sky130_ef_sc_hd__decap_40_12$1
XFILLER_85_436 vssd1 vccd1 vccd1 vssd1 sky130_fd_sc_hd__fill_2$1
XFILLER_57_149 vssd1 vccd1 vccd1 vssd1 sky130_ef_sc_hd__decap_40_12$1
XTAP_TAPCELL_ROW_107_1905 vccd1 vssd1 sky130_fd_sc_hd__tapvpwrvgnd_1$1
XFILLER_38_363 vccd1 vssd1 vccd1 vssd1 sky130_fd_sc_hd__fill_1$1
XFILLER_54_29 vssd1 vccd1 vccd1 vssd1 sky130_ef_sc_hd__decap_40_12$1
XFILLER_53_333 vssd1 vccd1 vccd1 vssd1 sky130_fd_sc_hd__fill_2$1
XFILLER_26_525 vssd1 vccd1 vccd1 vssd1 sky130_fd_sc_hd__fill_4$1
XTAP_TAPCELL_ROW_49_1034 vccd1 vssd1 sky130_fd_sc_hd__tapvpwrvgnd_1$1
XFILLER_80_141 vssd1 vccd1 vccd1 vssd1 sky130_ef_sc_hd__decap_40_12$1
XFILLER_65_193 vssd1 vccd1 vccd1 vssd1 sky130_ef_sc_hd__decap_40_12$1
X_1119_ _1449_/C1 _1118_/X _1123_/A2 hold98/X _1591_/D vssd1 vccd1 vccd1 vssd1 sky130_fd_sc_hd__o211a_1$1
XFILLER_26_569 vssd1 vccd1 vccd1 vssd1 sky130_ef_sc_hd__decap_40_12$1
XFILLER_81_697 vssd1 vccd1 vccd1 vssd1 sky130_ef_sc_hd__decap_40_12$1
XFILLER_41_517 vssd1 vccd1 vccd1 vssd1 sky130_ef_sc_hd__decap_40_12$1
XTAP_TAPCELL_ROW_62_1234 vccd1 vssd1 sky130_fd_sc_hd__tapvpwrvgnd_1$1
XTAP_TAPCELL_ROW_62_1223 vccd1 vssd1 sky130_fd_sc_hd__tapvpwrvgnd_1$1
XPHY_EDGE_ROW_17_Right_17 vccd1 vssd1 vccd1 vssd1 sky130_fd_sc_hd__decap_3$1
XTAP_TAPCELL_ROW_32_781 vccd1 vssd1 sky130_fd_sc_hd__tapvpwrvgnd_1$1
XFILLER_5_429 vssd1 vccd1 vccd1 vssd1 sky130_ef_sc_hd__decap_40_12$1
XFILLER_135_633 vccd1 vssd1 vccd1 vssd1 sky130_fd_sc_hd__fill_1$1
XFILLER_134_121 vssd1 vccd1 vccd1 vssd1 sky130_ef_sc_hd__decap_40_12$1
XFILLER_119_55 vccd1 vssd1 vccd1 vssd1 sky130_fd_sc_hd__fill_1$1
XFILLER_107_335 vccd1 vssd1 vccd1 vssd1 sky130_fd_sc_hd__fill_1$1
XFILLER_79_15 vssd1 vccd1 vccd1 vssd1 sky130_ef_sc_hd__decap_40_12$1
XFILLER_135_666 vssd1 vccd1 vccd1 vssd1 sky130_fd_sc_hd__fill_4$1
XFILLER_134_165 vssd1 vccd1 vccd1 vssd1 sky130_ef_sc_hd__decap_40_12$1
XFILLER_122_305 vssd1 vccd1 vccd1 vssd1 sky130_fd_sc_hd__fill_2$1
XFILLER_1_613 vssd1 vccd1 vccd1 vssd1 sky130_fd_sc_hd__fill_2$1
XFILLER_89_753 vssd1 vccd1 vccd1 vssd1 sky130_ef_sc_hd__decap_40_12$1
XFILLER_103_585 vssd1 vccd1 vccd1 vssd1 sky130_ef_sc_hd__decap_40_12$1
XFILLER_89_797 vssd1 vccd1 vccd1 vssd1 sky130_fd_sc_hd__fill_8$1
XTAP_TAPCELL_ROW_73_1396 vccd1 vssd1 sky130_fd_sc_hd__tapvpwrvgnd_1$1
XFILLER_0_167 vccd1 vssd1 vccd1 vssd1 sky130_fd_sc_hd__fill_1$1
XPHY_EDGE_ROW_26_Right_26 vccd1 vssd1 vccd1 vssd1 sky130_fd_sc_hd__decap_3$1
XFILLER_95_69 vssd1 vccd1 vccd1 vssd1 sky130_ef_sc_hd__decap_40_12$1
XFILLER_28_41 vssd1 vccd1 vccd1 vssd1 sky130_ef_sc_hd__decap_40_12$1
XFILLER_91_417 vssd1 vccd1 vccd1 vssd1 sky130_ef_sc_hd__decap_40_12$1
XFILLER_17_503 vccd1 vssd1 vccd1 vssd1 sky130_fd_sc_hd__fill_1$1
XFILLER_45_801 vssd1 vccd1 vccd1 vssd1 sky130_fd_sc_hd__fill_2$1
XFILLER_57_683 vccd1 vssd1 vccd1 vssd1 sky130_fd_sc_hd__fill_1$1
XFILLER_28_85 vssd1 vccd1 vccd1 vssd1 sky130_ef_sc_hd__decap_40_12$1
XFILLER_29_385 vssd1 vccd1 vccd1 vssd1 sky130_fd_sc_hd__fill_4$1
XFILLER_60_815 vccd1 vssd1 vccd1 vssd1 sky130_fd_sc_hd__fill_1$1
XFILLER_56_193 vssd1 vccd1 vccd1 vssd1 sky130_fd_sc_hd__fill_2$1
XFILLER_44_333 vssd1 vccd1 vccd1 vssd1 sky130_ef_sc_hd__decap_40_12$1
XFILLER_44_377 vssd1 vccd1 vccd1 vssd1 sky130_ef_sc_hd__decap_40_12$1
XFILLER_13_753 vssd1 vccd1 vccd1 vssd1 sky130_ef_sc_hd__decap_40_12$1
XPHY_EDGE_ROW_35_Right_35 vccd1 vssd1 vccd1 vssd1 sky130_fd_sc_hd__decap_3$1
XFILLER_8_245 vssd1 vccd1 vccd1 vssd1 sky130_fd_sc_hd__fill_4$1
XFILLER_13_797 vssd1 vccd1 vccd1 vssd1 sky130_ef_sc_hd__decap_40_12$1
XFILLER_40_583 vssd1 vccd1 vccd1 vssd1 sky130_fd_sc_hd__fill_4$1
XFILLER_60_83 vccd1 vssd1 vccd1 vssd1 sky130_fd_sc_hd__fill_1$1
XTAP_TAPCELL_ROW_10_453 vccd1 vssd1 sky130_fd_sc_hd__tapvpwrvgnd_1$1
XFILLER_8_289 vssd1 vccd1 vccd1 vssd1 sky130_ef_sc_hd__decap_40_12$1
XFILLER_125_165 vssd1 vccd1 vccd1 vssd1 sky130_fd_sc_hd__fill_2$1
XFILLER_113_305 vssd1 vccd1 vccd1 vssd1 sky130_ef_sc_hd__decap_40_12$1
X_1470_ _1470_/A _1470_/X _1474_/B vssd1 vccd1 vccd1 vssd1 sky130_fd_sc_hd__or2_1$1
XFILLER_99_539 vssd1 vccd1 vccd1 vssd1 sky130_ef_sc_hd__decap_40_12$1
XFILLER_4_473 vssd1 vccd1 vccd1 vssd1 sky130_fd_sc_hd__fill_2$1
XFILLER_113_349 vssd1 vccd1 vccd1 vssd1 sky130_ef_sc_hd__decap_40_12$1
XFILLER_69_81 vssd1 vccd1 vccd1 vssd1 sky130_ef_sc_hd__decap_40_12$1
XPHY_EDGE_ROW_44_Right_44 vccd1 vssd1 vccd1 vssd1 sky130_fd_sc_hd__decap_3$1
XFILLER_39_105 vssd1 vccd1 vccd1 vssd1 sky130_fd_sc_hd__fill_4$1
XFILLER_121_393 vssd1 vccd1 vccd1 vssd1 sky130_fd_sc_hd__fill_8$1
XFILLER_94_233 vssd1 vccd1 vccd1 vssd1 sky130_ef_sc_hd__decap_40_12$1
XFILLER_0_690 vssd1 vccd1 vccd1 vssd1 sky130_fd_sc_hd__fill_8$1
XFILLER_39_149 vssd1 vccd1 vccd1 vssd1 sky130_ef_sc_hd__decap_40_12$1
XFILLER_94_277 vssd1 vccd1 vccd1 vssd1 sky130_ef_sc_hd__decap_40_12$1
XFILLER_62_141 vssd1 vccd1 vccd1 vssd1 sky130_ef_sc_hd__decap_40_12$1
XFILLER_35_333 vssd1 vccd1 vccd1 vssd1 sky130_fd_sc_hd__fill_2$1
XFILLER_47_193 vssd1 vccd1 vccd1 vssd1 sky130_ef_sc_hd__decap_40_12$1
XTAP_TAPCELL_ROW_18_564 vccd1 vssd1 sky130_fd_sc_hd__tapvpwrvgnd_1$1
XTAP_TAPCELL_ROW_18_575 vccd1 vssd1 sky130_fd_sc_hd__tapvpwrvgnd_1$1
XFILLER_23_517 vssd1 vccd1 vccd1 vssd1 sky130_ef_sc_hd__decap_40_12$1
XTAP_TAPCELL_ROW_102_1835 vccd1 vssd1 sky130_fd_sc_hd__tapvpwrvgnd_1$1
XTAP_TAPCELL_ROW_102_1824 vccd1 vssd1 sky130_fd_sc_hd__tapvpwrvgnd_1$1
XPHY_EDGE_ROW_53_Right_53 vccd1 vssd1 vccd1 vssd1 sky130_fd_sc_hd__decap_3$1
XFILLER_31_561 vssd1 vccd1 vccd1 vssd1 sky130_ef_sc_hd__decap_40_12$1
XTAP_TAPCELL_ROW_135_2323 vccd1 vssd1 sky130_fd_sc_hd__tapvpwrvgnd_1$1
XFILLER_136_419 vccd1 vssd1 vccd1 vssd1 sky130_fd_sc_hd__fill_1$1
X_1806_ _1806_/A _1806_/X vssd1 vccd1 vccd1 vssd1 sky130_fd_sc_hd__clkbuf_2$1
XFILLER_116_121 vssd1 vccd1 vccd1 vssd1 sky130_ef_sc_hd__decap_40_12$1
Xhold201 _1529_/Q _0990_/A vssd1 vccd1 vccd1 vssd1 sky130_fd_sc_hd__dlygate4sd3_1$1
XFILLER_104_305 vssd1 vccd1 vccd1 vssd1 sky130_fd_sc_hd__fill_2$1
X_1737_ _1845_/A _1737_/CLK _1737_/D vccd1 vssd1 vccd1 vssd1 sky130_fd_sc_hd__dfxtp_1$1
Xhold212 _1548_/Q _1030_/A vssd1 vccd1 vccd1 vssd1 sky130_fd_sc_hd__dlygate4sd3_1$1
XFILLER_131_113 vssd1 vccd1 vccd1 vssd1 sky130_ef_sc_hd__decap_40_12$1
X_1668_ _1668_/Q _1763_/CLK _1668_/D vccd1 vssd1 vccd1 vssd1 sky130_fd_sc_hd__dfxtp_1$1
XFILLER_116_165 vssd1 vccd1 vccd1 vssd1 sky130_ef_sc_hd__decap_40_12$1
XPHY_EDGE_ROW_62_Right_62 vccd1 vssd1 vccd1 vssd1 sky130_fd_sc_hd__decap_3$1
XFILLER_132_669 vssd1 vccd1 vccd1 vssd1 sky130_ef_sc_hd__decap_40_12$1
XTAP_TAPCELL_ROW_113_1997 vccd1 vssd1 sky130_fd_sc_hd__tapvpwrvgnd_1$1
X_1599_ hold88/A _1729_/CLK _1599_/D vccd1 vssd1 vccd1 vssd1 sky130_fd_sc_hd__dfxtp_1$1
XFILLER_86_701 vssd1 vccd1 vccd1 vssd1 sky130_ef_sc_hd__decap_40_12$1
XFILLER_105_57 vssd1 vccd1 vccd1 vssd1 sky130_ef_sc_hd__decap_40_12$1
XFILLER_85_277 vssd1 vccd1 vccd1 vssd1 sky130_fd_sc_hd__fill_2$1
XFILLER_65_39 vssd1 vccd1 vccd1 vssd1 sky130_ef_sc_hd__decap_40_12$1
XFILLER_27_823 vccd1 vssd1 vccd1 vssd1 sky130_fd_sc_hd__fill_1$1
XFILLER_54_642 vssd1 vccd1 vccd1 vssd1 sky130_fd_sc_hd__fill_2$1
XFILLER_26_333 vssd1 vccd1 vccd1 vssd1 sky130_ef_sc_hd__decap_40_12$1
XTAP_TAPCELL_ROW_37_851 vccd1 vssd1 sky130_fd_sc_hd__tapvpwrvgnd_1$1
XFILLER_38_193 vssd1 vccd1 vccd1 vssd1 sky130_fd_sc_hd__fill_2$1
XFILLER_81_461 vssd1 vccd1 vccd1 vssd1 sky130_ef_sc_hd__decap_40_12$1
XFILLER_81_27 vssd1 vccd1 vccd1 vssd1 sky130_ef_sc_hd__decap_40_12$1
XPHY_EDGE_ROW_71_Right_71 vccd1 vssd1 vccd1 vssd1 sky130_fd_sc_hd__decap_3$1
XFILLER_54_697 vssd1 vccd1 vccd1 vssd1 sky130_fd_sc_hd__fill_2$1
XFILLER_26_377 vssd1 vccd1 vccd1 vssd1 sky130_ef_sc_hd__decap_40_12$1
XTAP_TAPCELL_ROW_37_862 vccd1 vssd1 sky130_fd_sc_hd__tapvpwrvgnd_1$1
XFILLER_10_701 vssd1 vccd1 vccd1 vssd1 sky130_ef_sc_hd__decap_40_12$1
XFILLER_14_65 vssd1 vccd1 vccd1 vssd1 sky130_ef_sc_hd__decap_40_12$1
XFILLER_127_419 vssd1 vccd1 vccd1 vssd1 sky130_fd_sc_hd__fill_4$1
XFILLER_6_749 vssd1 vccd1 vccd1 vssd1 sky130_fd_sc_hd__fill_4$1
XFILLER_5_237 vssd1 vccd1 vccd1 vssd1 sky130_ef_sc_hd__decap_40_12$1
XPHY_EDGE_ROW_80_Right_80 vccd1 vssd1 vccd1 vssd1 sky130_fd_sc_hd__decap_3$1
XTAP_TAPCELL_ROW_75_1425 vccd1 vssd1 sky130_fd_sc_hd__tapvpwrvgnd_1$1
XPHY_EDGE_ROW_15_Left_154 vccd1 vssd1 vccd1 vssd1 sky130_fd_sc_hd__decap_3$1
XFILLER_30_53 vssd1 vccd1 vccd1 vssd1 sky130_ef_sc_hd__decap_40_12$1
XFILLER_123_625 vssd1 vccd1 vccd1 vssd1 sky130_ef_sc_hd__decap_40_12$1
XFILLER_123_614 vssd1 vccd1 vccd1 vssd1 sky130_fd_sc_hd__fill_2$1
XFILLER_108_688 vssd1 vccd1 vccd1 vssd1 sky130_ef_sc_hd__decap_40_12$1
XFILLER_107_165 vssd1 vccd1 vccd1 vssd1 sky130_fd_sc_hd__fill_2$1
XFILLER_30_97 vssd1 vccd1 vccd1 vssd1 sky130_ef_sc_hd__decap_40_12$1
XFILLER_123_669 vssd1 vccd1 vccd1 vssd1 sky130_fd_sc_hd__fill_2$1
XFILLER_89_561 vssd1 vccd1 vccd1 vssd1 sky130_fd_sc_hd__fill_4$1
XFILLER_39_51 vssd1 vccd1 vccd1 vssd1 sky130_fd_sc_hd__fill_4$1
XFILLER_76_233 vssd1 vccd1 vccd1 vssd1 sky130_ef_sc_hd__decap_40_12$1
XFILLER_49_447 vccd1 vssd1 vccd1 vssd1 sky130_fd_sc_hd__fill_1$1
XFILLER_76_277 vssd1 vccd1 vccd1 vssd1 sky130_ef_sc_hd__decap_40_12$1
XFILLER_37_609 vssd1 vccd1 vccd1 vssd1 sky130_fd_sc_hd__fill_4$1
XFILLER_92_748 vssd1 vccd1 vccd1 vssd1 sky130_fd_sc_hd__fill_8$1
XFILLER_91_225 vssd1 vccd1 vccd1 vssd1 sky130_ef_sc_hd__decap_40_12$1
XPHY_EDGE_ROW_24_Left_163 vccd1 vssd1 vccd1 vssd1 sky130_fd_sc_hd__decap_3$1
XFILLER_57_491 vssd1 vccd1 vccd1 vssd1 sky130_ef_sc_hd__decap_40_12$1
XFILLER_17_333 vssd1 vccd1 vccd1 vssd1 sky130_fd_sc_hd__fill_2$1
XFILLER_29_193 vssd1 vccd1 vccd1 vssd1 sky130_ef_sc_hd__decap_40_12$1
XFILLER_44_141 vssd1 vccd1 vccd1 vssd1 sky130_ef_sc_hd__decap_40_12$1
XFILLER_45_653 vssd1 vccd1 vccd1 vssd1 sky130_fd_sc_hd__fill_4$1
XTAP_TAPCELL_ROW_86_1587 vccd1 vssd1 sky130_fd_sc_hd__tapvpwrvgnd_1$1
XFILLER_60_601 vssd1 vccd1 vccd1 vssd1 sky130_ef_sc_hd__decap_40_12$1
XFILLER_72_494 vssd1 vccd1 vccd1 vssd1 sky130_fd_sc_hd__fill_4$1
XTAP_TAPCELL_ROW_15_523 vccd1 vssd1 sky130_fd_sc_hd__tapvpwrvgnd_1$1
XFILLER_13_561 vssd1 vccd1 vccd1 vssd1 sky130_ef_sc_hd__decap_40_12$1
X_0970_ _0970_/A _0970_/X _0990_/B vssd1 vccd1 vccd1 vssd1 sky130_fd_sc_hd__or2_1$1
XFILLER_71_93 vssd1 vccd1 vccd1 vssd1 sky130_ef_sc_hd__decap_40_12$1
XTAP_TAPCELL_ROW_117_2053 vccd1 vssd1 sky130_fd_sc_hd__tapvpwrvgnd_1$1
XPHY_EDGE_ROW_33_Left_172 vccd1 vssd1 vccd1 vssd1 sky130_fd_sc_hd__decap_3$1
XFILLER_126_441 vssd1 vccd1 vccd1 vssd1 sky130_ef_sc_hd__decap_40_12$1
XTAP_TAPCELL_ROW_130_2253 vccd1 vssd1 sky130_fd_sc_hd__tapvpwrvgnd_1$1
XFILLER_114_625 vccd1 vssd1 vccd1 vssd1 sky130_fd_sc_hd__fill_1$1
XFILLER_113_113 vssd1 vccd1 vccd1 vssd1 sky130_ef_sc_hd__decap_40_12$1
X_1522_ hold28/A _1719_/CLK _1522_/D vccd1 vssd1 vccd1 vssd1 sky130_fd_sc_hd__dfxtp_1$1
XFILLER_102_809 vssd1 vccd1 vccd1 vssd1 sky130_fd_sc_hd__fill_2$1
X_1453_ _1455_/C1 _1452_/X _1465_/A2 hold125/X _1753_/D vssd1 vccd1 vccd1 vssd1 sky130_fd_sc_hd__o211a_1$1
XFILLER_68_701 vssd1 vccd1 vccd1 vssd1 sky130_ef_sc_hd__decap_40_12$1
X_1384_ _1384_/A _1384_/X _1398_/B vssd1 vccd1 vccd1 vssd1 sky130_fd_sc_hd__or2_1$1
XFILLER_68_734 vssd1 vccd1 vccd1 vssd1 sky130_fd_sc_hd__fill_2$1
XPHY_EDGE_ROW_42_Left_181 vccd1 vssd1 vccd1 vssd1 sky130_fd_sc_hd__decap_3$1
XFILLER_95_597 vssd1 vccd1 vccd1 vssd1 sky130_ef_sc_hd__decap_40_12$1
XFILLER_83_737 vccd1 vssd1 vccd1 vssd1 sky130_fd_sc_hd__fill_1$1
XFILLER_67_277 vssd1 vccd1 vccd1 vssd1 sky130_fd_sc_hd__fill_2$1
XFILLER_70_409 vssd1 vccd1 vccd1 vssd1 sky130_fd_sc_hd__fill_2$1
XFILLER_91_781 vssd1 vccd1 vccd1 vssd1 sky130_fd_sc_hd__fill_2$1
XFILLER_63_483 vccd1 vssd1 vccd1 vssd1 sky130_fd_sc_hd__fill_1$1
XFILLER_63_461 vssd1 vccd1 vccd1 vssd1 sky130_ef_sc_hd__decap_40_12$1
XTAP_TAPCELL_ROW_34_810 vccd1 vssd1 sky130_fd_sc_hd__tapvpwrvgnd_1$1
XFILLER_36_697 vssd1 vccd1 vccd1 vssd1 sky130_fd_sc_hd__fill_2$1
XFILLER_50_133 vssd1 vccd1 vccd1 vssd1 sky130_fd_sc_hd__fill_4$1
XFILLER_50_177 vssd1 vccd1 vccd1 vssd1 sky130_ef_sc_hd__decap_40_12$1
XPHY_EDGE_ROW_51_Left_190 vccd1 vssd1 vccd1 vssd1 sky130_fd_sc_hd__decap_3$1
XFILLER_31_391 vccd1 vssd1 vccd1 vssd1 sky130_fd_sc_hd__fill_1$1
XFILLER_136_249 vssd1 vccd1 vccd1 vssd1 sky130_fd_sc_hd__fill_2$1
XTAP_TAPCELL_ROW_57_1155 vccd1 vssd1 sky130_fd_sc_hd__tapvpwrvgnd_1$1
XFILLER_132_433 vssd1 vccd1 vccd1 vssd1 sky130_fd_sc_hd__fill_2$1
XFILLER_105_669 vssd1 vccd1 vccd1 vssd1 sky130_fd_sc_hd__fill_2$1
XFILLER_132_477 vssd1 vccd1 vccd1 vssd1 sky130_ef_sc_hd__decap_40_12$1
XFILLER_76_27 vccd1 vssd1 vccd1 vssd1 sky130_fd_sc_hd__fill_1$1
XTAP_TAPCELL_ROW_70_1355 vccd1 vssd1 sky130_fd_sc_hd__tapvpwrvgnd_1$1
XTAP_TAPCELL_ROW_70_1344 vccd1 vssd1 sky130_fd_sc_hd__tapvpwrvgnd_1$1
XFILLER_58_233 vssd1 vccd1 vccd1 vssd1 sky130_ef_sc_hd__decap_40_12$1
XFILLER_19_609 vssd1 vccd1 vccd1 vssd1 sky130_fd_sc_hd__fill_4$1
XFILLER_100_363 vccd1 vssd1 vccd1 vssd1 sky130_fd_sc_hd__fill_1$1
XFILLER_73_225 vssd1 vccd1 vccd1 vssd1 sky130_ef_sc_hd__decap_40_12$1
XFILLER_58_277 vssd1 vccd1 vccd1 vssd1 sky130_ef_sc_hd__decap_40_12$1
XFILLER_46_417 vssd1 vccd1 vccd1 vssd1 sky130_fd_sc_hd__fill_2$1
XFILLER_132_77 vssd1 vccd1 vccd1 vssd1 sky130_fd_sc_hd__fill_4$1
XFILLER_92_15 vssd1 vccd1 vccd1 vssd1 sky130_ef_sc_hd__decap_40_12$1
XFILLER_27_653 vccd1 vssd1 vccd1 vssd1 sky130_fd_sc_hd__fill_1$1
XFILLER_26_141 vssd1 vccd1 vccd1 vssd1 sky130_ef_sc_hd__decap_40_12$1
XFILLER_42_601 vssd1 vccd1 vccd1 vssd1 sky130_ef_sc_hd__decap_40_12$1
XFILLER_41_111 vccd1 vssd1 vccd1 vssd1 sky130_fd_sc_hd__fill_1$1
XFILLER_127_205 vssd1 vccd1 vccd1 vssd1 sky130_ef_sc_hd__decap_40_12$1
XFILLER_10_531 vccd1 vssd1 vccd1 vssd1 sky130_fd_sc_hd__fill_1$1
XFILLER_127_249 vssd1 vccd1 vccd1 vssd1 sky130_ef_sc_hd__decap_40_12$1
XFILLER_6_513 vssd1 vccd1 vccd1 vssd1 sky130_ef_sc_hd__decap_40_12$1
XFILLER_6_557 vssd1 vccd1 vccd1 vssd1 sky130_ef_sc_hd__decap_40_12$1
XFILLER_136_794 vccd1 vssd1 vccd1 vssd1 sky130_fd_sc_hd__fill_1$1
XFILLER_135_293 vssd1 vccd1 vccd1 vssd1 sky130_ef_sc_hd__decap_40_12$1
XFILLER_111_617 vssd1 vccd1 vccd1 vssd1 sky130_ef_sc_hd__decap_40_12$1
XFILLER_77_531 vccd1 vssd1 vccd1 vssd1 sky130_fd_sc_hd__fill_1$1
XFILLER_1_273 vssd1 vccd1 vccd1 vssd1 sky130_fd_sc_hd__fill_4$1
XTAP_TAPCELL_ROW_88_1616 vccd1 vssd1 sky130_fd_sc_hd__tapvpwrvgnd_1$1
XFILLER_92_523 vccd1 vssd1 vccd1 vssd1 sky130_fd_sc_hd__fill_1$1
XTAP_TAPCELL_ROW_88_1627 vccd1 vssd1 sky130_fd_sc_hd__tapvpwrvgnd_1$1
XFILLER_77_597 vssd1 vccd1 vccd1 vssd1 sky130_fd_sc_hd__fill_4$1
XFILLER_37_417 vssd1 vccd1 vccd1 vssd1 sky130_ef_sc_hd__decap_40_12$1
XFILLER_49_277 vssd1 vccd1 vccd1 vssd1 sky130_fd_sc_hd__fill_2$1
XFILLER_92_545 vssd1 vccd1 vccd1 vssd1 sky130_ef_sc_hd__decap_40_12$1
XFILLER_92_589 vssd1 vccd1 vccd1 vssd1 sky130_ef_sc_hd__decap_40_12$1
XFILLER_73_781 vssd1 vccd1 vccd1 vssd1 sky130_fd_sc_hd__fill_2$1
XFILLER_18_697 vssd1 vccd1 vccd1 vssd1 sky130_fd_sc_hd__fill_2$1
XFILLER_33_645 vssd1 vccd1 vccd1 vssd1 sky130_fd_sc_hd__fill_2$1
XFILLER_82_81 vssd1 vccd1 vccd1 vssd1 sky130_fd_sc_hd__fill_2$1
XFILLER_32_133 vssd1 vccd1 vccd1 vssd1 sky130_fd_sc_hd__fill_4$1
XFILLER_33_689 vssd1 vccd1 vccd1 vssd1 sky130_fd_sc_hd__fill_4$1
XANTENNA_29 hold172/X vssd1 vccd1 vccd1 vssd1 sky130_fd_sc_hd__diode_2$1
XANTENNA_18 _1478_/Q vssd1 vccd1 vccd1 vssd1 sky130_fd_sc_hd__diode_2$1
XFILLER_32_177 vssd1 vccd1 vccd1 vssd1 sky130_ef_sc_hd__decap_40_12$1
XFILLER_13_391 vccd1 vssd1 vccd1 vssd1 sky130_fd_sc_hd__fill_1$1
X_0953_ _1091_/C1 _0952_/X _0991_/A2 hold73/X _1510_/D vssd1 vccd1 vccd1 vssd1 sky130_fd_sc_hd__o211a_1$1
XTAP_TAPCELL_ROW_99_1778 vccd1 vssd1 sky130_fd_sc_hd__tapvpwrvgnd_1$1
X_0884_ _1626_/Q _1147_/A _0885_/C _1690_/Q _1279_/A vccd1 vssd1 vccd1 vssd1 sky130_fd_sc_hd__a22o_1$1
XFILLER_70_3 vssd1 vccd1 vccd1 vssd1 sky130_ef_sc_hd__decap_40_12$1
XFILLER_9_373 vssd1 vccd1 vccd1 vssd1 sky130_ef_sc_hd__decap_40_12$1
XFILLER_118_249 vssd1 vccd1 vccd1 vssd1 sky130_fd_sc_hd__fill_2$1
XTAP_TAPCELL_ROW_99_1789 vccd1 vssd1 sky130_fd_sc_hd__tapvpwrvgnd_1$1
XFILLER_127_783 vccd1 vssd1 vccd1 vssd1 sky130_fd_sc_hd__fill_1$1
XFILLER_114_400 vssd1 vccd1 vccd1 vssd1 sky130_fd_sc_hd__fill_4$1
XFILLER_99_111 vccd1 vssd1 vccd1 vssd1 sky130_fd_sc_hd__fill_1$1
Xoutput125 _1828_/X analog_ctrl[57] vssd1 vccd1 vccd1 vssd1 sky130_fd_sc_hd__buf_12$1
Xoutput114 _1818_/X analog_ctrl[47] vssd1 vccd1 vccd1 vssd1 sky130_fd_sc_hd__buf_12$1
Xoutput103 _1808_/X analog_ctrl[37] vssd1 vccd1 vccd1 vssd1 sky130_fd_sc_hd__buf_12$1
X_1505_ _1505_/Q _1761_/CLK _1505_/D vccd1 vssd1 vccd1 vssd1 sky130_fd_sc_hd__dfxtp_1$1
XFILLER_114_433 vssd1 vccd1 vccd1 vssd1 sky130_ef_sc_hd__decap_40_12$1
Xoutput158 _1661_/Q analog_ctrl[88] vssd1 vccd1 vccd1 vssd1 sky130_fd_sc_hd__buf_12$1
Xoutput147 _1650_/Q analog_ctrl[77] vssd1 vccd1 vccd1 vssd1 sky130_fd_sc_hd__buf_12$1
Xoutput136 _1640_/Q analog_ctrl[67] vssd1 vccd1 vccd1 vssd1 sky130_fd_sc_hd__buf_12$1
XFILLER_114_477 vssd1 vccd1 vccd1 vssd1 sky130_ef_sc_hd__decap_40_12$1
XFILLER_101_105 vssd1 vccd1 vccd1 vssd1 sky130_fd_sc_hd__fill_4$1
XFILLER_87_317 vssd1 vccd1 vccd1 vssd1 sky130_ef_sc_hd__decap_40_12$1
Xoutput169 _1780_/X analog_ctrl[9] vssd1 vccd1 vccd1 vssd1 sky130_fd_sc_hd__buf_12$1
XTAP_TAPCELL_ROW_110_1956 vccd1 vssd1 sky130_fd_sc_hd__tapvpwrvgnd_1$1
XTAP_TAPCELL_ROW_110_1945 vccd1 vssd1 sky130_fd_sc_hd__tapvpwrvgnd_1$1
X_1436_ _1853_/A _1436_/X _1474_/B vssd1 vccd1 vccd1 vssd1 sky130_fd_sc_hd__or2_1$1
XFILLER_68_531 vccd1 vssd1 vccd1 vssd1 sky130_fd_sc_hd__fill_1$1
XFILLER_101_149 vssd1 vccd1 vccd1 vssd1 sky130_ef_sc_hd__decap_40_12$1
X_1367_ _1431_/C1 _1366_/X _1409_/A2 hold142/X _1711_/D vssd1 vccd1 vccd1 vssd1 sky130_fd_sc_hd__o211a_1$1
XTAP_TAPCELL_ROW_52_1085 vccd1 vssd1 sky130_fd_sc_hd__tapvpwrvgnd_1$1
XTAP_TAPCELL_ROW_52_1074 vccd1 vssd1 sky130_fd_sc_hd__tapvpwrvgnd_1$1
XFILLER_95_361 vssd1 vccd1 vccd1 vssd1 sky130_ef_sc_hd__decap_40_12$1
XFILLER_83_523 vccd1 vssd1 vccd1 vssd1 sky130_fd_sc_hd__fill_1$1
XFILLER_83_501 vssd1 vccd1 vccd1 vssd1 sky130_fd_sc_hd__fill_2$1
XFILLER_56_737 vssd1 vccd1 vccd1 vssd1 sky130_ef_sc_hd__decap_40_12$1
XFILLER_55_225 vssd1 vccd1 vccd1 vssd1 sky130_ef_sc_hd__decap_40_12$1
XFILLER_28_417 vssd1 vccd1 vccd1 vssd1 sky130_fd_sc_hd__fill_2$1
X_1298_ _1298_/A _1298_/X _1330_/B vssd1 vccd1 vccd1 vssd1 sky130_fd_sc_hd__or2_1$1
XFILLER_83_578 vssd1 vccd1 vccd1 vssd1 sky130_ef_sc_hd__decap_40_12$1
XFILLER_71_729 vssd1 vccd1 vccd1 vssd1 sky130_ef_sc_hd__decap_40_12$1
XFILLER_64_781 vssd1 vccd1 vccd1 vssd1 sky130_ef_sc_hd__decap_40_12$1
XFILLER_24_601 vssd1 vccd1 vccd1 vssd1 sky130_ef_sc_hd__decap_40_12$1
XFILLER_23_111 vccd1 vssd1 vccd1 vssd1 sky130_fd_sc_hd__fill_1$1
XFILLER_24_645 vssd1 vccd1 vccd1 vssd1 sky130_ef_sc_hd__decap_40_12$1
XFILLER_62_29 vssd1 vccd1 vccd1 vssd1 sky130_ef_sc_hd__decap_40_12$1
XFILLER_11_317 vssd1 vccd1 vccd1 vssd1 sky130_ef_sc_hd__decap_40_12$1
XFILLER_109_205 vssd1 vccd1 vccd1 vssd1 sky130_ef_sc_hd__decap_40_12$1
XFILLER_118_761 vssd1 vccd1 vccd1 vssd1 sky130_fd_sc_hd__fill_2$1
XFILLER_109_249 vssd1 vccd1 vccd1 vssd1 sky130_ef_sc_hd__decap_40_12$1
XFILLER_118_772 vssd1 vccd1 vccd1 vssd1 sky130_ef_sc_hd__decap_40_12$1
XFILLER_11_55 vccd1 vssd1 vccd1 vssd1 sky130_fd_sc_hd__fill_1$1
XFILLER_3_505 vssd1 vccd1 vccd1 vssd1 sky130_ef_sc_hd__decap_40_12$1
XFILLER_133_753 vssd1 vccd1 vccd1 vssd1 sky130_ef_sc_hd__decap_40_12$1
XFILLER_127_55 vccd1 vssd1 vccd1 vssd1 sky130_fd_sc_hd__fill_1$1
XFILLER_117_293 vssd1 vccd1 vccd1 vssd1 sky130_ef_sc_hd__decap_40_12$1
XFILLER_87_15 vssd1 vccd1 vccd1 vssd1 sky130_ef_sc_hd__decap_40_12$1
XFILLER_133_797 vssd1 vccd1 vccd1 vssd1 sky130_ef_sc_hd__decap_40_12$1
XFILLER_120_458 vssd1 vccd1 vccd1 vssd1 sky130_fd_sc_hd__fill_2$1
XFILLER_59_553 vssd1 vccd1 vccd1 vssd1 sky130_fd_sc_hd__fill_4$1
XFILLER_101_683 vssd1 vccd1 vccd1 vssd1 sky130_ef_sc_hd__decap_40_12$1
XFILLER_86_361 vssd1 vccd1 vccd1 vssd1 sky130_fd_sc_hd__fill_2$1
XFILLER_74_501 vssd1 vccd1 vccd1 vssd1 sky130_ef_sc_hd__decap_40_12$1
XFILLER_59_597 vssd1 vccd1 vccd1 vssd1 sky130_ef_sc_hd__decap_40_12$1
XTAP_TAPCELL_ROW_6_387 vccd1 vssd1 sky130_fd_sc_hd__tapvpwrvgnd_1$1
XFILLER_19_417 vssd1 vccd1 vccd1 vssd1 sky130_ef_sc_hd__decap_40_12$1
XFILLER_100_193 vssd1 vccd1 vccd1 vssd1 sky130_fd_sc_hd__fill_2$1
Xafe_wb_285 analog_ctrl[102] afe_wb_285/HI vssd1 vccd1 vccd1 vssd1 sky130_fd_sc_hd__conb_1$1
XFILLER_61_217 vssd1 vccd1 vccd1 vssd1 sky130_fd_sc_hd__fill_4$1
XFILLER_55_781 vssd1 vccd1 vccd1 vssd1 sky130_fd_sc_hd__fill_2$1
XFILLER_27_461 vssd1 vccd1 vccd1 vssd1 sky130_ef_sc_hd__decap_40_12$1
XFILLER_36_41 vssd1 vccd1 vccd1 vssd1 sky130_ef_sc_hd__decap_40_12$1
XTAP_TAPCELL_ROW_83_1546 vccd1 vssd1 sky130_fd_sc_hd__tapvpwrvgnd_1$1
XFILLER_36_85 vssd1 vccd1 vccd1 vssd1 sky130_ef_sc_hd__decap_40_12$1
XFILLER_14_133 vssd1 vccd1 vccd1 vssd1 sky130_fd_sc_hd__fill_4$1
XFILLER_14_177 vssd1 vccd1 vccd1 vssd1 sky130_ef_sc_hd__decap_40_12$1
XTAP_TAPCELL_ROW_25_673 vccd1 vssd1 sky130_fd_sc_hd__tapvpwrvgnd_1$1
XFILLER_30_637 vssd1 vccd1 vccd1 vssd1 sky130_fd_sc_hd__fill_4$1
XFILLER_42_475 vccd1 vssd1 vccd1 vssd1 sky130_fd_sc_hd__fill_1$1
Xinput27 hold32/A hold31/X vssd1 vccd1 vccd1 vssd1 sky130_fd_sc_hd__clkbuf_4$1
Xinput16 hold8/A vccd1 vssd1 hold7/X vccd1 vssd1 sky130_fd_sc_hd__buf_4$1
XFILLER_10_361 vssd1 vccd1 vccd1 vssd1 sky130_fd_sc_hd__fill_2$1
Xinput38 vccd1 vssd1 hold83/A hold82/X vccd1 vssd1 sky130_fd_sc_hd__buf_2$1
Xinput49 input49/X vccd1 vssd1 input49/A vccd1 vssd1 sky130_fd_sc_hd__buf_4$1
XFILLER_128_569 vssd1 vccd1 vccd1 vssd1 sky130_ef_sc_hd__decap_40_12$1
XTAP_TAPCELL_ROW_114_2012 vccd1 vssd1 sky130_fd_sc_hd__tapvpwrvgnd_1$1
XFILLER_6_321 vssd1 vccd1 vccd1 vssd1 sky130_ef_sc_hd__decap_40_12$1
XFILLER_6_365 vssd1 vccd1 vccd1 vssd1 sky130_ef_sc_hd__decap_40_12$1
XFILLER_124_753 vssd1 vccd1 vccd1 vssd1 sky130_fd_sc_hd__fill_2$1
XFILLER_124_786 vssd1 vccd1 vccd1 vssd1 sky130_ef_sc_hd__decap_40_12$1
XFILLER_97_615 vccd1 vssd1 vccd1 vssd1 sky130_fd_sc_hd__fill_1$1
XFILLER_69_317 vssd1 vccd1 vccd1 vssd1 sky130_ef_sc_hd__decap_40_12$1
XFILLER_111_447 vccd1 vssd1 vccd1 vssd1 sky130_fd_sc_hd__fill_1$1
XFILLER_84_309 vssd1 vccd1 vccd1 vssd1 sky130_ef_sc_hd__decap_40_12$1
XFILLER_77_81 vssd1 vccd1 vccd1 vssd1 sky130_ef_sc_hd__decap_40_12$1
X_1221_ _1421_/C1 _1220_/X _1273_/A2 hold67/X _1640_/D vssd1 vccd1 vccd1 vssd1 sky130_fd_sc_hd__o211a_1$1
XFILLER_77_361 vssd1 vccd1 vccd1 vssd1 sky130_ef_sc_hd__decap_40_12$1
XFILLER_38_737 vssd1 vccd1 vccd1 vssd1 sky130_ef_sc_hd__decap_40_12$1
XFILLER_37_225 vssd1 vccd1 vccd1 vssd1 sky130_ef_sc_hd__decap_40_12$1
X_1152_ _1794_/A _1152_/X _1188_/B vssd1 vccd1 vccd1 vssd1 sky130_fd_sc_hd__or2_1$1
XTAP_TAPCELL_ROW_125_2174 vccd1 vssd1 sky130_fd_sc_hd__tapvpwrvgnd_1$1
XFILLER_53_729 vssd1 vccd1 vccd1 vssd1 sky130_ef_sc_hd__decap_40_12$1
X_1083_ _1091_/C1 _1082_/X _1123_/A2 hold78/X _1573_/D vssd1 vccd1 vccd1 vssd1 sky130_fd_sc_hd__o211a_1$1
XTAP_TAPCELL_ROW_44_960 vccd1 vssd1 sky130_fd_sc_hd__tapvpwrvgnd_1$1
XFILLER_21_615 vccd1 vssd1 vccd1 vssd1 sky130_fd_sc_hd__fill_1$1
XFILLER_33_497 vssd1 vccd1 vccd1 vssd1 sky130_fd_sc_hd__fill_4$1
XFILLER_119_547 vssd1 vccd1 vccd1 vssd1 sky130_ef_sc_hd__decap_40_12$1
XFILLER_119_536 vssd1 vccd1 vccd1 vssd1 sky130_fd_sc_hd__fill_2$1
X_0936_ hold18/X hold76/A _0935_/X _0936_/X vccd1 vssd1 vccd1 vssd1 sky130_fd_sc_hd__a21o_1$1
XFILLER_107_709 vssd1 vccd1 vccd1 vssd1 sky130_ef_sc_hd__decap_40_12$1
XFILLER_9_181 vssd1 vccd1 vccd1 vssd1 sky130_ef_sc_hd__decap_40_12$1
XFILLER_134_539 vccd1 vssd1 vccd1 vssd1 sky130_fd_sc_hd__fill_1$1
X_0867_ _0879_/B1 _0867_/X _0866_/X _1687_/Q _0875_/B1 _0864_/X vssd1 vccd1 vccd1
+ vssd1 sky130_fd_sc_hd__a2111o_1$1
XFILLER_115_753 vssd1 vccd1 vccd1 vssd1 sky130_ef_sc_hd__decap_40_12$1
X_0798_ _0798_/X _0906_/B1 _1548_/Q _1644_/Q _0866_/B1 vssd1 vccd1 _0797_/X vccd1
+ vssd1 sky130_fd_sc_hd__a221o_1$1
XFILLER_130_701 vssd1 vccd1 vccd1 vssd1 sky130_ef_sc_hd__decap_40_12$1
XTAP_TAPCELL_ROW_54_1114 vccd1 vssd1 sky130_fd_sc_hd__tapvpwrvgnd_1$1
XTAP_TAPCELL_ROW_54_1103 vccd1 vssd1 sky130_fd_sc_hd__tapvpwrvgnd_1$1
XFILLER_115_797 vssd1 vccd1 vccd1 vssd1 sky130_ef_sc_hd__decap_40_12$1
XFILLER_87_125 vssd1 vccd1 vccd1 vssd1 sky130_ef_sc_hd__decap_40_12$1
XFILLER_87_169 vssd1 vccd1 vccd1 vssd1 sky130_ef_sc_hd__decap_40_12$1
X_1419_ _1435_/C1 _1418_/X _1475_/A2 hold67/X _1736_/D vssd1 vccd1 vccd1 vssd1 sky130_fd_sc_hd__o211a_1$1
XFILLER_130_789 vccd1 vssd1 vccd1 vssd1 sky130_fd_sc_hd__fill_1$1
XFILLER_96_681 vssd1 vccd1 vccd1 vssd1 sky130_ef_sc_hd__decap_40_12$1
XFILLER_68_361 vssd1 vccd1 vccd1 vssd1 sky130_fd_sc_hd__fill_2$1
XFILLER_56_501 vssd1 vccd1 vccd1 vssd1 sky130_ef_sc_hd__decap_40_12$1
XTAP_TAPCELL_ROW_3_346 vccd1 vssd1 sky130_fd_sc_hd__tapvpwrvgnd_1$1
XFILLER_113_57 vssd1 vccd1 vccd1 vssd1 sky130_ef_sc_hd__decap_40_12$1
XFILLER_56_589 vccd1 vssd1 vccd1 vssd1 sky130_fd_sc_hd__fill_1$1
XFILLER_83_397 vssd1 vccd1 vccd1 vssd1 sky130_fd_sc_hd__fill_2$1
XFILLER_73_39 vssd1 vccd1 vccd1 vssd1 sky130_ef_sc_hd__decap_40_12$1
XFILLER_71_559 vccd1 vssd1 vccd1 vssd1 sky130_fd_sc_hd__fill_1$1
XFILLER_37_781 vssd1 vccd1 vccd1 vssd1 sky130_fd_sc_hd__fill_2$1
XFILLER_43_217 vssd1 vccd1 vccd1 vssd1 sky130_fd_sc_hd__fill_4$1
XTAP_TAPCELL_ROW_65_1276 vccd1 vssd1 sky130_fd_sc_hd__tapvpwrvgnd_1$1
XFILLER_51_261 vssd1 vccd1 vccd1 vssd1 sky130_ef_sc_hd__decap_40_12$1
XFILLER_12_637 vssd1 vccd1 vccd1 vssd1 sky130_fd_sc_hd__fill_4$1
XFILLER_24_475 vccd1 vssd1 vccd1 vssd1 sky130_fd_sc_hd__fill_1$1
XFILLER_11_125 vssd1 vccd1 vccd1 vssd1 sky130_ef_sc_hd__decap_40_12$1
XTAP_TAPCELL_ROW_22_632 vccd1 vssd1 sky130_fd_sc_hd__tapvpwrvgnd_1$1
XFILLER_11_169 vssd1 vccd1 vccd1 vssd1 sky130_ef_sc_hd__decap_40_12$1
XFILLER_138_21 vssd1 vccd1 vccd1 vssd1 sky130_fd_sc_hd__fill_4$1
XPHY_EDGE_ROW_129_Right_129 vccd1 vssd1 vccd1 vssd1 sky130_fd_sc_hd__decap_3$1
XFILLER_20_681 vssd1 vccd1 vccd1 vssd1 sky130_ef_sc_hd__decap_40_12$1
XFILLER_22_65 vssd1 vccd1 vccd1 vssd1 sky130_ef_sc_hd__decap_40_12$1
XFILLER_137_399 vssd1 vccd1 vccd1 vssd1 sky130_fd_sc_hd__fill_4$1
XFILLER_118_3 vssd1 vccd1 vccd1 vssd1 sky130_ef_sc_hd__decap_40_12$1
XFILLER_4_825 vssd1 vccd1 vccd1 vssd1 sky130_ef_sc_hd__decap_40_12$1
XFILLER_138_87 vccd1 vssd1 vccd1 vssd1 sky130_fd_sc_hd__fill_1$1
XFILLER_3_335 vccd1 vssd1 vccd1 vssd1 sky130_fd_sc_hd__fill_1$1
XFILLER_133_561 vssd1 vccd1 vccd1 vssd1 sky130_ef_sc_hd__decap_40_12$1
XFILLER_106_753 vssd1 vccd1 vccd1 vssd1 sky130_fd_sc_hd__fill_2$1
XFILLER_79_615 vccd1 vssd1 vccd1 vssd1 sky130_fd_sc_hd__fill_1$1
XFILLER_0_3 vssd1 vccd1 vccd1 vssd1 sky130_ef_sc_hd__decap_40_12$1
XFILLER_120_233 vssd1 vccd1 vccd1 vssd1 sky130_ef_sc_hd__decap_40_12$1
XFILLER_66_309 vssd1 vccd1 vccd1 vssd1 sky130_ef_sc_hd__decap_40_12$1
XFILLER_120_277 vssd1 vccd1 vccd1 vssd1 sky130_ef_sc_hd__decap_40_12$1
XFILLER_75_821 vssd1 vccd1 vccd1 vssd1 sky130_fd_sc_hd__fill_2$1
XFILLER_59_361 vssd1 vccd1 vccd1 vssd1 sky130_ef_sc_hd__decap_40_12$1
XFILLER_47_501 vssd1 vccd1 vccd1 vssd1 sky130_fd_sc_hd__fill_2$1
XFILLER_19_225 vssd1 vccd1 vccd1 vssd1 sky130_ef_sc_hd__decap_40_12$1
XFILLER_47_51 vssd1 vccd1 vccd1 vssd1 sky130_fd_sc_hd__fill_4$1
XFILLER_35_729 vssd1 vccd1 vccd1 vssd1 sky130_ef_sc_hd__decap_40_12$1
XFILLER_28_781 vssd1 vccd1 vccd1 vssd1 sky130_ef_sc_hd__decap_40_12$1
XFILLER_70_581 vssd1 vccd1 vccd1 vssd1 sky130_fd_sc_hd__fill_4$1
XFILLER_30_401 vssd1 vccd1 vccd1 vssd1 sky130_ef_sc_hd__decap_40_12$1
XTAP_TAPCELL_ROW_120_2093 vccd1 vssd1 sky130_fd_sc_hd__tapvpwrvgnd_1$1
XFILLER_15_497 vssd1 vccd1 vccd1 vssd1 sky130_fd_sc_hd__fill_4$1
XFILLER_30_445 vssd1 vccd1 vccd1 vssd1 sky130_ef_sc_hd__decap_40_12$1
XPHY_EDGE_ROW_7_Left_146 vccd1 vssd1 vccd1 vssd1 sky130_fd_sc_hd__decap_3$1
XFILLER_30_489 vssd1 vccd1 vccd1 vssd1 sky130_ef_sc_hd__decap_40_12$1
XFILLER_128_333 vssd1 vccd1 vccd1 vssd1 sky130_ef_sc_hd__decap_40_12$1
XFILLER_7_641 vssd1 vccd1 vccd1 vssd1 sky130_ef_sc_hd__decap_40_12$1
XTAP_TAPCELL_ROW_96_1737 vccd1 vssd1 sky130_fd_sc_hd__tapvpwrvgnd_1$1
XFILLER_7_685 vssd1 vccd1 vccd1 vssd1 sky130_ef_sc_hd__decap_40_12$1
XFILLER_6_195 vccd1 vssd1 vccd1 vssd1 sky130_fd_sc_hd__fill_1$1
XFILLER_112_701 vssd1 vccd1 vccd1 vssd1 sky130_ef_sc_hd__decap_40_12$1
XFILLER_97_412 vssd1 vccd1 vccd1 vssd1 sky130_ef_sc_hd__decap_40_12$1
XFILLER_69_125 vssd1 vccd1 vccd1 vssd1 sky130_ef_sc_hd__decap_40_12$1
XFILLER_33_3 vssd1 vccd1 vccd1 vssd1 sky130_ef_sc_hd__decap_40_12$1
XTAP_TAPCELL_ROW_127_2203 vccd1 vssd1 sky130_fd_sc_hd__tapvpwrvgnd_1$1
XFILLER_111_277 vssd1 vccd1 vccd1 vssd1 sky130_fd_sc_hd__fill_2$1
XFILLER_97_489 vssd1 vccd1 vccd1 vssd1 sky130_ef_sc_hd__decap_40_12$1
XFILLER_85_629 vssd1 vccd1 vccd1 vssd1 sky130_ef_sc_hd__decap_40_12$1
XFILLER_78_681 vssd1 vccd1 vccd1 vssd1 sky130_ef_sc_hd__decap_40_12$1
XFILLER_69_169 vssd1 vccd1 vccd1 vssd1 sky130_ef_sc_hd__decap_40_12$1
XFILLER_38_501 vssd1 vccd1 vccd1 vssd1 sky130_ef_sc_hd__decap_40_12$1
X_1204_ _1204_/A _1204_/X _1210_/B vssd1 vccd1 vccd1 vssd1 sky130_fd_sc_hd__or2_1$1
XFILLER_84_139 vccd1 vssd1 vccd1 vssd1 sky130_fd_sc_hd__fill_1$1
XFILLER_38_545 vssd1 vccd1 vccd1 vssd1 sky130_fd_sc_hd__fill_8$1
X_1135_ _1437_/C1 _1134_/X _1145_/A2 hold83/X _1599_/D vssd1 vccd1 vccd1 vssd1 sky130_fd_sc_hd__o211a_1$1
XFILLER_93_673 vssd1 vccd1 vccd1 vssd1 sky130_ef_sc_hd__decap_40_12$1
XFILLER_80_301 vssd1 vccd1 vccd1 vssd1 sky130_fd_sc_hd__fill_4$1
Xclkbuf_0_wb_clk_i clkbuf_0_wb_clk_i/X wb_clk_i vssd1 vccd1 vccd1 vssd1 sky130_fd_sc_hd__clkbuf_16$1
XTAP_TAPCELL_ROW_0_305 vccd1 vssd1 sky130_fd_sc_hd__tapvpwrvgnd_1$1
XFILLER_38_589 vssd1 vccd1 vccd1 vssd1 sky130_ef_sc_hd__decap_40_12$1
XFILLER_19_781 vssd1 vccd1 vccd1 vssd1 sky130_fd_sc_hd__fill_2$1
XFILLER_25_217 vssd1 vccd1 vccd1 vssd1 sky130_fd_sc_hd__fill_4$1
X_1066_ _1066_/A _1066_/X _1066_/B vssd1 vccd1 vccd1 vssd1 sky130_fd_sc_hd__or2_1$1
XFILLER_80_345 vssd1 vccd1 vccd1 vssd1 sky130_ef_sc_hd__decap_40_12$1
XTAP_TAPCELL_ROW_105_1877 vccd1 vssd1 sky130_fd_sc_hd__tapvpwrvgnd_1$1
XFILLER_33_261 vssd1 vccd1 vccd1 vssd1 sky130_ef_sc_hd__decap_40_12$1
XFILLER_40_209 vssd1 vccd1 vccd1 vssd1 sky130_ef_sc_hd__decap_40_12$1
XFILLER_21_445 vssd1 vccd1 vccd1 vssd1 sky130_fd_sc_hd__fill_2$1
XTAP_TAPCELL_ROW_138_2365 vccd1 vssd1 sky130_fd_sc_hd__tapvpwrvgnd_1$1
XTAP_TAPCELL_ROW_138_2387 vccd1 vssd1 sky130_fd_sc_hd__tapvpwrvgnd_1$1
XTAP_TAPCELL_ROW_138_2376 vccd1 vssd1 sky130_fd_sc_hd__tapvpwrvgnd_1$1
XFILLER_119_333 vssd1 vccd1 vccd1 vssd1 sky130_fd_sc_hd__fill_2$1
XTAP_TAPCELL_ROW_60_1195 vccd1 vssd1 sky130_fd_sc_hd__tapvpwrvgnd_1$1
XFILLER_135_837 vssd1 vccd1 vccd1 vssd1 sky130_fd_sc_hd__fill_2$1
X_0919_ _0919_/X _1015_/A _1600_/Q _1568_/Q hold10/A vssd1 vccd1 _0917_/X vccd1 vssd1
+ sky130_fd_sc_hd__a221o_1$1
XFILLER_134_325 vccd1 vssd1 vccd1 vssd1 sky130_fd_sc_hd__fill_1$1
XTAP_TAPCELL_ROW_8_427 vccd1 vssd1 sky130_fd_sc_hd__tapvpwrvgnd_1$1
XTAP_TAPCELL_ROW_8_416 vccd1 vssd1 sky130_fd_sc_hd__tapvpwrvgnd_1$1
XFILLER_1_839 vccd1 vssd1 vccd1 vssd1 sky130_fd_sc_hd__fill_1$1
XFILLER_102_233 vssd1 vccd1 vccd1 vssd1 sky130_ef_sc_hd__decap_40_12$1
XFILLER_0_349 vssd1 vccd1 vccd1 vssd1 sky130_fd_sc_hd__fill_8$1
XFILLER_130_564 vssd1 vccd1 vccd1 vssd1 sky130_fd_sc_hd__fill_8$1
XFILLER_102_277 vssd1 vccd1 vccd1 vssd1 sky130_ef_sc_hd__decap_40_12$1
XFILLER_88_489 vssd1 vccd1 vccd1 vssd1 sky130_ef_sc_hd__decap_40_12$1
XFILLER_29_501 vssd1 vccd1 vccd1 vssd1 sky130_fd_sc_hd__fill_2$1
XFILLER_48_309 vssd1 vccd1 vccd1 vssd1 sky130_ef_sc_hd__decap_40_12$1
XFILLER_84_27 vccd1 vssd1 vccd1 vssd1 sky130_fd_sc_hd__fill_1$1
XFILLER_90_109 vssd1 vccd1 vccd1 vssd1 sky130_ef_sc_hd__decap_40_12$1
XTAP_TAPCELL_ROW_67_1305 vccd1 vssd1 sky130_fd_sc_hd__tapvpwrvgnd_1$1
XFILLER_17_729 vssd1 vccd1 vccd1 vssd1 sky130_ef_sc_hd__decap_40_12$1
XTAP_TAPCELL_ROW_27_702 vccd1 vssd1 sky130_fd_sc_hd__tapvpwrvgnd_1$1
XFILLER_83_161 vssd1 vccd1 vccd1 vssd1 sky130_fd_sc_hd__fill_4$1
XTAP_TAPCELL_ROW_80_1505 vccd1 vssd1 sky130_fd_sc_hd__tapvpwrvgnd_1$1
XFILLER_71_389 vssd1 vccd1 vccd1 vssd1 sky130_fd_sc_hd__fill_2$1
XFILLER_52_581 vssd1 vccd1 vccd1 vssd1 sky130_fd_sc_hd__fill_4$1
XFILLER_12_401 vssd1 vccd1 vccd1 vssd1 sky130_ef_sc_hd__decap_40_12$1
XFILLER_40_710 vssd1 vccd1 vccd1 vssd1 sky130_ef_sc_hd__decap_40_12$1
XFILLER_12_445 vssd1 vccd1 vccd1 vssd1 sky130_ef_sc_hd__decap_40_12$1
XFILLER_40_754 vssd1 vccd1 vccd1 vssd1 sky130_fd_sc_hd__fill_2$1
XFILLER_12_489 vssd1 vccd1 vccd1 vssd1 sky130_ef_sc_hd__decap_40_12$1
XFILLER_137_163 vssd1 vccd1 vccd1 vssd1 sky130_fd_sc_hd__fill_4$1
XTAP_TAPCELL_ROW_78_1467 vccd1 vssd1 sky130_fd_sc_hd__tapvpwrvgnd_1$1
XFILLER_98_209 vssd1 vccd1 vccd1 vssd1 sky130_ef_sc_hd__decap_40_12$1
XFILLER_106_583 vssd1 vccd1 vccd1 vssd1 sky130_fd_sc_hd__fill_4$1
XFILLER_4_699 vccd1 vssd1 vccd1 vssd1 sky130_fd_sc_hd__fill_1$1
XFILLER_3_165 vssd1 vccd1 vccd1 vssd1 sky130_fd_sc_hd__fill_2$1
XTAP_TAPCELL_ROW_91_1667 vccd1 vssd1 sky130_fd_sc_hd__tapvpwrvgnd_1$1
XFILLER_58_83 vccd1 vssd1 vccd1 vssd1 sky130_fd_sc_hd__fill_1$1
Xhold5 hold5/A hold5/X vssd1 vccd1 vccd1 vssd1 sky130_fd_sc_hd__dlygate4sd3_1$1
XFILLER_121_597 vssd1 vccd1 vccd1 vssd1 sky130_fd_sc_hd__fill_8$1
XFILLER_66_139 vccd1 vssd1 vccd1 vssd1 sky130_fd_sc_hd__fill_1$1
XFILLER_48_832 vssd1 vccd1 vccd1 vssd1 sky130_fd_sc_hd__fill_8$1
XFILLER_81_109 vssd1 vccd1 vccd1 vssd1 sky130_fd_sc_hd__fill_2$1
XTAP_TAPCELL_ROW_122_2133 vccd1 vssd1 sky130_fd_sc_hd__tapvpwrvgnd_1$1
XFILLER_62_301 vssd1 vccd1 vccd1 vssd1 sky130_fd_sc_hd__fill_4$1
XFILLER_90_665 vssd1 vccd1 vccd1 vssd1 sky130_fd_sc_hd__fill_2$1
XFILLER_90_643 vccd1 vssd1 vccd1 vssd1 sky130_fd_sc_hd__fill_1$1
XFILLER_62_345 vssd1 vccd1 vccd1 vssd1 sky130_ef_sc_hd__decap_40_12$1
XFILLER_35_559 vccd1 vssd1 vccd1 vssd1 sky130_fd_sc_hd__fill_1$1
XFILLER_90_698 vssd1 vccd1 vccd1 vssd1 sky130_fd_sc_hd__fill_2$1
XFILLER_15_261 vssd1 vccd1 vccd1 vssd1 sky130_ef_sc_hd__decap_40_12$1
XFILLER_22_209 vssd1 vccd1 vccd1 vssd1 sky130_ef_sc_hd__decap_40_12$1
XFILLER_31_721 vssd1 vccd1 vccd1 vssd1 sky130_fd_sc_hd__fill_4$1
XFILLER_90_81 vssd1 vccd1 vccd1 vssd1 sky130_fd_sc_hd__fill_2$1
X_1822_ vccd1 vssd1 _1822_/X _1822_/A vccd1 vssd1 sky130_fd_sc_hd__buf_2$1
XFILLER_30_253 vssd1 vccd1 vccd1 vssd1 sky130_ef_sc_hd__decap_40_12$1
XFILLER_31_765 vssd1 vccd1 vccd1 vssd1 sky130_ef_sc_hd__decap_40_12$1
XFILLER_129_653 vssd1 vccd1 vccd1 vssd1 sky130_ef_sc_hd__decap_40_12$1
XTAP_TAPCELL_ROW_100_1796 vccd1 vssd1 sky130_fd_sc_hd__tapvpwrvgnd_1$1
XFILLER_128_141 vssd1 vccd1 vccd1 vssd1 sky130_ef_sc_hd__decap_40_12$1
XFILLER_117_804 vssd1 vccd1 vccd1 vssd1 sky130_ef_sc_hd__decap_40_12$1
X_1753_ _1753_/Q _1753_/CLK _1753_/D vccd1 vssd1 vccd1 vssd1 sky130_fd_sc_hd__dfxtp_1$1
XTAP_TAPCELL_ROW_13_495 vccd1 vssd1 sky130_fd_sc_hd__tapvpwrvgnd_1$1
XFILLER_129_697 vssd1 vccd1 vccd1 vssd1 sky130_ef_sc_hd__decap_40_12$1
X_1684_ _1684_/Q clkload5/A _1684_/D vccd1 vssd1 vccd1 vssd1 sky130_fd_sc_hd__dfxtp_1$1
XTAP_TAPCELL_ROW_133_2295 vccd1 vssd1 sky130_fd_sc_hd__tapvpwrvgnd_1$1
XFILLER_131_317 vssd1 vccd1 vccd1 vssd1 sky130_ef_sc_hd__decap_40_12$1
XFILLER_112_531 vccd1 vssd1 vccd1 vssd1 sky130_fd_sc_hd__fill_1$1
XFILLER_98_743 vssd1 vccd1 vccd1 vssd1 sky130_ef_sc_hd__decap_40_12$1
XFILLER_100_737 vssd1 vccd1 vccd1 vssd1 sky130_ef_sc_hd__decap_40_12$1
XTAP_TAPCELL_ROW_107_1906 vccd1 vssd1 sky130_fd_sc_hd__tapvpwrvgnd_1$1
XFILLER_72_109 vssd1 vccd1 vccd1 vssd1 sky130_ef_sc_hd__decap_40_12$1
XFILLER_54_813 vssd1 vccd1 vccd1 vssd1 sky130_fd_sc_hd__fill_8$1
XFILLER_65_161 vssd1 vccd1 vccd1 vssd1 sky130_fd_sc_hd__fill_4$1
XTAP_TAPCELL_ROW_49_1035 vccd1 vssd1 sky130_fd_sc_hd__tapvpwrvgnd_1$1
X_1118_ _1809_/A _1118_/X _1122_/B vssd1 vccd1 vccd1 vssd1 sky130_fd_sc_hd__or2_1$1
X_1049_ _0739_/D _1048_/X _1079_/A2 hold32/X _1557_/D vssd1 vccd1 vccd1 vssd1 sky130_fd_sc_hd__o211a_1$1
XFILLER_80_153 vssd1 vccd1 vccd1 vssd1 sky130_ef_sc_hd__decap_40_12$1
XFILLER_53_389 vssd1 vccd1 vccd1 vssd1 sky130_fd_sc_hd__fill_2$1
XFILLER_41_529 vssd1 vccd1 vccd1 vssd1 sky130_fd_sc_hd__fill_8$1
XFILLER_80_197 vssd1 vccd1 vccd1 vssd1 sky130_ef_sc_hd__decap_40_12$1
XTAP_TAPCELL_ROW_62_1235 vccd1 vssd1 sky130_fd_sc_hd__tapvpwrvgnd_1$1
XTAP_TAPCELL_ROW_62_1224 vccd1 vssd1 sky130_fd_sc_hd__tapvpwrvgnd_1$1
XFILLER_34_581 vssd1 vccd1 vccd1 vssd1 sky130_fd_sc_hd__fill_4$1
XFILLER_70_29 vssd1 vccd1 vccd1 vssd1 sky130_ef_sc_hd__decap_40_12$1
XTAP_TAPCELL_ROW_32_782 vccd1 vssd1 sky130_fd_sc_hd__tapvpwrvgnd_1$1
XFILLER_79_27 vssd1 vccd1 vccd1 vssd1 sky130_ef_sc_hd__decap_40_12$1
XFILLER_134_133 vssd1 vccd1 vccd1 vssd1 sky130_fd_sc_hd__fill_4$1
XFILLER_134_177 vssd1 vccd1 vccd1 vssd1 sky130_ef_sc_hd__decap_40_12$1
XFILLER_89_721 vssd1 vccd1 vccd1 vssd1 sky130_fd_sc_hd__fill_4$1
XPHY_EDGE_ROW_79_Left_218 vccd1 vssd1 vccd1 vssd1 sky130_fd_sc_hd__decap_3$1
XFILLER_135_55 vccd1 vssd1 vccd1 vssd1 sky130_fd_sc_hd__fill_1$1
XFILLER_115_391 vccd1 vssd1 vccd1 vssd1 sky130_fd_sc_hd__fill_1$1
XFILLER_89_765 vssd1 vccd1 vccd1 vssd1 sky130_ef_sc_hd__decap_40_12$1
XFILLER_0_113 vssd1 vccd1 vccd1 vssd1 sky130_ef_sc_hd__decap_40_12$1
XFILLER_1_669 vssd1 vccd1 vccd1 vssd1 sky130_fd_sc_hd__fill_2$1
XFILLER_130_361 vssd1 vccd1 vccd1 vssd1 sky130_fd_sc_hd__fill_2$1
XFILLER_95_15 vssd1 vccd1 vccd1 vssd1 sky130_ef_sc_hd__decap_40_12$1
XFILLER_88_253 vssd1 vccd1 vccd1 vssd1 sky130_ef_sc_hd__decap_40_12$1
XTAP_TAPCELL_ROW_73_1397 vccd1 vssd1 sky130_fd_sc_hd__tapvpwrvgnd_1$1
XFILLER_0_157 vssd1 vccd1 vccd1 vssd1 sky130_fd_sc_hd__fill_2$1
XFILLER_103_597 vssd1 vccd1 vccd1 vssd1 sky130_ef_sc_hd__decap_40_12$1
XFILLER_48_139 vccd1 vssd1 vccd1 vssd1 sky130_fd_sc_hd__fill_1$1
XFILLER_63_109 vssd1 vccd1 vccd1 vssd1 sky130_fd_sc_hd__fill_2$1
XFILLER_57_673 vssd1 vccd1 vccd1 vssd1 sky130_fd_sc_hd__fill_8$1
XFILLER_28_53 vssd1 vccd1 vccd1 vssd1 sky130_ef_sc_hd__decap_40_12$1
XFILLER_91_429 vssd1 vccd1 vccd1 vssd1 sky130_ef_sc_hd__decap_40_12$1
XFILLER_28_97 vssd1 vccd1 vccd1 vssd1 sky130_ef_sc_hd__decap_40_12$1
XFILLER_44_301 vssd1 vccd1 vccd1 vssd1 sky130_fd_sc_hd__fill_4$1
XFILLER_60_805 vssd1 vccd1 vccd1 vssd1 sky130_fd_sc_hd__fill_4$1
XFILLER_17_559 vccd1 vssd1 vccd1 vssd1 sky130_fd_sc_hd__fill_1$1
XFILLER_44_345 vssd1 vccd1 vccd1 vssd1 sky130_ef_sc_hd__decap_40_12$1
XPHY_EDGE_ROW_88_Left_227 vccd1 vssd1 vccd1 vssd1 sky130_fd_sc_hd__decap_3$1
XFILLER_32_529 vssd1 vccd1 vccd1 vssd1 sky130_fd_sc_hd__fill_2$1
XFILLER_44_41 vssd1 vccd1 vccd1 vssd1 sky130_ef_sc_hd__decap_40_12$1
XFILLER_44_389 vssd1 vccd1 vccd1 vssd1 sky130_ef_sc_hd__decap_40_12$1
XFILLER_13_721 vssd1 vccd1 vccd1 vssd1 sky130_fd_sc_hd__fill_4$1
XFILLER_44_85 vssd1 vccd1 vccd1 vssd1 sky130_ef_sc_hd__decap_40_12$1
XFILLER_12_253 vssd1 vccd1 vccd1 vssd1 sky130_ef_sc_hd__decap_40_12$1
XFILLER_9_725 vssd1 vccd1 vccd1 vssd1 sky130_fd_sc_hd__fill_2$1
XFILLER_13_765 vssd1 vccd1 vccd1 vssd1 sky130_ef_sc_hd__decap_40_12$1
XFILLER_126_601 vssd1 vccd1 vccd1 vssd1 sky130_fd_sc_hd__fill_2$1
XTAP_TAPCELL_ROW_10_443 vccd1 vssd1 sky130_fd_sc_hd__tapvpwrvgnd_1$1
XFILLER_125_111 vccd1 vssd1 vccd1 vssd1 sky130_fd_sc_hd__fill_1$1
XTAP_TAPCELL_ROW_10_454 vccd1 vssd1 sky130_fd_sc_hd__tapvpwrvgnd_1$1
XPHY_EDGE_ROW_97_Left_236 vccd1 vssd1 vccd1 vssd1 sky130_fd_sc_hd__decap_3$1
XFILLER_113_317 vssd1 vccd1 vccd1 vssd1 sky130_ef_sc_hd__decap_40_12$1
XFILLER_5_57 vssd1 vccd1 vccd1 vssd1 sky130_ef_sc_hd__decap_40_12$1
XFILLER_69_93 vssd1 vccd1 vccd1 vssd1 sky130_ef_sc_hd__decap_40_12$1
XFILLER_121_361 vssd1 vccd1 vccd1 vssd1 sky130_fd_sc_hd__fill_2$1
XFILLER_95_713 vccd1 vssd1 vccd1 vssd1 sky130_fd_sc_hd__fill_1$1
XFILLER_94_245 vssd1 vccd1 vccd1 vssd1 sky130_fd_sc_hd__fill_4$1
XFILLER_54_109 vssd1 vccd1 vccd1 vssd1 sky130_ef_sc_hd__decap_40_12$1
XFILLER_36_802 vssd1 vccd1 vccd1 vssd1 sky130_fd_sc_hd__fill_8$1
XFILLER_36_813 vssd1 vccd1 vccd1 vssd1 sky130_ef_sc_hd__decap_40_12$1
XFILLER_94_289 vssd1 vccd1 vccd1 vssd1 sky130_ef_sc_hd__decap_40_12$1
XFILLER_85_81 vssd1 vccd1 vccd1 vssd1 sky130_ef_sc_hd__decap_40_12$1
XFILLER_47_161 vssd1 vccd1 vccd1 vssd1 sky130_fd_sc_hd__fill_4$1
XFILLER_51_805 vssd1 vccd1 vccd1 vssd1 sky130_fd_sc_hd__fill_2$1
XFILLER_90_473 vssd1 vccd1 vccd1 vssd1 sky130_fd_sc_hd__fill_2$1
XFILLER_62_153 vssd1 vccd1 vccd1 vssd1 sky130_ef_sc_hd__decap_40_12$1
XTAP_TAPCELL_ROW_18_565 vccd1 vssd1 sky130_fd_sc_hd__tapvpwrvgnd_1$1
XTAP_TAPCELL_ROW_18_576 vccd1 vssd1 sky130_fd_sc_hd__tapvpwrvgnd_1$1
XFILLER_23_529 vssd1 vccd1 vccd1 vssd1 sky130_ef_sc_hd__decap_40_12$1
XFILLER_35_389 vssd1 vccd1 vccd1 vssd1 sky130_fd_sc_hd__fill_2$1
XTAP_TAPCELL_ROW_102_1836 vccd1 vssd1 sky130_fd_sc_hd__tapvpwrvgnd_1$1
XTAP_TAPCELL_ROW_102_1825 vccd1 vssd1 sky130_fd_sc_hd__tapvpwrvgnd_1$1
XFILLER_62_197 vssd1 vccd1 vccd1 vssd1 sky130_ef_sc_hd__decap_40_12$1
XFILLER_16_581 vssd1 vccd1 vccd1 vssd1 sky130_fd_sc_hd__fill_4$1
XFILLER_31_573 vssd1 vccd1 vccd1 vssd1 sky130_ef_sc_hd__decap_40_12$1
XTAP_TAPCELL_ROW_135_2324 vccd1 vssd1 sky130_fd_sc_hd__tapvpwrvgnd_1$1
XFILLER_129_461 vssd1 vccd1 vccd1 vssd1 sky130_ef_sc_hd__decap_40_12$1
X_1805_ _1805_/A _1805_/X vssd1 vccd1 vccd1 vssd1 sky130_fd_sc_hd__clkbuf_2$1
XFILLER_117_623 vssd1 vccd1 vccd1 vssd1 sky130_ef_sc_hd__decap_40_12$1
X_1736_ _1844_/A _1736_/CLK _1736_/D vccd1 vssd1 vccd1 vssd1 sky130_fd_sc_hd__dfxtp_1$1
Xhold202 _1675_/Q _1292_/A vssd1 vccd1 vccd1 vssd1 sky130_fd_sc_hd__dlygate4sd3_1$1
XFILLER_116_133 vssd1 vccd1 vccd1 vssd1 sky130_fd_sc_hd__fill_4$1
Xhold213 _1559_/Q _1052_/A vssd1 vccd1 vccd1 vssd1 sky130_fd_sc_hd__dlygate4sd3_1$1
XFILLER_116_177 vssd1 vccd1 vccd1 vssd1 sky130_ef_sc_hd__decap_40_12$1
X_1667_ _1667_/Q _1763_/CLK _1667_/D vccd1 vssd1 vccd1 vssd1 sky130_fd_sc_hd__dfxtp_1$1
XFILLER_131_125 vssd1 vccd1 vccd1 vssd1 sky130_ef_sc_hd__decap_40_12$1
X_1598_ _1598_/Q _1759_/CLK _1598_/D vccd1 vssd1 vccd1 vssd1 sky130_fd_sc_hd__dfxtp_1$1
XFILLER_98_551 vssd1 vccd1 vccd1 vssd1 sky130_fd_sc_hd__fill_8$1
XFILLER_131_169 vssd1 vccd1 vccd1 vssd1 sky130_ef_sc_hd__decap_40_12$1
XTAP_TAPCELL_ROW_113_1998 vccd1 vssd1 sky130_fd_sc_hd__tapvpwrvgnd_1$1
XFILLER_112_361 vssd1 vccd1 vccd1 vssd1 sky130_fd_sc_hd__fill_2$1
XFILLER_100_501 vssd1 vccd1 vccd1 vssd1 sky130_ef_sc_hd__decap_40_12$1
XFILLER_86_713 vssd1 vccd1 vccd1 vssd1 sky130_ef_sc_hd__decap_40_12$1
XFILLER_100_523 vccd1 vssd1 vccd1 vssd1 sky130_fd_sc_hd__fill_1$1
XFILLER_86_757 vssd1 vccd1 vccd1 vssd1 sky130_ef_sc_hd__decap_40_12$1
XFILLER_85_223 vccd1 vssd1 vccd1 vssd1 sky130_fd_sc_hd__fill_1$1
XFILLER_105_69 vssd1 vccd1 vccd1 vssd1 sky130_ef_sc_hd__decap_40_12$1
XFILLER_66_481 vssd1 vccd1 vccd1 vssd1 sky130_fd_sc_hd__fill_2$1
XFILLER_26_301 vssd1 vccd1 vccd1 vssd1 sky130_fd_sc_hd__fill_4$1
XFILLER_39_673 vssd1 vccd1 vccd1 vssd1 sky130_ef_sc_hd__decap_40_12$1
XFILLER_45_109 vssd1 vccd1 vccd1 vssd1 sky130_fd_sc_hd__fill_2$1
XFILLER_26_345 vssd1 vccd1 vccd1 vssd1 sky130_ef_sc_hd__decap_40_12$1
XTAP_TAPCELL_ROW_37_852 vccd1 vssd1 sky130_fd_sc_hd__tapvpwrvgnd_1$1
XFILLER_121_57 vssd1 vccd1 vccd1 vssd1 sky130_ef_sc_hd__decap_40_12$1
XFILLER_81_473 vssd1 vccd1 vccd1 vssd1 sky130_ef_sc_hd__decap_40_12$1
XFILLER_14_529 vssd1 vccd1 vccd1 vssd1 sky130_fd_sc_hd__fill_2$1
XFILLER_26_389 vssd1 vccd1 vccd1 vssd1 sky130_ef_sc_hd__decap_40_12$1
XFILLER_81_39 vssd1 vccd1 vccd1 vssd1 sky130_ef_sc_hd__decap_40_12$1
XFILLER_41_337 vssd1 vccd1 vccd1 vssd1 sky130_ef_sc_hd__decap_40_12$1
XFILLER_10_713 vssd1 vccd1 vccd1 vssd1 sky130_ef_sc_hd__decap_40_12$1
XFILLER_14_77 vssd1 vccd1 vccd1 vssd1 sky130_fd_sc_hd__fill_4$1
XFILLER_10_757 vssd1 vccd1 vccd1 vssd1 sky130_ef_sc_hd__decap_40_12$1
XFILLER_107_111 vccd1 vssd1 vccd1 vssd1 sky130_fd_sc_hd__fill_1$1
XFILLER_5_205 vssd1 vccd1 vccd1 vssd1 sky130_ef_sc_hd__decap_40_12$1
XTAP_TAPCELL_ROW_75_1426 vccd1 vssd1 sky130_fd_sc_hd__tapvpwrvgnd_1$1
XFILLER_5_249 vssd1 vccd1 vccd1 vssd1 sky130_ef_sc_hd__decap_40_12$1
XFILLER_30_65 vssd1 vccd1 vccd1 vssd1 sky130_ef_sc_hd__decap_40_12$1
XFILLER_123_637 vssd1 vccd1 vccd1 vssd1 sky130_ef_sc_hd__decap_40_12$1
XFILLER_100_3 vssd1 vccd1 vccd1 vssd1 sky130_ef_sc_hd__decap_40_12$1
XFILLER_110_309 vssd1 vccd1 vccd1 vssd1 sky130_ef_sc_hd__decap_40_12$1
XFILLER_103_361 vssd1 vccd1 vccd1 vssd1 sky130_ef_sc_hd__decap_40_12$1
XFILLER_76_245 vssd1 vccd1 vccd1 vssd1 sky130_fd_sc_hd__fill_4$1
XFILLER_76_289 vssd1 vccd1 vccd1 vssd1 sky130_ef_sc_hd__decap_40_12$1
XFILLER_64_429 vssd1 vccd1 vccd1 vssd1 sky130_fd_sc_hd__fill_2$1
XFILLER_57_481 vssd1 vccd1 vccd1 vssd1 sky130_fd_sc_hd__fill_2$1
XFILLER_18_813 vssd1 vccd1 vccd1 vssd1 sky130_fd_sc_hd__fill_8$1
XFILLER_29_161 vssd1 vccd1 vccd1 vssd1 sky130_fd_sc_hd__fill_4$1
XFILLER_36_109 vssd1 vccd1 vccd1 vssd1 sky130_ef_sc_hd__decap_40_12$1
XFILLER_91_237 vssd1 vccd1 vccd1 vssd1 sky130_ef_sc_hd__decap_40_12$1
XFILLER_55_51 vssd1 vccd1 vccd1 vssd1 sky130_fd_sc_hd__fill_4$1
XTAP_TAPCELL_ROW_86_1588 vccd1 vssd1 sky130_fd_sc_hd__tapvpwrvgnd_1$1
XFILLER_72_473 vssd1 vccd1 vccd1 vssd1 sky130_fd_sc_hd__fill_2$1
XFILLER_60_613 vssd1 vccd1 vccd1 vssd1 sky130_ef_sc_hd__decap_40_12$1
XFILLER_17_389 vssd1 vccd1 vccd1 vssd1 sky130_fd_sc_hd__fill_2$1
XFILLER_44_153 vssd1 vccd1 vccd1 vssd1 sky130_ef_sc_hd__decap_40_12$1
XFILLER_60_635 vccd1 vssd1 vccd1 vssd1 sky130_fd_sc_hd__fill_1$1
XTAP_TAPCELL_ROW_15_524 vccd1 vssd1 sky130_fd_sc_hd__tapvpwrvgnd_1$1
XFILLER_44_197 vssd1 vccd1 vccd1 vssd1 sky130_ef_sc_hd__decap_40_12$1
XFILLER_60_679 vssd1 vccd1 vccd1 vssd1 sky130_fd_sc_hd__fill_2$1
XFILLER_13_573 vssd1 vccd1 vccd1 vssd1 sky130_ef_sc_hd__decap_40_12$1
XFILLER_118_409 vssd1 vccd1 vccd1 vssd1 sky130_fd_sc_hd__fill_4$1
XTAP_TAPCELL_ROW_117_2054 vccd1 vssd1 sky130_fd_sc_hd__tapvpwrvgnd_1$1
XFILLER_126_453 vssd1 vccd1 vccd1 vssd1 sky130_fd_sc_hd__fill_4$1
XFILLER_126_431 vccd1 vssd1 vccd1 vssd1 sky130_fd_sc_hd__fill_1$1
XTAP_TAPCELL_ROW_130_2243 vccd1 vssd1 sky130_fd_sc_hd__tapvpwrvgnd_1$1
X_1521_ _1521_/Q _1740_/CLK _1521_/D vccd1 vssd1 vccd1 vssd1 sky130_fd_sc_hd__dfxtp_1$1
XFILLER_5_783 vccd1 vssd1 vccd1 vssd1 sky130_fd_sc_hd__fill_1$1
XTAP_TAPCELL_ROW_130_2254 vccd1 vssd1 sky130_fd_sc_hd__tapvpwrvgnd_1$1
XFILLER_113_125 vssd1 vccd1 vccd1 vssd1 sky130_ef_sc_hd__decap_40_12$1
XFILLER_99_337 vssd1 vccd1 vccd1 vssd1 sky130_ef_sc_hd__decap_40_12$1
X_1452_ _1452_/A _1452_/X _1464_/B vssd1 vccd1 vccd1 vssd1 sky130_fd_sc_hd__or2_1$1
XFILLER_113_169 vssd1 vccd1 vccd1 vssd1 sky130_ef_sc_hd__decap_40_12$1
XFILLER_110_810 vssd1 vccd1 vccd1 vssd1 sky130_fd_sc_hd__fill_2$1
XFILLER_68_713 vssd1 vccd1 vccd1 vssd1 sky130_fd_sc_hd__fill_8$1
XFILLER_122_681 vssd1 vccd1 vccd1 vssd1 sky130_ef_sc_hd__decap_40_12$1
XFILLER_95_543 vssd1 vccd1 vccd1 vssd1 sky130_ef_sc_hd__decap_40_12$1
X_1383_ _1443_/C1 _1382_/X _1399_/A2 hold98/X _1719_/D vssd1 vccd1 vccd1 vssd1 sky130_fd_sc_hd__o211a_1$1
XFILLER_68_757 vssd1 vccd1 vccd1 vssd1 sky130_ef_sc_hd__decap_40_12$1
XFILLER_67_223 vccd1 vssd1 vccd1 vssd1 sky130_fd_sc_hd__fill_1$1
XFILLER_27_109 vssd1 vccd1 vccd1 vssd1 sky130_fd_sc_hd__fill_2$1
XFILLER_36_643 vccd1 vssd1 vccd1 vssd1 sky130_fd_sc_hd__fill_1$1
XFILLER_63_473 vssd1 vccd1 vccd1 vssd1 sky130_fd_sc_hd__fill_8$1
XFILLER_91_793 vssd1 vccd1 vccd1 vssd1 sky130_ef_sc_hd__decap_40_12$1
XFILLER_51_646 vssd1 vccd1 vccd1 vssd1 sky130_ef_sc_hd__decap_40_12$1
XFILLER_23_337 vssd1 vccd1 vccd1 vssd1 sky130_ef_sc_hd__decap_40_12$1
XTAP_TAPCELL_ROW_34_811 vccd1 vssd1 sky130_fd_sc_hd__tapvpwrvgnd_1$1
XFILLER_50_189 vssd1 vccd1 vccd1 vssd1 sky130_fd_sc_hd__fill_4$1
XFILLER_137_729 vssd1 vccd1 vccd1 vssd1 sky130_ef_sc_hd__decap_40_12$1
XFILLER_137_707 vssd1 vccd1 vccd1 vssd1 sky130_fd_sc_hd__fill_8$1
XFILLER_117_453 vccd1 vssd1 vccd1 vssd1 sky130_fd_sc_hd__fill_1$1
XFILLER_3_709 vssd1 vccd1 vccd1 vssd1 sky130_ef_sc_hd__decap_40_12$1
X_1719_ _1719_/Q _1719_/CLK _1719_/D vccd1 vssd1 vccd1 vssd1 sky130_fd_sc_hd__dfxtp_1$1
XTAP_TAPCELL_ROW_57_1156 vccd1 vssd1 sky130_fd_sc_hd__tapvpwrvgnd_1$1
XFILLER_132_489 vssd1 vccd1 vccd1 vssd1 sky130_ef_sc_hd__decap_40_12$1
XFILLER_59_713 vssd1 vccd1 vccd1 vssd1 sky130_ef_sc_hd__decap_40_12$1
XFILLER_86_510 vssd1 vccd1 vccd1 vssd1 sky130_ef_sc_hd__decap_40_12$1
XTAP_TAPCELL_ROW_70_1356 vccd1 vssd1 sky130_fd_sc_hd__tapvpwrvgnd_1$1
XTAP_TAPCELL_ROW_70_1345 vccd1 vssd1 sky130_fd_sc_hd__tapvpwrvgnd_1$1
XFILLER_58_245 vssd1 vccd1 vccd1 vssd1 sky130_fd_sc_hd__fill_4$1
XFILLER_86_587 vccd1 vssd1 vccd1 vssd1 sky130_fd_sc_hd__fill_1$1
XFILLER_58_289 vssd1 vccd1 vccd1 vssd1 sky130_ef_sc_hd__decap_40_12$1
XFILLER_18_109 vssd1 vccd1 vccd1 vssd1 sky130_ef_sc_hd__decap_40_12$1
XFILLER_92_27 vccd1 vssd1 vccd1 vssd1 sky130_fd_sc_hd__fill_1$1
XFILLER_73_237 vssd1 vccd1 vccd1 vssd1 sky130_ef_sc_hd__decap_40_12$1
XFILLER_26_153 vssd1 vccd1 vccd1 vssd1 sky130_ef_sc_hd__decap_40_12$1
XFILLER_42_613 vssd1 vccd1 vccd1 vssd1 sky130_ef_sc_hd__decap_40_12$1
XFILLER_81_281 vssd1 vccd1 vccd1 vssd1 sky130_ef_sc_hd__decap_40_12$1
XFILLER_26_197 vssd1 vccd1 vccd1 vssd1 sky130_ef_sc_hd__decap_40_12$1
XFILLER_27_698 vssd1 vccd1 vccd1 vssd1 sky130_fd_sc_hd__fill_2$1
XFILLER_41_167 vccd1 vssd1 vccd1 vssd1 sky130_fd_sc_hd__fill_1$1
XFILLER_127_217 vssd1 vccd1 vccd1 vssd1 sky130_fd_sc_hd__fill_4$1
XFILLER_10_587 vccd1 vssd1 vccd1 vssd1 sky130_fd_sc_hd__fill_1$1
XFILLER_6_525 vssd1 vccd1 vccd1 vssd1 sky130_fd_sc_hd__fill_4$1
XFILLER_6_569 vssd1 vccd1 vccd1 vssd1 sky130_ef_sc_hd__decap_40_12$1
XTAP_TAPCELL_ROW_20_593 vccd1 vssd1 sky130_fd_sc_hd__tapvpwrvgnd_1$1
XFILLER_135_261 vssd1 vccd1 vccd1 vssd1 sky130_ef_sc_hd__decap_40_12$1
XFILLER_108_475 vccd1 vssd1 vccd1 vssd1 sky130_fd_sc_hd__fill_1$1
XFILLER_111_629 vssd1 vccd1 vccd1 vssd1 sky130_ef_sc_hd__decap_40_12$1
XFILLER_96_307 vccd1 vssd1 vccd1 vssd1 sky130_fd_sc_hd__fill_1$1
XFILLER_2_753 vssd1 vccd1 vccd1 vssd1 sky130_fd_sc_hd__fill_2$1
XFILLER_110_139 vccd1 vssd1 vccd1 vssd1 sky130_fd_sc_hd__fill_1$1
XFILLER_104_681 vssd1 vccd1 vccd1 vssd1 sky130_ef_sc_hd__decap_40_12$1
XFILLER_49_223 vccd1 vssd1 vccd1 vssd1 sky130_fd_sc_hd__fill_1$1
XFILLER_77_554 vssd1 vccd1 vccd1 vssd1 sky130_fd_sc_hd__fill_4$1
XTAP_TAPCELL_ROW_88_1617 vccd1 vssd1 sky130_fd_sc_hd__tapvpwrvgnd_1$1
XFILLER_65_727 vccd1 vssd1 vccd1 vssd1 sky130_fd_sc_hd__fill_1$1
XFILLER_37_429 vssd1 vccd1 vccd1 vssd1 sky130_ef_sc_hd__decap_40_12$1
XFILLER_92_557 vssd1 vccd1 vccd1 vssd1 sky130_ef_sc_hd__decap_40_12$1
XFILLER_66_83 vccd1 vssd1 vccd1 vssd1 sky130_fd_sc_hd__fill_1$1
XFILLER_18_643 vccd1 vssd1 vccd1 vssd1 sky130_fd_sc_hd__fill_1$1
XFILLER_33_613 vssd1 vccd1 vccd1 vssd1 sky130_fd_sc_hd__fill_2$1
XFILLER_45_473 vssd1 vccd1 vccd1 vssd1 sky130_ef_sc_hd__decap_40_12$1
XFILLER_60_421 vssd1 vccd1 vccd1 vssd1 sky130_fd_sc_hd__fill_2$1
XANTENNA_19 _1210_/B vssd1 vccd1 vccd1 vssd1 sky130_fd_sc_hd__diode_2$1
XFILLER_20_307 vccd1 vssd1 vccd1 vssd1 sky130_fd_sc_hd__fill_1$1
XFILLER_32_189 vssd1 vccd1 vccd1 vssd1 sky130_fd_sc_hd__fill_4$1
X_0952_ _1782_/A _0952_/X _0990_/B vssd1 vccd1 vccd1 vssd1 sky130_fd_sc_hd__or2_1$1
XFILLER_119_729 vssd1 vccd1 vccd1 vssd1 sky130_ef_sc_hd__decap_40_12$1
XTAP_TAPCELL_ROW_99_1779 vccd1 vssd1 sky130_fd_sc_hd__tapvpwrvgnd_1$1
X_0883_ _1722_/Q _1344_/A _0885_/B _1658_/Q _1213_/A vccd1 vssd1 vccd1 vssd1 sky130_fd_sc_hd__a22o_1$1
XFILLER_9_385 vssd1 vccd1 vccd1 vssd1 sky130_fd_sc_hd__fill_4$1
XFILLER_63_3 vssd1 vccd1 vccd1 vssd1 sky130_ef_sc_hd__decap_40_12$1
XFILLER_114_412 vssd1 vccd1 vccd1 vssd1 sky130_fd_sc_hd__fill_8$1
Xoutput115 _1819_/X analog_ctrl[48] vssd1 vccd1 vccd1 vssd1 sky130_fd_sc_hd__buf_12$1
Xoutput104 _1809_/X analog_ctrl[38] vssd1 vccd1 vccd1 vssd1 sky130_fd_sc_hd__buf_12$1
X_1504_ _1504_/Q _1760_/CLK _1504_/D vccd1 vssd1 vccd1 vssd1 sky130_fd_sc_hd__dfxtp_1$1
XFILLER_114_445 vssd1 vccd1 vccd1 vssd1 sky130_ef_sc_hd__decap_40_12$1
Xoutput159 _1662_/Q analog_ctrl[89] vssd1 vccd1 vccd1 vssd1 sky130_fd_sc_hd__buf_12$1
Xoutput148 _1651_/Q analog_ctrl[78] vssd1 vccd1 vccd1 vssd1 sky130_fd_sc_hd__buf_12$1
Xoutput137 _1641_/Q analog_ctrl[68] vssd1 vccd1 vccd1 vssd1 sky130_fd_sc_hd__buf_12$1
Xoutput126 _1829_/X analog_ctrl[58] vssd1 vccd1 vccd1 vssd1 sky130_fd_sc_hd__buf_12$1
XFILLER_99_167 vccd1 vssd1 vccd1 vssd1 sky130_fd_sc_hd__fill_1$1
XFILLER_114_489 vssd1 vccd1 vccd1 vssd1 sky130_ef_sc_hd__decap_40_12$1
XTAP_TAPCELL_ROW_110_1957 vccd1 vssd1 sky130_fd_sc_hd__tapvpwrvgnd_1$1
XTAP_TAPCELL_ROW_110_1946 vccd1 vssd1 sky130_fd_sc_hd__tapvpwrvgnd_1$1
XFILLER_87_329 vssd1 vccd1 vccd1 vssd1 sky130_fd_sc_hd__fill_4$1
X_1435_ _1435_/C1 _1434_/X _1465_/A2 hold210/X _1744_/D vssd1 vccd1 vccd1 vssd1 sky130_fd_sc_hd__o211a_1$1
XFILLER_68_554 vssd1 vccd1 vccd1 vssd1 sky130_fd_sc_hd__fill_8$1
X_1366_ _1834_/A _1366_/X _1408_/B vssd1 vccd1 vccd1 vssd1 sky130_fd_sc_hd__or2_1$1
XTAP_TAPCELL_ROW_52_1075 vccd1 vssd1 sky130_fd_sc_hd__tapvpwrvgnd_1$1
XFILLER_95_373 vssd1 vccd1 vccd1 vssd1 sky130_ef_sc_hd__decap_40_12$1
XFILLER_68_587 vccd1 vssd1 vccd1 vssd1 sky130_fd_sc_hd__fill_1$1
XFILLER_56_749 vssd1 vccd1 vccd1 vssd1 sky130_fd_sc_hd__fill_4$1
XTAP_TAPCELL_ROW_52_1086 vccd1 vssd1 sky130_fd_sc_hd__tapvpwrvgnd_1$1
X_1297_ _1447_/C1 _1296_/X _1331_/A2 hold183/X _1677_/D vssd1 vccd1 vccd1 vssd1 sky130_fd_sc_hd__o211a_1$1
XFILLER_55_237 vssd1 vccd1 vccd1 vssd1 sky130_ef_sc_hd__decap_40_12$1
XFILLER_102_15 vssd1 vccd1 vccd1 vssd1 sky130_ef_sc_hd__decap_40_12$1
XFILLER_63_281 vssd1 vccd1 vccd1 vssd1 sky130_ef_sc_hd__decap_40_12$1
XFILLER_24_613 vssd1 vccd1 vccd1 vssd1 sky130_ef_sc_hd__decap_40_12$1
XFILLER_36_473 vssd1 vccd1 vccd1 vssd1 sky130_fd_sc_hd__fill_2$1
XFILLER_24_657 vssd1 vccd1 vccd1 vssd1 sky130_ef_sc_hd__decap_40_12$1
XFILLER_11_329 vssd1 vccd1 vccd1 vssd1 sky130_fd_sc_hd__fill_4$1
XFILLER_23_167 vccd1 vssd1 vccd1 vssd1 sky130_fd_sc_hd__fill_1$1
XFILLER_109_217 vssd1 vccd1 vccd1 vssd1 sky130_fd_sc_hd__fill_4$1
XFILLER_137_559 vccd1 vssd1 vccd1 vssd1 sky130_fd_sc_hd__fill_1$1
XFILLER_124_209 vssd1 vccd1 vccd1 vssd1 sky130_ef_sc_hd__decap_40_12$1
XFILLER_118_784 vssd1 vccd1 vccd1 vssd1 sky130_fd_sc_hd__fill_2$1
XFILLER_117_261 vssd1 vccd1 vccd1 vssd1 sky130_ef_sc_hd__decap_40_12$1
XFILLER_3_517 vssd1 vccd1 vccd1 vssd1 sky130_ef_sc_hd__decap_40_12$1
XFILLER_133_765 vssd1 vccd1 vccd1 vssd1 sky130_ef_sc_hd__decap_40_12$1
XFILLER_132_253 vssd1 vccd1 vccd1 vssd1 sky130_ef_sc_hd__decap_40_12$1
XFILLER_87_27 vssd1 vccd1 vccd1 vssd1 sky130_ef_sc_hd__decap_40_12$1
XFILLER_78_307 vccd1 vssd1 vccd1 vssd1 sky130_fd_sc_hd__fill_1$1
Xclkbuf_leaf_15_wb_clk_i _1726_/CLK clkbuf_2_3__f_wb_clk_i/X vssd1 vccd1 vccd1 vssd1
+ sky130_fd_sc_hd__clkbuf_8$1
XFILLER_87_841 vccd1 vssd1 vccd1 vssd1 sky130_fd_sc_hd__fill_1$1
XFILLER_101_673 vssd1 vccd1 vccd1 vssd1 sky130_fd_sc_hd__fill_2$1
XFILLER_74_513 vccd1 vssd1 vccd1 vssd1 sky130_fd_sc_hd__fill_1$1
XTAP_TAPCELL_ROW_6_388 vccd1 vssd1 sky130_fd_sc_hd__tapvpwrvgnd_1$1
XFILLER_19_429 vssd1 vccd1 vccd1 vssd1 sky130_ef_sc_hd__decap_40_12$1
XFILLER_47_727 vccd1 vssd1 vccd1 vssd1 sky130_fd_sc_hd__fill_1$1
XFILLER_101_695 vssd1 vccd1 vccd1 vssd1 sky130_ef_sc_hd__decap_40_12$1
Xafe_wb_286 analog_ctrl[103] afe_wb_286/HI vssd1 vccd1 vccd1 vssd1 sky130_fd_sc_hd__conb_1$1
XFILLER_36_53 vssd1 vccd1 vccd1 vssd1 sky130_ef_sc_hd__decap_40_12$1
XFILLER_15_613 vssd1 vccd1 vccd1 vssd1 sky130_fd_sc_hd__fill_2$1
XFILLER_27_473 vssd1 vccd1 vccd1 vssd1 sky130_ef_sc_hd__decap_40_12$1
XFILLER_36_97 vssd1 vccd1 vccd1 vssd1 sky130_ef_sc_hd__decap_40_12$1
XFILLER_42_421 vssd1 vccd1 vccd1 vssd1 sky130_ef_sc_hd__decap_40_12$1
XTAP_TAPCELL_ROW_83_1547 vccd1 vssd1 sky130_fd_sc_hd__tapvpwrvgnd_1$1
XFILLER_52_41 vssd1 vccd1 vccd1 vssd1 sky130_ef_sc_hd__decap_40_12$1
XFILLER_14_189 vssd1 vccd1 vccd1 vssd1 sky130_fd_sc_hd__fill_4$1
XTAP_TAPCELL_ROW_25_674 vccd1 vssd1 sky130_fd_sc_hd__tapvpwrvgnd_1$1
XFILLER_42_465 vssd1 vccd1 vccd1 vssd1 sky130_fd_sc_hd__fill_8$1
XFILLER_52_85 vssd1 vccd1 vccd1 vssd1 sky130_ef_sc_hd__decap_40_12$1
XFILLER_11_841 vccd1 vssd1 vccd1 vssd1 sky130_fd_sc_hd__fill_1$1
Xinput28 hold46/A hold45/X vssd1 vccd1 vccd1 vssd1 sky130_fd_sc_hd__clkbuf_4$1
Xinput17 hold5/A vccd1 vssd1 hold4/X vccd1 vssd1 sky130_fd_sc_hd__buf_4$1
XFILLER_7_823 vccd1 vssd1 vccd1 vssd1 sky130_fd_sc_hd__fill_1$1
Xinput39 vccd1 vssd1 input39/X input39/A vccd1 vssd1 sky130_fd_sc_hd__buf_2$1
XTAP_TAPCELL_ROW_114_2013 vccd1 vssd1 sky130_fd_sc_hd__tapvpwrvgnd_1$1
XFILLER_6_333 vssd1 vccd1 vccd1 vssd1 sky130_ef_sc_hd__decap_40_12$1
XFILLER_6_377 vssd1 vccd1 vccd1 vssd1 sky130_ef_sc_hd__decap_40_12$1
XFILLER_136_581 vssd1 vccd1 vccd1 vssd1 sky130_fd_sc_hd__fill_4$1
XFILLER_124_798 vssd1 vccd1 vccd1 vssd1 sky130_fd_sc_hd__fill_8$1
XFILLER_69_329 vssd1 vccd1 vccd1 vssd1 sky130_fd_sc_hd__fill_4$1
XFILLER_96_137 vssd1 vccd1 vccd1 vssd1 sky130_fd_sc_hd__fill_2$1
X_1220_ _1640_/Q _1220_/X _1270_/B vssd1 vccd1 vccd1 vssd1 sky130_fd_sc_hd__or2_1$1
XFILLER_77_373 vssd1 vccd1 vccd1 vssd1 sky130_ef_sc_hd__decap_40_12$1
XFILLER_77_93 vssd1 vccd1 vccd1 vssd1 sky130_ef_sc_hd__decap_40_12$1
X_1151_ _1289_/C1 _1150_/X _1189_/A2 hold73/X _1606_/D vssd1 vccd1 vccd1 vssd1 sky130_fd_sc_hd__o211a_1$1
XFILLER_92_321 vssd1 vccd1 vccd1 vssd1 sky130_ef_sc_hd__decap_40_12$1
XFILLER_37_237 vssd1 vccd1 vccd1 vssd1 sky130_ef_sc_hd__decap_40_12$1
XFILLER_38_749 vssd1 vccd1 vccd1 vssd1 sky130_fd_sc_hd__fill_4$1
XTAP_TAPCELL_ROW_125_2175 vccd1 vssd1 sky130_fd_sc_hd__tapvpwrvgnd_1$1
XFILLER_92_365 vssd1 vccd1 vccd1 vssd1 sky130_ef_sc_hd__decap_40_12$1
X_1082_ _1787_/A _1082_/X _1122_/B vssd1 vccd1 vccd1 vssd1 sky130_fd_sc_hd__or2_1$1
XFILLER_93_81 vssd1 vccd1 vccd1 vssd1 sky130_ef_sc_hd__decap_40_12$1
XFILLER_18_473 vssd1 vccd1 vccd1 vssd1 sky130_fd_sc_hd__fill_2$1
XFILLER_45_281 vssd1 vccd1 vccd1 vssd1 sky130_ef_sc_hd__decap_40_12$1
XFILLER_61_741 vssd1 vccd1 vccd1 vssd1 sky130_ef_sc_hd__decap_40_12$1
XFILLER_61_785 vssd1 vccd1 vccd1 vssd1 sky130_ef_sc_hd__decap_40_12$1
XFILLER_60_251 vccd1 vssd1 vccd1 vssd1 sky130_fd_sc_hd__fill_1$1
XTAP_TAPCELL_ROW_44_961 vccd1 vssd1 sky130_fd_sc_hd__tapvpwrvgnd_1$1
XFILLER_20_137 vssd1 vccd1 vccd1 vssd1 sky130_fd_sc_hd__fill_2$1
X_0935_ hold74/A _1411_/A _0935_/X _1667_/Q hold6/X vccd1 vssd1 vccd1 vssd1 sky130_fd_sc_hd__a22o_1$1
XFILLER_119_559 vccd1 vssd1 vccd1 vssd1 sky130_fd_sc_hd__fill_1$1
X_0866_ _1751_/Q _0881_/B1 _0866_/X _1559_/Q _0866_/B1 vccd1 vssd1 vccd1 vssd1 sky130_fd_sc_hd__a22o_1$1
XFILLER_9_193 vssd1 vccd1 vccd1 vssd1 sky130_ef_sc_hd__decap_40_12$1
XFILLER_106_209 vssd1 vccd1 vccd1 vssd1 sky130_ef_sc_hd__decap_40_12$1
X_0797_ _1798_/A _0879_/A2 _0797_/X input10/X _0826_/B1 vccd1 vssd1 vccd1 vssd1 sky130_fd_sc_hd__a22o_1$1
XFILLER_115_765 vssd1 vccd1 vccd1 vssd1 sky130_ef_sc_hd__decap_40_12$1
XFILLER_114_253 vssd1 vccd1 vccd1 vssd1 sky130_ef_sc_hd__decap_40_12$1
XTAP_TAPCELL_ROW_54_1115 vccd1 vssd1 sky130_fd_sc_hd__tapvpwrvgnd_1$1
XTAP_TAPCELL_ROW_54_1104 vccd1 vssd1 sky130_fd_sc_hd__tapvpwrvgnd_1$1
XFILLER_130_713 vssd1 vccd1 vccd1 vssd1 sky130_ef_sc_hd__decap_40_12$1
XFILLER_130_757 vssd1 vccd1 vccd1 vssd1 sky130_ef_sc_hd__decap_40_12$1
XFILLER_87_137 vssd1 vccd1 vccd1 vssd1 sky130_ef_sc_hd__decap_40_12$1
XFILLER_69_841 vccd1 vssd1 vccd1 vssd1 sky130_fd_sc_hd__fill_1$1
X_1418_ _1844_/A _1418_/X _1474_/B vssd1 vccd1 vccd1 vssd1 sky130_fd_sc_hd__or2_1$1
XFILLER_84_800 vssd1 vccd1 vccd1 vssd1 sky130_fd_sc_hd__fill_4$1
XFILLER_56_513 vssd1 vccd1 vccd1 vssd1 sky130_fd_sc_hd__fill_8$1
XFILLER_29_727 vccd1 vssd1 vccd1 vssd1 sky130_fd_sc_hd__fill_1$1
XFILLER_96_693 vssd1 vccd1 vccd1 vssd1 sky130_fd_sc_hd__fill_4$1
XFILLER_95_181 vssd1 vccd1 vccd1 vssd1 sky130_ef_sc_hd__decap_40_12$1
X_1349_ _1441_/C1 _1348_/X _1409_/A2 hold73/X _1702_/D vssd1 vccd1 vccd1 vssd1 sky130_fd_sc_hd__o211a_1$1
XTAP_TAPCELL_ROW_3_347 vccd1 vssd1 sky130_fd_sc_hd__tapvpwrvgnd_1$1
XFILLER_113_69 vssd1 vccd1 vccd1 vssd1 sky130_ef_sc_hd__decap_40_12$1
XFILLER_56_579 vccd1 vssd1 vccd1 vssd1 sky130_fd_sc_hd__fill_1$1
XFILLER_83_387 vssd1 vccd1 vccd1 vssd1 sky130_fd_sc_hd__fill_4$1
XFILLER_24_421 vssd1 vccd1 vccd1 vssd1 sky130_ef_sc_hd__decap_40_12$1
XTAP_TAPCELL_ROW_65_1277 vccd1 vssd1 sky130_fd_sc_hd__tapvpwrvgnd_1$1
XFILLER_51_273 vssd1 vccd1 vccd1 vssd1 sky130_fd_sc_hd__fill_4$1
XFILLER_11_137 vssd1 vccd1 vccd1 vssd1 sky130_ef_sc_hd__decap_40_12$1
XTAP_TAPCELL_ROW_22_633 vccd1 vssd1 sky130_fd_sc_hd__tapvpwrvgnd_1$1
XFILLER_137_301 vssd1 vccd1 vccd1 vssd1 sky130_fd_sc_hd__fill_4$1
XFILLER_138_33 vssd1 vccd1 vccd1 vssd1 sky130_fd_sc_hd__fill_2$1
XFILLER_20_693 vssd1 vccd1 vccd1 vssd1 sky130_fd_sc_hd__fill_4$1
XFILLER_138_55 vccd1 vssd1 vccd1 vssd1 sky130_fd_sc_hd__fill_1$1
XFILLER_125_529 vssd1 vccd1 vccd1 vssd1 sky130_ef_sc_hd__decap_40_12$1
XFILLER_98_15 vssd1 vccd1 vccd1 vssd1 sky130_ef_sc_hd__decap_40_12$1
XFILLER_22_77 vssd1 vccd1 vccd1 vssd1 sky130_fd_sc_hd__fill_4$1
XFILLER_118_581 vssd1 vccd1 vccd1 vssd1 sky130_fd_sc_hd__fill_4$1
XFILLER_106_721 vssd1 vccd1 vccd1 vssd1 sky130_ef_sc_hd__decap_40_12$1
XFILLER_4_837 vssd1 vccd1 vccd1 vssd1 sky130_fd_sc_hd__fill_4$1
XFILLER_133_573 vssd1 vccd1 vccd1 vssd1 sky130_ef_sc_hd__decap_40_12$1
XFILLER_120_245 vssd1 vccd1 vccd1 vssd1 sky130_fd_sc_hd__fill_4$1
XFILLER_78_137 vssd1 vccd1 vccd1 vssd1 sky130_fd_sc_hd__fill_2$1
XFILLER_120_289 vssd1 vccd1 vccd1 vssd1 sky130_ef_sc_hd__decap_40_12$1
XFILLER_87_671 vccd1 vssd1 vccd1 vssd1 sky130_fd_sc_hd__fill_1$1
XFILLER_59_373 vssd1 vccd1 vccd1 vssd1 sky130_ef_sc_hd__decap_40_12$1
XFILLER_74_321 vssd1 vccd1 vccd1 vssd1 sky130_ef_sc_hd__decap_40_12$1
XFILLER_19_237 vssd1 vccd1 vccd1 vssd1 sky130_ef_sc_hd__decap_40_12$1
XFILLER_74_365 vssd1 vccd1 vccd1 vssd1 sky130_ef_sc_hd__decap_40_12$1
XFILLER_28_793 vssd1 vccd1 vccd1 vssd1 sky130_ef_sc_hd__decap_40_12$1
XFILLER_63_51 vssd1 vccd1 vccd1 vssd1 sky130_fd_sc_hd__fill_4$1
XFILLER_27_281 vssd1 vccd1 vccd1 vssd1 sky130_ef_sc_hd__decap_40_12$1
XFILLER_30_413 vssd1 vccd1 vccd1 vssd1 sky130_fd_sc_hd__fill_4$1
XFILLER_42_251 vccd1 vssd1 vccd1 vssd1 sky130_fd_sc_hd__fill_1$1
XFILLER_43_785 vssd1 vccd1 vccd1 vssd1 sky130_ef_sc_hd__decap_40_12$1
XTAP_TAPCELL_ROW_120_2094 vccd1 vssd1 sky130_fd_sc_hd__tapvpwrvgnd_1$1
XTAP_TAPCELL_ROW_41_920 vccd1 vssd1 sky130_fd_sc_hd__tapvpwrvgnd_1$1
XFILLER_128_301 vssd1 vccd1 vccd1 vssd1 sky130_fd_sc_hd__fill_4$1
XFILLER_30_457 vssd1 vccd1 vccd1 vssd1 sky130_ef_sc_hd__decap_40_12$1
XFILLER_128_345 vssd1 vccd1 vccd1 vssd1 sky130_ef_sc_hd__decap_40_12$1
XFILLER_11_671 vccd1 vssd1 vccd1 vssd1 sky130_fd_sc_hd__fill_1$1
XFILLER_116_529 vssd1 vccd1 vccd1 vssd1 sky130_fd_sc_hd__fill_2$1
XTAP_TAPCELL_ROW_96_1738 vccd1 vssd1 sky130_fd_sc_hd__tapvpwrvgnd_1$1
XFILLER_7_653 vssd1 vccd1 vccd1 vssd1 sky130_ef_sc_hd__decap_40_12$1
XFILLER_6_141 vssd1 vccd1 vccd1 vssd1 sky130_ef_sc_hd__decap_40_12$1
XFILLER_7_697 vssd1 vccd1 vccd1 vssd1 sky130_ef_sc_hd__decap_40_12$1
XFILLER_112_713 vssd1 vccd1 vccd1 vssd1 sky130_ef_sc_hd__decap_40_12$1
XFILLER_97_424 vssd1 vccd1 vccd1 vssd1 sky130_ef_sc_hd__decap_40_12$1
XFILLER_88_81 vssd1 vccd1 vccd1 vssd1 sky130_fd_sc_hd__fill_2$1
XTAP_TAPCELL_ROW_127_2204 vccd1 vssd1 sky130_fd_sc_hd__tapvpwrvgnd_1$1
XFILLER_112_757 vssd1 vccd1 vccd1 vssd1 sky130_ef_sc_hd__decap_40_12$1
XFILLER_111_223 vccd1 vssd1 vccd1 vssd1 sky130_fd_sc_hd__fill_1$1
XFILLER_69_137 vssd1 vccd1 vccd1 vssd1 sky130_ef_sc_hd__decap_40_12$1
X_1203_ _1437_/C1 _1202_/X _1211_/A2 hold146/X _1632_/D vssd1 vccd1 vccd1 vssd1 sky130_fd_sc_hd__o211a_1$1
XFILLER_66_811 vccd1 vssd1 vccd1 vssd1 sky130_fd_sc_hd__fill_1$1
XFILLER_26_3 vssd1 vccd1 vccd1 vssd1 sky130_ef_sc_hd__decap_40_12$1
XFILLER_38_513 vssd1 vccd1 vccd1 vssd1 sky130_ef_sc_hd__decap_40_12$1
XPHY_EDGE_ROW_108_Left_247 vccd1 vssd1 vccd1 vssd1 sky130_fd_sc_hd__decap_3$1
XFILLER_78_693 vssd1 vccd1 vccd1 vssd1 sky130_fd_sc_hd__fill_4$1
XFILLER_77_181 vssd1 vccd1 vccd1 vssd1 sky130_ef_sc_hd__decap_40_12$1
X_1134_ hold88/X _1134_/X _1144_/B vssd1 vccd1 vccd1 vssd1 sky130_fd_sc_hd__or2_1$1
XFILLER_53_505 vssd1 vccd1 vccd1 vssd1 sky130_ef_sc_hd__decap_40_12$1
XTAP_TAPCELL_ROW_0_306 vccd1 vssd1 sky130_fd_sc_hd__tapvpwrvgnd_1$1
X_1065_ _1463_/C1 _1064_/X _1079_/A2 hold86/X _1565_/D vssd1 vccd1 vccd1 vssd1 sky130_fd_sc_hd__o211a_1$1
XFILLER_93_685 vssd1 vccd1 vccd1 vssd1 sky130_fd_sc_hd__fill_8$1
XFILLER_53_538 vssd1 vccd1 vccd1 vssd1 sky130_ef_sc_hd__decap_40_12$1
XFILLER_92_195 vccd1 vssd1 vccd1 vssd1 sky130_fd_sc_hd__fill_1$1
XFILLER_80_357 vssd1 vccd1 vccd1 vssd1 sky130_fd_sc_hd__fill_4$1
XTAP_TAPCELL_ROW_105_1878 vccd1 vssd1 sky130_fd_sc_hd__tapvpwrvgnd_1$1
XFILLER_34_796 vssd1 vccd1 vccd1 vssd1 sky130_fd_sc_hd__fill_8$1
XFILLER_33_273 vssd1 vccd1 vccd1 vssd1 sky130_fd_sc_hd__fill_4$1
XTAP_TAPCELL_ROW_138_2366 vccd1 vssd1 sky130_fd_sc_hd__tapvpwrvgnd_1$1
XPHY_EDGE_ROW_117_Left_256 vccd1 vssd1 vccd1 vssd1 sky130_fd_sc_hd__decap_3$1
XTAP_TAPCELL_ROW_138_2388 vccd1 vssd1 sky130_fd_sc_hd__tapvpwrvgnd_1$1
XTAP_TAPCELL_ROW_138_2377 vccd1 vssd1 sky130_fd_sc_hd__tapvpwrvgnd_1$1
X_0918_ _1632_/Q _0740_/X _0921_/B _1664_/Q _1213_/A vccd1 vssd1 vccd1 vssd1 sky130_fd_sc_hd__a22o_1$1
XTAP_TAPCELL_ROW_60_1196 vccd1 vssd1 sky130_fd_sc_hd__tapvpwrvgnd_1$1
XFILLER_119_389 vssd1 vccd1 vccd1 vssd1 sky130_fd_sc_hd__fill_2$1
X_0849_ _0752_/A _1492_/D _0845_/X _1443_/C1 _1492_/Q _0848_/X vssd1 vccd1 vccd1 vssd1
+ sky130_fd_sc_hd__o221a_1$1
XTAP_TAPCELL_ROW_8_417 vccd1 vssd1 sky130_fd_sc_hd__tapvpwrvgnd_1$1
XFILLER_103_724 vssd1 vccd1 vccd1 vssd1 sky130_fd_sc_hd__fill_4$1
XFILLER_68_29 vssd1 vccd1 vccd1 vssd1 sky130_ef_sc_hd__decap_40_12$1
XFILLER_102_245 vssd1 vccd1 vccd1 vssd1 sky130_fd_sc_hd__fill_4$1
XPHY_EDGE_ROW_126_Left_265 vccd1 vssd1 vccd1 vssd1 sky130_fd_sc_hd__decap_3$1
XFILLER_102_289 vssd1 vccd1 vccd1 vssd1 sky130_ef_sc_hd__decap_40_12$1
XFILLER_96_490 vssd1 vccd1 vccd1 vssd1 sky130_ef_sc_hd__decap_40_12$1
XFILLER_56_321 vssd1 vccd1 vccd1 vssd1 sky130_ef_sc_hd__decap_40_12$1
XTAP_TAPCELL_ROW_67_1306 vccd1 vssd1 sky130_fd_sc_hd__tapvpwrvgnd_1$1
XFILLER_56_365 vssd1 vccd1 vccd1 vssd1 sky130_ef_sc_hd__decap_40_12$1
XFILLER_29_557 vssd1 vccd1 vccd1 vssd1 sky130_fd_sc_hd__fill_2$1
XFILLER_17_55 vccd1 vssd1 vccd1 vssd1 sky130_fd_sc_hd__fill_1$1
XTAP_TAPCELL_ROW_27_703 vccd1 vssd1 sky130_fd_sc_hd__tapvpwrvgnd_1$1
XFILLER_71_335 vccd1 vssd1 vccd1 vssd1 sky130_fd_sc_hd__fill_1$1
XFILLER_44_549 vccd1 vssd1 vccd1 vssd1 sky130_fd_sc_hd__fill_1$1
XTAP_TAPCELL_ROW_80_1506 vccd1 vssd1 sky130_fd_sc_hd__tapvpwrvgnd_1$1
XFILLER_24_251 vccd1 vssd1 vccd1 vssd1 sky130_fd_sc_hd__fill_1$1
XFILLER_25_785 vssd1 vccd1 vccd1 vssd1 sky130_fd_sc_hd__fill_4$1
XPHY_EDGE_ROW_135_Left_274 vccd1 vssd1 vccd1 vssd1 sky130_fd_sc_hd__decap_3$1
XFILLER_12_413 vssd1 vccd1 vccd1 vssd1 sky130_fd_sc_hd__fill_4$1
XFILLER_40_722 vssd1 vccd1 vccd1 vssd1 sky130_ef_sc_hd__decap_40_12$1
XFILLER_130_3 vssd1 vccd1 vccd1 vssd1 sky130_ef_sc_hd__decap_40_12$1
XFILLER_129_109 vssd1 vccd1 vccd1 vssd1 sky130_fd_sc_hd__fill_2$1
XFILLER_8_417 vssd1 vccd1 vccd1 vssd1 sky130_fd_sc_hd__fill_2$1
XFILLER_12_457 vssd1 vccd1 vccd1 vssd1 sky130_ef_sc_hd__decap_40_12$1
XFILLER_138_643 vccd1 vssd1 vccd1 vssd1 sky130_fd_sc_hd__fill_1$1
XFILLER_137_153 vssd1 vccd1 vccd1 vssd1 sky130_fd_sc_hd__fill_2$1
XFILLER_4_601 vssd1 vccd1 vccd1 vssd1 sky130_ef_sc_hd__decap_40_12$1
XFILLER_125_337 vssd1 vccd1 vccd1 vssd1 sky130_ef_sc_hd__decap_40_12$1
XTAP_TAPCELL_ROW_78_1468 vccd1 vssd1 sky130_fd_sc_hd__tapvpwrvgnd_1$1
Xclkbuf_leaf_30_wb_clk_i _1704_/CLK clkload1/A vssd1 vccd1 vccd1 vssd1 sky130_fd_sc_hd__clkbuf_8$1
XFILLER_3_111 vccd1 vssd1 vccd1 vssd1 sky130_fd_sc_hd__fill_1$1
XFILLER_4_645 vssd1 vccd1 vccd1 vssd1 sky130_ef_sc_hd__decap_40_12$1
XTAP_TAPCELL_ROW_91_1668 vccd1 vssd1 sky130_fd_sc_hd__tapvpwrvgnd_1$1
Xhold6 hold6/A hold6/X vssd1 vccd1 vccd1 vssd1 sky130_fd_sc_hd__dlygate4sd3_1$1
XFILLER_59_181 vssd1 vccd1 vccd1 vssd1 sky130_ef_sc_hd__decap_40_12$1
XFILLER_75_641 vssd1 vccd1 vccd1 vssd1 sky130_fd_sc_hd__fill_4$1
XFILLER_35_505 vssd1 vccd1 vccd1 vssd1 sky130_ef_sc_hd__decap_40_12$1
XTAP_TAPCELL_ROW_122_2134 vccd1 vssd1 sky130_fd_sc_hd__tapvpwrvgnd_1$1
XTAP_TAPCELL_ROW_122_2123 vccd1 vssd1 sky130_fd_sc_hd__tapvpwrvgnd_1$1
XFILLER_74_195 vccd1 vssd1 vccd1 vssd1 sky130_fd_sc_hd__fill_1$1
XFILLER_74_83 vccd1 vssd1 vccd1 vssd1 sky130_fd_sc_hd__fill_1$1
XFILLER_62_357 vssd1 vccd1 vccd1 vssd1 sky130_fd_sc_hd__fill_4$1
XFILLER_90_688 vssd1 vccd1 vccd1 vssd1 sky130_fd_sc_hd__fill_2$1
XFILLER_15_273 vssd1 vccd1 vccd1 vssd1 sky130_fd_sc_hd__fill_4$1
XFILLER_30_221 vssd1 vccd1 vccd1 vssd1 sky130_ef_sc_hd__decap_40_12$1
XFILLER_129_610 vssd1 vccd1 vccd1 vssd1 sky130_fd_sc_hd__fill_4$1
X_1821_ _1821_/A _1821_/X vssd1 vccd1 vccd1 vssd1 sky130_fd_sc_hd__clkbuf_2$1
XFILLER_31_777 vssd1 vccd1 vccd1 vssd1 sky130_fd_sc_hd__fill_4$1
XFILLER_30_265 vssd1 vccd1 vccd1 vssd1 sky130_ef_sc_hd__decap_40_12$1
XFILLER_129_665 vssd1 vccd1 vccd1 vssd1 sky130_fd_sc_hd__fill_4$1
XFILLER_128_153 vssd1 vccd1 vccd1 vssd1 sky130_ef_sc_hd__decap_40_12$1
XFILLER_117_816 vssd1 vccd1 vccd1 vssd1 sky130_fd_sc_hd__fill_2$1
X_1752_ _1752_/Q _1752_/CLK _1752_/D vccd1 vssd1 vccd1 vssd1 sky130_fd_sc_hd__dfxtp_1$1
XTAP_TAPCELL_ROW_100_1797 vccd1 vssd1 sky130_fd_sc_hd__tapvpwrvgnd_1$1
XTAP_TAPCELL_ROW_13_496 vccd1 vssd1 sky130_fd_sc_hd__tapvpwrvgnd_1$1
XFILLER_128_197 vssd1 vccd1 vccd1 vssd1 sky130_ef_sc_hd__decap_40_12$1
XFILLER_117_838 vssd1 vccd1 vccd1 vssd1 sky130_fd_sc_hd__fill_2$1
X_1683_ _1683_/Q _1748_/CLK _1683_/D vccd1 vssd1 vccd1 vssd1 sky130_fd_sc_hd__dfxtp_1$1
XFILLER_7_461 vssd1 vccd1 vccd1 vssd1 sky130_ef_sc_hd__decap_40_12$1
XTAP_TAPCELL_ROW_133_2296 vccd1 vssd1 sky130_fd_sc_hd__tapvpwrvgnd_1$1
XFILLER_131_329 vssd1 vccd1 vccd1 vssd1 sky130_fd_sc_hd__fill_4$1
XFILLER_112_521 vssd1 vccd1 vccd1 vssd1 sky130_fd_sc_hd__fill_8$1
XFILLER_98_755 vccd1 vssd1 vccd1 vssd1 sky130_fd_sc_hd__fill_1$1
XFILLER_97_221 vssd1 vccd1 vccd1 vssd1 sky130_fd_sc_hd__fill_2$1
XFILLER_112_587 vccd1 vssd1 vccd1 vssd1 sky130_fd_sc_hd__fill_1$1
XFILLER_85_405 vssd1 vccd1 vccd1 vssd1 sky130_ef_sc_hd__decap_40_12$1
XFILLER_100_749 vssd1 vccd1 vccd1 vssd1 sky130_fd_sc_hd__fill_4$1
XFILLER_85_438 vccd1 vssd1 vccd1 vssd1 sky130_fd_sc_hd__fill_1$1
XFILLER_66_630 vssd1 vccd1 vccd1 vssd1 sky130_ef_sc_hd__decap_40_12$1
XFILLER_38_321 vssd1 vccd1 vccd1 vssd1 sky130_ef_sc_hd__decap_40_12$1
XTAP_TAPCELL_ROW_107_1907 vccd1 vssd1 sky130_fd_sc_hd__tapvpwrvgnd_1$1
XFILLER_81_633 vssd1 vccd1 vccd1 vssd1 sky130_ef_sc_hd__decap_40_12$1
X_1117_ _1387_/C1 _1116_/X _1123_/A2 hold46/X _1590_/D vssd1 vccd1 vccd1 vssd1 sky130_fd_sc_hd__o211a_1$1
XFILLER_38_365 vssd1 vccd1 vccd1 vssd1 sky130_ef_sc_hd__decap_40_12$1
XFILLER_80_121 vssd1 vccd1 vccd1 vssd1 sky130_ef_sc_hd__decap_40_12$1
XFILLER_53_335 vccd1 vssd1 vccd1 vssd1 sky130_fd_sc_hd__fill_1$1
XTAP_TAPCELL_ROW_49_1036 vccd1 vssd1 sky130_fd_sc_hd__tapvpwrvgnd_1$1
X_1048_ hold51/X _1048_/X _1078_/B vssd1 vccd1 vccd1 vssd1 sky130_fd_sc_hd__or2_1$1
XFILLER_110_15 vssd1 vccd1 vccd1 vssd1 sky130_ef_sc_hd__decap_40_12$1
XFILLER_80_165 vssd1 vccd1 vccd1 vssd1 sky130_ef_sc_hd__decap_40_12$1
XFILLER_22_711 vssd1 vccd1 vccd1 vssd1 sky130_ef_sc_hd__decap_40_12$1
XTAP_TAPCELL_ROW_62_1236 vccd1 vssd1 sky130_fd_sc_hd__tapvpwrvgnd_1$1
XTAP_TAPCELL_ROW_62_1225 vccd1 vssd1 sky130_fd_sc_hd__tapvpwrvgnd_1$1
XFILLER_21_221 vssd1 vccd1 vccd1 vssd1 sky130_fd_sc_hd__fill_2$1
XPHY_EDGE_ROW_3_Right_3 vccd1 vssd1 vccd1 vssd1 sky130_fd_sc_hd__decap_3$1
XTAP_TAPCELL_ROW_32_783 vccd1 vssd1 sky130_fd_sc_hd__tapvpwrvgnd_1$1
XFILLER_135_613 vssd1 vccd1 vccd1 vssd1 sky130_fd_sc_hd__fill_2$1
XFILLER_108_805 vssd1 vccd1 vccd1 vssd1 sky130_fd_sc_hd__fill_4$1
XFILLER_119_57 vssd1 vccd1 vccd1 vssd1 sky130_ef_sc_hd__decap_40_12$1
XFILLER_107_337 vssd1 vccd1 vccd1 vssd1 sky130_ef_sc_hd__decap_40_12$1
XFILLER_79_39 vssd1 vccd1 vccd1 vssd1 sky130_ef_sc_hd__decap_40_12$1
XFILLER_134_189 vssd1 vccd1 vccd1 vssd1 sky130_fd_sc_hd__fill_4$1
XFILLER_122_307 vccd1 vssd1 vccd1 vssd1 sky130_fd_sc_hd__fill_1$1
XFILLER_1_615 vccd1 vssd1 vccd1 vssd1 sky130_fd_sc_hd__fill_1$1
XFILLER_131_841 vccd1 vssd1 vccd1 vssd1 sky130_fd_sc_hd__fill_1$1
XFILLER_88_221 vssd1 vccd1 vccd1 vssd1 sky130_ef_sc_hd__decap_40_12$1
XFILLER_0_125 vssd1 vccd1 vccd1 vssd1 sky130_ef_sc_hd__decap_40_12$1
XFILLER_95_27 vssd1 vccd1 vccd1 vssd1 sky130_ef_sc_hd__decap_40_12$1
XFILLER_89_777 vssd1 vccd1 vccd1 vssd1 sky130_fd_sc_hd__fill_4$1
XFILLER_88_265 vssd1 vccd1 vccd1 vssd1 sky130_ef_sc_hd__decap_40_12$1
XTAP_TAPCELL_ROW_73_1398 vccd1 vssd1 sky130_fd_sc_hd__tapvpwrvgnd_1$1
XFILLER_0_169 vssd1 vccd1 vccd1 vssd1 sky130_ef_sc_hd__decap_40_12$1
XFILLER_28_65 vssd1 vccd1 vccd1 vssd1 sky130_ef_sc_hd__decap_40_12$1
XFILLER_17_505 vssd1 vccd1 vccd1 vssd1 sky130_ef_sc_hd__decap_40_12$1
XFILLER_56_195 vccd1 vssd1 vccd1 vssd1 sky130_fd_sc_hd__fill_1$1
XFILLER_44_357 vssd1 vccd1 vccd1 vssd1 sky130_fd_sc_hd__fill_4$1
XFILLER_72_699 vccd1 vssd1 vccd1 vssd1 sky130_fd_sc_hd__fill_1$1
XFILLER_71_165 vssd1 vccd1 vccd1 vssd1 sky130_fd_sc_hd__fill_2$1
XFILLER_44_53 vssd1 vccd1 vccd1 vssd1 sky130_ef_sc_hd__decap_40_12$1
XFILLER_12_221 vssd1 vccd1 vccd1 vssd1 sky130_ef_sc_hd__decap_40_12$1
XFILLER_13_777 vssd1 vccd1 vccd1 vssd1 sky130_fd_sc_hd__fill_4$1
XFILLER_44_97 vssd1 vccd1 vccd1 vssd1 sky130_ef_sc_hd__decap_40_12$1
XFILLER_100_81 vssd1 vccd1 vccd1 vssd1 sky130_fd_sc_hd__fill_2$1
XFILLER_12_265 vssd1 vccd1 vccd1 vssd1 sky130_ef_sc_hd__decap_40_12$1
XFILLER_60_41 vssd1 vccd1 vccd1 vssd1 sky130_ef_sc_hd__decap_40_12$1
XFILLER_60_85 vssd1 vccd1 vccd1 vssd1 sky130_ef_sc_hd__decap_40_12$1
XTAP_TAPCELL_ROW_10_455 vccd1 vssd1 sky130_fd_sc_hd__tapvpwrvgnd_1$1
XTAP_TAPCELL_ROW_10_444 vccd1 vssd1 sky130_fd_sc_hd__tapvpwrvgnd_1$1
XFILLER_125_167 vccd1 vssd1 vccd1 vssd1 sky130_fd_sc_hd__fill_1$1
XFILLER_113_329 vssd1 vccd1 vccd1 vssd1 sky130_fd_sc_hd__fill_4$1
XFILLER_5_69 vssd1 vccd1 vccd1 vssd1 sky130_ef_sc_hd__decap_40_12$1
XFILLER_4_475 vccd1 vssd1 vccd1 vssd1 sky130_fd_sc_hd__fill_1$1
XFILLER_79_221 vssd1 vccd1 vccd1 vssd1 sky130_fd_sc_hd__fill_2$1
XFILLER_67_405 vssd1 vccd1 vccd1 vssd1 sky130_ef_sc_hd__decap_40_12$1
XFILLER_67_449 vssd1 vccd1 vccd1 vssd1 sky130_ef_sc_hd__decap_40_12$1
XFILLER_48_630 vssd1 vccd1 vccd1 vssd1 sky130_ef_sc_hd__decap_40_12$1
XFILLER_85_93 vssd1 vccd1 vccd1 vssd1 sky130_ef_sc_hd__decap_40_12$1
XFILLER_75_460 vssd1 vccd1 vccd1 vssd1 sky130_ef_sc_hd__decap_40_12$1
XFILLER_36_825 vccd1 vssd1 vccd1 vssd1 sky130_fd_sc_hd__fill_1$1
XFILLER_62_121 vssd1 vccd1 vccd1 vssd1 sky130_ef_sc_hd__decap_40_12$1
XFILLER_35_335 vccd1 vssd1 vccd1 vssd1 sky130_fd_sc_hd__fill_1$1
XFILLER_62_165 vssd1 vccd1 vccd1 vssd1 sky130_ef_sc_hd__decap_40_12$1
XFILLER_50_305 vssd1 vccd1 vccd1 vssd1 sky130_fd_sc_hd__fill_2$1
XTAP_TAPCELL_ROW_18_566 vccd1 vssd1 sky130_fd_sc_hd__tapvpwrvgnd_1$1
XTAP_TAPCELL_ROW_18_577 vccd1 vssd1 sky130_fd_sc_hd__tapvpwrvgnd_1$1
XTAP_TAPCELL_ROW_102_1837 vccd1 vssd1 sky130_fd_sc_hd__tapvpwrvgnd_1$1
XTAP_TAPCELL_ROW_102_1826 vccd1 vssd1 sky130_fd_sc_hd__tapvpwrvgnd_1$1
XFILLER_93_3 vssd1 vccd1 vccd1 vssd1 sky130_ef_sc_hd__decap_40_12$1
XFILLER_31_541 vssd1 vccd1 vccd1 vssd1 sky130_ef_sc_hd__decap_40_12$1
XFILLER_31_585 vssd1 vccd1 vccd1 vssd1 sky130_ef_sc_hd__decap_40_12$1
XTAP_TAPCELL_ROW_135_2325 vccd1 vssd1 sky130_fd_sc_hd__tapvpwrvgnd_1$1
XFILLER_129_440 vssd1 vccd1 vccd1 vssd1 sky130_fd_sc_hd__fill_8$1
XFILLER_117_602 vssd1 vccd1 vccd1 vssd1 sky130_fd_sc_hd__fill_2$1
X_1804_ _1804_/A _1804_/X vssd1 vccd1 vccd1 vssd1 sky130_fd_sc_hd__clkbuf_2$1
XFILLER_129_473 vssd1 vccd1 vccd1 vssd1 sky130_ef_sc_hd__decap_40_12$1
XFILLER_117_635 vssd1 vccd1 vccd1 vssd1 sky130_ef_sc_hd__decap_40_12$1
X_1735_ _1843_/A _1738_/CLK _1735_/D vccd1 vssd1 vccd1 vssd1 sky130_fd_sc_hd__dfxtp_1$1
XFILLER_8_781 vssd1 vccd1 vccd1 vssd1 sky130_ef_sc_hd__decap_40_12$1
Xhold203 _1676_/Q _1294_/A vssd1 vccd1 vccd1 vssd1 sky130_fd_sc_hd__dlygate4sd3_1$1
Xhold214 _1552_/Q _1038_/A vssd1 vccd1 vccd1 vssd1 sky130_fd_sc_hd__dlygate4sd3_1$1
XFILLER_132_627 vssd1 vccd1 vccd1 vssd1 sky130_fd_sc_hd__fill_8$1
XFILLER_116_189 vssd1 vccd1 vccd1 vssd1 sky130_fd_sc_hd__fill_4$1
XFILLER_104_307 vccd1 vssd1 vccd1 vssd1 sky130_fd_sc_hd__fill_1$1
X_1666_ _1666_/Q _1738_/CLK _1666_/D vccd1 vssd1 vccd1 vssd1 sky130_fd_sc_hd__dfxtp_1$1
X_1597_ _1597_/Q _1757_/CLK _1597_/D vccd1 vssd1 vccd1 vssd1 sky130_fd_sc_hd__dfxtp_1$1
XFILLER_131_137 vssd1 vccd1 vccd1 vssd1 sky130_ef_sc_hd__decap_40_12$1
XFILLER_113_841 vccd1 vssd1 vccd1 vssd1 sky130_fd_sc_hd__fill_1$1
XTAP_TAPCELL_ROW_113_1999 vccd1 vssd1 sky130_fd_sc_hd__tapvpwrvgnd_1$1
XTAP_TAPCELL_ROW_113_1988 vccd1 vssd1 sky130_fd_sc_hd__tapvpwrvgnd_1$1
XFILLER_105_15 vssd1 vccd1 vccd1 vssd1 sky130_ef_sc_hd__decap_40_12$1
XFILLER_86_725 vssd1 vccd1 vccd1 vssd1 sky130_fd_sc_hd__fill_4$1
XFILLER_100_513 vssd1 vccd1 vccd1 vssd1 sky130_fd_sc_hd__fill_8$1
XFILLER_98_596 vssd1 vccd1 vccd1 vssd1 sky130_ef_sc_hd__decap_40_12$1
XFILLER_86_769 vssd1 vccd1 vccd1 vssd1 sky130_fd_sc_hd__fill_2$1
XFILLER_85_279 vccd1 vssd1 vccd1 vssd1 sky130_fd_sc_hd__fill_1$1
XFILLER_73_419 vssd1 vccd1 vccd1 vssd1 sky130_ef_sc_hd__decap_40_12$1
XFILLER_39_685 vssd1 vccd1 vccd1 vssd1 sky130_ef_sc_hd__decap_40_12$1
XFILLER_38_195 vccd1 vssd1 vccd1 vssd1 sky130_fd_sc_hd__fill_1$1
XFILLER_121_69 vssd1 vccd1 vccd1 vssd1 sky130_ef_sc_hd__decap_40_12$1
XFILLER_53_165 vssd1 vccd1 vccd1 vssd1 sky130_fd_sc_hd__fill_2$1
XFILLER_26_357 vssd1 vccd1 vccd1 vssd1 sky130_fd_sc_hd__fill_4$1
XTAP_TAPCELL_ROW_37_853 vccd1 vssd1 sky130_fd_sc_hd__tapvpwrvgnd_1$1
XFILLER_41_305 vssd1 vccd1 vccd1 vssd1 sky130_ef_sc_hd__decap_40_12$1
XFILLER_81_485 vssd1 vccd1 vccd1 vssd1 sky130_ef_sc_hd__decap_40_12$1
XFILLER_54_699 vccd1 vssd1 vccd1 vssd1 sky130_fd_sc_hd__fill_1$1
XFILLER_41_349 vssd1 vccd1 vccd1 vssd1 sky130_ef_sc_hd__decap_40_12$1
XFILLER_10_725 vssd1 vccd1 vccd1 vssd1 sky130_ef_sc_hd__decap_40_12$1
XFILLER_22_585 vssd1 vccd1 vccd1 vssd1 sky130_fd_sc_hd__fill_2$1
XFILLER_10_769 vccd1 vssd1 vccd1 vssd1 sky130_fd_sc_hd__fill_1$1
XFILLER_5_217 vssd1 vccd1 vccd1 vssd1 sky130_fd_sc_hd__fill_4$1
XTAP_TAPCELL_ROW_75_1427 vccd1 vssd1 sky130_fd_sc_hd__tapvpwrvgnd_1$1
XFILLER_107_167 vccd1 vssd1 vccd1 vssd1 sky130_fd_sc_hd__fill_1$1
XFILLER_30_77 vssd1 vccd1 vccd1 vssd1 sky130_fd_sc_hd__fill_4$1
XFILLER_123_649 vssd1 vccd1 vccd1 vssd1 sky130_ef_sc_hd__decap_40_12$1
XFILLER_122_137 vssd1 vccd1 vccd1 vssd1 sky130_fd_sc_hd__fill_2$1
XFILLER_116_690 vssd1 vccd1 vccd1 vssd1 sky130_fd_sc_hd__fill_8$1
XFILLER_89_541 vssd1 vccd1 vccd1 vssd1 sky130_ef_sc_hd__decap_40_12$1
XFILLER_1_445 vssd1 vccd1 vccd1 vssd1 sky130_fd_sc_hd__fill_2$1
XFILLER_49_405 vssd1 vccd1 vccd1 vssd1 sky130_ef_sc_hd__decap_40_12$1
XFILLER_131_671 vccd1 vssd1 vccd1 vssd1 sky130_fd_sc_hd__fill_1$1
XFILLER_103_373 vssd1 vccd1 vccd1 vssd1 sky130_ef_sc_hd__decap_40_12$1
XFILLER_77_725 vssd1 vccd1 vccd1 vssd1 sky130_fd_sc_hd__fill_2$1
XFILLER_49_449 vccd1 vssd1 vccd1 vssd1 sky130_fd_sc_hd__fill_1$1
XFILLER_91_205 vssd1 vccd1 vccd1 vssd1 sky130_ef_sc_hd__decap_40_12$1
XFILLER_64_419 vccd1 vssd1 vccd1 vssd1 sky130_fd_sc_hd__fill_1$1
XFILLER_91_249 vssd1 vccd1 vccd1 vssd1 sky130_ef_sc_hd__decap_40_12$1
XFILLER_17_335 vccd1 vssd1 vccd1 vssd1 sky130_fd_sc_hd__fill_1$1
XFILLER_44_121 vssd1 vccd1 vccd1 vssd1 sky130_ef_sc_hd__decap_40_12$1
XTAP_TAPCELL_ROW_86_1589 vccd1 vssd1 sky130_fd_sc_hd__tapvpwrvgnd_1$1
XFILLER_32_305 vssd1 vccd1 vccd1 vssd1 sky130_fd_sc_hd__fill_2$1
XFILLER_44_165 vssd1 vccd1 vccd1 vssd1 sky130_ef_sc_hd__decap_40_12$1
XFILLER_60_625 vssd1 vccd1 vccd1 vssd1 sky130_fd_sc_hd__fill_8$1
XTAP_TAPCELL_ROW_15_525 vccd1 vssd1 sky130_fd_sc_hd__tapvpwrvgnd_1$1
XFILLER_9_501 vssd1 vccd1 vccd1 vssd1 sky130_fd_sc_hd__fill_2$1
XFILLER_13_541 vssd1 vccd1 vccd1 vssd1 sky130_ef_sc_hd__decap_40_12$1
XFILLER_71_51 vssd1 vccd1 vccd1 vssd1 sky130_fd_sc_hd__fill_4$1
XFILLER_13_585 vssd1 vccd1 vccd1 vssd1 sky130_ef_sc_hd__decap_40_12$1
XFILLER_126_421 vssd1 vccd1 vccd1 vssd1 sky130_fd_sc_hd__fill_8$1
XTAP_TAPCELL_ROW_117_2055 vccd1 vssd1 sky130_fd_sc_hd__tapvpwrvgnd_1$1
XFILLER_138_281 vssd1 vccd1 vccd1 vssd1 sky130_fd_sc_hd__fill_2$1
XTAP_TAPCELL_ROW_130_2244 vccd1 vssd1 sky130_fd_sc_hd__tapvpwrvgnd_1$1
XFILLER_114_605 vssd1 vccd1 vccd1 vssd1 sky130_fd_sc_hd__fill_2$1
XFILLER_99_305 vssd1 vccd1 vccd1 vssd1 sky130_ef_sc_hd__decap_40_12$1
X_1520_ _1520_/Q clkload5/A _1520_/D vccd1 vssd1 vccd1 vssd1 sky130_fd_sc_hd__dfxtp_1$1
XTAP_TAPCELL_ROW_130_2255 vccd1 vssd1 sky130_fd_sc_hd__tapvpwrvgnd_1$1
XFILLER_113_137 vssd1 vccd1 vccd1 vssd1 sky130_ef_sc_hd__decap_40_12$1
X_1451_ _1455_/C1 _1450_/X _1465_/A2 hold120/X _1752_/D vssd1 vccd1 vccd1 vssd1 sky130_fd_sc_hd__o211a_1$1
XFILLER_99_349 vssd1 vccd1 vccd1 vssd1 sky130_ef_sc_hd__decap_40_12$1
X_1382_ _1382_/A _1382_/X _1398_/B vssd1 vccd1 vccd1 vssd1 sky130_fd_sc_hd__or2_1$1
XFILLER_122_693 vssd1 vccd1 vccd1 vssd1 sky130_fd_sc_hd__fill_4$1
XFILLER_121_181 vssd1 vccd1 vccd1 vssd1 sky130_ef_sc_hd__decap_40_12$1
XFILLER_96_81 vssd1 vccd1 vccd1 vssd1 sky130_fd_sc_hd__fill_2$1
XFILLER_95_555 vssd1 vccd1 vccd1 vssd1 sky130_fd_sc_hd__fill_4$1
XFILLER_68_769 vssd1 vccd1 vccd1 vssd1 sky130_ef_sc_hd__decap_40_12$1
XFILLER_67_279 vccd1 vssd1 vccd1 vssd1 sky130_fd_sc_hd__fill_1$1
XFILLER_82_249 vssd1 vccd1 vccd1 vssd1 sky130_fd_sc_hd__fill_2$1
XFILLER_91_783 vccd1 vssd1 vccd1 vssd1 sky130_fd_sc_hd__fill_1$1
XFILLER_51_614 vssd1 vccd1 vccd1 vssd1 sky130_fd_sc_hd__fill_2$1
XFILLER_23_305 vssd1 vccd1 vccd1 vssd1 sky130_ef_sc_hd__decap_40_12$1
XFILLER_24_817 vssd1 vccd1 vccd1 vssd1 sky130_fd_sc_hd__fill_2$1
XFILLER_35_165 vssd1 vccd1 vccd1 vssd1 sky130_fd_sc_hd__fill_2$1
XTAP_TAPCELL_ROW_34_812 vccd1 vssd1 sky130_fd_sc_hd__tapvpwrvgnd_1$1
XFILLER_36_699 vccd1 vssd1 vccd1 vssd1 sky130_fd_sc_hd__fill_1$1
XFILLER_51_658 vssd1 vccd1 vccd1 vssd1 sky130_fd_sc_hd__fill_8$1
XFILLER_23_349 vssd1 vccd1 vccd1 vssd1 sky130_ef_sc_hd__decap_40_12$1
XFILLER_31_393 vssd1 vccd1 vccd1 vssd1 sky130_ef_sc_hd__decap_40_12$1
XFILLER_129_281 vssd1 vccd1 vccd1 vssd1 sky130_ef_sc_hd__decap_40_12$1
XFILLER_117_421 vssd1 vccd1 vccd1 vssd1 sky130_ef_sc_hd__decap_40_12$1
X_1718_ _1718_/Q clkload7/A _1718_/D vccd1 vssd1 vccd1 vssd1 sky130_fd_sc_hd__dfxtp_1$1
XFILLER_2_209 vssd1 vccd1 vccd1 vssd1 sky130_ef_sc_hd__decap_40_12$1
XFILLER_104_137 vssd1 vccd1 vccd1 vssd1 sky130_fd_sc_hd__fill_2$1
X_1649_ _1649_/Q _1740_/CLK _1649_/D vccd1 vssd1 vccd1 vssd1 sky130_fd_sc_hd__dfxtp_1$1
XTAP_TAPCELL_ROW_57_1157 vccd1 vssd1 sky130_fd_sc_hd__tapvpwrvgnd_1$1
XFILLER_113_671 vccd1 vssd1 vccd1 vssd1 sky130_fd_sc_hd__fill_1$1
XFILLER_86_533 vssd1 vccd1 vccd1 vssd1 sky130_ef_sc_hd__decap_40_12$1
XFILLER_86_522 vssd1 vccd1 vccd1 vssd1 sky130_fd_sc_hd__fill_8$1
XFILLER_76_29 vssd1 vccd1 vccd1 vssd1 sky130_ef_sc_hd__decap_40_12$1
XTAP_TAPCELL_ROW_70_1357 vccd1 vssd1 sky130_fd_sc_hd__tapvpwrvgnd_1$1
XTAP_TAPCELL_ROW_70_1346 vccd1 vssd1 sky130_fd_sc_hd__tapvpwrvgnd_1$1
XFILLER_59_725 vssd1 vccd1 vccd1 vssd1 sky130_fd_sc_hd__fill_2$1
XFILLER_100_321 vssd1 vccd1 vccd1 vssd1 sky130_ef_sc_hd__decap_40_12$1
XFILLER_100_365 vssd1 vccd1 vccd1 vssd1 sky130_ef_sc_hd__decap_40_12$1
XFILLER_73_205 vssd1 vccd1 vccd1 vssd1 sky130_ef_sc_hd__decap_40_12$1
XFILLER_46_419 vccd1 vssd1 vccd1 vssd1 sky130_fd_sc_hd__fill_1$1
XFILLER_73_249 vssd1 vccd1 vccd1 vssd1 sky130_ef_sc_hd__decap_40_12$1
XFILLER_26_121 vssd1 vccd1 vccd1 vssd1 sky130_ef_sc_hd__decap_40_12$1
XFILLER_82_750 vssd1 vccd1 vccd1 vssd1 sky130_fd_sc_hd__fill_4$1
XFILLER_15_817 vccd1 vssd1 vccd1 vssd1 sky130_fd_sc_hd__fill_1$1
XFILLER_27_677 vccd1 vssd1 vccd1 vssd1 sky130_fd_sc_hd__fill_1$1
XFILLER_54_474 vssd1 vccd1 vccd1 vssd1 sky130_fd_sc_hd__fill_2$1
XFILLER_14_305 vssd1 vccd1 vccd1 vssd1 sky130_fd_sc_hd__fill_2$1
XFILLER_26_165 vssd1 vccd1 vccd1 vssd1 sky130_ef_sc_hd__decap_40_12$1
XFILLER_41_113 vssd1 vccd1 vccd1 vssd1 sky130_ef_sc_hd__decap_40_12$1
XFILLER_42_625 vssd1 vccd1 vccd1 vssd1 sky130_fd_sc_hd__fill_2$1
XFILLER_81_293 vssd1 vccd1 vccd1 vssd1 sky130_ef_sc_hd__decap_40_12$1
XFILLER_25_55 vccd1 vssd1 vccd1 vssd1 sky130_fd_sc_hd__fill_1$1
XFILLER_30_809 vssd1 vccd1 vccd1 vssd1 sky130_fd_sc_hd__fill_2$1
XFILLER_10_533 vssd1 vccd1 vccd1 vssd1 sky130_ef_sc_hd__decap_40_12$1
XFILLER_136_752 vssd1 vccd1 vccd1 vssd1 sky130_fd_sc_hd__fill_4$1
XFILLER_108_421 vssd1 vccd1 vccd1 vssd1 sky130_ef_sc_hd__decap_40_12$1
XFILLER_136_785 vssd1 vccd1 vccd1 vssd1 sky130_fd_sc_hd__fill_2$1
XFILLER_123_402 vccd1 vssd1 vccd1 vssd1 sky130_fd_sc_hd__fill_1$1
XTAP_TAPCELL_ROW_20_594 vccd1 vssd1 sky130_fd_sc_hd__tapvpwrvgnd_1$1
XFILLER_135_273 vssd1 vccd1 vccd1 vssd1 sky130_fd_sc_hd__fill_4$1
XFILLER_104_693 vssd1 vccd1 vccd1 vssd1 sky130_fd_sc_hd__fill_4$1
XFILLER_2_15 vssd1 vccd1 vccd1 vssd1 sky130_ef_sc_hd__decap_40_12$1
XFILLER_103_181 vssd1 vccd1 vccd1 vssd1 sky130_ef_sc_hd__decap_40_12$1
XTAP_TAPCELL_ROW_88_1618 vccd1 vssd1 sky130_fd_sc_hd__tapvpwrvgnd_1$1
XFILLER_49_279 vccd1 vssd1 vccd1 vssd1 sky130_fd_sc_hd__fill_1$1
XFILLER_64_249 vssd1 vccd1 vccd1 vssd1 sky130_fd_sc_hd__fill_2$1
XFILLER_92_569 vssd1 vccd1 vccd1 vssd1 sky130_ef_sc_hd__decap_40_12$1
XFILLER_45_441 vssd1 vccd1 vccd1 vssd1 sky130_fd_sc_hd__fill_4$1
XFILLER_73_783 vccd1 vssd1 vccd1 vssd1 sky130_fd_sc_hd__fill_1$1
XFILLER_17_165 vssd1 vccd1 vccd1 vssd1 sky130_fd_sc_hd__fill_2$1
XFILLER_18_699 vccd1 vssd1 vccd1 vssd1 sky130_fd_sc_hd__fill_1$1
XFILLER_45_485 vssd1 vccd1 vccd1 vssd1 sky130_ef_sc_hd__decap_40_12$1
XFILLER_82_83 vccd1 vssd1 vccd1 vssd1 sky130_fd_sc_hd__fill_1$1
XFILLER_21_809 vssd1 vccd1 vccd1 vssd1 sky130_ef_sc_hd__decap_40_12$1
XFILLER_33_647 vccd1 vssd1 vccd1 vssd1 sky130_fd_sc_hd__fill_1$1
XFILLER_60_477 vssd1 vccd1 vccd1 vssd1 sky130_fd_sc_hd__fill_4$1
X_0951_ _1091_/C1 _0950_/X _0991_/A2 hold78/X _1509_/D vssd1 vccd1 vccd1 vssd1 sky130_fd_sc_hd__o211a_1$1
XFILLER_13_393 vssd1 vccd1 vccd1 vssd1 sky130_ef_sc_hd__decap_40_12$1
X_0882_ _0882_/X _1015_/A _1812_/A _1562_/Q hold10/A vssd1 vccd1 _0881_/X vccd1 vssd1
+ sky130_fd_sc_hd__a221o_1$1
XFILLER_127_785 vssd1 vccd1 vccd1 vssd1 sky130_fd_sc_hd__fill_4$1
XFILLER_126_251 vccd1 vssd1 vccd1 vssd1 sky130_fd_sc_hd__fill_1$1
XFILLER_56_3 vssd1 vccd1 vccd1 vssd1 sky130_ef_sc_hd__decap_40_12$1
Xoutput116 _1820_/X analog_ctrl[49] vssd1 vccd1 vccd1 vssd1 sky130_fd_sc_hd__buf_12$1
Xoutput105 _1810_/X analog_ctrl[39] vssd1 vccd1 vccd1 vssd1 sky130_fd_sc_hd__buf_12$1
X_1503_ _1503_/Q _1760_/CLK _1503_/D vccd1 vssd1 vccd1 vssd1 sky130_fd_sc_hd__dfxtp_1$1
XFILLER_99_113 vssd1 vccd1 vccd1 vssd1 sky130_ef_sc_hd__decap_40_12$1
Xoutput149 _1652_/Q analog_ctrl[79] vssd1 vccd1 vccd1 vssd1 sky130_fd_sc_hd__buf_12$1
Xoutput138 _1642_/Q analog_ctrl[69] vssd1 vccd1 vccd1 vssd1 sky130_fd_sc_hd__buf_12$1
Xoutput127 _1830_/X analog_ctrl[59] vssd1 vccd1 vccd1 vssd1 sky130_fd_sc_hd__buf_12$1
XFILLER_114_457 vssd1 vccd1 vccd1 vssd1 sky130_ef_sc_hd__decap_40_12$1
XFILLER_88_809 vssd1 vccd1 vccd1 vssd1 sky130_fd_sc_hd__fill_2$1
XTAP_TAPCELL_ROW_110_1947 vccd1 vssd1 sky130_fd_sc_hd__tapvpwrvgnd_1$1
X_1434_ _1852_/A _1434_/X _1464_/B vssd1 vccd1 vccd1 vssd1 sky130_fd_sc_hd__or2_1$1
XFILLER_110_641 vssd1 vccd1 vccd1 vssd1 sky130_fd_sc_hd__fill_2$1
X_1365_ _1431_/C1 _1364_/X _1399_/A2 hold155/X _1710_/D vssd1 vccd1 vccd1 vssd1 sky130_fd_sc_hd__o211a_1$1
XTAP_TAPCELL_ROW_52_1076 vccd1 vssd1 sky130_fd_sc_hd__tapvpwrvgnd_1$1
XFILLER_95_385 vssd1 vccd1 vccd1 vssd1 sky130_fd_sc_hd__fill_4$1
XFILLER_83_503 vccd1 vssd1 vccd1 vssd1 sky130_fd_sc_hd__fill_1$1
XFILLER_55_205 vssd1 vccd1 vccd1 vssd1 sky130_ef_sc_hd__decap_40_12$1
XTAP_TAPCELL_ROW_52_1087 vccd1 vssd1 sky130_fd_sc_hd__tapvpwrvgnd_1$1
XFILLER_28_419 vccd1 vssd1 vccd1 vssd1 sky130_fd_sc_hd__fill_1$1
XFILLER_110_696 vssd1 vccd1 vccd1 vssd1 sky130_fd_sc_hd__fill_4$1
X_1296_ _1296_/A _1296_/X _1330_/B vssd1 vccd1 vccd1 vssd1 sky130_fd_sc_hd__or2_1$1
XFILLER_55_249 vssd1 vccd1 vccd1 vssd1 sky130_ef_sc_hd__decap_40_12$1
XFILLER_102_27 vccd1 vssd1 vccd1 vssd1 sky130_fd_sc_hd__fill_1$1
XFILLER_23_113 vssd1 vccd1 vccd1 vssd1 sky130_ef_sc_hd__decap_40_12$1
XFILLER_24_625 vssd1 vccd1 vccd1 vssd1 sky130_ef_sc_hd__decap_40_12$1
XFILLER_63_293 vssd1 vccd1 vccd1 vssd1 sky130_ef_sc_hd__decap_40_12$1
XFILLER_12_809 vssd1 vccd1 vccd1 vssd1 sky130_fd_sc_hd__fill_2$1
XFILLER_24_669 vssd1 vccd1 vccd1 vssd1 sky130_ef_sc_hd__decap_40_12$1
XFILLER_118_763 vccd1 vssd1 vccd1 vssd1 sky130_fd_sc_hd__fill_1$1
XFILLER_11_57 vssd1 vccd1 vccd1 vssd1 sky130_ef_sc_hd__decap_40_12$1
XFILLER_132_221 vssd1 vccd1 vccd1 vssd1 sky130_ef_sc_hd__decap_40_12$1
XFILLER_127_57 vssd1 vccd1 vccd1 vssd1 sky130_ef_sc_hd__decap_40_12$1
XFILLER_117_273 vssd1 vccd1 vccd1 vssd1 sky130_fd_sc_hd__fill_4$1
XFILLER_105_413 vssd1 vccd1 vccd1 vssd1 sky130_fd_sc_hd__fill_4$1
XFILLER_3_529 vssd1 vccd1 vccd1 vssd1 sky130_ef_sc_hd__decap_40_12$1
XFILLER_133_777 vssd1 vccd1 vccd1 vssd1 sky130_fd_sc_hd__fill_4$1
XFILLER_105_446 vssd1 vccd1 vccd1 vssd1 sky130_fd_sc_hd__fill_2$1
XFILLER_87_39 vssd1 vccd1 vccd1 vssd1 sky130_ef_sc_hd__decap_40_12$1
XFILLER_132_265 vssd1 vccd1 vccd1 vssd1 sky130_ef_sc_hd__decap_40_12$1
XFILLER_120_405 vssd1 vccd1 vccd1 vssd1 sky130_ef_sc_hd__decap_40_12$1
XFILLER_101_663 vssd1 vccd1 vccd1 vssd1 sky130_fd_sc_hd__fill_2$1
XFILLER_86_363 vccd1 vssd1 vccd1 vssd1 sky130_fd_sc_hd__fill_1$1
XTAP_TAPCELL_ROW_6_389 vccd1 vssd1 sky130_fd_sc_hd__tapvpwrvgnd_1$1
XFILLER_47_717 vssd1 vccd1 vccd1 vssd1 sky130_fd_sc_hd__fill_8$1
XFILLER_100_195 vccd1 vssd1 vccd1 vssd1 sky130_fd_sc_hd__fill_1$1
XFILLER_46_249 vssd1 vccd1 vccd1 vssd1 sky130_fd_sc_hd__fill_2$1
XFILLER_62_709 vssd1 vccd1 vccd1 vssd1 sky130_fd_sc_hd__fill_2$1
XFILLER_27_441 vssd1 vccd1 vccd1 vssd1 sky130_fd_sc_hd__fill_4$1
XFILLER_55_783 vccd1 vssd1 vccd1 vssd1 sky130_fd_sc_hd__fill_1$1
XFILLER_27_485 vssd1 vccd1 vccd1 vssd1 sky130_ef_sc_hd__decap_40_12$1
XFILLER_36_65 vssd1 vccd1 vccd1 vssd1 sky130_ef_sc_hd__decap_40_12$1
XTAP_TAPCELL_ROW_83_1548 vccd1 vssd1 sky130_fd_sc_hd__tapvpwrvgnd_1$1
XFILLER_15_669 vssd1 vccd1 vccd1 vssd1 sky130_fd_sc_hd__fill_2$1
XFILLER_42_433 vssd1 vccd1 vccd1 vssd1 sky130_ef_sc_hd__decap_40_12$1
XTAP_TAPCELL_ROW_25_675 vccd1 vssd1 sky130_fd_sc_hd__tapvpwrvgnd_1$1
XFILLER_42_477 vssd1 vccd1 vccd1 vssd1 sky130_ef_sc_hd__decap_40_12$1
XFILLER_52_53 vssd1 vccd1 vccd1 vssd1 sky130_ef_sc_hd__decap_40_12$1
Xinput18 hold24/A hold23/X vssd1 vccd1 vccd1 vssd1 sky130_fd_sc_hd__clkbuf_4$1
XFILLER_52_97 vssd1 vccd1 vccd1 vssd1 sky130_ef_sc_hd__decap_40_12$1
XFILLER_6_301 vssd1 vccd1 vccd1 vssd1 sky130_fd_sc_hd__fill_4$1
Xinput29 hold98/A hold97/X vssd1 vccd1 vccd1 vssd1 sky130_fd_sc_hd__clkbuf_4$1
XTAP_TAPCELL_ROW_114_2014 vccd1 vssd1 sky130_fd_sc_hd__tapvpwrvgnd_1$1
XTAP_TAPCELL_ROW_114_2003 vccd1 vssd1 sky130_fd_sc_hd__tapvpwrvgnd_1$1
XFILLER_109_741 vssd1 vccd1 vccd1 vssd1 sky130_fd_sc_hd__fill_8$1
XFILLER_10_363 vccd1 vssd1 vccd1 vssd1 sky130_fd_sc_hd__fill_1$1
XFILLER_109_785 vssd1 vccd1 vccd1 vssd1 sky130_fd_sc_hd__fill_4$1
XFILLER_108_251 vccd1 vssd1 vccd1 vssd1 sky130_fd_sc_hd__fill_1$1
XFILLER_6_345 vssd1 vccd1 vccd1 vssd1 sky130_ef_sc_hd__decap_40_12$1
XFILLER_123_221 vssd1 vccd1 vccd1 vssd1 sky130_fd_sc_hd__fill_2$1
XFILLER_6_389 vssd1 vccd1 vccd1 vssd1 sky130_ef_sc_hd__decap_40_12$1
XFILLER_124_755 vccd1 vssd1 vccd1 vssd1 sky130_fd_sc_hd__fill_1$1
XFILLER_97_617 vssd1 vccd1 vccd1 vssd1 sky130_ef_sc_hd__decap_40_12$1
XFILLER_111_449 vssd1 vccd1 vccd1 vssd1 sky130_ef_sc_hd__decap_40_12$1
XFILLER_93_823 vccd1 vssd1 vccd1 vssd1 sky130_fd_sc_hd__fill_1$1
XFILLER_65_503 vccd1 vssd1 vccd1 vssd1 sky130_fd_sc_hd__fill_1$1
XFILLER_37_205 vssd1 vccd1 vccd1 vssd1 sky130_ef_sc_hd__decap_40_12$1
X_1150_ _1793_/A _1150_/X _1188_/B vssd1 vccd1 vccd1 vssd1 sky130_fd_sc_hd__or2_1$1
XFILLER_92_333 vssd1 vccd1 vccd1 vssd1 sky130_ef_sc_hd__decap_40_12$1
XFILLER_77_385 vssd1 vccd1 vccd1 vssd1 sky130_fd_sc_hd__fill_4$1
X_1081_ _1081_/Y hold10/X _1411_/B vssd1 vccd1 vccd1 vssd1 sky130_fd_sc_hd__nand2_2$1
XTAP_TAPCELL_ROW_125_2176 vccd1 vssd1 sky130_fd_sc_hd__tapvpwrvgnd_1$1
XFILLER_37_249 vssd1 vccd1 vccd1 vssd1 sky130_ef_sc_hd__decap_40_12$1
XFILLER_92_377 vssd1 vccd1 vccd1 vssd1 sky130_ef_sc_hd__decap_40_12$1
XFILLER_93_93 vssd1 vccd1 vccd1 vssd1 sky130_ef_sc_hd__decap_40_12$1
XFILLER_61_753 vssd1 vccd1 vccd1 vssd1 sky130_ef_sc_hd__decap_40_12$1
XFILLER_45_293 vssd1 vccd1 vccd1 vssd1 sky130_ef_sc_hd__decap_40_12$1
XFILLER_61_797 vssd1 vccd1 vccd1 vssd1 sky130_ef_sc_hd__decap_40_12$1
XFILLER_21_617 vssd1 vccd1 vccd1 vssd1 sky130_ef_sc_hd__decap_40_12$1
XTAP_TAPCELL_ROW_44_962 vccd1 vssd1 sky130_fd_sc_hd__tapvpwrvgnd_1$1
X_0934_ _0752_/A _1506_/D _0932_/X _1409_/C1 _1506_/Q _0933_/X vssd1 vccd1 vccd1 vssd1
+ sky130_fd_sc_hd__o221a_1$1
XFILLER_119_505 vssd1 vccd1 vccd1 vssd1 sky130_fd_sc_hd__fill_4$1
XFILLER_9_161 vssd1 vccd1 vccd1 vssd1 sky130_fd_sc_hd__fill_4$1
XFILLER_119_538 vccd1 vssd1 vccd1 vssd1 sky130_fd_sc_hd__fill_1$1
X_0865_ _1147_/A _1623_/Q _0863_/X _0865_/X vccd1 vssd1 vccd1 vssd1 sky130_fd_sc_hd__a21o_1$1
XFILLER_127_582 vssd1 vccd1 vccd1 vssd1 sky130_fd_sc_hd__fill_4$1
X_0796_ _1816_/A _0878_/A2 _0796_/X _1783_/A _0875_/A2 vccd1 vssd1 vccd1 vssd1 sky130_fd_sc_hd__a22o_1$1
XFILLER_115_777 vssd1 vccd1 vccd1 vssd1 sky130_fd_sc_hd__fill_4$1
XFILLER_114_221 vssd1 vccd1 vccd1 vssd1 sky130_ef_sc_hd__decap_40_12$1
XFILLER_88_606 vssd1 vccd1 vccd1 vssd1 sky130_ef_sc_hd__decap_40_12$1
XTAP_TAPCELL_ROW_54_1116 vccd1 vssd1 sky130_fd_sc_hd__tapvpwrvgnd_1$1
XTAP_TAPCELL_ROW_54_1105 vccd1 vssd1 sky130_fd_sc_hd__tapvpwrvgnd_1$1
XFILLER_130_725 vssd1 vccd1 vccd1 vssd1 sky130_ef_sc_hd__decap_40_12$1
XFILLER_114_265 vssd1 vccd1 vccd1 vssd1 sky130_ef_sc_hd__decap_40_12$1
XFILLER_102_405 vssd1 vccd1 vccd1 vssd1 sky130_fd_sc_hd__fill_2$1
XFILLER_88_639 vssd1 vccd1 vccd1 vssd1 sky130_fd_sc_hd__fill_4$1
XFILLER_87_105 vssd1 vccd1 vccd1 vssd1 sky130_fd_sc_hd__fill_4$1
XFILLER_130_747 vssd1 vccd1 vccd1 vssd1 sky130_fd_sc_hd__fill_8$1
XFILLER_130_769 vssd1 vccd1 vccd1 vssd1 sky130_ef_sc_hd__decap_40_12$1
X_1417_ _1417_/C1 _1416_/X _1475_/A2 hold71/X _1735_/D vssd1 vccd1 vccd1 vssd1 sky130_fd_sc_hd__o211a_1$1
XFILLER_87_149 vssd1 vccd1 vccd1 vssd1 sky130_ef_sc_hd__decap_40_12$1
XFILLER_68_363 vccd1 vssd1 vccd1 vssd1 sky130_fd_sc_hd__fill_1$1
XFILLER_113_15 vssd1 vccd1 vccd1 vssd1 sky130_ef_sc_hd__decap_40_12$1
XFILLER_95_193 vssd1 vccd1 vccd1 vssd1 sky130_ef_sc_hd__decap_40_12$1
XFILLER_84_834 vssd1 vccd1 vccd1 vssd1 sky130_fd_sc_hd__fill_8$1
X_1348_ _1825_/A _1348_/X _1408_/B vssd1 vccd1 vccd1 vssd1 sky130_fd_sc_hd__or2_1$1
XFILLER_83_333 vssd1 vccd1 vccd1 vssd1 sky130_fd_sc_hd__fill_2$1
XTAP_TAPCELL_ROW_3_348 vccd1 vssd1 sky130_fd_sc_hd__tapvpwrvgnd_1$1
X_1279_ _1279_/Y _1279_/A _1411_/B vssd1 vccd1 vccd1 vssd1 sky130_fd_sc_hd__nand2_2$1
XFILLER_56_569 vssd1 vccd1 vccd1 vssd1 sky130_fd_sc_hd__fill_2$1
XFILLER_28_249 vssd1 vccd1 vccd1 vssd1 sky130_fd_sc_hd__fill_2$1
XFILLER_37_783 vccd1 vssd1 vccd1 vssd1 sky130_fd_sc_hd__fill_1$1
XFILLER_24_433 vssd1 vccd1 vccd1 vssd1 sky130_ef_sc_hd__decap_40_12$1
XTAP_TAPCELL_ROW_65_1278 vccd1 vssd1 sky130_fd_sc_hd__tapvpwrvgnd_1$1
XFILLER_11_105 vssd1 vccd1 vccd1 vssd1 sky130_fd_sc_hd__fill_4$1
XFILLER_24_477 vssd1 vccd1 vccd1 vssd1 sky130_ef_sc_hd__decap_40_12$1
XTAP_TAPCELL_ROW_22_623 vccd1 vssd1 sky130_fd_sc_hd__tapvpwrvgnd_1$1
XTAP_TAPCELL_ROW_22_634 vccd1 vssd1 sky130_fd_sc_hd__tapvpwrvgnd_1$1
XFILLER_11_149 vssd1 vccd1 vccd1 vssd1 sky130_ef_sc_hd__decap_40_12$1
XFILLER_7_109 vssd1 vccd1 vccd1 vssd1 sky130_fd_sc_hd__fill_2$1
XFILLER_4_805 vssd1 vccd1 vccd1 vssd1 sky130_fd_sc_hd__fill_4$1
XFILLER_106_733 vssd1 vccd1 vccd1 vssd1 sky130_ef_sc_hd__decap_40_12$1
XFILLER_98_27 vccd1 vssd1 vccd1 vssd1 sky130_fd_sc_hd__fill_1$1
XFILLER_106_755 vccd1 vssd1 vccd1 vssd1 sky130_fd_sc_hd__fill_1$1
XFILLER_105_221 vssd1 vccd1 vccd1 vssd1 sky130_fd_sc_hd__fill_2$1
XFILLER_3_337 vssd1 vccd1 vccd1 vssd1 sky130_ef_sc_hd__decap_40_12$1
XFILLER_133_585 vssd1 vccd1 vccd1 vssd1 sky130_ef_sc_hd__decap_40_12$1
XFILLER_121_725 vssd1 vccd1 vccd1 vssd1 sky130_fd_sc_hd__fill_2$1
XFILLER_79_617 vssd1 vccd1 vccd1 vssd1 sky130_ef_sc_hd__decap_40_12$1
XPHY_EDGE_ROW_110_Right_110 vccd1 vssd1 vccd1 vssd1 sky130_fd_sc_hd__decap_3$1
XFILLER_75_823 vccd1 vssd1 vccd1 vssd1 sky130_fd_sc_hd__fill_1$1
XFILLER_19_205 vssd1 vccd1 vccd1 vssd1 sky130_ef_sc_hd__decap_40_12$1
XFILLER_47_503 vccd1 vssd1 vccd1 vssd1 sky130_fd_sc_hd__fill_1$1
XFILLER_74_333 vssd1 vccd1 vccd1 vssd1 sky130_ef_sc_hd__decap_40_12$1
XFILLER_59_385 vccd1 vssd1 vccd1 vssd1 sky130_fd_sc_hd__fill_1$1
XFILLER_86_193 vssd1 vccd1 vccd1 vssd1 sky130_fd_sc_hd__fill_2$1
XFILLER_19_249 vssd1 vccd1 vccd1 vssd1 sky130_ef_sc_hd__decap_40_12$1
XFILLER_47_558 vssd1 vccd1 vccd1 vssd1 sky130_fd_sc_hd__fill_2$1
XFILLER_74_377 vssd1 vccd1 vccd1 vssd1 sky130_fd_sc_hd__fill_2$1
XFILLER_103_81 vssd1 vccd1 vccd1 vssd1 sky130_ef_sc_hd__decap_40_12$1
XFILLER_27_293 vssd1 vccd1 vccd1 vssd1 sky130_ef_sc_hd__decap_40_12$1
XTAP_TAPCELL_ROW_120_2095 vccd1 vssd1 sky130_fd_sc_hd__tapvpwrvgnd_1$1
XTAP_TAPCELL_ROW_41_910 vccd1 vssd1 sky130_fd_sc_hd__tapvpwrvgnd_1$1
XTAP_TAPCELL_ROW_41_921 vccd1 vssd1 sky130_fd_sc_hd__tapvpwrvgnd_1$1
XFILLER_43_797 vssd1 vccd1 vccd1 vssd1 sky130_ef_sc_hd__decap_40_12$1
XFILLER_30_469 vssd1 vccd1 vccd1 vssd1 sky130_fd_sc_hd__fill_4$1
XFILLER_128_357 vssd1 vccd1 vccd1 vssd1 sky130_fd_sc_hd__fill_4$1
XTAP_TAPCELL_ROW_96_1739 vccd1 vssd1 sky130_fd_sc_hd__tapvpwrvgnd_1$1
XFILLER_10_193 vssd1 vccd1 vccd1 vssd1 sky130_fd_sc_hd__fill_2$1
XFILLER_7_665 vssd1 vccd1 vccd1 vssd1 sky130_fd_sc_hd__fill_4$1
XFILLER_6_153 vssd1 vccd1 vccd1 vssd1 sky130_ef_sc_hd__decap_40_12$1
XFILLER_124_530 vssd1 vccd1 vccd1 vssd1 sky130_fd_sc_hd__fill_2$1
XFILLER_6_197 vssd1 vccd1 vccd1 vssd1 sky130_ef_sc_hd__decap_40_12$1
XFILLER_112_725 vssd1 vccd1 vccd1 vssd1 sky130_ef_sc_hd__decap_40_12$1
XFILLER_69_105 vssd1 vccd1 vccd1 vssd1 sky130_fd_sc_hd__fill_4$1
XFILLER_112_747 vccd1 vssd1 vccd1 vssd1 sky130_fd_sc_hd__fill_1$1
XFILLER_112_769 vssd1 vccd1 vccd1 vssd1 sky130_fd_sc_hd__fill_8$1
XFILLER_97_436 vssd1 vccd1 vccd1 vssd1 sky130_ef_sc_hd__decap_40_12$1
XFILLER_85_609 vssd1 vccd1 vccd1 vssd1 sky130_fd_sc_hd__fill_4$1
XFILLER_69_149 vssd1 vccd1 vccd1 vssd1 sky130_ef_sc_hd__decap_40_12$1
XTAP_TAPCELL_ROW_127_2205 vccd1 vssd1 sky130_fd_sc_hd__tapvpwrvgnd_1$1
XFILLER_111_279 vccd1 vssd1 vccd1 vssd1 sky130_fd_sc_hd__fill_1$1
X_1202_ _1202_/A _1202_/X _1210_/B vssd1 vccd1 vccd1 vssd1 sky130_fd_sc_hd__or2_1$1
XFILLER_19_3 vssd1 vccd1 vccd1 vssd1 sky130_ef_sc_hd__decap_40_12$1
XFILLER_38_525 vssd1 vccd1 vccd1 vssd1 sky130_fd_sc_hd__fill_4$1
X_1133_ _1461_/C1 _1132_/X _1145_/A2 hold81/X _1598_/D vssd1 vccd1 vccd1 vssd1 sky130_fd_sc_hd__o211a_1$1
XFILLER_92_141 vssd1 vccd1 vccd1 vssd1 sky130_ef_sc_hd__decap_40_12$1
XFILLER_77_193 vssd1 vccd1 vccd1 vssd1 sky130_ef_sc_hd__decap_40_12$1
XFILLER_65_333 vssd1 vccd1 vccd1 vssd1 sky130_fd_sc_hd__fill_2$1
XTAP_TAPCELL_ROW_0_307 vccd1 vssd1 sky130_fd_sc_hd__tapvpwrvgnd_1$1
X_1064_ _1064_/A _1064_/X _1078_/B vssd1 vccd1 vccd1 vssd1 sky130_fd_sc_hd__or2_1$1
XFILLER_93_697 vssd1 vccd1 vccd1 vssd1 sky130_fd_sc_hd__fill_4$1
XFILLER_53_517 vssd1 vccd1 vccd1 vssd1 sky130_ef_sc_hd__decap_40_12$1
XFILLER_19_783 vccd1 vssd1 vccd1 vssd1 sky130_fd_sc_hd__fill_1$1
XFILLER_34_753 vssd1 vccd1 vccd1 vssd1 sky130_fd_sc_hd__fill_2$1
XTAP_TAPCELL_ROW_105_1879 vccd1 vssd1 sky130_fd_sc_hd__tapvpwrvgnd_1$1
XTAP_TAPCELL_ROW_105_1868 vccd1 vssd1 sky130_fd_sc_hd__tapvpwrvgnd_1$1
XFILLER_80_369 vccd1 vssd1 vccd1 vssd1 sky130_fd_sc_hd__fill_1$1
Xclkbuf_leaf_0_wb_clk_i clkload2/A clkload0/A vssd1 vccd1 vccd1 vssd1 sky130_fd_sc_hd__clkbuf_8$1
XFILLER_61_561 vssd1 vccd1 vccd1 vssd1 sky130_ef_sc_hd__decap_40_12$1
XFILLER_34_764 vssd1 vccd1 vccd1 vssd1 sky130_fd_sc_hd__fill_8$1
XFILLER_21_447 vccd1 vssd1 vccd1 vssd1 sky130_fd_sc_hd__fill_1$1
XTAP_TAPCELL_ROW_138_2389 vccd1 vssd1 sky130_fd_sc_hd__tapvpwrvgnd_1$1
XTAP_TAPCELL_ROW_138_2378 vccd1 vssd1 sky130_fd_sc_hd__tapvpwrvgnd_1$1
XTAP_TAPCELL_ROW_138_2367 vccd1 vssd1 sky130_fd_sc_hd__tapvpwrvgnd_1$1
X_0917_ _1728_/Q _1344_/A _0917_/X _1760_/Q _1411_/A vccd1 vssd1 vccd1 vssd1 sky130_fd_sc_hd__a22o_1$1
XFILLER_119_335 vccd1 vssd1 vccd1 vssd1 sky130_fd_sc_hd__fill_1$1
XFILLER_134_305 vssd1 vccd1 vccd1 vssd1 sky130_fd_sc_hd__fill_2$1
XFILLER_107_519 vccd1 vssd1 vccd1 vssd1 sky130_fd_sc_hd__fill_1$1
XTAP_TAPCELL_ROW_60_1197 vccd1 vssd1 sky130_fd_sc_hd__tapvpwrvgnd_1$1
XFILLER_135_839 vccd1 vssd1 vccd1 vssd1 sky130_fd_sc_hd__fill_1$1
XFILLER_108_15 vssd1 vccd1 vccd1 vssd1 sky130_ef_sc_hd__decap_40_12$1
X_0848_ _0879_/B1 _0848_/X _0847_/X _1620_/Q _0878_/A2 _0846_/X vssd1 vccd1 vccd1
+ vssd1 sky130_fd_sc_hd__a2111o_1$1
XFILLER_115_541 vssd1 vccd1 vccd1 vssd1 sky130_ef_sc_hd__decap_40_12$1
X_0779_ _0779_/X _0906_/B1 _1845_/A _1641_/Q _0881_/B1 vssd1 vccd1 _0778_/X vccd1
+ vssd1 sky130_fd_sc_hd__a221o_1$1
XTAP_TAPCELL_ROW_8_418 vccd1 vssd1 sky130_fd_sc_hd__tapvpwrvgnd_1$1
XFILLER_130_511 vccd1 vssd1 vccd1 vssd1 sky130_fd_sc_hd__fill_1$1
XFILLER_0_307 vccd1 vssd1 vccd1 vssd1 sky130_fd_sc_hd__fill_1$1
XFILLER_103_736 vssd1 vccd1 vccd1 vssd1 sky130_fd_sc_hd__fill_8$1
XFILLER_29_503 vccd1 vssd1 vccd1 vssd1 sky130_fd_sc_hd__fill_1$1
XFILLER_84_29 vssd1 vccd1 vccd1 vssd1 sky130_ef_sc_hd__decap_40_12$1
XFILLER_72_804 vssd1 vccd1 vccd1 vssd1 sky130_fd_sc_hd__fill_8$1
XFILLER_68_193 vssd1 vccd1 vccd1 vssd1 sky130_fd_sc_hd__fill_2$1
XTAP_TAPCELL_ROW_67_1307 vccd1 vssd1 sky130_fd_sc_hd__tapvpwrvgnd_1$1
XFILLER_56_333 vssd1 vccd1 vccd1 vssd1 sky130_ef_sc_hd__decap_40_12$1
XFILLER_17_709 vssd1 vccd1 vccd1 vssd1 sky130_ef_sc_hd__decap_40_12$1
XFILLER_84_697 vssd1 vccd1 vccd1 vssd1 sky130_fd_sc_hd__fill_2$1
XFILLER_56_399 vssd1 vccd1 vccd1 vssd1 sky130_ef_sc_hd__decap_40_12$1
XFILLER_56_377 vssd1 vccd1 vccd1 vssd1 sky130_fd_sc_hd__fill_4$1
XTAP_TAPCELL_ROW_27_704 vccd1 vssd1 sky130_fd_sc_hd__tapvpwrvgnd_1$1
XTAP_TAPCELL_ROW_80_1507 vccd1 vssd1 sky130_fd_sc_hd__tapvpwrvgnd_1$1
XFILLER_40_701 vssd1 vccd1 vccd1 vssd1 sky130_fd_sc_hd__fill_2$1
XFILLER_40_734 vssd1 vccd1 vccd1 vssd1 sky130_ef_sc_hd__decap_40_12$1
XFILLER_12_469 vssd1 vccd1 vccd1 vssd1 sky130_fd_sc_hd__fill_4$1
XFILLER_33_55 vccd1 vssd1 vccd1 vssd1 sky130_fd_sc_hd__fill_1$1
XFILLER_137_121 vssd1 vccd1 vccd1 vssd1 sky130_fd_sc_hd__fill_2$1
XFILLER_137_110 vssd1 vccd1 vccd1 vssd1 sky130_fd_sc_hd__fill_2$1
XFILLER_126_806 vssd1 vccd1 vccd1 vssd1 sky130_fd_sc_hd__fill_4$1
XFILLER_125_305 vssd1 vccd1 vccd1 vssd1 sky130_ef_sc_hd__decap_40_12$1
XFILLER_123_3 vssd1 vccd1 vccd1 vssd1 sky130_ef_sc_hd__decap_40_12$1
XFILLER_138_699 vccd1 vssd1 vccd1 vssd1 sky130_fd_sc_hd__fill_1$1
XTAP_TAPCELL_ROW_78_1469 vccd1 vssd1 sky130_fd_sc_hd__tapvpwrvgnd_1$1
XFILLER_4_613 vssd1 vccd1 vccd1 vssd1 sky130_ef_sc_hd__decap_40_12$1
XFILLER_125_349 vssd1 vccd1 vccd1 vssd1 sky130_ef_sc_hd__decap_40_12$1
XFILLER_4_657 vssd1 vccd1 vccd1 vssd1 sky130_ef_sc_hd__decap_40_12$1
XFILLER_121_500 vssd1 vccd1 vccd1 vssd1 sky130_fd_sc_hd__fill_4$1
XFILLER_3_167 vccd1 vssd1 vccd1 vssd1 sky130_fd_sc_hd__fill_1$1
XTAP_TAPCELL_ROW_91_1669 vccd1 vssd1 sky130_fd_sc_hd__tapvpwrvgnd_1$1
XTAP_TAPCELL_ROW_91_1658 vccd1 vssd1 sky130_fd_sc_hd__tapvpwrvgnd_1$1
XFILLER_0_841 vccd1 vssd1 vccd1 vssd1 sky130_fd_sc_hd__fill_1$1
XFILLER_58_41 vssd1 vccd1 vccd1 vssd1 sky130_ef_sc_hd__decap_40_12$1
Xhold7 wbs_adr_i[3] hold7/X vssd1 vccd1 vccd1 vssd1 sky130_fd_sc_hd__dlygate4sd3_1$1
XFILLER_102_791 vssd1 vccd1 vccd1 vssd1 sky130_fd_sc_hd__fill_8$1
XFILLER_87_480 vssd1 vccd1 vccd1 vssd1 sky130_fd_sc_hd__fill_8$1
XFILLER_58_85 vssd1 vccd1 vccd1 vssd1 sky130_ef_sc_hd__decap_40_12$1
XFILLER_74_141 vssd1 vccd1 vccd1 vssd1 sky130_ef_sc_hd__decap_40_12$1
XFILLER_59_193 vssd1 vccd1 vccd1 vssd1 sky130_ef_sc_hd__decap_40_12$1
XFILLER_47_333 vssd1 vccd1 vccd1 vssd1 sky130_fd_sc_hd__fill_2$1
XTAP_TAPCELL_ROW_122_2124 vccd1 vssd1 sky130_fd_sc_hd__tapvpwrvgnd_1$1
XFILLER_90_601 vssd1 vccd1 vccd1 vssd1 sky130_ef_sc_hd__decap_40_12$1
XFILLER_35_517 vssd1 vccd1 vccd1 vssd1 sky130_ef_sc_hd__decap_40_12$1
XTAP_TAPCELL_ROW_122_2135 vccd1 vssd1 sky130_fd_sc_hd__tapvpwrvgnd_1$1
XFILLER_90_645 vssd1 vccd1 vccd1 vssd1 sky130_ef_sc_hd__decap_40_12$1
XFILLER_16_731 vssd1 vccd1 vccd1 vssd1 sky130_ef_sc_hd__decap_40_12$1
XFILLER_43_561 vccd1 vssd1 vccd1 vssd1 sky130_fd_sc_hd__fill_1$1
X_1820_ _1820_/A _1820_/X vssd1 vccd1 vccd1 vssd1 sky130_fd_sc_hd__clkbuf_2$1
XFILLER_30_233 vssd1 vccd1 vccd1 vssd1 sky130_ef_sc_hd__decap_40_12$1
XFILLER_128_121 vssd1 vccd1 vccd1 vssd1 sky130_ef_sc_hd__decap_40_12$1
XFILLER_90_83 vccd1 vssd1 vccd1 vssd1 sky130_fd_sc_hd__fill_1$1
XFILLER_30_277 vssd1 vccd1 vccd1 vssd1 sky130_ef_sc_hd__decap_40_12$1
XTAP_TAPCELL_ROW_100_1798 vccd1 vssd1 sky130_fd_sc_hd__tapvpwrvgnd_1$1
X_1751_ _1751_/Q clkload6/A _1751_/D vccd1 vssd1 vccd1 vssd1 sky130_fd_sc_hd__dfxtp_1$1
XTAP_TAPCELL_ROW_13_497 vccd1 vssd1 sky130_fd_sc_hd__tapvpwrvgnd_1$1
XFILLER_128_165 vssd1 vccd1 vccd1 vssd1 sky130_ef_sc_hd__decap_40_12$1
XFILLER_116_305 vssd1 vccd1 vccd1 vssd1 sky130_fd_sc_hd__fill_2$1
X_1682_ hold44/A _1748_/CLK _1682_/D vccd1 vssd1 vccd1 vssd1 sky130_fd_sc_hd__dfxtp_1$1
XFILLER_7_473 vssd1 vccd1 vccd1 vssd1 sky130_ef_sc_hd__decap_40_12$1
XFILLER_99_81 vssd1 vccd1 vccd1 vssd1 sky130_ef_sc_hd__decap_40_12$1
XTAP_TAPCELL_ROW_133_2297 vccd1 vssd1 sky130_fd_sc_hd__tapvpwrvgnd_1$1
XFILLER_98_712 vssd1 vccd1 vccd1 vssd1 sky130_ef_sc_hd__decap_40_12$1
XFILLER_112_533 vssd1 vccd1 vccd1 vssd1 sky130_ef_sc_hd__decap_40_12$1
XFILLER_97_277 vssd1 vccd1 vccd1 vssd1 sky130_fd_sc_hd__fill_2$1
XFILLER_85_417 vssd1 vccd1 vccd1 vssd1 sky130_fd_sc_hd__fill_2$1
XFILLER_39_812 vccd1 vssd1 vccd1 vssd1 sky130_fd_sc_hd__fill_1$1
XTAP_TAPCELL_ROW_107_1908 vccd1 vssd1 sky130_fd_sc_hd__tapvpwrvgnd_1$1
XFILLER_66_642 vssd1 vccd1 vccd1 vssd1 sky130_fd_sc_hd__fill_2$1
XFILLER_38_333 vssd1 vccd1 vccd1 vssd1 sky130_ef_sc_hd__decap_40_12$1
XFILLER_93_461 vssd1 vccd1 vccd1 vssd1 sky130_ef_sc_hd__decap_40_12$1
X_1116_ _1808_/A _1116_/X _1122_/B vssd1 vccd1 vccd1 vssd1 sky130_fd_sc_hd__or2_1$1
XFILLER_38_377 vssd1 vccd1 vccd1 vssd1 sky130_ef_sc_hd__decap_40_12$1
XFILLER_81_645 vssd1 vccd1 vccd1 vssd1 sky130_ef_sc_hd__decap_40_12$1
XFILLER_80_133 vssd1 vccd1 vccd1 vssd1 sky130_fd_sc_hd__fill_4$1
XTAP_TAPCELL_ROW_49_1037 vccd1 vssd1 sky130_fd_sc_hd__tapvpwrvgnd_1$1
X_1047_ _1443_/C1 _1046_/X _1079_/A2 hold90/X hold91/A vssd1 vccd1 vccd1 vssd1 sky130_fd_sc_hd__o211a_1$1
XFILLER_0_81 vssd1 vccd1 vccd1 vssd1 sky130_fd_sc_hd__fill_2$1
XFILLER_22_701 vssd1 vccd1 vccd1 vssd1 sky130_fd_sc_hd__fill_4$1
XFILLER_110_27 vccd1 vssd1 vccd1 vssd1 sky130_fd_sc_hd__fill_1$1
XFILLER_80_177 vssd1 vccd1 vccd1 vssd1 sky130_ef_sc_hd__decap_40_12$1
XTAP_TAPCELL_ROW_62_1237 vccd1 vssd1 sky130_fd_sc_hd__tapvpwrvgnd_1$1
XTAP_TAPCELL_ROW_62_1226 vccd1 vssd1 sky130_fd_sc_hd__tapvpwrvgnd_1$1
XFILLER_22_723 vssd1 vccd1 vccd1 vssd1 sky130_ef_sc_hd__decap_40_12$1
XFILLER_61_391 vccd1 vssd1 vccd1 vssd1 sky130_fd_sc_hd__fill_1$1
XFILLER_21_277 vssd1 vccd1 vccd1 vssd1 sky130_fd_sc_hd__fill_2$1
XTAP_TAPCELL_ROW_32_773 vccd1 vssd1 sky130_fd_sc_hd__tapvpwrvgnd_1$1
XTAP_TAPCELL_ROW_32_784 vccd1 vssd1 sky130_fd_sc_hd__tapvpwrvgnd_1$1
XFILLER_119_165 vssd1 vccd1 vccd1 vssd1 sky130_fd_sc_hd__fill_2$1
XFILLER_119_69 vssd1 vccd1 vccd1 vssd1 sky130_ef_sc_hd__decap_40_12$1
XFILLER_107_305 vssd1 vccd1 vccd1 vssd1 sky130_ef_sc_hd__decap_40_12$1
XFILLER_123_809 vssd1 vccd1 vccd1 vssd1 sky130_ef_sc_hd__decap_40_12$1
XFILLER_107_349 vssd1 vccd1 vccd1 vssd1 sky130_ef_sc_hd__decap_40_12$1
XFILLER_115_393 vssd1 vccd1 vccd1 vssd1 sky130_ef_sc_hd__decap_40_12$1
XFILLER_88_233 vssd1 vccd1 vccd1 vssd1 sky130_ef_sc_hd__decap_40_12$1
XFILLER_135_57 vssd1 vccd1 vccd1 vssd1 sky130_ef_sc_hd__decap_40_12$1
XFILLER_130_363 vccd1 vssd1 vccd1 vssd1 sky130_fd_sc_hd__fill_1$1
XFILLER_95_39 vssd1 vccd1 vccd1 vssd1 sky130_ef_sc_hd__decap_40_12$1
XFILLER_76_417 vssd1 vccd1 vccd1 vssd1 sky130_fd_sc_hd__fill_2$1
XTAP_TAPCELL_ROW_73_1399 vccd1 vssd1 sky130_fd_sc_hd__tapvpwrvgnd_1$1
XTAP_TAPCELL_ROW_73_1388 vccd1 vssd1 sky130_fd_sc_hd__tapvpwrvgnd_1$1
XFILLER_49_609 vssd1 vccd1 vccd1 vssd1 sky130_fd_sc_hd__fill_4$1
XFILLER_0_137 vssd1 vccd1 vccd1 vssd1 sky130_fd_sc_hd__fill_2$1
XFILLER_88_277 vssd1 vccd1 vccd1 vssd1 sky130_ef_sc_hd__decap_40_12$1
XFILLER_29_333 vssd1 vccd1 vccd1 vssd1 sky130_fd_sc_hd__fill_2$1
XFILLER_57_697 vssd1 vccd1 vccd1 vssd1 sky130_ef_sc_hd__decap_40_12$1
XFILLER_56_141 vssd1 vccd1 vccd1 vssd1 sky130_ef_sc_hd__decap_40_12$1
XFILLER_17_517 vssd1 vccd1 vccd1 vssd1 sky130_ef_sc_hd__decap_40_12$1
XFILLER_28_77 vssd1 vccd1 vccd1 vssd1 sky130_fd_sc_hd__fill_4$1
XFILLER_71_111 vccd1 vssd1 vccd1 vssd1 sky130_fd_sc_hd__fill_1$1
XFILLER_25_561 vssd1 vccd1 vccd1 vssd1 sky130_ef_sc_hd__decap_40_12$1
XFILLER_44_65 vssd1 vccd1 vccd1 vssd1 sky130_ef_sc_hd__decap_40_12$1
XFILLER_12_233 vssd1 vccd1 vccd1 vssd1 sky130_ef_sc_hd__decap_40_12$1
XFILLER_9_727 vccd1 vssd1 vccd1 vssd1 sky130_fd_sc_hd__fill_1$1
XFILLER_40_531 vccd1 vssd1 vccd1 vssd1 sky130_fd_sc_hd__fill_1$1
XFILLER_12_277 vssd1 vccd1 vccd1 vssd1 sky130_ef_sc_hd__decap_40_12$1
XFILLER_60_53 vssd1 vccd1 vccd1 vssd1 sky130_ef_sc_hd__decap_40_12$1
XFILLER_125_113 vssd1 vccd1 vccd1 vssd1 sky130_ef_sc_hd__decap_40_12$1
XFILLER_60_97 vssd1 vccd1 vccd1 vssd1 sky130_ef_sc_hd__decap_40_12$1
XTAP_TAPCELL_ROW_10_456 vccd1 vssd1 sky130_fd_sc_hd__tapvpwrvgnd_1$1
XTAP_TAPCELL_ROW_10_445 vccd1 vssd1 sky130_fd_sc_hd__tapvpwrvgnd_1$1
XFILLER_126_669 vssd1 vccd1 vccd1 vssd1 sky130_fd_sc_hd__fill_2$1
XFILLER_114_809 vssd1 vccd1 vccd1 vssd1 sky130_fd_sc_hd__fill_2$1
XFILLER_5_15 vssd1 vccd1 vccd1 vssd1 sky130_ef_sc_hd__decap_40_12$1
XFILLER_4_421 vssd1 vccd1 vccd1 vssd1 sky130_ef_sc_hd__decap_40_12$1
XFILLER_69_51 vssd1 vccd1 vccd1 vssd1 sky130_fd_sc_hd__fill_4$1
XFILLER_121_363 vccd1 vssd1 vccd1 vssd1 sky130_fd_sc_hd__fill_1$1
XFILLER_95_726 vssd1 vccd1 vccd1 vssd1 sky130_fd_sc_hd__fill_2$1
XFILLER_79_277 vssd1 vccd1 vccd1 vssd1 sky130_fd_sc_hd__fill_2$1
XFILLER_67_417 vssd1 vccd1 vccd1 vssd1 sky130_ef_sc_hd__decap_40_12$1
XFILLER_0_671 vccd1 vssd1 vccd1 vssd1 sky130_fd_sc_hd__fill_1$1
XPHY_EDGE_ROW_13_Right_13 vccd1 vssd1 vccd1 vssd1 sky130_fd_sc_hd__decap_3$1
XFILLER_48_642 vssd1 vccd1 vccd1 vssd1 sky130_fd_sc_hd__fill_2$1
XFILLER_75_472 vssd1 vccd1 vccd1 vssd1 sky130_ef_sc_hd__decap_40_12$1
XFILLER_62_133 vssd1 vccd1 vccd1 vssd1 sky130_fd_sc_hd__fill_4$1
XFILLER_90_475 vccd1 vssd1 vccd1 vssd1 sky130_fd_sc_hd__fill_1$1
XFILLER_63_689 vssd1 vccd1 vccd1 vssd1 sky130_fd_sc_hd__fill_2$1
XFILLER_51_807 vccd1 vssd1 vccd1 vssd1 sky130_fd_sc_hd__fill_1$1
XTAP_TAPCELL_ROW_18_567 vccd1 vssd1 sky130_fd_sc_hd__tapvpwrvgnd_1$1
XTAP_TAPCELL_ROW_102_1827 vccd1 vssd1 sky130_fd_sc_hd__tapvpwrvgnd_1$1
XFILLER_62_177 vssd1 vccd1 vccd1 vssd1 sky130_ef_sc_hd__decap_40_12$1
XFILLER_31_553 vssd1 vccd1 vccd1 vssd1 sky130_fd_sc_hd__fill_4$1
XFILLER_43_391 vccd1 vssd1 vccd1 vssd1 sky130_fd_sc_hd__fill_1$1
XFILLER_86_3 vssd1 vccd1 vccd1 vssd1 sky130_ef_sc_hd__decap_40_12$1
XTAP_TAPCELL_ROW_135_2326 vccd1 vssd1 sky130_fd_sc_hd__tapvpwrvgnd_1$1
XPHY_EDGE_ROW_22_Right_22 vccd1 vssd1 vccd1 vssd1 sky130_fd_sc_hd__decap_3$1
XFILLER_31_597 vssd1 vccd1 vccd1 vssd1 sky130_ef_sc_hd__decap_40_12$1
X_1803_ _1803_/A _1803_/X vssd1 vccd1 vccd1 vssd1 sky130_fd_sc_hd__clkbuf_2$1
XFILLER_129_485 vssd1 vccd1 vccd1 vssd1 sky130_ef_sc_hd__decap_40_12$1
X_1734_ _1842_/A _1737_/CLK _1734_/D vccd1 vssd1 vccd1 vssd1 sky130_fd_sc_hd__dfxtp_1$1
XFILLER_117_647 vssd1 vccd1 vccd1 vssd1 sky130_ef_sc_hd__decap_40_12$1
XFILLER_105_809 vssd1 vccd1 vccd1 vssd1 sky130_ef_sc_hd__decap_40_12$1
Xhold215 _1712_/Q _1368_/A vssd1 vccd1 vccd1 vssd1 sky130_fd_sc_hd__dlygate4sd3_1$1
Xhold204 _1689_/Q _1320_/A vssd1 vccd1 vccd1 vssd1 sky130_fd_sc_hd__dlygate4sd3_1$1
XFILLER_8_793 vssd1 vccd1 vccd1 vssd1 sky130_ef_sc_hd__decap_40_12$1
XFILLER_7_281 vssd1 vccd1 vccd1 vssd1 sky130_ef_sc_hd__decap_40_12$1
XFILLER_132_617 vccd1 vssd1 vccd1 vssd1 sky130_fd_sc_hd__fill_1$1
XFILLER_131_105 vssd1 vccd1 vccd1 vssd1 sky130_fd_sc_hd__fill_4$1
X_1665_ _1665_/Q _1763_/CLK _1665_/D vccd1 vssd1 vccd1 vssd1 sky130_fd_sc_hd__dfxtp_1$1
X_1596_ hold27/A _1757_/CLK _1596_/D vccd1 vssd1 vccd1 vssd1 sky130_fd_sc_hd__dfxtp_1$1
XFILLER_132_639 vssd1 vccd1 vccd1 vssd1 sky130_fd_sc_hd__fill_4$1
XFILLER_98_531 vccd1 vssd1 vccd1 vssd1 sky130_fd_sc_hd__fill_1$1
XFILLER_131_149 vssd1 vccd1 vccd1 vssd1 sky130_ef_sc_hd__decap_40_12$1
XTAP_TAPCELL_ROW_113_1989 vccd1 vssd1 sky130_fd_sc_hd__tapvpwrvgnd_1$1
XFILLER_112_363 vccd1 vssd1 vccd1 vssd1 sky130_fd_sc_hd__fill_1$1
XFILLER_105_27 vssd1 vccd1 vccd1 vssd1 sky130_ef_sc_hd__decap_40_12$1
XFILLER_85_225 vssd1 vccd1 vccd1 vssd1 sky130_ef_sc_hd__decap_40_12$1
XFILLER_58_417 vssd1 vccd1 vccd1 vssd1 sky130_fd_sc_hd__fill_2$1
XPHY_EDGE_ROW_31_Right_31 vccd1 vssd1 vccd1 vssd1 sky130_fd_sc_hd__decap_3$1
XFILLER_94_781 vssd1 vccd1 vccd1 vssd1 sky130_ef_sc_hd__decap_40_12$1
XFILLER_38_141 vssd1 vccd1 vccd1 vssd1 sky130_ef_sc_hd__decap_40_12$1
XFILLER_121_15 vssd1 vccd1 vccd1 vssd1 sky130_ef_sc_hd__decap_40_12$1
XFILLER_81_420 vssd1 vccd1 vccd1 vssd1 sky130_ef_sc_hd__decap_40_12$1
XFILLER_54_645 vssd1 vccd1 vccd1 vssd1 sky130_fd_sc_hd__fill_8$1
XFILLER_53_111 vccd1 vssd1 vccd1 vssd1 sky130_fd_sc_hd__fill_1$1
XFILLER_39_697 vssd1 vccd1 vccd1 vssd1 sky130_fd_sc_hd__fill_2$1
XTAP_TAPCELL_ROW_37_854 vccd1 vssd1 sky130_fd_sc_hd__tapvpwrvgnd_1$1
XFILLER_81_497 vssd1 vccd1 vccd1 vssd1 sky130_fd_sc_hd__fill_4$1
XFILLER_41_317 vssd1 vccd1 vccd1 vssd1 sky130_ef_sc_hd__decap_40_12$1
XFILLER_50_840 vssd1 vccd1 vccd1 vssd1 sky130_fd_sc_hd__fill_2$1
XFILLER_22_531 vccd1 vssd1 vccd1 vssd1 sky130_fd_sc_hd__fill_1$1
XPHY_EDGE_ROW_40_Right_40 vccd1 vssd1 vccd1 vssd1 sky130_fd_sc_hd__decap_3$1
XFILLER_10_737 vssd1 vccd1 vccd1 vssd1 sky130_ef_sc_hd__decap_40_12$1
XFILLER_108_625 vssd1 vccd1 vccd1 vssd1 sky130_fd_sc_hd__fill_2$1
XFILLER_107_113 vssd1 vccd1 vccd1 vssd1 sky130_ef_sc_hd__decap_40_12$1
XTAP_TAPCELL_ROW_75_1428 vccd1 vssd1 sky130_fd_sc_hd__tapvpwrvgnd_1$1
XFILLER_135_499 vssd1 vccd1 vccd1 vssd1 sky130_fd_sc_hd__fill_4$1
XFILLER_89_553 vssd1 vccd1 vccd1 vssd1 sky130_fd_sc_hd__fill_4$1
XFILLER_49_417 vssd1 vccd1 vccd1 vssd1 sky130_ef_sc_hd__decap_40_12$1
XFILLER_130_193 vssd1 vccd1 vccd1 vssd1 sky130_fd_sc_hd__fill_2$1
XFILLER_91_217 vssd1 vccd1 vccd1 vssd1 sky130_fd_sc_hd__fill_4$1
XFILLER_57_461 vccd1 vssd1 vccd1 vssd1 sky130_fd_sc_hd__fill_1$1
XFILLER_44_133 vssd1 vccd1 vccd1 vssd1 sky130_fd_sc_hd__fill_4$1
XFILLER_72_475 vccd1 vssd1 vccd1 vssd1 sky130_fd_sc_hd__fill_1$1
XTAP_TAPCELL_ROW_15_526 vccd1 vssd1 sky130_fd_sc_hd__tapvpwrvgnd_1$1
XFILLER_44_177 vssd1 vccd1 vccd1 vssd1 sky130_ef_sc_hd__decap_40_12$1
XFILLER_111_81 vssd1 vccd1 vccd1 vssd1 sky130_ef_sc_hd__decap_40_12$1
XFILLER_13_553 vssd1 vccd1 vccd1 vssd1 sky130_fd_sc_hd__fill_4$1
XFILLER_25_391 vccd1 vssd1 vccd1 vssd1 sky130_fd_sc_hd__fill_1$1
XFILLER_40_361 vssd1 vccd1 vccd1 vssd1 sky130_fd_sc_hd__fill_2$1
XFILLER_9_557 vssd1 vccd1 vccd1 vssd1 sky130_fd_sc_hd__fill_2$1
XFILLER_13_597 vssd1 vccd1 vccd1 vssd1 sky130_ef_sc_hd__decap_40_12$1
XFILLER_126_400 vssd1 vccd1 vccd1 vssd1 sky130_fd_sc_hd__fill_2$1
XTAP_TAPCELL_ROW_117_2056 vccd1 vssd1 sky130_fd_sc_hd__tapvpwrvgnd_1$1
XFILLER_5_741 vssd1 vccd1 vccd1 vssd1 sky130_ef_sc_hd__decap_40_12$1
XFILLER_126_477 vssd1 vccd1 vccd1 vssd1 sky130_ef_sc_hd__decap_40_12$1
XFILLER_99_317 vssd1 vccd1 vccd1 vssd1 sky130_ef_sc_hd__decap_40_12$1
XFILLER_4_251 vccd1 vssd1 vccd1 vssd1 sky130_fd_sc_hd__fill_1$1
XTAP_TAPCELL_ROW_130_2256 vccd1 vssd1 sky130_fd_sc_hd__tapvpwrvgnd_1$1
XTAP_TAPCELL_ROW_130_2245 vccd1 vssd1 sky130_fd_sc_hd__tapvpwrvgnd_1$1
XFILLER_113_105 vssd1 vccd1 vccd1 vssd1 sky130_fd_sc_hd__fill_4$1
X_1450_ _1450_/A _1450_/X _1464_/B vssd1 vccd1 vccd1 vssd1 sky130_fd_sc_hd__or2_1$1
XFILLER_5_785 vssd1 vccd1 vccd1 vssd1 sky130_ef_sc_hd__decap_40_12$1
XFILLER_113_149 vssd1 vccd1 vccd1 vssd1 sky130_ef_sc_hd__decap_40_12$1
X_1381_ _1447_/C1 _1380_/X _1399_/A2 hold46/X _1718_/D vssd1 vccd1 vccd1 vssd1 sky130_fd_sc_hd__o211a_1$1
XFILLER_68_726 vssd1 vccd1 vccd1 vssd1 sky130_fd_sc_hd__fill_8$1
XFILLER_67_225 vssd1 vccd1 vccd1 vssd1 sky130_ef_sc_hd__decap_40_12$1
XFILLER_121_193 vssd1 vccd1 vccd1 vssd1 sky130_ef_sc_hd__decap_40_12$1
XFILLER_83_729 vssd1 vccd1 vccd1 vssd1 sky130_fd_sc_hd__fill_8$1
XFILLER_35_111 vccd1 vssd1 vccd1 vssd1 sky130_fd_sc_hd__fill_1$1
XFILLER_36_645 vssd1 vccd1 vccd1 vssd1 sky130_ef_sc_hd__decap_40_12$1
XPHY_EDGE_ROW_11_Left_150 vccd1 vssd1 vccd1 vssd1 sky130_fd_sc_hd__decap_3$1
XFILLER_23_317 vssd1 vccd1 vccd1 vssd1 sky130_ef_sc_hd__decap_40_12$1
XTAP_TAPCELL_ROW_34_813 vccd1 vssd1 sky130_fd_sc_hd__tapvpwrvgnd_1$1
XFILLER_31_361 vssd1 vccd1 vccd1 vssd1 sky130_ef_sc_hd__decap_40_12$1
XFILLER_129_293 vssd1 vccd1 vccd1 vssd1 sky130_ef_sc_hd__decap_40_12$1
XFILLER_117_433 vssd1 vccd1 vccd1 vssd1 sky130_fd_sc_hd__fill_2$1
X_1717_ hold39/A _1717_/CLK _1717_/D vccd1 vssd1 vccd1 vssd1 sky130_fd_sc_hd__dfxtp_1$1
XFILLER_105_617 vssd1 vccd1 vccd1 vssd1 sky130_ef_sc_hd__decap_40_12$1
XFILLER_116_15 vssd1 vccd1 vccd1 vssd1 sky130_ef_sc_hd__decap_40_12$1
X_1648_ _1648_/Q clkload2/A _1648_/D vccd1 vssd1 vccd1 vssd1 sky130_fd_sc_hd__dfxtp_2$1
XTAP_TAPCELL_ROW_57_1158 vccd1 vssd1 sky130_fd_sc_hd__tapvpwrvgnd_1$1
XFILLER_113_661 vssd1 vccd1 vccd1 vssd1 sky130_fd_sc_hd__fill_8$1
XFILLER_98_361 vssd1 vccd1 vccd1 vssd1 sky130_fd_sc_hd__fill_2$1
XTAP_TAPCELL_ROW_70_1347 vccd1 vssd1 sky130_fd_sc_hd__tapvpwrvgnd_1$1
X_1579_ _1797_/A _1579_/CLK _1579_/D vccd1 vssd1 vccd1 vssd1 sky130_fd_sc_hd__dfxtp_1$1
XFILLER_112_193 vssd1 vccd1 vccd1 vssd1 sky130_fd_sc_hd__fill_2$1
XFILLER_100_333 vssd1 vccd1 vccd1 vssd1 sky130_ef_sc_hd__decap_40_12$1
XFILLER_86_545 vssd1 vccd1 vccd1 vssd1 sky130_ef_sc_hd__decap_40_12$1
XFILLER_100_377 vssd1 vccd1 vccd1 vssd1 sky130_ef_sc_hd__decap_40_12$1
XFILLER_86_589 vssd1 vccd1 vccd1 vssd1 sky130_ef_sc_hd__decap_40_12$1
XFILLER_74_718 vssd1 vccd1 vccd1 vssd1 sky130_ef_sc_hd__decap_40_12$1
XFILLER_73_217 vssd1 vccd1 vccd1 vssd1 sky130_fd_sc_hd__fill_4$1
XFILLER_67_770 vssd1 vccd1 vccd1 vssd1 sky130_ef_sc_hd__decap_40_12$1
XFILLER_39_461 vssd1 vccd1 vccd1 vssd1 sky130_ef_sc_hd__decap_40_12$1
XFILLER_92_29 vssd1 vccd1 vccd1 vssd1 sky130_ef_sc_hd__decap_40_12$1
XFILLER_54_431 vccd1 vssd1 vccd1 vssd1 sky130_fd_sc_hd__fill_1$1
XFILLER_26_133 vssd1 vccd1 vccd1 vssd1 sky130_fd_sc_hd__fill_4$1
XFILLER_81_261 vssd1 vccd1 vccd1 vssd1 sky130_ef_sc_hd__decap_40_12$1
XFILLER_26_177 vssd1 vccd1 vccd1 vssd1 sky130_ef_sc_hd__decap_40_12$1
XFILLER_41_125 vssd1 vccd1 vccd1 vssd1 sky130_ef_sc_hd__decap_40_12$1
XFILLER_10_501 vssd1 vccd1 vccd1 vssd1 sky130_ef_sc_hd__decap_40_12$1
XFILLER_22_361 vssd1 vccd1 vccd1 vssd1 sky130_fd_sc_hd__fill_2$1
XFILLER_41_169 vssd1 vccd1 vccd1 vssd1 sky130_ef_sc_hd__decap_40_12$1
XFILLER_10_545 vssd1 vccd1 vccd1 vssd1 sky130_ef_sc_hd__decap_40_12$1
XFILLER_41_55 vccd1 vssd1 vccd1 vssd1 sky130_fd_sc_hd__fill_1$1
XFILLER_108_433 vssd1 vccd1 vccd1 vssd1 sky130_ef_sc_hd__decap_40_12$1
XFILLER_10_589 vssd1 vccd1 vccd1 vssd1 sky130_ef_sc_hd__decap_40_12$1
XFILLER_108_477 vssd1 vccd1 vccd1 vssd1 sky130_fd_sc_hd__fill_4$1
XTAP_TAPCELL_ROW_20_595 vccd1 vssd1 sky130_fd_sc_hd__tapvpwrvgnd_1$1
XFILLER_123_447 vccd1 vssd1 vccd1 vssd1 sky130_fd_sc_hd__fill_1$1
XFILLER_111_609 vssd1 vccd1 vccd1 vssd1 sky130_fd_sc_hd__fill_4$1
XFILLER_96_309 vssd1 vccd1 vccd1 vssd1 sky130_ef_sc_hd__decap_40_12$1
XFILLER_2_755 vccd1 vssd1 vccd1 vssd1 sky130_fd_sc_hd__fill_1$1
XFILLER_1_221 vssd1 vccd1 vccd1 vssd1 sky130_fd_sc_hd__fill_2$1
XFILLER_89_361 vssd1 vccd1 vccd1 vssd1 sky130_ef_sc_hd__decap_40_12$1
XFILLER_106_81 vssd1 vccd1 vccd1 vssd1 sky130_fd_sc_hd__fill_2$1
XFILLER_103_193 vssd1 vccd1 vccd1 vssd1 sky130_ef_sc_hd__decap_40_12$1
XFILLER_2_27 vccd1 vssd1 vccd1 vssd1 sky130_fd_sc_hd__fill_1$1
XFILLER_49_225 vssd1 vccd1 vccd1 vssd1 sky130_ef_sc_hd__decap_40_12$1
XTAP_TAPCELL_ROW_88_1619 vccd1 vssd1 sky130_fd_sc_hd__tapvpwrvgnd_1$1
XFILLER_66_41 vssd1 vccd1 vccd1 vssd1 sky130_ef_sc_hd__decap_40_12$1
XFILLER_65_729 vssd1 vccd1 vccd1 vssd1 sky130_ef_sc_hd__decap_40_12$1
XFILLER_18_601 vssd1 vccd1 vccd1 vssd1 sky130_ef_sc_hd__decap_40_12$1
XFILLER_66_85 vssd1 vccd1 vccd1 vssd1 sky130_ef_sc_hd__decap_40_12$1
XFILLER_17_111 vccd1 vssd1 vccd1 vssd1 sky130_fd_sc_hd__fill_1$1
XFILLER_18_645 vssd1 vccd1 vccd1 vssd1 sky130_ef_sc_hd__decap_40_12$1
XFILLER_45_453 vssd1 vccd1 vccd1 vssd1 sky130_fd_sc_hd__fill_2$1
XFILLER_60_401 vssd1 vccd1 vccd1 vssd1 sky130_ef_sc_hd__decap_40_12$1
XFILLER_33_615 vccd1 vssd1 vccd1 vssd1 sky130_fd_sc_hd__fill_1$1
XFILLER_45_497 vssd1 vccd1 vccd1 vssd1 sky130_fd_sc_hd__fill_4$1
XFILLER_13_361 vssd1 vccd1 vccd1 vssd1 sky130_ef_sc_hd__decap_40_12$1
XFILLER_20_309 vssd1 vccd1 vccd1 vssd1 sky130_ef_sc_hd__decap_40_12$1
X_0950_ _1781_/A _0950_/X _0990_/B vssd1 vccd1 vccd1 vssd1 sky130_fd_sc_hd__or2_1$1
X_0881_ _1530_/Q _0949_/A _0881_/X _1754_/Q _0881_/B1 vccd1 vssd1 vccd1 vssd1 sky130_fd_sc_hd__a22o_1$1
XPHY_EDGE_ROW_124_Right_124 vccd1 vssd1 vccd1 vssd1 sky130_fd_sc_hd__decap_3$1
Xoutput106 _1775_/X analog_ctrl[3] vssd1 vccd1 vccd1 vssd1 sky130_fd_sc_hd__buf_12$1
X_1502_ _1502_/Q _1633_/CLK _1502_/D vccd1 vssd1 vccd1 vssd1 sky130_fd_sc_hd__dfxtp_1$1
XFILLER_99_125 vssd1 vccd1 vccd1 vssd1 sky130_ef_sc_hd__decap_40_12$1
Xoutput117 _1776_/X analog_ctrl[4] vssd1 vccd1 vccd1 vssd1 sky130_fd_sc_hd__buf_12$1
Xoutput128 _1777_/X analog_ctrl[5] vssd1 vccd1 vccd1 vssd1 sky130_fd_sc_hd__buf_12$1
Xoutput139 _1778_/X analog_ctrl[6] vssd1 vccd1 vccd1 vssd1 sky130_fd_sc_hd__buf_12$1
XFILLER_114_469 vssd1 vccd1 vccd1 vssd1 sky130_fd_sc_hd__fill_4$1
XFILLER_99_169 vssd1 vccd1 vccd1 vssd1 sky130_ef_sc_hd__decap_40_12$1
X_1433_ _1435_/C1 _1432_/X _1475_/A2 hold142/X _1743_/D vssd1 vccd1 vccd1 vssd1 sky130_fd_sc_hd__o211a_1$1
XFILLER_49_3 vssd1 vccd1 vccd1 vssd1 sky130_ef_sc_hd__decap_40_12$1
XTAP_TAPCELL_ROW_110_1948 vccd1 vssd1 sky130_fd_sc_hd__tapvpwrvgnd_1$1
XFILLER_68_501 vssd1 vccd1 vccd1 vssd1 sky130_fd_sc_hd__fill_8$1
X_1364_ _1833_/A _1364_/X _1398_/B vssd1 vccd1 vccd1 vssd1 sky130_fd_sc_hd__or2_1$1
X_1295_ _1435_/C1 _1294_/X _1343_/A2 hold199/X _1676_/D vssd1 vccd1 vccd1 vssd1 sky130_fd_sc_hd__o211a_1$1
XFILLER_68_589 vssd1 vccd1 vccd1 vssd1 sky130_ef_sc_hd__decap_40_12$1
XFILLER_68_567 vssd1 vccd1 vccd1 vssd1 sky130_ef_sc_hd__decap_40_12$1
XTAP_TAPCELL_ROW_52_1077 vccd1 vssd1 sky130_fd_sc_hd__tapvpwrvgnd_1$1
XFILLER_83_548 vssd1 vccd1 vccd1 vssd1 sky130_ef_sc_hd__decap_40_12$1
XFILLER_55_217 vssd1 vccd1 vccd1 vssd1 sky130_fd_sc_hd__fill_4$1
XFILLER_70_209 vssd1 vccd1 vccd1 vssd1 sky130_ef_sc_hd__decap_40_12$1
XFILLER_63_261 vssd1 vccd1 vccd1 vssd1 sky130_ef_sc_hd__decap_40_12$1
XFILLER_24_637 vssd1 vccd1 vccd1 vssd1 sky130_fd_sc_hd__fill_4$1
XFILLER_36_475 vccd1 vssd1 vccd1 vssd1 sky130_fd_sc_hd__fill_1$1
XFILLER_23_125 vssd1 vccd1 vccd1 vssd1 sky130_ef_sc_hd__decap_40_12$1
XFILLER_23_169 vssd1 vccd1 vccd1 vssd1 sky130_ef_sc_hd__decap_40_12$1
XFILLER_20_821 vssd1 vccd1 vccd1 vssd1 sky130_fd_sc_hd__fill_2$1
XFILLER_118_786 vccd1 vssd1 vccd1 vssd1 sky130_fd_sc_hd__fill_1$1
XFILLER_118_753 vssd1 vccd1 vccd1 vssd1 sky130_fd_sc_hd__fill_2$1
XFILLER_11_69 vssd1 vccd1 vccd1 vssd1 sky130_ef_sc_hd__decap_40_12$1
XFILLER_132_233 vssd1 vccd1 vccd1 vssd1 sky130_ef_sc_hd__decap_40_12$1
XFILLER_127_69 vssd1 vccd1 vccd1 vssd1 sky130_ef_sc_hd__decap_40_12$1
XFILLER_78_309 vssd1 vccd1 vccd1 vssd1 sky130_ef_sc_hd__decap_40_12$1
XFILLER_132_277 vssd1 vccd1 vccd1 vssd1 sky130_ef_sc_hd__decap_40_12$1
XFILLER_120_417 vssd1 vccd1 vccd1 vssd1 sky130_fd_sc_hd__fill_2$1
XFILLER_101_675 vccd1 vssd1 vccd1 vssd1 sky130_fd_sc_hd__fill_1$1
XFILLER_100_141 vssd1 vccd1 vccd1 vssd1 sky130_ef_sc_hd__decap_40_12$1
XFILLER_47_729 vssd1 vccd1 vccd1 vssd1 sky130_ef_sc_hd__decap_40_12$1
XFILLER_82_581 vssd1 vccd1 vccd1 vssd1 sky130_fd_sc_hd__fill_4$1
XFILLER_15_615 vccd1 vssd1 vccd1 vssd1 sky130_fd_sc_hd__fill_1$1
XFILLER_36_77 vssd1 vccd1 vccd1 vssd1 sky130_fd_sc_hd__fill_4$1
XFILLER_42_401 vssd1 vccd1 vccd1 vssd1 sky130_ef_sc_hd__decap_40_12$1
XTAP_TAPCELL_ROW_83_1549 vccd1 vssd1 sky130_fd_sc_hd__tapvpwrvgnd_1$1
XTAP_TAPCELL_ROW_83_1538 vccd1 vssd1 sky130_fd_sc_hd__tapvpwrvgnd_1$1
XFILLER_27_497 vssd1 vccd1 vccd1 vssd1 sky130_fd_sc_hd__fill_4$1
XFILLER_42_445 vssd1 vccd1 vccd1 vssd1 sky130_ef_sc_hd__decap_40_12$1
Xclkbuf_leaf_24_wb_clk_i _1739_/CLK clkbuf_2_3__f_wb_clk_i/X vssd1 vccd1 vccd1 vssd1
+ sky130_fd_sc_hd__clkbuf_8$1
XTAP_TAPCELL_ROW_25_676 vccd1 vssd1 sky130_fd_sc_hd__tapvpwrvgnd_1$1
XFILLER_42_489 vssd1 vccd1 vccd1 vssd1 sky130_ef_sc_hd__decap_40_12$1
XFILLER_52_65 vssd1 vccd1 vccd1 vssd1 sky130_ef_sc_hd__decap_40_12$1
Xinput19 wbs_cyc_i _0947_/C vssd1 vccd1 vccd1 vssd1 sky130_fd_sc_hd__clkbuf_2$1
XTAP_TAPCELL_ROW_114_2004 vccd1 vssd1 sky130_fd_sc_hd__tapvpwrvgnd_1$1
XFILLER_109_720 vssd1 vccd1 vccd1 vssd1 sky130_fd_sc_hd__fill_8$1
XFILLER_124_701 vssd1 vccd1 vccd1 vssd1 sky130_ef_sc_hd__decap_40_12$1
XTAP_TAPCELL_ROW_114_2015 vccd1 vssd1 sky130_fd_sc_hd__tapvpwrvgnd_1$1
XTAP_TAPCELL_ROW_98_1770 vccd1 vssd1 sky130_fd_sc_hd__tapvpwrvgnd_1$1
XFILLER_6_357 vssd1 vccd1 vccd1 vssd1 sky130_fd_sc_hd__fill_4$1
XFILLER_123_277 vssd1 vccd1 vccd1 vssd1 sky130_fd_sc_hd__fill_2$1
XFILLER_97_629 vssd1 vccd1 vccd1 vssd1 sky130_ef_sc_hd__decap_40_12$1
XFILLER_111_439 vssd1 vccd1 vccd1 vssd1 sky130_fd_sc_hd__fill_8$1
XFILLER_96_139 vccd1 vssd1 vccd1 vssd1 sky130_fd_sc_hd__fill_1$1
XFILLER_77_51 vssd1 vccd1 vccd1 vssd1 sky130_fd_sc_hd__fill_4$1
XFILLER_2_585 vssd1 vccd1 vccd1 vssd1 sky130_fd_sc_hd__fill_2$1
XFILLER_92_301 vssd1 vccd1 vccd1 vssd1 sky130_fd_sc_hd__fill_4$1
XFILLER_37_217 vssd1 vccd1 vccd1 vssd1 sky130_fd_sc_hd__fill_4$1
X_1080_ _1140_/B _1411_/B hold10/A vccd1 vssd1 vccd1 vssd1 sky130_fd_sc_hd__and2_1$1
XTAP_TAPCELL_ROW_125_2177 vccd1 vssd1 sky130_fd_sc_hd__tapvpwrvgnd_1$1
XFILLER_92_345 vssd1 vccd1 vccd1 vssd1 sky130_ef_sc_hd__decap_40_12$1
XFILLER_92_389 vssd1 vccd1 vccd1 vssd1 sky130_ef_sc_hd__decap_40_12$1
XFILLER_80_529 vssd1 vccd1 vccd1 vssd1 sky130_fd_sc_hd__fill_2$1
XFILLER_52_209 vssd1 vccd1 vccd1 vssd1 sky130_ef_sc_hd__decap_40_12$1
XFILLER_18_475 vccd1 vssd1 vccd1 vssd1 sky130_fd_sc_hd__fill_1$1
XFILLER_45_261 vssd1 vccd1 vccd1 vssd1 sky130_ef_sc_hd__decap_40_12$1
XFILLER_46_795 vssd1 vccd1 vccd1 vssd1 sky130_ef_sc_hd__decap_40_12$1
XFILLER_33_445 vssd1 vccd1 vccd1 vssd1 sky130_fd_sc_hd__fill_2$1
XFILLER_61_765 vssd1 vccd1 vccd1 vssd1 sky130_ef_sc_hd__decap_40_12$1
XFILLER_60_253 vssd1 vccd1 vccd1 vssd1 sky130_ef_sc_hd__decap_40_12$1
XFILLER_21_629 vssd1 vccd1 vccd1 vssd1 sky130_ef_sc_hd__decap_40_12$1
XTAP_TAPCELL_ROW_44_963 vccd1 vssd1 sky130_fd_sc_hd__tapvpwrvgnd_1$1
XFILLER_14_681 vssd1 vccd1 vccd1 vssd1 sky130_ef_sc_hd__decap_40_12$1
XFILLER_20_139 vccd1 vssd1 vccd1 vssd1 sky130_fd_sc_hd__fill_1$1
X_0933_ _0945_/A _0933_/X _0933_/B _0933_/C vccd1 vssd1 vccd1 vssd1 sky130_fd_sc_hd__or3_1$1
X_0864_ _1809_/A _0879_/A2 _0864_/X _1527_/Q _0875_/A2 vccd1 vssd1 vccd1 vssd1 sky130_fd_sc_hd__a22o_1$1
XFILLER_127_561 vssd1 vccd1 vccd1 vssd1 sky130_ef_sc_hd__decap_40_12$1
XFILLER_127_594 vssd1 vccd1 vccd1 vssd1 sky130_ef_sc_hd__decap_40_12$1
X_0795_ _0880_/A2 _1483_/D _0791_/X _1431_/C1 _1483_/Q _0794_/X vssd1 vccd1 vccd1
+ vssd1 sky130_fd_sc_hd__o221a_1$1
XFILLER_114_233 vssd1 vccd1 vccd1 vssd1 sky130_ef_sc_hd__decap_40_12$1
XTAP_TAPCELL_ROW_54_1117 vccd1 vssd1 sky130_fd_sc_hd__tapvpwrvgnd_1$1
XTAP_TAPCELL_ROW_54_1106 vccd1 vssd1 sky130_fd_sc_hd__tapvpwrvgnd_1$1
XFILLER_130_737 vssd1 vccd1 vccd1 vssd1 sky130_fd_sc_hd__fill_4$1
XFILLER_114_277 vssd1 vccd1 vccd1 vssd1 sky130_ef_sc_hd__decap_40_12$1
X_1416_ _1843_/A _1416_/X _1474_/B vssd1 vccd1 vccd1 vssd1 sky130_fd_sc_hd__or2_1$1
XFILLER_110_450 vssd1 vccd1 vccd1 vssd1 sky130_fd_sc_hd__fill_8$1
X_1347_ _1421_/C1 _1346_/X _1409_/A2 hold78/X _1701_/D vssd1 vccd1 vccd1 vssd1 sky130_fd_sc_hd__o211a_1$1
XFILLER_3_81 vssd1 vccd1 vccd1 vssd1 sky130_ef_sc_hd__decap_40_12$1
XFILLER_29_729 vssd1 vccd1 vccd1 vssd1 sky130_ef_sc_hd__decap_40_12$1
XFILLER_113_27 vssd1 vccd1 vccd1 vssd1 sky130_ef_sc_hd__decap_40_12$1
XFILLER_95_161 vssd1 vccd1 vccd1 vssd1 sky130_fd_sc_hd__fill_4$1
XTAP_TAPCELL_ROW_3_349 vccd1 vssd1 sky130_fd_sc_hd__tapvpwrvgnd_1$1
XTAP_TAPCELL_ROW_3_338 vccd1 vssd1 sky130_fd_sc_hd__tapvpwrvgnd_1$1
X_1278_ _1278_/X _1411_/B _1279_/A vccd1 vssd1 vccd1 vssd1 sky130_fd_sc_hd__and2_1$1
XFILLER_52_721 vssd1 vccd1 vccd1 vssd1 sky130_fd_sc_hd__fill_4$1
XFILLER_24_401 vssd1 vccd1 vccd1 vssd1 sky130_ef_sc_hd__decap_40_12$1
XFILLER_24_445 vssd1 vccd1 vccd1 vssd1 sky130_ef_sc_hd__decap_40_12$1
XTAP_TAPCELL_ROW_65_1279 vccd1 vssd1 sky130_fd_sc_hd__tapvpwrvgnd_1$1
XTAP_TAPCELL_ROW_65_1268 vccd1 vssd1 sky130_fd_sc_hd__tapvpwrvgnd_1$1
XTAP_TAPCELL_ROW_22_624 vccd1 vssd1 sky130_fd_sc_hd__tapvpwrvgnd_1$1
XTAP_TAPCELL_ROW_22_635 vccd1 vssd1 sky130_fd_sc_hd__tapvpwrvgnd_1$1
XFILLER_24_489 vssd1 vccd1 vccd1 vssd1 sky130_ef_sc_hd__decap_40_12$1
XFILLER_138_57 vssd1 vccd1 vccd1 vssd1 sky130_fd_sc_hd__fill_2$1
XFILLER_106_701 vssd1 vccd1 vccd1 vssd1 sky130_ef_sc_hd__decap_40_12$1
XFILLER_3_305 vssd1 vccd1 vccd1 vssd1 sky130_ef_sc_hd__decap_40_12$1
XFILLER_106_745 vssd1 vccd1 vccd1 vssd1 sky130_fd_sc_hd__fill_8$1
XFILLER_3_349 vssd1 vccd1 vccd1 vssd1 sky130_ef_sc_hd__decap_40_12$1
XFILLER_105_277 vssd1 vccd1 vccd1 vssd1 sky130_fd_sc_hd__fill_2$1
XFILLER_79_629 vssd1 vccd1 vccd1 vssd1 sky130_ef_sc_hd__decap_40_12$1
XFILLER_133_597 vssd1 vccd1 vccd1 vssd1 sky130_ef_sc_hd__decap_40_12$1
XFILLER_78_139 vccd1 vssd1 vccd1 vssd1 sky130_fd_sc_hd__fill_1$1
XFILLER_93_109 vssd1 vccd1 vccd1 vssd1 sky130_fd_sc_hd__fill_2$1
XFILLER_87_673 vssd1 vccd1 vccd1 vssd1 sky130_ef_sc_hd__decap_40_12$1
XFILLER_101_461 vssd1 vccd1 vccd1 vssd1 sky130_fd_sc_hd__fill_2$1
XFILLER_74_301 vssd1 vccd1 vccd1 vssd1 sky130_fd_sc_hd__fill_4$1
XFILLER_19_217 vssd1 vccd1 vccd1 vssd1 sky130_fd_sc_hd__fill_4$1
XFILLER_47_515 vssd1 vccd1 vccd1 vssd1 sky130_fd_sc_hd__fill_4$1
XFILLER_90_805 vccd1 vssd1 vccd1 vssd1 sky130_fd_sc_hd__fill_1$1
XFILLER_74_345 vssd1 vccd1 vccd1 vssd1 sky130_ef_sc_hd__decap_40_12$1
XFILLER_27_261 vssd1 vccd1 vccd1 vssd1 sky130_ef_sc_hd__decap_40_12$1
XFILLER_34_209 vssd1 vccd1 vccd1 vssd1 sky130_ef_sc_hd__decap_40_12$1
XFILLER_103_93 vssd1 vccd1 vccd1 vssd1 sky130_ef_sc_hd__decap_40_12$1
XFILLER_15_445 vssd1 vccd1 vccd1 vssd1 sky130_fd_sc_hd__fill_2$1
XPHY_EDGE_ROW_69_Right_69 vccd1 vssd1 vccd1 vssd1 sky130_fd_sc_hd__decap_3$1
XFILLER_42_253 vssd1 vccd1 vccd1 vssd1 sky130_ef_sc_hd__decap_40_12$1
XTAP_TAPCELL_ROW_120_2096 vccd1 vssd1 sky130_fd_sc_hd__tapvpwrvgnd_1$1
XFILLER_8_15 vssd1 vccd1 vccd1 vssd1 sky130_ef_sc_hd__decap_40_12$1
XTAP_TAPCELL_ROW_41_911 vccd1 vssd1 sky130_fd_sc_hd__tapvpwrvgnd_1$1
XTAP_TAPCELL_ROW_41_922 vccd1 vssd1 sky130_fd_sc_hd__tapvpwrvgnd_1$1
XFILLER_11_673 vssd1 vccd1 vccd1 vssd1 sky130_ef_sc_hd__decap_40_12$1
XFILLER_6_121 vssd1 vccd1 vccd1 vssd1 sky130_ef_sc_hd__decap_40_12$1
XFILLER_6_165 vssd1 vccd1 vccd1 vssd1 sky130_ef_sc_hd__decap_40_12$1
XPHY_EDGE_ROW_78_Right_78 vccd1 vssd1 vccd1 vssd1 sky130_fd_sc_hd__decap_3$1
XFILLER_124_597 vssd1 vccd1 vccd1 vssd1 sky130_fd_sc_hd__fill_2$1
XFILLER_112_737 vssd1 vccd1 vccd1 vssd1 sky130_fd_sc_hd__fill_2$1
XFILLER_111_225 vssd1 vccd1 vccd1 vssd1 sky130_ef_sc_hd__decap_40_12$1
XFILLER_88_83 vccd1 vssd1 vccd1 vssd1 sky130_fd_sc_hd__fill_1$1
XTAP_TAPCELL_ROW_127_2206 vccd1 vssd1 sky130_fd_sc_hd__tapvpwrvgnd_1$1
X_1201_ _1471_/C1 _1200_/X _1211_/A2 hold83/X _1631_/D vssd1 vccd1 vccd1 vssd1 sky130_fd_sc_hd__o211a_1$1
XFILLER_84_109 vssd1 vccd1 vccd1 vssd1 sky130_ef_sc_hd__decap_40_12$1
XFILLER_66_813 vssd1 vccd1 vccd1 vssd1 sky130_ef_sc_hd__decap_40_12$1
XFILLER_93_621 vccd1 vssd1 vccd1 vssd1 sky130_fd_sc_hd__fill_1$1
XFILLER_77_161 vssd1 vccd1 vccd1 vssd1 sky130_fd_sc_hd__fill_4$1
X_1132_ _1132_/A _1132_/X _1144_/B vssd1 vccd1 vccd1 vssd1 sky130_fd_sc_hd__or2_1$1
X_1063_ _1463_/C1 _1062_/X _1079_/A2 hold14/X _1564_/D vssd1 vccd1 vccd1 vssd1 sky130_fd_sc_hd__o211a_1$1
XFILLER_92_153 vssd1 vccd1 vccd1 vssd1 sky130_ef_sc_hd__decap_40_12$1
XFILLER_65_389 vssd1 vccd1 vccd1 vssd1 sky130_fd_sc_hd__fill_2$1
XFILLER_53_529 vccd1 vssd1 vccd1 vssd1 sky130_fd_sc_hd__fill_1$1
XFILLER_92_197 vssd1 vccd1 vccd1 vssd1 sky130_ef_sc_hd__decap_40_12$1
XPHY_EDGE_ROW_87_Right_87 vccd1 vssd1 vccd1 vssd1 sky130_fd_sc_hd__decap_3$1
XFILLER_34_743 vssd1 vccd1 vccd1 vssd1 sky130_fd_sc_hd__fill_2$1
XFILLER_46_581 vssd1 vccd1 vccd1 vssd1 sky130_fd_sc_hd__fill_4$1
XTAP_TAPCELL_ROW_105_1869 vccd1 vssd1 sky130_fd_sc_hd__tapvpwrvgnd_1$1
XFILLER_61_573 vssd1 vccd1 vccd1 vssd1 sky130_ef_sc_hd__decap_40_12$1
XTAP_TAPCELL_ROW_138_2379 vccd1 vssd1 sky130_fd_sc_hd__tapvpwrvgnd_1$1
XTAP_TAPCELL_ROW_138_2368 vccd1 vssd1 sky130_fd_sc_hd__tapvpwrvgnd_1$1
X_0916_ _0752_/A _1503_/D _0912_/X _1465_/C1 _1503_/Q _0915_/X vssd1 vccd1 vccd1 vssd1
+ sky130_fd_sc_hd__o221a_1$1
XTAP_TAPCELL_ROW_60_1198 vccd1 vssd1 sky130_fd_sc_hd__tapvpwrvgnd_1$1
XPHY_EDGE_ROW_96_Right_96 vccd1 vssd1 vccd1 vssd1 sky130_fd_sc_hd__decap_3$1
X_0847_ _1716_/Q _0878_/B1 _0847_/X _1652_/Q _0906_/B1 vccd1 vssd1 vccd1 vssd1 sky130_fd_sc_hd__a22o_1$1
XFILLER_127_391 vccd1 vssd1 vccd1 vssd1 sky130_fd_sc_hd__fill_1$1
XFILLER_108_27 vccd1 vssd1 vccd1 vssd1 sky130_fd_sc_hd__fill_1$1
X_0778_ _1828_/A _0878_/B1 _0778_/X _1776_/A _0866_/B1 vccd1 vssd1 vccd1 vssd1 sky130_fd_sc_hd__a22o_1$1
XTAP_TAPCELL_ROW_8_419 vccd1 vssd1 sky130_fd_sc_hd__tapvpwrvgnd_1$1
XFILLER_1_809 vssd1 vccd1 vccd1 vssd1 sky130_ef_sc_hd__decap_40_12$1
XFILLER_130_501 vssd1 vccd1 vccd1 vssd1 sky130_fd_sc_hd__fill_8$1
XFILLER_115_553 vssd1 vccd1 vccd1 vssd1 sky130_fd_sc_hd__fill_2$1
XFILLER_124_15 vssd1 vccd1 vccd1 vssd1 sky130_ef_sc_hd__decap_40_12$1
XFILLER_75_109 vssd1 vccd1 vccd1 vssd1 sky130_fd_sc_hd__fill_2$1
XFILLER_69_673 vssd1 vccd1 vccd1 vssd1 sky130_fd_sc_hd__fill_2$1
XFILLER_56_301 vssd1 vccd1 vccd1 vssd1 sky130_fd_sc_hd__fill_4$1
XFILLER_56_345 vssd1 vccd1 vccd1 vssd1 sky130_ef_sc_hd__decap_40_12$1
XPHY_EDGE_ROW_3_Left_142 vccd1 vssd1 vccd1 vssd1 sky130_fd_sc_hd__decap_3$1
XFILLER_29_559 vccd1 vssd1 vccd1 vssd1 sky130_fd_sc_hd__fill_1$1
XTAP_TAPCELL_ROW_67_1308 vccd1 vssd1 sky130_fd_sc_hd__tapvpwrvgnd_1$1
XFILLER_16_209 vssd1 vccd1 vccd1 vssd1 sky130_ef_sc_hd__decap_40_12$1
XTAP_TAPCELL_ROW_27_705 vccd1 vssd1 sky130_fd_sc_hd__tapvpwrvgnd_1$1
XFILLER_44_529 vssd1 vccd1 vccd1 vssd1 sky130_fd_sc_hd__fill_2$1
XFILLER_71_337 vssd1 vccd1 vccd1 vssd1 sky130_ef_sc_hd__decap_40_12$1
XFILLER_17_57 vssd1 vccd1 vccd1 vssd1 sky130_ef_sc_hd__decap_40_12$1
XFILLER_24_253 vssd1 vccd1 vccd1 vssd1 sky130_ef_sc_hd__decap_40_12$1
XFILLER_40_746 vssd1 vccd1 vccd1 vssd1 sky130_fd_sc_hd__fill_8$1
XFILLER_8_419 vccd1 vssd1 vccd1 vssd1 sky130_fd_sc_hd__fill_1$1
XFILLER_40_757 vssd1 vccd1 vccd1 vssd1 sky130_ef_sc_hd__decap_40_12$1
XPHY_EDGE_ROW_49_Left_188 vccd1 vssd1 vccd1 vssd1 sky130_fd_sc_hd__decap_3$1
XFILLER_137_177 vccd1 vssd1 vccd1 vssd1 sky130_fd_sc_hd__fill_1$1
XFILLER_125_317 vssd1 vccd1 vccd1 vssd1 sky130_ef_sc_hd__decap_40_12$1
XFILLER_116_3 vssd1 vccd1 vccd1 vssd1 sky130_ef_sc_hd__decap_40_12$1
XFILLER_4_625 vssd1 vccd1 vccd1 vssd1 sky130_ef_sc_hd__decap_40_12$1
XFILLER_3_113 vssd1 vccd1 vccd1 vssd1 sky130_ef_sc_hd__decap_40_12$1
XFILLER_133_361 vssd1 vccd1 vccd1 vssd1 sky130_fd_sc_hd__fill_4$1
XFILLER_4_669 vssd1 vccd1 vccd1 vssd1 sky130_ef_sc_hd__decap_40_12$1
XTAP_TAPCELL_ROW_91_1659 vccd1 vssd1 sky130_fd_sc_hd__tapvpwrvgnd_1$1
XFILLER_66_109 vssd1 vccd1 vccd1 vssd1 sky130_ef_sc_hd__decap_40_12$1
XFILLER_58_53 vssd1 vccd1 vccd1 vssd1 sky130_ef_sc_hd__decap_40_12$1
Xhold8 hold8/A hold8/X vssd1 vccd1 vccd1 vssd1 sky130_fd_sc_hd__dlygate4sd3_1$1
XFILLER_59_161 vssd1 vccd1 vccd1 vssd1 sky130_fd_sc_hd__fill_4$1
XFILLER_58_97 vssd1 vccd1 vccd1 vssd1 sky130_ef_sc_hd__decap_40_12$1
XPHY_EDGE_ROW_58_Left_197 vccd1 vssd1 vccd1 vssd1 sky130_fd_sc_hd__decap_3$1
XTAP_TAPCELL_ROW_122_2125 vccd1 vssd1 sky130_fd_sc_hd__tapvpwrvgnd_1$1
XFILLER_114_81 vssd1 vccd1 vccd1 vssd1 sky130_fd_sc_hd__fill_2$1
XFILLER_90_613 vssd1 vccd1 vccd1 vssd1 sky130_ef_sc_hd__decap_40_12$1
XFILLER_74_153 vssd1 vccd1 vccd1 vssd1 sky130_ef_sc_hd__decap_40_12$1
XFILLER_74_41 vssd1 vccd1 vccd1 vssd1 sky130_ef_sc_hd__decap_40_12$1
XFILLER_35_529 vssd1 vccd1 vccd1 vssd1 sky130_ef_sc_hd__decap_40_12$1
XFILLER_47_389 vssd1 vccd1 vccd1 vssd1 sky130_fd_sc_hd__fill_2$1
XTAP_TAPCELL_ROW_122_2136 vccd1 vssd1 sky130_fd_sc_hd__tapvpwrvgnd_1$1
XFILLER_90_657 vssd1 vccd1 vccd1 vssd1 sky130_fd_sc_hd__fill_8$1
XFILLER_74_197 vssd1 vccd1 vccd1 vssd1 sky130_ef_sc_hd__decap_40_12$1
XFILLER_74_85 vssd1 vccd1 vccd1 vssd1 sky130_ef_sc_hd__decap_40_12$1
XFILLER_16_743 vssd1 vccd1 vccd1 vssd1 sky130_ef_sc_hd__decap_40_12$1
XFILLER_28_581 vssd1 vccd1 vccd1 vssd1 sky130_fd_sc_hd__fill_4$1
XFILLER_30_245 vssd1 vccd1 vccd1 vssd1 sky130_fd_sc_hd__fill_4$1
X_1750_ _1750_/Q clkload7/A _1750_/D vccd1 vssd1 vccd1 vssd1 sky130_fd_sc_hd__dfxtp_1$1
XFILLER_30_289 vssd1 vccd1 vccd1 vssd1 sky130_ef_sc_hd__decap_40_12$1
XFILLER_128_133 vssd1 vccd1 vccd1 vssd1 sky130_fd_sc_hd__fill_4$1
XTAP_TAPCELL_ROW_100_1799 vccd1 vssd1 sky130_fd_sc_hd__tapvpwrvgnd_1$1
XFILLER_7_441 vssd1 vccd1 vccd1 vssd1 sky130_fd_sc_hd__fill_4$1
XTAP_TAPCELL_ROW_13_498 vccd1 vssd1 sky130_fd_sc_hd__tapvpwrvgnd_1$1
XFILLER_129_689 vccd1 vssd1 vccd1 vssd1 sky130_fd_sc_hd__fill_1$1
XFILLER_128_177 vssd1 vccd1 vccd1 vssd1 sky130_ef_sc_hd__decap_40_12$1
X_1681_ _1681_/Q _1742_/CLK _1681_/D vccd1 vssd1 vccd1 vssd1 sky130_fd_sc_hd__dfxtp_1$1
XFILLER_7_485 vssd1 vccd1 vccd1 vssd1 sky130_ef_sc_hd__decap_40_12$1
XFILLER_109_391 vccd1 vssd1 vccd1 vssd1 sky130_fd_sc_hd__fill_1$1
XTAP_TAPCELL_ROW_133_2298 vccd1 vssd1 sky130_fd_sc_hd__tapvpwrvgnd_1$1
XFILLER_124_361 vssd1 vccd1 vccd1 vssd1 sky130_fd_sc_hd__fill_2$1
XFILLER_99_93 vssd1 vccd1 vccd1 vssd1 sky130_ef_sc_hd__decap_40_12$1
XFILLER_98_724 vssd1 vccd1 vccd1 vssd1 sky130_ef_sc_hd__decap_40_12$1
XFILLER_98_757 vssd1 vccd1 vccd1 vssd1 sky130_ef_sc_hd__decap_40_12$1
XFILLER_97_223 vccd1 vssd1 vccd1 vssd1 sky130_fd_sc_hd__fill_1$1
XFILLER_31_3 vssd1 vccd1 vccd1 vssd1 sky130_ef_sc_hd__decap_40_12$1
XFILLER_112_545 vssd1 vccd1 vccd1 vssd1 sky130_ef_sc_hd__decap_40_12$1
XFILLER_112_589 vssd1 vccd1 vccd1 vssd1 sky130_ef_sc_hd__decap_40_12$1
XFILLER_57_109 vssd1 vccd1 vccd1 vssd1 sky130_fd_sc_hd__fill_2$1
XFILLER_38_301 vssd1 vccd1 vccd1 vssd1 sky130_fd_sc_hd__fill_4$1
XFILLER_38_345 vssd1 vccd1 vccd1 vssd1 sky130_ef_sc_hd__decap_40_12$1
XTAP_TAPCELL_ROW_107_1909 vccd1 vssd1 sky130_fd_sc_hd__tapvpwrvgnd_1$1
X_1115_ _1443_/C1 _1114_/X _1081_/Y hold32/X _1589_/D vssd1 vccd1 vccd1 vssd1 sky130_fd_sc_hd__o211a_1$1
XFILLER_93_473 vssd1 vccd1 vccd1 vssd1 sky130_ef_sc_hd__decap_40_12$1
XFILLER_81_602 vssd1 vccd1 vccd1 vssd1 sky130_fd_sc_hd__fill_4$1
XFILLER_26_529 vssd1 vccd1 vccd1 vssd1 sky130_fd_sc_hd__fill_2$1
XFILLER_38_389 vssd1 vccd1 vccd1 vssd1 sky130_ef_sc_hd__decap_40_12$1
XFILLER_81_657 vssd1 vccd1 vccd1 vssd1 sky130_ef_sc_hd__decap_40_12$1
XFILLER_53_337 vssd1 vccd1 vccd1 vssd1 sky130_ef_sc_hd__decap_40_12$1
XTAP_TAPCELL_ROW_49_1038 vccd1 vssd1 sky130_fd_sc_hd__tapvpwrvgnd_1$1
X_1046_ _1556_/Q _1046_/X _1078_/B vssd1 vccd1 vccd1 vssd1 sky130_fd_sc_hd__or2_1$1
XFILLER_80_189 vssd1 vccd1 vccd1 vssd1 sky130_fd_sc_hd__fill_4$1
XTAP_TAPCELL_ROW_62_1227 vccd1 vssd1 sky130_fd_sc_hd__tapvpwrvgnd_1$1
XFILLER_22_735 vssd1 vccd1 vccd1 vssd1 sky130_fd_sc_hd__fill_4$1
XFILLER_21_223 vccd1 vssd1 vccd1 vssd1 sky130_fd_sc_hd__fill_1$1
XFILLER_22_757 vssd1 vccd1 vccd1 vssd1 sky130_ef_sc_hd__decap_40_12$1
XFILLER_119_111 vccd1 vssd1 vccd1 vssd1 sky130_fd_sc_hd__fill_1$1
XTAP_TAPCELL_ROW_32_774 vccd1 vssd1 sky130_fd_sc_hd__tapvpwrvgnd_1$1
XTAP_TAPCELL_ROW_32_785 vccd1 vssd1 sky130_fd_sc_hd__tapvpwrvgnd_1$1
XFILLER_119_15 vssd1 vccd1 vccd1 vssd1 sky130_ef_sc_hd__decap_40_12$1
XFILLER_135_615 vccd1 vssd1 vccd1 vssd1 sky130_fd_sc_hd__fill_1$1
XFILLER_107_317 vssd1 vccd1 vccd1 vssd1 sky130_ef_sc_hd__decap_40_12$1
XFILLER_122_309 vssd1 vccd1 vccd1 vssd1 sky130_ef_sc_hd__decap_40_12$1
XFILLER_115_361 vssd1 vccd1 vccd1 vssd1 sky130_ef_sc_hd__decap_40_12$1
XFILLER_1_617 vssd1 vccd1 vccd1 vssd1 sky130_ef_sc_hd__decap_40_12$1
XFILLER_135_69 vssd1 vccd1 vccd1 vssd1 sky130_ef_sc_hd__decap_40_12$1
XFILLER_88_245 vssd1 vccd1 vccd1 vssd1 sky130_fd_sc_hd__fill_4$1
XTAP_TAPCELL_ROW_73_1389 vccd1 vssd1 sky130_fd_sc_hd__tapvpwrvgnd_1$1
XFILLER_88_289 vssd1 vccd1 vccd1 vssd1 sky130_ef_sc_hd__decap_40_12$1
XFILLER_57_621 vssd1 vccd1 vccd1 vssd1 sky130_ef_sc_hd__decap_40_12$1
XFILLER_48_109 vssd1 vccd1 vccd1 vssd1 sky130_ef_sc_hd__decap_40_12$1
XFILLER_84_473 vssd1 vccd1 vccd1 vssd1 sky130_fd_sc_hd__fill_2$1
XFILLER_56_153 vssd1 vccd1 vccd1 vssd1 sky130_ef_sc_hd__decap_40_12$1
XFILLER_17_529 vssd1 vccd1 vccd1 vssd1 sky130_ef_sc_hd__decap_40_12$1
XFILLER_45_827 vssd1 vccd1 vccd1 vssd1 sky130_ef_sc_hd__decap_40_12$1
XFILLER_56_197 vssd1 vccd1 vccd1 vssd1 sky130_ef_sc_hd__decap_40_12$1
XFILLER_29_389 vssd1 vccd1 vccd1 vssd1 sky130_fd_sc_hd__fill_2$1
XFILLER_71_167 vccd1 vssd1 vccd1 vssd1 sky130_fd_sc_hd__fill_1$1
XFILLER_25_573 vssd1 vccd1 vccd1 vssd1 sky130_ef_sc_hd__decap_40_12$1
XFILLER_44_77 vssd1 vccd1 vccd1 vssd1 sky130_fd_sc_hd__fill_4$1
XFILLER_12_245 vssd1 vccd1 vccd1 vssd1 sky130_fd_sc_hd__fill_4$1
XFILLER_40_587 vccd1 vssd1 vccd1 vssd1 sky130_fd_sc_hd__fill_1$1
XFILLER_100_83 vccd1 vssd1 vccd1 vssd1 sky130_fd_sc_hd__fill_1$1
XFILLER_60_65 vssd1 vccd1 vccd1 vssd1 sky130_ef_sc_hd__decap_40_12$1
XFILLER_8_249 vssd1 vccd1 vccd1 vssd1 sky130_fd_sc_hd__fill_2$1
XFILLER_12_289 vssd1 vccd1 vccd1 vssd1 sky130_ef_sc_hd__decap_40_12$1
XFILLER_138_475 vccd1 vssd1 vccd1 vssd1 sky130_fd_sc_hd__fill_1$1
XFILLER_126_637 vssd1 vccd1 vccd1 vssd1 sky130_fd_sc_hd__fill_2$1
XTAP_TAPCELL_ROW_10_457 vccd1 vssd1 sky130_fd_sc_hd__tapvpwrvgnd_1$1
XTAP_TAPCELL_ROW_10_446 vccd1 vssd1 sky130_fd_sc_hd__tapvpwrvgnd_1$1
XFILLER_125_125 vssd1 vccd1 vccd1 vssd1 sky130_ef_sc_hd__decap_40_12$1
XFILLER_5_27 vssd1 vccd1 vccd1 vssd1 sky130_ef_sc_hd__decap_40_12$1
XFILLER_4_433 vssd1 vccd1 vccd1 vssd1 sky130_ef_sc_hd__decap_40_12$1
XFILLER_125_169 vssd1 vccd1 vccd1 vssd1 sky130_ef_sc_hd__decap_40_12$1
XFILLER_109_81 vssd1 vccd1 vccd1 vssd1 sky130_ef_sc_hd__decap_40_12$1
XFILLER_4_477 vssd1 vccd1 vccd1 vssd1 sky130_ef_sc_hd__decap_40_12$1
XFILLER_106_361 vssd1 vccd1 vccd1 vssd1 sky130_fd_sc_hd__fill_2$1
XFILLER_79_223 vccd1 vssd1 vccd1 vssd1 sky130_fd_sc_hd__fill_1$1
XPHY_EDGE_ROW_66_Left_205 vccd1 vssd1 vccd1 vssd1 sky130_fd_sc_hd__decap_3$1
XFILLER_67_429 vssd1 vccd1 vccd1 vssd1 sky130_fd_sc_hd__fill_4$1
XFILLER_39_109 vssd1 vccd1 vccd1 vssd1 sky130_fd_sc_hd__fill_2$1
XFILLER_48_610 vssd1 vccd1 vccd1 vssd1 sky130_fd_sc_hd__fill_4$1
XFILLER_85_51 vssd1 vccd1 vccd1 vssd1 sky130_fd_sc_hd__fill_4$1
XFILLER_90_421 vssd1 vccd1 vccd1 vssd1 sky130_ef_sc_hd__decap_40_12$1
XFILLER_75_484 vssd1 vccd1 vccd1 vssd1 sky130_ef_sc_hd__decap_40_12$1
XFILLER_35_337 vssd1 vccd1 vccd1 vssd1 sky130_ef_sc_hd__decap_40_12$1
XTAP_TAPCELL_ROW_18_568 vccd1 vssd1 sky130_fd_sc_hd__tapvpwrvgnd_1$1
XTAP_TAPCELL_ROW_102_1828 vccd1 vssd1 sky130_fd_sc_hd__tapvpwrvgnd_1$1
XFILLER_62_189 vssd1 vccd1 vccd1 vssd1 sky130_fd_sc_hd__fill_4$1
XFILLER_50_307 vccd1 vssd1 vccd1 vssd1 sky130_fd_sc_hd__fill_1$1
XPHY_EDGE_ROW_75_Left_214 vccd1 vssd1 vccd1 vssd1 sky130_fd_sc_hd__decap_3$1
XTAP_TAPCELL_ROW_135_2327 vccd1 vssd1 sky130_fd_sc_hd__tapvpwrvgnd_1$1
XFILLER_79_3 vssd1 vccd1 vccd1 vssd1 sky130_ef_sc_hd__decap_40_12$1
X_1802_ _1802_/A _1802_/X vssd1 vccd1 vccd1 vssd1 sky130_fd_sc_hd__clkbuf_2$1
XFILLER_117_615 vccd1 vssd1 vccd1 vssd1 sky130_fd_sc_hd__fill_1$1
X_1733_ _1841_/A _1736_/CLK _1733_/D vccd1 vssd1 vccd1 vssd1 sky130_fd_sc_hd__dfxtp_1$1
XFILLER_129_497 vssd1 vccd1 vccd1 vssd1 sky130_fd_sc_hd__fill_4$1
XFILLER_117_659 vssd1 vccd1 vccd1 vssd1 sky130_ef_sc_hd__decap_40_12$1
Xhold205 _1687_/Q _1316_/A vssd1 vccd1 vccd1 vssd1 sky130_fd_sc_hd__dlygate4sd3_1$1
Xhold216 _1680_/Q _1302_/A vssd1 vccd1 vccd1 vssd1 sky130_fd_sc_hd__dlygate4sd3_1$1
XFILLER_7_293 vssd1 vccd1 vccd1 vssd1 sky130_ef_sc_hd__decap_40_12$1
XFILLER_104_309 vssd1 vccd1 vccd1 vssd1 sky130_ef_sc_hd__decap_40_12$1
X_1664_ _1664_/Q _1747_/CLK _1664_/D vccd1 vssd1 vccd1 vssd1 sky130_fd_sc_hd__dfxtp_1$1
XFILLER_125_681 vssd1 vccd1 vccd1 vssd1 sky130_fd_sc_hd__fill_2$1
X_1595_ _1595_/Q _1755_/CLK _1595_/D vccd1 vssd1 vccd1 vssd1 sky130_fd_sc_hd__dfxtp_1$1
XFILLER_113_821 vssd1 vccd1 vccd1 vssd1 sky130_fd_sc_hd__fill_2$1
XPHY_EDGE_ROW_84_Left_223 vccd1 vssd1 vccd1 vssd1 sky130_fd_sc_hd__decap_3$1
XFILLER_105_39 vssd1 vccd1 vccd1 vssd1 sky130_ef_sc_hd__decap_40_12$1
XFILLER_85_237 vssd1 vccd1 vccd1 vssd1 sky130_ef_sc_hd__decap_40_12$1
XFILLER_39_632 vssd1 vccd1 vccd1 vssd1 sky130_ef_sc_hd__decap_40_12$1
XFILLER_66_473 vssd1 vccd1 vccd1 vssd1 sky130_fd_sc_hd__fill_2$1
XFILLER_38_153 vssd1 vccd1 vccd1 vssd1 sky130_ef_sc_hd__decap_40_12$1
XFILLER_94_793 vssd1 vccd1 vccd1 vssd1 sky130_ef_sc_hd__decap_40_12$1
XFILLER_93_281 vssd1 vccd1 vccd1 vssd1 sky130_ef_sc_hd__decap_40_12$1
XFILLER_81_432 vssd1 vccd1 vccd1 vssd1 sky130_ef_sc_hd__decap_40_12$1
XFILLER_38_197 vssd1 vccd1 vccd1 vssd1 sky130_ef_sc_hd__decap_40_12$1
XFILLER_121_27 vssd1 vccd1 vccd1 vssd1 sky130_ef_sc_hd__decap_40_12$1
XFILLER_54_657 vssd1 vccd1 vccd1 vssd1 sky130_fd_sc_hd__fill_4$1
XTAP_TAPCELL_ROW_37_855 vccd1 vssd1 sky130_fd_sc_hd__tapvpwrvgnd_1$1
XFILLER_42_808 vssd1 vccd1 vccd1 vssd1 sky130_fd_sc_hd__fill_4$1
XPHY_EDGE_ROW_138_Right_138 vccd1 vssd1 vccd1 vssd1 sky130_fd_sc_hd__decap_3$1
XPHY_EDGE_ROW_93_Left_232 vccd1 vssd1 vccd1 vssd1 sky130_fd_sc_hd__decap_3$1
XFILLER_53_167 vccd1 vssd1 vccd1 vssd1 sky130_fd_sc_hd__fill_1$1
X_1029_ _1091_/C1 _1028_/X _1053_/A2 hold197/X _1547_/D vssd1 vccd1 vccd1 vssd1 sky130_fd_sc_hd__o211a_1$1
XFILLER_41_329 vssd1 vccd1 vccd1 vssd1 sky130_fd_sc_hd__fill_4$1
XFILLER_22_587 vccd1 vssd1 vccd1 vssd1 sky130_fd_sc_hd__fill_1$1
XFILLER_10_749 vssd1 vccd1 vccd1 vssd1 sky130_fd_sc_hd__fill_4$1
XFILLER_135_434 vssd1 vccd1 vccd1 vssd1 sky130_fd_sc_hd__fill_2$1
XFILLER_107_125 vssd1 vccd1 vccd1 vssd1 sky130_ef_sc_hd__decap_40_12$1
XTAP_TAPCELL_ROW_75_1418 vccd1 vssd1 sky130_fd_sc_hd__tapvpwrvgnd_1$1
XFILLER_107_169 vssd1 vccd1 vccd1 vssd1 sky130_ef_sc_hd__decap_40_12$1
XTAP_TAPCELL_ROW_75_1429 vccd1 vssd1 sky130_fd_sc_hd__tapvpwrvgnd_1$1
XFILLER_122_139 vccd1 vssd1 vccd1 vssd1 sky130_fd_sc_hd__fill_1$1
XFILLER_89_565 vssd1 vccd1 vccd1 vssd1 sky130_fd_sc_hd__fill_2$1
XFILLER_1_447 vccd1 vssd1 vccd1 vssd1 sky130_fd_sc_hd__fill_1$1
XFILLER_131_673 vssd1 vccd1 vccd1 vssd1 sky130_ef_sc_hd__decap_40_12$1
XFILLER_77_727 vccd1 vssd1 vccd1 vssd1 sky130_fd_sc_hd__fill_1$1
XFILLER_39_55 vccd1 vssd1 vccd1 vssd1 sky130_fd_sc_hd__fill_1$1
XFILLER_49_429 vssd1 vccd1 vccd1 vssd1 sky130_ef_sc_hd__decap_40_12$1
XFILLER_85_771 vssd1 vccd1 vccd1 vssd1 sky130_ef_sc_hd__decap_40_12$1
XFILLER_18_805 vssd1 vccd1 vccd1 vssd1 sky130_fd_sc_hd__fill_4$1
XFILLER_72_421 vssd1 vccd1 vccd1 vssd1 sky130_ef_sc_hd__decap_40_12$1
XFILLER_17_337 vssd1 vccd1 vccd1 vssd1 sky130_ef_sc_hd__decap_40_12$1
XFILLER_45_657 vssd1 vccd1 vccd1 vssd1 sky130_fd_sc_hd__fill_2$1
XPHY_EDGE_ROW_105_Right_105 vccd1 vssd1 vccd1 vssd1 sky130_fd_sc_hd__decap_3$1
XFILLER_72_498 vssd1 vccd1 vccd1 vssd1 sky130_fd_sc_hd__fill_2$1
XFILLER_32_307 vccd1 vssd1 vccd1 vssd1 sky130_fd_sc_hd__fill_1$1
XFILLER_44_189 vssd1 vccd1 vccd1 vssd1 sky130_fd_sc_hd__fill_4$1
XTAP_TAPCELL_ROW_15_527 vccd1 vssd1 sky130_fd_sc_hd__tapvpwrvgnd_1$1
XFILLER_41_841 vccd1 vssd1 vccd1 vssd1 sky130_fd_sc_hd__fill_1$1
XFILLER_111_93 vssd1 vccd1 vccd1 vssd1 sky130_ef_sc_hd__decap_40_12$1
XFILLER_9_503 vccd1 vssd1 vccd1 vssd1 sky130_fd_sc_hd__fill_1$1
XTAP_TAPCELL_ROW_117_2057 vccd1 vssd1 sky130_fd_sc_hd__tapvpwrvgnd_1$1
XFILLER_5_753 vssd1 vccd1 vccd1 vssd1 sky130_ef_sc_hd__decap_40_12$1
XTAP_TAPCELL_ROW_130_2257 vccd1 vssd1 sky130_fd_sc_hd__tapvpwrvgnd_1$1
XTAP_TAPCELL_ROW_130_2246 vccd1 vssd1 sky130_fd_sc_hd__tapvpwrvgnd_1$1
XFILLER_126_489 vssd1 vccd1 vccd1 vssd1 sky130_ef_sc_hd__decap_40_12$1
XFILLER_99_329 vssd1 vccd1 vccd1 vssd1 sky130_fd_sc_hd__fill_4$1
XFILLER_5_797 vssd1 vccd1 vccd1 vssd1 sky130_ef_sc_hd__decap_40_12$1
X_1380_ _1380_/A _1380_/X _1398_/B vssd1 vccd1 vccd1 vssd1 sky130_fd_sc_hd__or2_1$1
XFILLER_121_161 vssd1 vccd1 vccd1 vssd1 sky130_fd_sc_hd__fill_4$1
XFILLER_110_813 vssd1 vccd1 vccd1 vssd1 sky130_ef_sc_hd__decap_40_12$1
XFILLER_96_83 vccd1 vssd1 vccd1 vssd1 sky130_fd_sc_hd__fill_1$1
XFILLER_67_237 vssd1 vccd1 vccd1 vssd1 sky130_ef_sc_hd__decap_40_12$1
XFILLER_76_771 vccd1 vssd1 vccd1 vssd1 sky130_fd_sc_hd__fill_1$1
XFILLER_76_793 vssd1 vccd1 vccd1 vssd1 sky130_fd_sc_hd__fill_8$1
XFILLER_75_281 vssd1 vccd1 vccd1 vssd1 sky130_ef_sc_hd__decap_40_12$1
XFILLER_48_473 vssd1 vccd1 vccd1 vssd1 sky130_fd_sc_hd__fill_2$1
XFILLER_24_819 vccd1 vssd1 vccd1 vssd1 sky130_fd_sc_hd__fill_1$1
XFILLER_36_657 vssd1 vccd1 vccd1 vssd1 sky130_ef_sc_hd__decap_40_12$1
XFILLER_91_785 vssd1 vccd1 vccd1 vssd1 sky130_fd_sc_hd__fill_2$1
XFILLER_90_251 vccd1 vssd1 vccd1 vssd1 sky130_fd_sc_hd__fill_1$1
XFILLER_23_329 vssd1 vccd1 vccd1 vssd1 sky130_fd_sc_hd__fill_4$1
XTAP_TAPCELL_ROW_34_803 vccd1 vssd1 sky130_fd_sc_hd__tapvpwrvgnd_1$1
XTAP_TAPCELL_ROW_34_814 vccd1 vssd1 sky130_fd_sc_hd__tapvpwrvgnd_1$1
XFILLER_35_167 vccd1 vssd1 vccd1 vssd1 sky130_fd_sc_hd__fill_1$1
XFILLER_50_137 vssd1 vccd1 vccd1 vssd1 sky130_fd_sc_hd__fill_2$1
XFILLER_31_373 vssd1 vccd1 vccd1 vssd1 sky130_ef_sc_hd__decap_40_12$1
XFILLER_136_209 vssd1 vccd1 vccd1 vssd1 sky130_ef_sc_hd__decap_40_12$1
XFILLER_117_478 vssd1 vccd1 vccd1 vssd1 sky130_ef_sc_hd__decap_40_12$1
X_1716_ _1716_/Q _1716_/CLK _1716_/D vccd1 vssd1 vccd1 vssd1 sky130_fd_sc_hd__dfxtp_1$1
XFILLER_105_629 vssd1 vccd1 vccd1 vssd1 sky130_ef_sc_hd__decap_40_12$1
X_1647_ _1647_/Q clkload8/A _1647_/D vccd1 vssd1 vccd1 vssd1 sky130_fd_sc_hd__dfxtp_2$1
XTAP_TAPCELL_ROW_57_1159 vccd1 vssd1 sky130_fd_sc_hd__tapvpwrvgnd_1$1
XTAP_TAPCELL_ROW_57_1148 vccd1 vssd1 sky130_fd_sc_hd__tapvpwrvgnd_1$1
XFILLER_6_81 vssd1 vccd1 vccd1 vssd1 sky130_fd_sc_hd__fill_2$1
XFILLER_116_27 vccd1 vssd1 vccd1 vssd1 sky130_fd_sc_hd__fill_1$1
XFILLER_104_139 vccd1 vssd1 vccd1 vssd1 sky130_fd_sc_hd__fill_1$1
XFILLER_99_841 vccd1 vssd1 vccd1 vssd1 sky130_fd_sc_hd__fill_1$1
XFILLER_59_705 vccd1 vssd1 vccd1 vssd1 sky130_fd_sc_hd__fill_1$1
XFILLER_113_673 vssd1 vccd1 vccd1 vssd1 sky130_ef_sc_hd__decap_40_12$1
XFILLER_100_301 vssd1 vccd1 vccd1 vssd1 sky130_fd_sc_hd__fill_4$1
XTAP_TAPCELL_ROW_70_1348 vccd1 vssd1 sky130_fd_sc_hd__tapvpwrvgnd_1$1
XFILLER_59_727 vccd1 vssd1 vccd1 vssd1 sky130_fd_sc_hd__fill_1$1
X_1578_ _1796_/A _1579_/CLK _1578_/D vccd1 vssd1 vccd1 vssd1 sky130_fd_sc_hd__dfxtp_1$1
XFILLER_86_557 vssd1 vccd1 vccd1 vssd1 sky130_ef_sc_hd__decap_40_12$1
XFILLER_59_749 vssd1 vccd1 vccd1 vssd1 sky130_ef_sc_hd__decap_40_12$1
XFILLER_132_15 vssd1 vccd1 vccd1 vssd1 sky130_ef_sc_hd__decap_40_12$1
XFILLER_100_345 vssd1 vccd1 vccd1 vssd1 sky130_ef_sc_hd__decap_40_12$1
XFILLER_100_389 vssd1 vccd1 vccd1 vssd1 sky130_ef_sc_hd__decap_40_12$1
XFILLER_67_782 vssd1 vccd1 vccd1 vssd1 sky130_fd_sc_hd__fill_2$1
XFILLER_54_421 vssd1 vccd1 vccd1 vssd1 sky130_fd_sc_hd__fill_8$1
XFILLER_27_613 vssd1 vccd1 vccd1 vssd1 sky130_fd_sc_hd__fill_2$1
XFILLER_39_473 vssd1 vccd1 vccd1 vssd1 sky130_ef_sc_hd__decap_40_12$1
XFILLER_81_273 vssd1 vccd1 vccd1 vssd1 sky130_fd_sc_hd__fill_4$1
XFILLER_14_307 vccd1 vssd1 vccd1 vssd1 sky130_fd_sc_hd__fill_1$1
XFILLER_26_189 vssd1 vccd1 vccd1 vssd1 sky130_fd_sc_hd__fill_4$1
XFILLER_42_627 vccd1 vssd1 vccd1 vssd1 sky130_fd_sc_hd__fill_1$1
XTAP_TAPCELL_ROW_85_1580 vccd1 vssd1 sky130_fd_sc_hd__tapvpwrvgnd_1$1
XFILLER_23_841 vccd1 vssd1 vccd1 vssd1 sky130_fd_sc_hd__fill_1$1
XFILLER_25_57 vssd1 vccd1 vccd1 vssd1 sky130_ef_sc_hd__decap_40_12$1
XFILLER_35_690 vssd1 vccd1 vccd1 vssd1 sky130_fd_sc_hd__fill_8$1
XFILLER_41_137 vssd1 vccd1 vccd1 vssd1 sky130_ef_sc_hd__decap_40_12$1
XFILLER_50_693 vssd1 vccd1 vccd1 vssd1 sky130_fd_sc_hd__fill_4$1
XFILLER_10_513 vssd1 vccd1 vccd1 vssd1 sky130_ef_sc_hd__decap_40_12$1
XFILLER_108_401 vssd1 vccd1 vccd1 vssd1 sky130_ef_sc_hd__decap_40_12$1
XFILLER_10_557 vssd1 vccd1 vccd1 vssd1 sky130_ef_sc_hd__decap_40_12$1
XFILLER_108_445 vssd1 vccd1 vccd1 vssd1 sky130_ef_sc_hd__decap_40_12$1
XTAP_TAPCELL_ROW_20_596 vccd1 vssd1 sky130_fd_sc_hd__tapvpwrvgnd_1$1
XFILLER_2_701 vssd1 vccd1 vccd1 vssd1 sky130_ef_sc_hd__decap_40_12$1
XFILLER_9_3 vssd1 vccd1 vccd1 vssd1 sky130_ef_sc_hd__decap_40_12$1
XFILLER_110_109 vssd1 vccd1 vccd1 vssd1 sky130_ef_sc_hd__decap_40_12$1
XFILLER_89_373 vccd1 vssd1 vccd1 vssd1 sky130_fd_sc_hd__fill_1$1
XFILLER_77_513 vssd1 vccd1 vccd1 vssd1 sky130_ef_sc_hd__decap_40_12$1
XFILLER_1_277 vssd1 vccd1 vccd1 vssd1 sky130_fd_sc_hd__fill_2$1
XFILLER_131_470 vssd1 vccd1 vccd1 vssd1 sky130_ef_sc_hd__decap_40_12$1
XFILLER_103_161 vssd1 vccd1 vccd1 vssd1 sky130_fd_sc_hd__fill_4$1
XFILLER_49_237 vssd1 vccd1 vccd1 vssd1 sky130_ef_sc_hd__decap_40_12$1
XFILLER_92_505 vssd1 vccd1 vccd1 vssd1 sky130_ef_sc_hd__decap_40_12$1
XFILLER_66_53 vssd1 vccd1 vccd1 vssd1 sky130_ef_sc_hd__decap_40_12$1
XFILLER_66_97 vssd1 vccd1 vccd1 vssd1 sky130_ef_sc_hd__decap_40_12$1
XFILLER_57_281 vssd1 vccd1 vccd1 vssd1 sky130_ef_sc_hd__decap_40_12$1
XFILLER_18_613 vssd1 vccd1 vccd1 vssd1 sky130_ef_sc_hd__decap_40_12$1
XFILLER_18_657 vssd1 vccd1 vccd1 vssd1 sky130_ef_sc_hd__decap_40_12$1
XFILLER_122_81 vssd1 vccd1 vccd1 vssd1 sky130_fd_sc_hd__fill_2$1
XFILLER_82_41 vssd1 vccd1 vccd1 vssd1 sky130_ef_sc_hd__decap_40_12$1
XFILLER_73_785 vssd1 vccd1 vccd1 vssd1 sky130_ef_sc_hd__decap_40_12$1
XFILLER_72_251 vccd1 vssd1 vccd1 vssd1 sky130_fd_sc_hd__fill_1$1
XFILLER_60_413 vssd1 vccd1 vccd1 vssd1 sky130_fd_sc_hd__fill_4$1
XFILLER_17_167 vccd1 vssd1 vccd1 vssd1 sky130_fd_sc_hd__fill_1$1
XFILLER_60_446 vssd1 vccd1 vccd1 vssd1 sky130_ef_sc_hd__decap_40_12$1
XFILLER_32_137 vssd1 vccd1 vccd1 vssd1 sky130_fd_sc_hd__fill_2$1
XFILLER_82_85 vssd1 vccd1 vccd1 vssd1 sky130_ef_sc_hd__decap_40_12$1
XFILLER_41_660 vssd1 vccd1 vccd1 vssd1 sky130_ef_sc_hd__decap_40_12$1
XFILLER_9_333 vssd1 vccd1 vccd1 vssd1 sky130_fd_sc_hd__fill_2$1
XFILLER_13_373 vssd1 vccd1 vccd1 vssd1 sky130_ef_sc_hd__decap_40_12$1
XFILLER_127_710 vssd1 vccd1 vccd1 vssd1 sky130_ef_sc_hd__decap_40_12$1
XFILLER_118_209 vssd1 vccd1 vccd1 vssd1 sky130_ef_sc_hd__decap_40_12$1
X_0880_ _0880_/A2 _1497_/D _0877_/X _1455_/C1 _1497_/Q _0879_/X vssd1 vccd1 vccd1
+ vssd1 sky130_fd_sc_hd__o221a_1$1
XFILLER_126_253 vssd1 vccd1 vccd1 vssd1 sky130_ef_sc_hd__decap_40_12$1
Xoutput107 _1811_/X analog_ctrl[40] vssd1 vccd1 vccd1 vssd1 sky130_fd_sc_hd__buf_12$1
X_1501_ _1501_/Q _1757_/CLK _1501_/D vccd1 vssd1 vccd1 vssd1 sky130_fd_sc_hd__dfxtp_1$1
Xoutput129 _1831_/X analog_ctrl[60] vssd1 vccd1 vccd1 vssd1 sky130_fd_sc_hd__buf_12$1
Xoutput118 _1821_/X analog_ctrl[50] vssd1 vccd1 vccd1 vssd1 sky130_fd_sc_hd__buf_12$1
XFILLER_5_561 vssd1 vccd1 vccd1 vssd1 sky130_ef_sc_hd__decap_40_12$1
XFILLER_99_137 vssd1 vccd1 vccd1 vssd1 sky130_ef_sc_hd__decap_40_12$1
X_1432_ _1851_/A _1432_/X _1474_/B vssd1 vccd1 vccd1 vssd1 sky130_fd_sc_hd__or2_1$1
XTAP_TAPCELL_ROW_110_1949 vccd1 vssd1 sky130_fd_sc_hd__tapvpwrvgnd_1$1
XFILLER_101_109 vssd1 vccd1 vccd1 vssd1 sky130_fd_sc_hd__fill_2$1
XFILLER_96_811 vccd1 vssd1 vccd1 vssd1 sky130_fd_sc_hd__fill_1$1
XFILLER_122_481 vccd1 vssd1 vccd1 vssd1 sky130_fd_sc_hd__fill_1$1
XFILLER_110_643 vccd1 vssd1 vccd1 vssd1 sky130_fd_sc_hd__fill_1$1
X_1363_ _1447_/C1 _1362_/X _1399_/A2 hold183/X _1709_/D vssd1 vccd1 vccd1 vssd1 sky130_fd_sc_hd__o211a_1$1
XFILLER_83_505 vccd1 vssd1 vccd1 vssd1 sky130_fd_sc_hd__fill_1$1
X_1294_ _1294_/A _1294_/X _1342_/B vssd1 vccd1 vccd1 vssd1 sky130_fd_sc_hd__or2_1$1
XFILLER_68_579 vssd1 vccd1 vccd1 vssd1 sky130_fd_sc_hd__fill_8$1
XTAP_TAPCELL_ROW_52_1078 vccd1 vssd1 sky130_fd_sc_hd__tapvpwrvgnd_1$1
XFILLER_36_421 vssd1 vccd1 vccd1 vssd1 sky130_ef_sc_hd__decap_40_12$1
XFILLER_102_29 vssd1 vccd1 vccd1 vssd1 sky130_ef_sc_hd__decap_40_12$1
XFILLER_63_273 vssd1 vccd1 vccd1 vssd1 sky130_fd_sc_hd__fill_4$1
XFILLER_51_446 vssd1 vccd1 vccd1 vssd1 sky130_fd_sc_hd__fill_2$1
XFILLER_23_137 vssd1 vccd1 vccd1 vssd1 sky130_ef_sc_hd__decap_40_12$1
XFILLER_137_529 vssd1 vccd1 vccd1 vssd1 sky130_ef_sc_hd__decap_40_12$1
XFILLER_31_181 vssd1 vccd1 vccd1 vssd1 sky130_ef_sc_hd__decap_40_12$1
XFILLER_11_15 vssd1 vccd1 vccd1 vssd1 sky130_ef_sc_hd__decap_40_12$1
XFILLER_127_15 vssd1 vccd1 vccd1 vssd1 sky130_ef_sc_hd__decap_40_12$1
XFILLER_132_245 vssd1 vccd1 vccd1 vssd1 sky130_fd_sc_hd__fill_4$1
XFILLER_132_289 vssd1 vccd1 vccd1 vssd1 sky130_ef_sc_hd__decap_40_12$1
XFILLER_86_321 vssd1 vccd1 vccd1 vssd1 sky130_ef_sc_hd__decap_40_12$1
XFILLER_101_665 vccd1 vssd1 vccd1 vssd1 sky130_fd_sc_hd__fill_1$1
XFILLER_86_365 vssd1 vccd1 vccd1 vssd1 sky130_ef_sc_hd__decap_40_12$1
XFILLER_59_557 vssd1 vccd1 vccd1 vssd1 sky130_fd_sc_hd__fill_2$1
XFILLER_100_153 vssd1 vccd1 vccd1 vssd1 sky130_ef_sc_hd__decap_40_12$1
XFILLER_100_197 vssd1 vccd1 vccd1 vssd1 sky130_ef_sc_hd__decap_40_12$1
XFILLER_55_741 vssd1 vccd1 vccd1 vssd1 sky130_ef_sc_hd__decap_40_12$1
XFILLER_39_281 vssd1 vccd1 vccd1 vssd1 sky130_ef_sc_hd__decap_40_12$1
XFILLER_55_785 vssd1 vccd1 vccd1 vssd1 sky130_fd_sc_hd__fill_4$1
XFILLER_54_251 vccd1 vssd1 vccd1 vssd1 sky130_fd_sc_hd__fill_1$1
XFILLER_42_413 vssd1 vccd1 vccd1 vssd1 sky130_fd_sc_hd__fill_4$1
XTAP_TAPCELL_ROW_83_1539 vccd1 vssd1 sky130_fd_sc_hd__tapvpwrvgnd_1$1
XFILLER_82_593 vssd1 vccd1 vccd1 vssd1 sky130_fd_sc_hd__fill_2$1
XFILLER_70_755 vccd1 vssd1 vccd1 vssd1 sky130_fd_sc_hd__fill_1$1
XFILLER_14_137 vssd1 vccd1 vccd1 vssd1 sky130_fd_sc_hd__fill_2$1
XFILLER_42_457 vssd1 vccd1 vccd1 vssd1 sky130_fd_sc_hd__fill_4$1
XFILLER_23_671 vccd1 vssd1 vccd1 vssd1 sky130_fd_sc_hd__fill_1$1
XTAP_TAPCELL_ROW_25_677 vccd1 vssd1 sky130_fd_sc_hd__tapvpwrvgnd_1$1
XFILLER_52_77 vssd1 vccd1 vccd1 vssd1 sky130_fd_sc_hd__fill_4$1
XFILLER_10_321 vssd1 vccd1 vccd1 vssd1 sky130_ef_sc_hd__decap_40_12$1
XPHY_EDGE_ROW_30_Left_169 vccd1 vssd1 vccd1 vssd1 sky130_fd_sc_hd__decap_3$1
XTAP_TAPCELL_ROW_114_2005 vccd1 vssd1 sky130_fd_sc_hd__tapvpwrvgnd_1$1
XFILLER_10_365 vssd1 vccd1 vccd1 vssd1 sky130_ef_sc_hd__decap_40_12$1
XTAP_TAPCELL_ROW_114_2016 vccd1 vssd1 sky130_fd_sc_hd__tapvpwrvgnd_1$1
XFILLER_108_253 vssd1 vccd1 vccd1 vssd1 sky130_ef_sc_hd__decap_40_12$1
XTAP_TAPCELL_ROW_98_1771 vccd1 vssd1 sky130_fd_sc_hd__tapvpwrvgnd_1$1
XFILLER_124_713 vssd1 vccd1 vccd1 vssd1 sky130_fd_sc_hd__fill_8$1
XFILLER_123_223 vccd1 vssd1 vccd1 vssd1 sky130_fd_sc_hd__fill_1$1
XFILLER_2_531 vccd1 vssd1 vccd1 vssd1 sky130_fd_sc_hd__fill_1$1
XFILLER_117_81 vssd1 vccd1 vccd1 vssd1 sky130_ef_sc_hd__decap_40_12$1
XFILLER_78_811 vccd1 vssd1 vccd1 vssd1 sky130_fd_sc_hd__fill_1$1
XFILLER_104_492 vssd1 vccd1 vccd1 vssd1 sky130_ef_sc_hd__decap_40_12$1
XFILLER_89_181 vssd1 vccd1 vccd1 vssd1 sky130_ef_sc_hd__decap_40_12$1
XFILLER_65_505 vssd1 vccd1 vccd1 vssd1 sky130_ef_sc_hd__decap_40_12$1
XTAP_TAPCELL_ROW_5_380 vccd1 vssd1 sky130_fd_sc_hd__tapvpwrvgnd_1$1
XFILLER_92_357 vssd1 vccd1 vccd1 vssd1 sky130_fd_sc_hd__fill_4$1
XFILLER_93_51 vssd1 vccd1 vccd1 vssd1 sky130_fd_sc_hd__fill_4$1
XFILLER_18_421 vssd1 vccd1 vccd1 vssd1 sky130_ef_sc_hd__decap_40_12$1
XTAP_TAPCELL_ROW_125_2178 vccd1 vssd1 sky130_fd_sc_hd__tapvpwrvgnd_1$1
XFILLER_60_221 vssd1 vccd1 vccd1 vssd1 sky130_ef_sc_hd__decap_40_12$1
XFILLER_45_273 vssd1 vccd1 vccd1 vssd1 sky130_fd_sc_hd__fill_4$1
XFILLER_61_777 vssd1 vccd1 vccd1 vssd1 sky130_fd_sc_hd__fill_4$1
XFILLER_60_265 vssd1 vccd1 vccd1 vssd1 sky130_ef_sc_hd__decap_40_12$1
XTAP_TAPCELL_ROW_44_953 vccd1 vssd1 sky130_fd_sc_hd__tapvpwrvgnd_1$1
XTAP_TAPCELL_ROW_44_964 vccd1 vssd1 sky130_fd_sc_hd__tapvpwrvgnd_1$1
XFILLER_14_693 vssd1 vccd1 vccd1 vssd1 sky130_fd_sc_hd__fill_4$1
X_0932_ _0932_/X _0753_/X _1602_/Q _1570_/Q _0944_/A2 vssd1 vccd1 _0931_/X vccd1 vssd1
+ sky130_fd_sc_hd__a221o_1$1
XFILLER_13_181 vssd1 vccd1 vccd1 vssd1 sky130_ef_sc_hd__decap_40_12$1
X_0863_ _1719_/Q _0878_/B1 _0863_/X _1655_/Q _1213_/A vccd1 vssd1 vccd1 vssd1 sky130_fd_sc_hd__a22o_1$1
XFILLER_61_3 vssd1 vccd1 vccd1 vssd1 sky130_ef_sc_hd__decap_40_12$1
XFILLER_127_573 vccd1 vssd1 vccd1 vssd1 sky130_fd_sc_hd__fill_1$1
X_0794_ _0879_/B1 _0794_/X _0793_/X _1785_/A _0875_/A2 _0792_/X vssd1 vccd1 vccd1
+ vssd1 sky130_fd_sc_hd__a2111o_1$1
XFILLER_114_245 vssd1 vccd1 vccd1 vssd1 sky130_fd_sc_hd__fill_4$1
XTAP_TAPCELL_ROW_54_1107 vccd1 vssd1 sky130_fd_sc_hd__tapvpwrvgnd_1$1
XFILLER_5_391 vccd1 vssd1 vccd1 vssd1 sky130_fd_sc_hd__fill_1$1
XFILLER_102_407 vccd1 vssd1 vccd1 vssd1 sky130_fd_sc_hd__fill_1$1
XFILLER_114_289 vssd1 vccd1 vccd1 vssd1 sky130_ef_sc_hd__decap_40_12$1
X_1415_ _1441_/C1 _1414_/X _1475_/A2 hold73/X _1734_/D vssd1 vccd1 vccd1 vssd1 sky130_fd_sc_hd__o211a_1$1
XFILLER_68_321 vssd1 vccd1 vccd1 vssd1 sky130_ef_sc_hd__decap_40_12$1
XFILLER_68_365 vssd1 vccd1 vccd1 vssd1 sky130_ef_sc_hd__decap_40_12$1
X_1346_ _1824_/A _1346_/X _1408_/B vssd1 vccd1 vccd1 vssd1 sky130_fd_sc_hd__or2_1$1
XTAP_TAPCELL_ROW_3_339 vccd1 vssd1 sky130_fd_sc_hd__tapvpwrvgnd_1$1
XFILLER_3_93 vssd1 vccd1 vccd1 vssd1 sky130_ef_sc_hd__decap_40_12$1
X_1277_ _1475_/C1 _1276_/X _1277_/A2 hold2/X _1668_/D vssd1 vccd1 vccd1 vssd1 sky130_fd_sc_hd__o211a_1$1
XFILLER_113_39 vssd1 vccd1 vccd1 vssd1 sky130_ef_sc_hd__decap_40_12$1
XFILLER_83_335 vccd1 vssd1 vccd1 vssd1 sky130_fd_sc_hd__fill_1$1
XFILLER_56_549 vssd1 vccd1 vccd1 vssd1 sky130_ef_sc_hd__decap_40_12$1
XFILLER_37_741 vssd1 vccd1 vccd1 vssd1 sky130_ef_sc_hd__decap_40_12$1
XFILLER_36_251 vccd1 vssd1 vccd1 vssd1 sky130_fd_sc_hd__fill_1$1
XFILLER_37_785 vssd1 vccd1 vccd1 vssd1 sky130_ef_sc_hd__decap_40_12$1
XFILLER_51_221 vssd1 vccd1 vccd1 vssd1 sky130_fd_sc_hd__fill_2$1
XFILLER_24_413 vssd1 vccd1 vccd1 vssd1 sky130_fd_sc_hd__fill_4$1
XTAP_TAPCELL_ROW_65_1269 vccd1 vssd1 sky130_fd_sc_hd__tapvpwrvgnd_1$1
XFILLER_52_755 vccd1 vssd1 vccd1 vssd1 sky130_fd_sc_hd__fill_1$1
XFILLER_24_457 vssd1 vccd1 vccd1 vssd1 sky130_ef_sc_hd__decap_40_12$1
XTAP_TAPCELL_ROW_22_625 vccd1 vssd1 sky130_fd_sc_hd__tapvpwrvgnd_1$1
XFILLER_20_641 vssd1 vccd1 vccd1 vssd1 sky130_fd_sc_hd__fill_2$1
XTAP_TAPCELL_ROW_22_636 vccd1 vssd1 sky130_fd_sc_hd__tapvpwrvgnd_1$1
XFILLER_138_25 vssd1 vccd1 vccd1 vssd1 sky130_fd_sc_hd__fill_2$1
XFILLER_138_47 vssd1 vccd1 vccd1 vssd1 sky130_fd_sc_hd__fill_8$1
XFILLER_106_713 vssd1 vccd1 vccd1 vssd1 sky130_fd_sc_hd__fill_2$1
XFILLER_98_29 vssd1 vccd1 vccd1 vssd1 sky130_ef_sc_hd__decap_40_12$1
XFILLER_3_317 vssd1 vccd1 vccd1 vssd1 sky130_ef_sc_hd__decap_40_12$1
XFILLER_106_757 vssd1 vccd1 vccd1 vssd1 sky130_ef_sc_hd__decap_40_12$1
XFILLER_105_223 vccd1 vssd1 vccd1 vssd1 sky130_fd_sc_hd__fill_1$1
XFILLER_133_554 vssd1 vccd1 vccd1 vssd1 sky130_fd_sc_hd__fill_4$1
XFILLER_121_727 vccd1 vssd1 vccd1 vssd1 sky130_fd_sc_hd__fill_1$1
XTAP_TAPCELL_ROW_93_1690 vccd1 vssd1 sky130_fd_sc_hd__tapvpwrvgnd_1$1
XFILLER_101_440 vssd1 vccd1 vccd1 vssd1 sky130_fd_sc_hd__fill_8$1
XFILLER_87_641 vssd1 vccd1 vccd1 vssd1 sky130_ef_sc_hd__decap_40_12$1
XFILLER_47_505 vssd1 vccd1 vccd1 vssd1 sky130_fd_sc_hd__fill_4$1
XFILLER_101_484 vssd1 vccd1 vccd1 vssd1 sky130_fd_sc_hd__fill_4$1
XFILLER_87_685 vssd1 vccd1 vccd1 vssd1 sky130_ef_sc_hd__decap_40_12$1
XFILLER_47_55 vccd1 vssd1 vccd1 vssd1 sky130_fd_sc_hd__fill_1$1
XFILLER_86_195 vccd1 vssd1 vccd1 vssd1 sky130_fd_sc_hd__fill_1$1
XFILLER_74_357 vssd1 vccd1 vccd1 vssd1 sky130_fd_sc_hd__fill_4$1
XFILLER_70_530 vssd1 vccd1 vccd1 vssd1 sky130_fd_sc_hd__fill_2$1
XFILLER_27_273 vssd1 vccd1 vccd1 vssd1 sky130_fd_sc_hd__fill_4$1
XFILLER_42_221 vssd1 vccd1 vccd1 vssd1 sky130_ef_sc_hd__decap_40_12$1
XTAP_TAPCELL_ROW_120_2097 vccd1 vssd1 sky130_fd_sc_hd__tapvpwrvgnd_1$1
XFILLER_70_585 vssd1 vccd1 vccd1 vssd1 sky130_fd_sc_hd__fill_2$1
XTAP_TAPCELL_ROW_41_912 vccd1 vssd1 sky130_fd_sc_hd__tapvpwrvgnd_1$1
XFILLER_42_265 vssd1 vccd1 vccd1 vssd1 sky130_ef_sc_hd__decap_40_12$1
XFILLER_129_816 vssd1 vccd1 vccd1 vssd1 sky130_fd_sc_hd__fill_8$1
XFILLER_11_641 vssd1 vccd1 vccd1 vssd1 sky130_ef_sc_hd__decap_40_12$1
XFILLER_8_27 vccd1 vssd1 vccd1 vssd1 sky130_fd_sc_hd__fill_1$1
XFILLER_11_685 vssd1 vccd1 vccd1 vssd1 sky130_ef_sc_hd__decap_40_12$1
XFILLER_10_195 vccd1 vssd1 vccd1 vssd1 sky130_fd_sc_hd__fill_1$1
XFILLER_6_133 vssd1 vccd1 vccd1 vssd1 sky130_fd_sc_hd__fill_4$1
XFILLER_124_510 vssd1 vccd1 vccd1 vssd1 sky130_ef_sc_hd__decap_40_12$1
XFILLER_6_177 vssd1 vccd1 vccd1 vssd1 sky130_ef_sc_hd__decap_40_12$1
XFILLER_111_237 vssd1 vccd1 vccd1 vssd1 sky130_ef_sc_hd__decap_40_12$1
XFILLER_97_449 vssd1 vccd1 vccd1 vssd1 sky130_fd_sc_hd__fill_4$1
XFILLER_2_361 vssd1 vccd1 vccd1 vssd1 sky130_fd_sc_hd__fill_2$1
XTAP_TAPCELL_ROW_127_2207 vccd1 vssd1 sky130_fd_sc_hd__tapvpwrvgnd_1$1
X_1200_ _1200_/A _1200_/X _1210_/B vssd1 vccd1 vccd1 vssd1 sky130_fd_sc_hd__or2_1$1
XFILLER_78_641 vssd1 vccd1 vccd1 vssd1 sky130_fd_sc_hd__fill_2$1
XFILLER_66_825 vccd1 vssd1 vccd1 vssd1 sky130_fd_sc_hd__fill_1$1
X_1131_ _1461_/C1 _1130_/X _1145_/A2 hold86/X _1597_/D vssd1 vccd1 vccd1 vssd1 sky130_fd_sc_hd__o211a_1$1
XTAP_TAPCELL_ROW_109_1940 vccd1 vssd1 sky130_fd_sc_hd__tapvpwrvgnd_1$1
XFILLER_92_121 vssd1 vccd1 vccd1 vssd1 sky130_ef_sc_hd__decap_40_12$1
XFILLER_65_335 vccd1 vssd1 vccd1 vssd1 sky130_fd_sc_hd__fill_1$1
XFILLER_19_741 vssd1 vccd1 vccd1 vssd1 sky130_ef_sc_hd__decap_40_12$1
X_1062_ hold40/X _1062_/X _1078_/B vssd1 vccd1 vccd1 vssd1 sky130_fd_sc_hd__or2_1$1
XFILLER_92_165 vssd1 vccd1 vccd1 vssd1 sky130_ef_sc_hd__decap_40_12$1
XFILLER_80_305 vssd1 vccd1 vccd1 vssd1 sky130_fd_sc_hd__fill_2$1
XFILLER_18_251 vccd1 vssd1 vccd1 vssd1 sky130_fd_sc_hd__fill_1$1
XFILLER_19_785 vssd1 vccd1 vccd1 vssd1 sky130_fd_sc_hd__fill_4$1
XFILLER_33_221 vssd1 vccd1 vccd1 vssd1 sky130_fd_sc_hd__fill_2$1
XFILLER_34_755 vccd1 vssd1 vccd1 vssd1 sky130_fd_sc_hd__fill_1$1
XFILLER_61_585 vssd1 vccd1 vccd1 vssd1 sky130_ef_sc_hd__decap_40_12$1
XFILLER_21_405 vssd1 vccd1 vccd1 vssd1 sky130_ef_sc_hd__decap_40_12$1
XFILLER_21_449 vssd1 vccd1 vccd1 vssd1 sky130_ef_sc_hd__decap_40_12$1
XTAP_TAPCELL_ROW_138_2369 vccd1 vssd1 sky130_fd_sc_hd__tapvpwrvgnd_1$1
XFILLER_119_337 vssd1 vccd1 vccd1 vssd1 sky130_ef_sc_hd__decap_40_12$1
X_0915_ _0945_/A _0915_/X _0915_/B _0915_/C vccd1 vssd1 vccd1 vssd1 sky130_fd_sc_hd__or3_1$1
XTAP_TAPCELL_ROW_60_1199 vccd1 vssd1 sky130_fd_sc_hd__tapvpwrvgnd_1$1
XFILLER_134_307 vccd1 vssd1 vccd1 vssd1 sky130_fd_sc_hd__fill_1$1
X_0846_ _1806_/A _0879_/A2 _0846_/X _1684_/Q _0875_/B1 vccd1 vssd1 vccd1 vssd1 sky130_fd_sc_hd__a22o_1$1
X_0777_ _0880_/A2 _1480_/D _0773_/X _1421_/C1 _1480_/Q _0776_/X vssd1 vccd1 vccd1
+ vssd1 sky130_fd_sc_hd__o221a_1$1
XFILLER_103_705 vssd1 vccd1 vccd1 vssd1 sky130_fd_sc_hd__fill_2$1
XFILLER_88_405 vssd1 vccd1 vccd1 vssd1 sky130_ef_sc_hd__decap_40_12$1
XFILLER_0_309 vssd1 vccd1 vccd1 vssd1 sky130_ef_sc_hd__decap_40_12$1
XFILLER_124_27 vccd1 vssd1 vccd1 vssd1 sky130_fd_sc_hd__fill_1$1
XFILLER_111_771 vssd1 vccd1 vccd1 vssd1 sky130_ef_sc_hd__decap_40_12$1
XFILLER_29_505 vssd1 vccd1 vccd1 vssd1 sky130_ef_sc_hd__decap_40_12$1
X_1329_ _1463_/C1 _1328_/X _1331_/A2 hold86/X _1693_/D vssd1 vccd1 vccd1 vssd1 sky130_fd_sc_hd__o211a_1$1
XFILLER_68_195 vccd1 vssd1 vccd1 vssd1 sky130_fd_sc_hd__fill_1$1
XFILLER_84_699 vccd1 vssd1 vccd1 vssd1 sky130_fd_sc_hd__fill_1$1
XFILLER_83_165 vssd1 vccd1 vccd1 vssd1 sky130_fd_sc_hd__fill_2$1
XFILLER_71_305 vssd1 vccd1 vccd1 vssd1 sky130_ef_sc_hd__decap_40_12$1
XTAP_TAPCELL_ROW_67_1309 vccd1 vssd1 sky130_fd_sc_hd__tapvpwrvgnd_1$1
XFILLER_56_357 vssd1 vccd1 vccd1 vssd1 sky130_fd_sc_hd__fill_4$1
XTAP_TAPCELL_ROW_27_706 vccd1 vssd1 sky130_fd_sc_hd__tapvpwrvgnd_1$1
XFILLER_71_349 vssd1 vccd1 vccd1 vssd1 sky130_ef_sc_hd__decap_40_12$1
XFILLER_17_69 vssd1 vccd1 vccd1 vssd1 sky130_ef_sc_hd__decap_40_12$1
XFILLER_52_530 vssd1 vccd1 vccd1 vssd1 sky130_fd_sc_hd__fill_2$1
XFILLER_24_221 vssd1 vccd1 vccd1 vssd1 sky130_ef_sc_hd__decap_40_12$1
XFILLER_52_585 vssd1 vccd1 vccd1 vssd1 sky130_fd_sc_hd__fill_2$1
XFILLER_24_265 vssd1 vccd1 vccd1 vssd1 sky130_ef_sc_hd__decap_40_12$1
XFILLER_33_57 vssd1 vccd1 vccd1 vssd1 sky130_ef_sc_hd__decap_40_12$1
XFILLER_40_769 vssd1 vccd1 vccd1 vssd1 sky130_ef_sc_hd__decap_40_12$1
XFILLER_137_167 vccd1 vssd1 vccd1 vssd1 sky130_fd_sc_hd__fill_1$1
XFILLER_125_329 vssd1 vccd1 vccd1 vssd1 sky130_fd_sc_hd__fill_4$1
XPHY_EDGE_ROW_104_Left_243 vccd1 vssd1 vccd1 vssd1 sky130_fd_sc_hd__decap_3$1
XTAP_TAPCELL_ROW_95_1730 vccd1 vssd1 sky130_fd_sc_hd__tapvpwrvgnd_1$1
XFILLER_134_841 vccd1 vssd1 vccd1 vssd1 sky130_fd_sc_hd__fill_1$1
XFILLER_109_3 vssd1 vccd1 vccd1 vssd1 sky130_ef_sc_hd__decap_40_12$1
XFILLER_4_637 vssd1 vccd1 vccd1 vssd1 sky130_fd_sc_hd__fill_4$1
XFILLER_3_125 vssd1 vccd1 vccd1 vssd1 sky130_ef_sc_hd__decap_40_12$1
XFILLER_3_169 vssd1 vccd1 vccd1 vssd1 sky130_ef_sc_hd__decap_40_12$1
XFILLER_121_524 vssd1 vccd1 vccd1 vssd1 sky130_ef_sc_hd__decap_40_12$1
XFILLER_106_587 vccd1 vssd1 vccd1 vssd1 sky130_fd_sc_hd__fill_1$1
XFILLER_58_65 vssd1 vccd1 vccd1 vssd1 sky130_ef_sc_hd__decap_40_12$1
Xhold9 hold9/A hold9/X vssd1 vccd1 vccd1 vssd1 sky130_fd_sc_hd__dlygate4sd3_1$1
XPHY_EDGE_ROW_113_Left_252 vccd1 vssd1 vccd1 vssd1 sky130_fd_sc_hd__decap_3$1
XFILLER_101_281 vssd1 vccd1 vccd1 vssd1 sky130_ef_sc_hd__decap_40_12$1
XFILLER_87_493 vssd1 vccd1 vccd1 vssd1 sky130_fd_sc_hd__fill_8$1
XFILLER_75_655 vssd1 vccd1 vccd1 vssd1 sky130_ef_sc_hd__decap_40_12$1
XFILLER_74_121 vssd1 vccd1 vccd1 vssd1 sky130_ef_sc_hd__decap_40_12$1
XFILLER_47_335 vccd1 vssd1 vccd1 vssd1 sky130_fd_sc_hd__fill_1$1
XFILLER_74_165 vssd1 vccd1 vccd1 vssd1 sky130_ef_sc_hd__decap_40_12$1
XFILLER_62_305 vssd1 vccd1 vccd1 vssd1 sky130_fd_sc_hd__fill_2$1
XTAP_TAPCELL_ROW_122_2137 vccd1 vssd1 sky130_fd_sc_hd__tapvpwrvgnd_1$1
XTAP_TAPCELL_ROW_122_2126 vccd1 vssd1 sky130_fd_sc_hd__tapvpwrvgnd_1$1
XFILLER_90_625 vssd1 vccd1 vccd1 vssd1 sky130_ef_sc_hd__decap_40_12$1
XFILLER_74_53 vssd1 vccd1 vccd1 vssd1 sky130_ef_sc_hd__decap_40_12$1
XFILLER_74_97 vssd1 vccd1 vccd1 vssd1 sky130_ef_sc_hd__decap_40_12$1
XFILLER_55_390 vssd1 vccd1 vccd1 vssd1 sky130_fd_sc_hd__fill_2$1
XFILLER_15_221 vssd1 vccd1 vccd1 vssd1 sky130_fd_sc_hd__fill_2$1
XFILLER_16_755 vccd1 vssd1 vccd1 vssd1 sky130_fd_sc_hd__fill_1$1
XFILLER_43_541 vssd1 vccd1 vccd1 vssd1 sky130_ef_sc_hd__decap_40_12$1
XFILLER_130_81 vssd1 vccd1 vccd1 vssd1 sky130_fd_sc_hd__fill_2$1
XFILLER_31_725 vssd1 vccd1 vccd1 vssd1 sky130_fd_sc_hd__fill_2$1
XFILLER_90_41 vssd1 vccd1 vccd1 vssd1 sky130_ef_sc_hd__decap_40_12$1
XPHY_EDGE_ROW_122_Left_261 vccd1 vssd1 vccd1 vssd1 sky130_fd_sc_hd__decap_3$1
XFILLER_90_85 vssd1 vccd1 vccd1 vssd1 sky130_ef_sc_hd__decap_40_12$1
XTAP_TAPCELL_ROW_13_488 vccd1 vssd1 sky130_fd_sc_hd__tapvpwrvgnd_1$1
XTAP_TAPCELL_ROW_13_499 vccd1 vssd1 sky130_fd_sc_hd__tapvpwrvgnd_1$1
XFILLER_116_307 vccd1 vssd1 vccd1 vssd1 sky130_fd_sc_hd__fill_1$1
X_1680_ _1680_/Q clkload7/A _1680_/D vccd1 vssd1 vccd1 vssd1 sky130_fd_sc_hd__dfxtp_1$1
XFILLER_128_189 vssd1 vccd1 vccd1 vssd1 sky130_fd_sc_hd__fill_4$1
XFILLER_125_841 vccd1 vssd1 vccd1 vssd1 sky130_fd_sc_hd__fill_1$1
XFILLER_7_497 vssd1 vccd1 vccd1 vssd1 sky130_fd_sc_hd__fill_4$1
XTAP_TAPCELL_ROW_133_2299 vccd1 vssd1 sky130_fd_sc_hd__tapvpwrvgnd_1$1
XTAP_TAPCELL_ROW_133_2288 vccd1 vssd1 sky130_fd_sc_hd__tapvpwrvgnd_1$1
XFILLER_98_736 vssd1 vccd1 vccd1 vssd1 sky130_fd_sc_hd__fill_2$1
XFILLER_112_557 vssd1 vccd1 vccd1 vssd1 sky130_ef_sc_hd__decap_40_12$1
XFILLER_98_769 vssd1 vccd1 vccd1 vssd1 sky130_fd_sc_hd__fill_4$1
XPHY_EDGE_ROW_131_Left_270 vccd1 vssd1 vccd1 vssd1 sky130_fd_sc_hd__decap_3$1
XFILLER_97_279 vccd1 vssd1 vccd1 vssd1 sky130_fd_sc_hd__fill_1$1
XFILLER_85_419 vccd1 vssd1 vccd1 vssd1 sky130_fd_sc_hd__fill_1$1
XFILLER_24_3 vssd1 vccd1 vccd1 vssd1 sky130_ef_sc_hd__decap_40_12$1
XPHY_EDGE_ROW_119_Right_119 vccd1 vssd1 vccd1 vssd1 sky130_fd_sc_hd__decap_3$1
X_1114_ _1807_/A _1114_/X _1144_/B vssd1 vccd1 vccd1 vssd1 sky130_fd_sc_hd__or2_1$1
XFILLER_65_165 vssd1 vccd1 vccd1 vssd1 sky130_fd_sc_hd__fill_2$1
XFILLER_53_305 vssd1 vccd1 vccd1 vssd1 sky130_ef_sc_hd__decap_40_12$1
XFILLER_38_357 vssd1 vccd1 vccd1 vssd1 sky130_fd_sc_hd__fill_4$1
XTAP_TAPCELL_ROW_49_1039 vccd1 vssd1 sky130_fd_sc_hd__tapvpwrvgnd_1$1
XTAP_TAPCELL_ROW_49_1028 vccd1 vssd1 sky130_fd_sc_hd__tapvpwrvgnd_1$1
X_1045_ _1443_/C1 _1044_/X _1079_/A2 hold172/X _1555_/D vssd1 vccd1 vccd1 vssd1 sky130_fd_sc_hd__o211a_1$1
XFILLER_81_669 vssd1 vccd1 vccd1 vssd1 sky130_fd_sc_hd__fill_2$1
XFILLER_53_349 vssd1 vccd1 vccd1 vssd1 sky130_ef_sc_hd__decap_40_12$1
XFILLER_0_83 vccd1 vssd1 vccd1 vssd1 sky130_fd_sc_hd__fill_1$1
XFILLER_110_29 vssd1 vccd1 vccd1 vssd1 sky130_ef_sc_hd__decap_40_12$1
XTAP_TAPCELL_ROW_62_1228 vccd1 vssd1 sky130_fd_sc_hd__tapvpwrvgnd_1$1
XFILLER_34_585 vssd1 vccd1 vccd1 vssd1 sky130_fd_sc_hd__fill_2$1
XFILLER_61_393 vssd1 vccd1 vccd1 vssd1 sky130_ef_sc_hd__decap_40_12$1
XFILLER_22_769 vssd1 vccd1 vccd1 vssd1 sky130_ef_sc_hd__decap_40_12$1
XFILLER_9_81 vssd1 vccd1 vccd1 vssd1 sky130_ef_sc_hd__decap_40_12$1
XFILLER_21_279 vccd1 vssd1 vccd1 vssd1 sky130_fd_sc_hd__fill_1$1
XTAP_TAPCELL_ROW_32_775 vccd1 vssd1 sky130_fd_sc_hd__tapvpwrvgnd_1$1
XFILLER_119_27 vssd1 vccd1 vccd1 vssd1 sky130_ef_sc_hd__decap_40_12$1
XTAP_TAPCELL_ROW_32_786 vccd1 vssd1 sky130_fd_sc_hd__tapvpwrvgnd_1$1
XFILLER_119_167 vccd1 vssd1 vccd1 vssd1 sky130_fd_sc_hd__fill_1$1
XFILLER_134_137 vssd1 vccd1 vccd1 vssd1 sky130_fd_sc_hd__fill_2$1
XFILLER_107_329 vssd1 vccd1 vccd1 vssd1 sky130_fd_sc_hd__fill_4$1
X_0829_ _1521_/Q _0949_/A _0829_/X _1649_/Q _1213_/A vccd1 vssd1 vccd1 vssd1 sky130_fd_sc_hd__a22o_1$1
XTAP_TAPCELL_ROW_77_1460 vccd1 vssd1 sky130_fd_sc_hd__tapvpwrvgnd_1$1
XFILLER_135_15 vssd1 vccd1 vccd1 vssd1 sky130_ef_sc_hd__decap_40_12$1
XFILLER_115_373 vssd1 vccd1 vccd1 vssd1 sky130_ef_sc_hd__decap_40_12$1
XFILLER_103_513 vssd1 vccd1 vccd1 vssd1 sky130_ef_sc_hd__decap_40_12$1
XFILLER_89_725 vssd1 vccd1 vccd1 vssd1 sky130_fd_sc_hd__fill_2$1
XFILLER_1_629 vssd1 vccd1 vccd1 vssd1 sky130_ef_sc_hd__decap_40_12$1
XFILLER_130_321 vssd1 vccd1 vccd1 vssd1 sky130_ef_sc_hd__decap_40_12$1
XFILLER_103_557 vssd1 vccd1 vccd1 vssd1 sky130_fd_sc_hd__fill_2$1
XFILLER_0_139 vccd1 vssd1 vccd1 vssd1 sky130_fd_sc_hd__fill_1$1
XFILLER_130_365 vssd1 vccd1 vccd1 vssd1 sky130_ef_sc_hd__decap_40_12$1
XFILLER_76_419 vccd1 vssd1 vccd1 vssd1 sky130_fd_sc_hd__fill_1$1
XFILLER_57_633 vssd1 vccd1 vccd1 vssd1 sky130_ef_sc_hd__decap_40_12$1
XFILLER_56_121 vssd1 vccd1 vccd1 vssd1 sky130_ef_sc_hd__decap_40_12$1
XFILLER_29_335 vccd1 vssd1 vccd1 vssd1 sky130_fd_sc_hd__fill_1$1
XFILLER_84_441 vssd1 vccd1 vccd1 vssd1 sky130_ef_sc_hd__decap_40_12$1
XFILLER_56_165 vssd1 vccd1 vccd1 vssd1 sky130_ef_sc_hd__decap_40_12$1
XFILLER_44_305 vssd1 vccd1 vccd1 vssd1 sky130_fd_sc_hd__fill_2$1
XFILLER_71_113 vssd1 vccd1 vccd1 vssd1 sky130_ef_sc_hd__decap_40_12$1
XFILLER_45_839 vccd1 vssd1 vccd1 vssd1 sky130_fd_sc_hd__fill_1$1
XFILLER_60_809 vssd1 vccd1 vccd1 vssd1 sky130_fd_sc_hd__fill_2$1
XFILLER_25_541 vssd1 vccd1 vccd1 vssd1 sky130_ef_sc_hd__decap_40_12$1
XFILLER_13_725 vssd1 vccd1 vccd1 vssd1 sky130_fd_sc_hd__fill_2$1
XFILLER_25_585 vssd1 vccd1 vccd1 vssd1 sky130_ef_sc_hd__decap_40_12$1
XFILLER_40_533 vssd1 vccd1 vccd1 vssd1 sky130_fd_sc_hd__fill_4$1
XFILLER_9_729 vssd1 vccd1 vccd1 vssd1 sky130_ef_sc_hd__decap_40_12$1
XFILLER_138_421 vssd1 vccd1 vccd1 vssd1 sky130_fd_sc_hd__fill_2$1
XFILLER_60_77 vssd1 vccd1 vccd1 vssd1 sky130_fd_sc_hd__fill_4$1
XTAP_TAPCELL_ROW_10_447 vccd1 vssd1 sky130_fd_sc_hd__tapvpwrvgnd_1$1
XFILLER_125_137 vssd1 vccd1 vccd1 vssd1 sky130_ef_sc_hd__decap_40_12$1
XFILLER_107_841 vccd1 vssd1 vccd1 vssd1 sky130_fd_sc_hd__fill_1$1
XFILLER_4_401 vssd1 vccd1 vccd1 vssd1 sky130_ef_sc_hd__decap_40_12$1
XFILLER_5_39 vssd1 vccd1 vccd1 vssd1 sky130_ef_sc_hd__decap_40_12$1
XFILLER_4_445 vssd1 vccd1 vccd1 vssd1 sky130_ef_sc_hd__decap_40_12$1
XFILLER_122_811 vccd1 vssd1 vccd1 vssd1 sky130_fd_sc_hd__fill_1$1
XFILLER_109_93 vssd1 vccd1 vccd1 vssd1 sky130_ef_sc_hd__decap_40_12$1
XFILLER_4_489 vssd1 vccd1 vccd1 vssd1 sky130_ef_sc_hd__decap_40_12$1
XFILLER_133_181 vssd1 vccd1 vccd1 vssd1 sky130_ef_sc_hd__decap_40_12$1
XFILLER_79_279 vccd1 vssd1 vccd1 vssd1 sky130_fd_sc_hd__fill_1$1
XFILLER_0_673 vssd1 vccd1 vccd1 vssd1 sky130_ef_sc_hd__decap_40_12$1
XFILLER_125_81 vssd1 vccd1 vccd1 vssd1 sky130_ef_sc_hd__decap_40_12$1
XFILLER_94_249 vssd1 vccd1 vccd1 vssd1 sky130_fd_sc_hd__fill_2$1
XFILLER_35_305 vssd1 vccd1 vccd1 vssd1 sky130_ef_sc_hd__decap_40_12$1
XFILLER_90_411 vssd1 vccd1 vccd1 vssd1 sky130_fd_sc_hd__fill_8$1
XFILLER_75_496 vssd1 vccd1 vccd1 vssd1 sky130_fd_sc_hd__fill_8$1
XFILLER_63_625 vssd1 vccd1 vccd1 vssd1 sky130_ef_sc_hd__decap_40_12$1
XFILLER_47_165 vssd1 vccd1 vccd1 vssd1 sky130_fd_sc_hd__fill_2$1
XFILLER_90_433 vssd1 vccd1 vccd1 vssd1 sky130_ef_sc_hd__decap_40_12$1
XFILLER_63_669 vssd1 vccd1 vccd1 vssd1 sky130_fd_sc_hd__fill_2$1
XFILLER_35_349 vssd1 vccd1 vccd1 vssd1 sky130_ef_sc_hd__decap_40_12$1
XTAP_TAPCELL_ROW_102_1829 vccd1 vssd1 sky130_fd_sc_hd__tapvpwrvgnd_1$1
XFILLER_90_477 vssd1 vccd1 vccd1 vssd1 sky130_ef_sc_hd__decap_40_12$1
XFILLER_16_585 vssd1 vccd1 vccd1 vssd1 sky130_fd_sc_hd__fill_2$1
XTAP_TAPCELL_ROW_18_569 vccd1 vssd1 sky130_fd_sc_hd__tapvpwrvgnd_1$1
XFILLER_71_691 vccd1 vssd1 vccd1 vssd1 sky130_fd_sc_hd__fill_1$1
XFILLER_43_393 vssd1 vccd1 vccd1 vssd1 sky130_ef_sc_hd__decap_40_12$1
X_1801_ _1801_/A _1801_/X vssd1 vccd1 vccd1 vssd1 sky130_fd_sc_hd__clkbuf_2$1
XTAP_TAPCELL_ROW_135_2328 vccd1 vssd1 sky130_fd_sc_hd__tapvpwrvgnd_1$1
XFILLER_129_421 vccd1 vssd1 vccd1 vssd1 sky130_fd_sc_hd__fill_1$1
X_1732_ _1732_/Q _1761_/CLK hold3/X vccd1 vssd1 vccd1 vssd1 sky130_fd_sc_hd__dfxtp_1$1
XFILLER_116_137 vssd1 vccd1 vccd1 vssd1 sky130_fd_sc_hd__fill_2$1
X_1663_ _1663_/Q _1729_/CLK _1663_/D vccd1 vssd1 vccd1 vssd1 sky130_fd_sc_hd__dfxtp_2$1
Xhold206 _1684_/Q _1310_/A vssd1 vccd1 vccd1 vssd1 sky130_fd_sc_hd__dlygate4sd3_1$1
XFILLER_7_261 vssd1 vccd1 vccd1 vssd1 sky130_ef_sc_hd__decap_40_12$1
Xhold217 _1520_/Q _0972_/A vssd1 vccd1 vccd1 vssd1 sky130_fd_sc_hd__dlygate4sd3_1$1
XFILLER_125_671 vccd1 vssd1 vccd1 vssd1 sky130_fd_sc_hd__fill_1$1
X_1594_ _1812_/A _1754_/CLK _1594_/D vccd1 vssd1 vccd1 vssd1 sky130_fd_sc_hd__dfxtp_1$1
XTAP_TAPCELL_ROW_59_1190 vccd1 vssd1 sky130_fd_sc_hd__tapvpwrvgnd_1$1
XFILLER_112_321 vssd1 vccd1 vccd1 vssd1 sky130_ef_sc_hd__decap_40_12$1
XFILLER_85_205 vssd1 vccd1 vccd1 vssd1 sky130_ef_sc_hd__decap_40_12$1
XFILLER_58_419 vccd1 vssd1 vccd1 vssd1 sky130_fd_sc_hd__fill_1$1
XPHY_EDGE_ROW_7_Right_7 vccd1 vssd1 vccd1 vssd1 sky130_fd_sc_hd__decap_3$1
XFILLER_39_611 vssd1 vccd1 vccd1 vssd1 sky130_fd_sc_hd__fill_4$1
XFILLER_39_600 vssd1 vccd1 vccd1 vssd1 sky130_fd_sc_hd__fill_4$1
XFILLER_85_249 vssd1 vccd1 vccd1 vssd1 sky130_ef_sc_hd__decap_40_12$1
XFILLER_38_121 vssd1 vccd1 vccd1 vssd1 sky130_ef_sc_hd__decap_40_12$1
XFILLER_39_644 vssd1 vccd1 vccd1 vssd1 sky130_ef_sc_hd__decap_40_12$1
XFILLER_53_113 vssd1 vccd1 vccd1 vssd1 sky130_ef_sc_hd__decap_40_12$1
XFILLER_26_305 vssd1 vccd1 vccd1 vssd1 sky130_fd_sc_hd__fill_2$1
XFILLER_38_165 vssd1 vccd1 vccd1 vssd1 sky130_ef_sc_hd__decap_40_12$1
XFILLER_39_699 vccd1 vssd1 vccd1 vssd1 sky130_fd_sc_hd__fill_1$1
XFILLER_121_39 vssd1 vccd1 vccd1 vssd1 sky130_ef_sc_hd__decap_40_12$1
XFILLER_93_293 vssd1 vccd1 vccd1 vssd1 sky130_ef_sc_hd__decap_40_12$1
XFILLER_81_444 vssd1 vccd1 vccd1 vssd1 sky130_fd_sc_hd__fill_4$1
XFILLER_54_669 vssd1 vccd1 vccd1 vssd1 sky130_ef_sc_hd__decap_40_12$1
XTAP_TAPCELL_ROW_37_856 vccd1 vssd1 sky130_fd_sc_hd__tapvpwrvgnd_1$1
X_1028_ _1778_/A _1028_/X _1052_/B vssd1 vccd1 vccd1 vssd1 sky130_fd_sc_hd__or2_1$1
XFILLER_14_15 vssd1 vccd1 vccd1 vssd1 sky130_ef_sc_hd__decap_40_12$1
XFILLER_22_533 vssd1 vccd1 vccd1 vssd1 sky130_ef_sc_hd__decap_40_12$1
XFILLER_108_627 vccd1 vssd1 vccd1 vssd1 sky130_fd_sc_hd__fill_1$1
XFILLER_107_137 vssd1 vccd1 vccd1 vssd1 sky130_ef_sc_hd__decap_40_12$1
XFILLER_104_800 vssd1 vccd1 vccd1 vssd1 sky130_ef_sc_hd__decap_40_12$1
XTAP_TAPCELL_ROW_75_1419 vccd1 vssd1 sky130_fd_sc_hd__tapvpwrvgnd_1$1
XFILLER_131_641 vssd1 vccd1 vccd1 vssd1 sky130_ef_sc_hd__decap_40_12$1
XFILLER_115_181 vssd1 vccd1 vccd1 vssd1 sky130_ef_sc_hd__decap_40_12$1
XFILLER_131_685 vssd1 vccd1 vccd1 vssd1 sky130_ef_sc_hd__decap_40_12$1
XFILLER_130_195 vccd1 vssd1 vccd1 vssd1 sky130_fd_sc_hd__fill_1$1
Xclkbuf_leaf_18_wb_clk_i _1633_/CLK clkbuf_2_3__f_wb_clk_i/X vssd1 vccd1 vccd1 vssd1
+ sky130_fd_sc_hd__clkbuf_8$1
XFILLER_76_249 vssd1 vccd1 vccd1 vssd1 sky130_fd_sc_hd__fill_2$1
XFILLER_85_783 vccd1 vssd1 vccd1 vssd1 sky130_fd_sc_hd__fill_1$1
XFILLER_17_305 vssd1 vccd1 vccd1 vssd1 sky130_ef_sc_hd__decap_40_12$1
XFILLER_29_165 vssd1 vccd1 vccd1 vssd1 sky130_fd_sc_hd__fill_2$1
XFILLER_72_433 vssd1 vccd1 vccd1 vssd1 sky130_ef_sc_hd__decap_40_12$1
XFILLER_55_55 vccd1 vssd1 vccd1 vssd1 sky130_fd_sc_hd__fill_1$1
XFILLER_17_349 vssd1 vccd1 vccd1 vssd1 sky130_ef_sc_hd__decap_40_12$1
XTAP_TAPCELL_ROW_15_528 vccd1 vssd1 sky130_fd_sc_hd__tapvpwrvgnd_1$1
XFILLER_25_393 vssd1 vccd1 vccd1 vssd1 sky130_ef_sc_hd__decap_40_12$1
XFILLER_40_363 vccd1 vssd1 vccd1 vssd1 sky130_fd_sc_hd__fill_1$1
XFILLER_9_559 vccd1 vssd1 vccd1 vssd1 sky130_fd_sc_hd__fill_1$1
XFILLER_138_251 vccd1 vssd1 vccd1 vssd1 sky130_fd_sc_hd__fill_1$1
XTAP_TAPCELL_ROW_117_2058 vccd1 vssd1 sky130_fd_sc_hd__tapvpwrvgnd_1$1
XFILLER_5_721 vssd1 vccd1 vccd1 vssd1 sky130_fd_sc_hd__fill_4$1
XFILLER_126_457 vssd1 vccd1 vccd1 vssd1 sky130_fd_sc_hd__fill_2$1
XFILLER_5_765 vssd1 vccd1 vccd1 vssd1 sky130_ef_sc_hd__decap_40_12$1
XTAP_TAPCELL_ROW_130_2247 vccd1 vssd1 sky130_fd_sc_hd__tapvpwrvgnd_1$1
XFILLER_4_253 vssd1 vccd1 vccd1 vssd1 sky130_ef_sc_hd__decap_40_12$1
XFILLER_134_490 vssd1 vccd1 vccd1 vssd1 sky130_ef_sc_hd__decap_40_12$1
XFILLER_122_641 vssd1 vccd1 vccd1 vssd1 sky130_fd_sc_hd__fill_2$1
XTAP_TAPCELL_ROW_112_1980 vccd1 vssd1 sky130_fd_sc_hd__tapvpwrvgnd_1$1
XFILLER_110_825 vssd1 vccd1 vccd1 vssd1 sky130_ef_sc_hd__decap_40_12$1
XFILLER_95_503 vccd1 vssd1 vccd1 vssd1 sky130_fd_sc_hd__fill_1$1
XFILLER_67_205 vssd1 vccd1 vccd1 vssd1 sky130_ef_sc_hd__decap_40_12$1
XFILLER_67_249 vssd1 vccd1 vccd1 vssd1 sky130_ef_sc_hd__decap_40_12$1
XFILLER_0_492 vssd1 vccd1 vccd1 vssd1 sky130_ef_sc_hd__decap_40_12$1
XFILLER_35_113 vssd1 vccd1 vccd1 vssd1 sky130_ef_sc_hd__decap_40_12$1
XFILLER_36_625 vssd1 vccd1 vccd1 vssd1 sky130_ef_sc_hd__decap_40_12$1
XFILLER_75_293 vssd1 vccd1 vccd1 vssd1 sky130_ef_sc_hd__decap_40_12$1
XFILLER_24_809 vssd1 vccd1 vccd1 vssd1 sky130_fd_sc_hd__fill_2$1
XFILLER_36_669 vssd1 vccd1 vccd1 vssd1 sky130_ef_sc_hd__decap_40_12$1
XFILLER_51_617 vssd1 vccd1 vccd1 vssd1 sky130_ef_sc_hd__decap_40_12$1
XFILLER_51_606 vssd1 vccd1 vccd1 vssd1 sky130_fd_sc_hd__fill_8$1
XTAP_TAPCELL_ROW_34_804 vccd1 vssd1 sky130_fd_sc_hd__tapvpwrvgnd_1$1
XTAP_TAPCELL_ROW_34_815 vccd1 vssd1 sky130_fd_sc_hd__tapvpwrvgnd_1$1
XFILLER_91_3 vssd1 vccd1 vccd1 vssd1 sky130_ef_sc_hd__decap_40_12$1
XFILLER_31_385 vssd1 vccd1 vccd1 vssd1 sky130_fd_sc_hd__fill_4$1
XFILLER_117_402 vssd1 vccd1 vccd1 vssd1 sky130_ef_sc_hd__decap_40_12$1
X_1715_ _1715_/Q _1719_/CLK _1715_/D vccd1 vssd1 vccd1 vssd1 sky130_fd_sc_hd__dfxtp_1$1
XFILLER_8_581 vssd1 vccd1 vccd1 vssd1 sky130_fd_sc_hd__fill_4$1
X_1646_ _1646_/Q clkload8/A _1646_/D vccd1 vssd1 vccd1 vssd1 sky130_fd_sc_hd__dfxtp_2$1
XTAP_TAPCELL_ROW_57_1149 vccd1 vssd1 sky130_fd_sc_hd__tapvpwrvgnd_1$1
XFILLER_132_449 vssd1 vccd1 vccd1 vssd1 sky130_ef_sc_hd__decap_40_12$1
X_1577_ _1791_/A _1579_/CLK _1577_/D vccd1 vssd1 vccd1 vssd1 sky130_fd_sc_hd__dfxtp_1$1
XFILLER_113_685 vssd1 vccd1 vccd1 vssd1 sky130_ef_sc_hd__decap_40_12$1
XFILLER_98_363 vccd1 vssd1 vccd1 vssd1 sky130_fd_sc_hd__fill_1$1
XFILLER_112_195 vccd1 vssd1 vccd1 vssd1 sky130_fd_sc_hd__fill_1$1
XFILLER_98_396 vssd1 vccd1 vccd1 vssd1 sky130_fd_sc_hd__fill_2$1
XTAP_TAPCELL_ROW_70_1349 vccd1 vssd1 sky130_fd_sc_hd__tapvpwrvgnd_1$1
XFILLER_58_249 vssd1 vccd1 vccd1 vssd1 sky130_fd_sc_hd__fill_2$1
XFILLER_132_27 vccd1 vssd1 vccd1 vssd1 sky130_fd_sc_hd__fill_1$1
XFILLER_100_357 vssd1 vccd1 vccd1 vssd1 sky130_fd_sc_hd__fill_4$1
XFILLER_86_569 vssd1 vccd1 vccd1 vssd1 sky130_ef_sc_hd__decap_40_12$1
XFILLER_39_441 vssd1 vccd1 vccd1 vssd1 sky130_fd_sc_hd__fill_4$1
XFILLER_39_485 vssd1 vccd1 vccd1 vssd1 sky130_ef_sc_hd__decap_40_12$1
XFILLER_15_809 vssd1 vccd1 vccd1 vssd1 sky130_fd_sc_hd__fill_8$1
XFILLER_54_477 vssd1 vccd1 vccd1 vssd1 sky130_ef_sc_hd__decap_40_12$1
XFILLER_41_105 vssd1 vccd1 vccd1 vssd1 sky130_fd_sc_hd__fill_4$1
XTAP_TAPCELL_ROW_85_1581 vccd1 vssd1 sky130_fd_sc_hd__tapvpwrvgnd_1$1
XTAP_TAPCELL_ROW_85_1570 vccd1 vssd1 sky130_fd_sc_hd__tapvpwrvgnd_1$1
XFILLER_25_69 vssd1 vccd1 vccd1 vssd1 sky130_ef_sc_hd__decap_40_12$1
XFILLER_41_149 vssd1 vccd1 vccd1 vssd1 sky130_ef_sc_hd__decap_40_12$1
XFILLER_10_525 vssd1 vccd1 vccd1 vssd1 sky130_fd_sc_hd__fill_4$1
XFILLER_22_363 vccd1 vssd1 vccd1 vssd1 sky130_fd_sc_hd__fill_1$1
XFILLER_10_569 vssd1 vccd1 vccd1 vssd1 sky130_ef_sc_hd__decap_40_12$1
XFILLER_41_57 vssd1 vccd1 vccd1 vssd1 sky130_ef_sc_hd__decap_40_12$1
XFILLER_108_413 vssd1 vccd1 vccd1 vssd1 sky130_fd_sc_hd__fill_4$1
XFILLER_6_529 vssd1 vccd1 vccd1 vssd1 sky130_fd_sc_hd__fill_2$1
XFILLER_135_221 vssd1 vccd1 vccd1 vssd1 sky130_fd_sc_hd__fill_2$1
XFILLER_108_457 vssd1 vccd1 vccd1 vssd1 sky130_ef_sc_hd__decap_40_12$1
XTAP_TAPCELL_ROW_20_597 vccd1 vssd1 sky130_fd_sc_hd__tapvpwrvgnd_1$1
XFILLER_2_713 vssd1 vccd1 vccd1 vssd1 sky130_ef_sc_hd__decap_40_12$1
XFILLER_123_449 vssd1 vccd1 vccd1 vssd1 sky130_ef_sc_hd__decap_40_12$1
XFILLER_104_641 vssd1 vccd1 vccd1 vssd1 sky130_fd_sc_hd__fill_2$1
XFILLER_2_757 vssd1 vccd1 vccd1 vssd1 sky130_ef_sc_hd__decap_40_12$1
XFILLER_1_223 vccd1 vssd1 vccd1 vssd1 sky130_fd_sc_hd__fill_1$1
XFILLER_77_503 vccd1 vssd1 vccd1 vssd1 sky130_fd_sc_hd__fill_1$1
XFILLER_49_205 vssd1 vccd1 vccd1 vssd1 sky130_ef_sc_hd__decap_40_12$1
XFILLER_131_482 vssd1 vccd1 vccd1 vssd1 sky130_ef_sc_hd__decap_40_12$1
XFILLER_77_525 vssd1 vccd1 vccd1 vssd1 sky130_fd_sc_hd__fill_4$1
XFILLER_2_29 vssd1 vccd1 vccd1 vssd1 sky130_ef_sc_hd__decap_40_12$1
XFILLER_106_83 vccd1 vssd1 vccd1 vssd1 sky130_fd_sc_hd__fill_1$1
XFILLER_77_558 vssd1 vccd1 vccd1 vssd1 sky130_fd_sc_hd__fill_2$1
XFILLER_65_709 vssd1 vccd1 vccd1 vssd1 sky130_ef_sc_hd__decap_40_12$1
XFILLER_49_249 vssd1 vccd1 vccd1 vssd1 sky130_ef_sc_hd__decap_40_12$1
XFILLER_92_517 vssd1 vccd1 vccd1 vssd1 sky130_fd_sc_hd__fill_4$1
XFILLER_66_65 vssd1 vccd1 vccd1 vssd1 sky130_ef_sc_hd__decap_40_12$1
XFILLER_58_794 vssd1 vccd1 vccd1 vssd1 sky130_fd_sc_hd__fill_2$1
XFILLER_18_625 vssd1 vccd1 vccd1 vssd1 sky130_ef_sc_hd__decap_40_12$1
XFILLER_73_753 vssd1 vccd1 vccd1 vssd1 sky130_ef_sc_hd__decap_40_12$1
XFILLER_73_731 vccd1 vssd1 vccd1 vssd1 sky130_fd_sc_hd__fill_1$1
XFILLER_57_293 vssd1 vccd1 vccd1 vssd1 sky130_ef_sc_hd__decap_40_12$1
XFILLER_17_113 vssd1 vccd1 vccd1 vssd1 sky130_ef_sc_hd__decap_40_12$1
XFILLER_18_669 vssd1 vccd1 vccd1 vssd1 sky130_ef_sc_hd__decap_40_12$1
XFILLER_73_797 vssd1 vccd1 vccd1 vssd1 sky130_ef_sc_hd__decap_40_12$1
XFILLER_33_617 vssd1 vccd1 vccd1 vssd1 sky130_ef_sc_hd__decap_40_12$1
XFILLER_82_53 vssd1 vccd1 vccd1 vssd1 sky130_ef_sc_hd__decap_40_12$1
XFILLER_26_691 vccd1 vssd1 vccd1 vssd1 sky130_fd_sc_hd__fill_1$1
XFILLER_82_97 vssd1 vccd1 vccd1 vssd1 sky130_ef_sc_hd__decap_40_12$1
XFILLER_60_458 vssd1 vccd1 vccd1 vssd1 sky130_ef_sc_hd__decap_40_12$1
XFILLER_13_385 vssd1 vccd1 vccd1 vssd1 sky130_fd_sc_hd__fill_4$1
XFILLER_40_193 vssd1 vccd1 vccd1 vssd1 sky130_fd_sc_hd__fill_2$1
XFILLER_127_722 vssd1 vccd1 vccd1 vssd1 sky130_fd_sc_hd__fill_4$1
XFILLER_9_389 vssd1 vccd1 vccd1 vssd1 sky130_fd_sc_hd__fill_2$1
XFILLER_126_221 vssd1 vccd1 vccd1 vssd1 sky130_ef_sc_hd__decap_40_12$1
X_1500_ _1500_/Q _1757_/CLK _1500_/D vccd1 vssd1 vccd1 vssd1 sky130_fd_sc_hd__dfxtp_1$1
XFILLER_126_265 vssd1 vccd1 vccd1 vssd1 sky130_ef_sc_hd__decap_40_12$1
XFILLER_99_105 vssd1 vccd1 vccd1 vssd1 sky130_fd_sc_hd__fill_4$1
Xoutput119 _1822_/X analog_ctrl[51] vssd1 vccd1 vccd1 vssd1 sky130_fd_sc_hd__buf_12$1
Xoutput108 _1812_/X analog_ctrl[41] vssd1 vccd1 vccd1 vssd1 sky130_fd_sc_hd__buf_12$1
XFILLER_5_573 vssd1 vccd1 vccd1 vssd1 sky130_ef_sc_hd__decap_40_12$1
XFILLER_99_149 vssd1 vccd1 vccd1 vssd1 sky130_ef_sc_hd__decap_40_12$1
X_1431_ _1431_/C1 _1430_/X _1475_/A2 hold155/X _1742_/D vssd1 vccd1 vccd1 vssd1 sky130_fd_sc_hd__o211a_1$1
XFILLER_95_333 vssd1 vccd1 vccd1 vssd1 sky130_fd_sc_hd__fill_2$1
X_1362_ _1832_/A _1362_/X _1398_/B vssd1 vccd1 vccd1 vssd1 sky130_fd_sc_hd__or2_1$1
Xoutput90 _1796_/X analog_ctrl[25] vssd1 vccd1 vccd1 vssd1 sky130_fd_sc_hd__buf_12$1
X_1293_ _1431_/C1 _1292_/X _1343_/A2 hold197/X _1675_/D vssd1 vccd1 vccd1 vssd1 sky130_fd_sc_hd__o211a_1$1
XTAP_TAPCELL_ROW_52_1079 vccd1 vssd1 sky130_fd_sc_hd__tapvpwrvgnd_1$1
XFILLER_83_517 vssd1 vccd1 vccd1 vssd1 sky130_fd_sc_hd__fill_4$1
XFILLER_76_580 vssd1 vccd1 vccd1 vssd1 sky130_fd_sc_hd__fill_8$1
XFILLER_49_783 vccd1 vssd1 vccd1 vssd1 sky130_fd_sc_hd__fill_1$1
XFILLER_64_753 vssd1 vccd1 vccd1 vssd1 sky130_fd_sc_hd__fill_2$1
XFILLER_36_433 vssd1 vccd1 vccd1 vssd1 sky130_ef_sc_hd__decap_40_12$1
XFILLER_91_561 vssd1 vccd1 vccd1 vssd1 sky130_fd_sc_hd__fill_4$1
XFILLER_36_477 vssd1 vccd1 vccd1 vssd1 sky130_ef_sc_hd__decap_40_12$1
XFILLER_23_105 vssd1 vccd1 vccd1 vssd1 sky130_fd_sc_hd__fill_4$1
XFILLER_23_149 vssd1 vccd1 vccd1 vssd1 sky130_ef_sc_hd__decap_40_12$1
XFILLER_137_519 vssd1 vccd1 vccd1 vssd1 sky130_fd_sc_hd__fill_4$1
XFILLER_31_193 vssd1 vccd1 vccd1 vssd1 sky130_ef_sc_hd__decap_40_12$1
XFILLER_118_755 vccd1 vssd1 vccd1 vssd1 sky130_fd_sc_hd__fill_1$1
XFILLER_117_221 vssd1 vccd1 vccd1 vssd1 sky130_fd_sc_hd__fill_2$1
XFILLER_11_27 vssd1 vccd1 vccd1 vssd1 sky130_ef_sc_hd__decap_40_12$1
XFILLER_133_714 vssd1 vccd1 vccd1 vssd1 sky130_ef_sc_hd__decap_40_12$1
XFILLER_127_27 vssd1 vccd1 vccd1 vssd1 sky130_ef_sc_hd__decap_40_12$1
X_1629_ _1629_/Q _1752_/CLK hold87/X vccd1 vssd1 vccd1 vssd1 sky130_fd_sc_hd__dfxtp_1$1
XFILLER_105_449 vssd1 vccd1 vccd1 vssd1 sky130_ef_sc_hd__decap_40_12$1
XFILLER_105_438 vssd1 vccd1 vccd1 vssd1 sky130_fd_sc_hd__fill_8$1
XFILLER_120_419 vccd1 vssd1 vccd1 vssd1 sky130_fd_sc_hd__fill_1$1
XFILLER_87_812 vssd1 vccd1 vccd1 vssd1 sky130_ef_sc_hd__decap_40_12$1
XFILLER_59_503 vccd1 vssd1 vccd1 vssd1 sky130_fd_sc_hd__fill_1$1
XFILLER_101_655 vssd1 vccd1 vccd1 vssd1 sky130_fd_sc_hd__fill_8$1
XFILLER_100_121 vssd1 vccd1 vccd1 vssd1 sky130_ef_sc_hd__decap_40_12$1
XFILLER_98_193 vssd1 vccd1 vccd1 vssd1 sky130_fd_sc_hd__fill_2$1
XFILLER_86_333 vssd1 vccd1 vccd1 vssd1 sky130_ef_sc_hd__decap_40_12$1
XFILLER_100_165 vssd1 vccd1 vccd1 vssd1 sky130_ef_sc_hd__decap_40_12$1
XTAP_TAPCELL_ROW_87_1610 vccd1 vssd1 sky130_fd_sc_hd__tapvpwrvgnd_1$1
XFILLER_86_377 vssd1 vccd1 vccd1 vssd1 sky130_ef_sc_hd__decap_40_12$1
XFILLER_55_753 vssd1 vccd1 vccd1 vssd1 sky130_ef_sc_hd__decap_40_12$1
XFILLER_39_293 vssd1 vccd1 vccd1 vssd1 sky130_ef_sc_hd__decap_40_12$1
XFILLER_70_701 vssd1 vccd1 vccd1 vssd1 sky130_ef_sc_hd__decap_40_12$1
XFILLER_15_617 vssd1 vccd1 vccd1 vssd1 sky130_ef_sc_hd__decap_40_12$1
XTAP_TAPCELL_ROW_25_678 vccd1 vssd1 sky130_fd_sc_hd__tapvpwrvgnd_1$1
XFILLER_128_519 vssd1 vccd1 vccd1 vssd1 sky130_ef_sc_hd__decap_40_12$1
XFILLER_10_333 vssd1 vccd1 vccd1 vssd1 sky130_ef_sc_hd__decap_40_12$1
XFILLER_22_193 vssd1 vccd1 vccd1 vssd1 sky130_fd_sc_hd__fill_2$1
XFILLER_10_377 vssd1 vccd1 vccd1 vssd1 sky130_ef_sc_hd__decap_40_12$1
XFILLER_136_530 vssd1 vccd1 vccd1 vssd1 sky130_fd_sc_hd__fill_2$1
XTAP_TAPCELL_ROW_114_2017 vccd1 vssd1 sky130_fd_sc_hd__tapvpwrvgnd_1$1
XTAP_TAPCELL_ROW_114_2006 vccd1 vssd1 sky130_fd_sc_hd__tapvpwrvgnd_1$1
XFILLER_108_221 vssd1 vccd1 vccd1 vssd1 sky130_ef_sc_hd__decap_40_12$1
XTAP_TAPCELL_ROW_98_1772 vccd1 vssd1 sky130_fd_sc_hd__tapvpwrvgnd_1$1
XFILLER_136_585 vssd1 vccd1 vccd1 vssd1 sky130_fd_sc_hd__fill_2$1
XFILLER_108_265 vssd1 vccd1 vccd1 vssd1 sky130_ef_sc_hd__decap_40_12$1
Xclkbuf_leaf_33_wb_clk_i _1575_/CLK clkload1/A vssd1 vccd1 vccd1 vssd1 sky130_fd_sc_hd__clkbuf_8$1
XFILLER_123_279 vccd1 vssd1 vccd1 vssd1 sky130_fd_sc_hd__fill_1$1
XFILLER_117_93 vssd1 vccd1 vccd1 vssd1 sky130_ef_sc_hd__decap_40_12$1
XFILLER_2_587 vccd1 vssd1 vccd1 vssd1 sky130_fd_sc_hd__fill_1$1
XFILLER_89_193 vssd1 vccd1 vccd1 vssd1 sky130_ef_sc_hd__decap_40_12$1
XFILLER_77_333 vssd1 vccd1 vccd1 vssd1 sky130_fd_sc_hd__fill_2$1
XFILLER_65_517 vssd1 vccd1 vccd1 vssd1 sky130_ef_sc_hd__decap_40_12$1
XTAP_TAPCELL_ROW_5_381 vccd1 vssd1 sky130_fd_sc_hd__tapvpwrvgnd_1$1
XTAP_TAPCELL_ROW_5_370 vccd1 vssd1 sky130_fd_sc_hd__tapvpwrvgnd_1$1
XFILLER_133_81 vssd1 vccd1 vccd1 vssd1 sky130_ef_sc_hd__decap_40_12$1
XTAP_TAPCELL_ROW_125_2168 vccd1 vssd1 sky130_fd_sc_hd__tapvpwrvgnd_1$1
XFILLER_18_433 vssd1 vccd1 vccd1 vssd1 sky130_ef_sc_hd__decap_40_12$1
XTAP_TAPCELL_ROW_125_2179 vccd1 vssd1 sky130_fd_sc_hd__tapvpwrvgnd_1$1
XFILLER_73_561 vssd1 vccd1 vccd1 vssd1 sky130_ef_sc_hd__decap_40_12$1
XFILLER_18_477 vssd1 vccd1 vccd1 vssd1 sky130_ef_sc_hd__decap_40_12$1
XFILLER_60_233 vssd1 vccd1 vccd1 vssd1 sky130_ef_sc_hd__decap_40_12$1
XFILLER_21_609 vssd1 vccd1 vccd1 vssd1 sky130_fd_sc_hd__fill_4$1
XFILLER_33_447 vccd1 vssd1 vccd1 vssd1 sky130_fd_sc_hd__fill_1$1
XTAP_TAPCELL_ROW_44_954 vccd1 vssd1 sky130_fd_sc_hd__tapvpwrvgnd_1$1
XTAP_TAPCELL_ROW_44_965 vccd1 vssd1 sky130_fd_sc_hd__tapvpwrvgnd_1$1
X_0931_ _1730_/Q _1344_/A _0931_/X _1762_/Q _1411_/A vccd1 vssd1 vccd1 vssd1 sky130_fd_sc_hd__a22o_1$1
XFILLER_60_277 vssd1 vccd1 vccd1 vssd1 sky130_ef_sc_hd__decap_40_12$1
XFILLER_13_193 vssd1 vccd1 vccd1 vssd1 sky130_ef_sc_hd__decap_40_12$1
X_0862_ _0880_/A2 _1494_/D _0859_/X _1447_/C1 _1494_/Q _0861_/X vssd1 vccd1 vccd1
+ vssd1 sky130_fd_sc_hd__o221a_1$1
XFILLER_127_541 vssd1 vccd1 vccd1 vssd1 sky130_ef_sc_hd__decap_40_12$1
X_0793_ _1778_/A _0866_/B1 _0793_/X _1643_/Q _0906_/B1 vccd1 vssd1 vccd1 vssd1 sky130_fd_sc_hd__a22o_1$1
XFILLER_54_3 vssd1 vccd1 vccd1 vssd1 sky130_ef_sc_hd__decap_40_12$1
XTAP_TAPCELL_ROW_54_1108 vccd1 vssd1 sky130_fd_sc_hd__tapvpwrvgnd_1$1
X_1414_ _1842_/A _1414_/X _1474_/B vssd1 vccd1 vccd1 vssd1 sky130_fd_sc_hd__or2_1$1
X_1345_ _1345_/Y _1345_/A _1411_/B vssd1 vccd1 vccd1 vssd1 sky130_fd_sc_hd__nand2_2$1
XFILLER_68_333 vssd1 vccd1 vccd1 vssd1 sky130_ef_sc_hd__decap_40_12$1
XFILLER_29_709 vssd1 vccd1 vccd1 vssd1 sky130_ef_sc_hd__decap_40_12$1
XFILLER_96_697 vssd1 vccd1 vccd1 vssd1 sky130_fd_sc_hd__fill_2$1
XFILLER_68_377 vssd1 vccd1 vccd1 vssd1 sky130_ef_sc_hd__decap_40_12$1
X_1276_ _1668_/Q _1276_/X _1276_/B vssd1 vccd1 vccd1 vssd1 sky130_fd_sc_hd__or2_1$1
XTAP_TAPCELL_ROW_69_1340 vccd1 vssd1 sky130_fd_sc_hd__tapvpwrvgnd_1$1
XFILLER_37_753 vssd1 vccd1 vccd1 vssd1 sky130_ef_sc_hd__decap_40_12$1
XFILLER_37_797 vssd1 vccd1 vccd1 vssd1 sky130_fd_sc_hd__fill_8$1
XFILLER_91_391 vccd1 vssd1 vccd1 vssd1 sky130_fd_sc_hd__fill_1$1
XFILLER_24_469 vssd1 vccd1 vccd1 vssd1 sky130_fd_sc_hd__fill_4$1
XFILLER_51_277 vssd1 vccd1 vccd1 vssd1 sky130_fd_sc_hd__fill_2$1
XTAP_TAPCELL_ROW_22_626 vccd1 vssd1 sky130_fd_sc_hd__tapvpwrvgnd_1$1
XFILLER_138_817 vssd1 vccd1 vccd1 vssd1 sky130_fd_sc_hd__fill_2$1
XFILLER_22_15 vssd1 vccd1 vccd1 vssd1 sky130_ef_sc_hd__decap_40_12$1
XTAP_TAPCELL_ROW_22_637 vccd1 vssd1 sky130_fd_sc_hd__tapvpwrvgnd_1$1
XFILLER_138_839 vccd1 vssd1 vccd1 vssd1 sky130_fd_sc_hd__fill_1$1
XFILLER_137_305 vssd1 vccd1 vccd1 vssd1 sky130_fd_sc_hd__fill_2$1
XFILLER_137_316 vssd1 vccd1 vccd1 vssd1 sky130_ef_sc_hd__decap_40_12$1
XFILLER_20_697 vssd1 vccd1 vccd1 vssd1 sky130_fd_sc_hd__fill_2$1
XFILLER_118_585 vssd1 vccd1 vccd1 vssd1 sky130_fd_sc_hd__fill_2$1
XFILLER_3_329 vssd1 vccd1 vccd1 vssd1 sky130_fd_sc_hd__fill_4$1
XFILLER_106_769 vssd1 vccd1 vccd1 vssd1 sky130_ef_sc_hd__decap_40_12$1
XFILLER_79_609 vssd1 vccd1 vccd1 vssd1 sky130_fd_sc_hd__fill_4$1
XFILLER_105_279 vccd1 vssd1 vccd1 vssd1 sky130_fd_sc_hd__fill_1$1
XTAP_TAPCELL_ROW_93_1691 vccd1 vssd1 sky130_fd_sc_hd__tapvpwrvgnd_1$1
XFILLER_120_249 vssd1 vccd1 vccd1 vssd1 sky130_fd_sc_hd__fill_2$1
XFILLER_87_653 vssd1 vccd1 vccd1 vssd1 sky130_ef_sc_hd__decap_40_12$1
XFILLER_86_141 vssd1 vccd1 vccd1 vssd1 sky130_ef_sc_hd__decap_40_12$1
XFILLER_59_333 vssd1 vccd1 vccd1 vssd1 sky130_fd_sc_hd__fill_2$1
XFILLER_101_463 vccd1 vssd1 vccd1 vssd1 sky130_fd_sc_hd__fill_1$1
XFILLER_87_697 vssd1 vccd1 vccd1 vssd1 sky130_ef_sc_hd__decap_40_12$1
XFILLER_28_720 vssd1 vccd1 vccd1 vssd1 sky130_ef_sc_hd__decap_40_12$1
XFILLER_103_51 vssd1 vccd1 vccd1 vssd1 sky130_fd_sc_hd__fill_4$1
XFILLER_55_561 vssd1 vccd1 vccd1 vssd1 sky130_fd_sc_hd__fill_8$1
XFILLER_43_723 vssd1 vccd1 vccd1 vssd1 sky130_fd_sc_hd__fill_4$1
XFILLER_63_55 vccd1 vssd1 vccd1 vssd1 sky130_fd_sc_hd__fill_1$1
XFILLER_15_447 vccd1 vssd1 vccd1 vssd1 sky130_fd_sc_hd__fill_1$1
XFILLER_42_233 vssd1 vccd1 vccd1 vssd1 sky130_ef_sc_hd__decap_40_12$1
XTAP_TAPCELL_ROW_120_2098 vccd1 vssd1 sky130_fd_sc_hd__tapvpwrvgnd_1$1
XFILLER_30_417 vssd1 vccd1 vccd1 vssd1 sky130_fd_sc_hd__fill_2$1
XTAP_TAPCELL_ROW_41_913 vccd1 vssd1 sky130_fd_sc_hd__tapvpwrvgnd_1$1
XFILLER_42_277 vssd1 vccd1 vccd1 vssd1 sky130_ef_sc_hd__decap_40_12$1
XFILLER_128_305 vssd1 vccd1 vccd1 vssd1 sky130_fd_sc_hd__fill_2$1
XFILLER_11_653 vssd1 vccd1 vccd1 vssd1 sky130_ef_sc_hd__decap_40_12$1
XFILLER_10_141 vssd1 vccd1 vccd1 vssd1 sky130_ef_sc_hd__decap_40_12$1
XFILLER_7_613 vssd1 vccd1 vccd1 vssd1 sky130_fd_sc_hd__fill_2$1
XFILLER_109_541 vssd1 vccd1 vccd1 vssd1 sky130_ef_sc_hd__decap_40_12$1
XFILLER_11_697 vssd1 vccd1 vccd1 vssd1 sky130_ef_sc_hd__decap_40_12$1
XFILLER_12_81 vssd1 vccd1 vccd1 vssd1 sky130_fd_sc_hd__fill_2$1
XFILLER_128_81 vssd1 vccd1 vccd1 vssd1 sky130_fd_sc_hd__fill_2$1
XFILLER_124_522 vssd1 vccd1 vccd1 vssd1 sky130_fd_sc_hd__fill_8$1
XFILLER_6_189 vssd1 vccd1 vccd1 vssd1 sky130_fd_sc_hd__fill_4$1
XFILLER_88_41 vssd1 vccd1 vccd1 vssd1 sky130_ef_sc_hd__decap_40_12$1
XFILLER_3_841 vccd1 vssd1 vccd1 vssd1 sky130_fd_sc_hd__fill_1$1
XFILLER_124_599 vccd1 vssd1 vccd1 vssd1 sky130_fd_sc_hd__fill_1$1
XFILLER_112_739 vccd1 vssd1 vccd1 vssd1 sky130_fd_sc_hd__fill_1$1
XFILLER_111_205 vssd1 vccd1 vccd1 vssd1 sky130_ef_sc_hd__decap_40_12$1
XFILLER_88_85 vssd1 vccd1 vccd1 vssd1 sky130_ef_sc_hd__decap_40_12$1
XTAP_TAPCELL_ROW_127_2208 vccd1 vssd1 sky130_fd_sc_hd__tapvpwrvgnd_1$1
XFILLER_111_249 vssd1 vccd1 vccd1 vssd1 sky130_ef_sc_hd__decap_40_12$1
X_1130_ _1130_/A _1130_/X _1144_/B vssd1 vccd1 vccd1 vssd1 sky130_fd_sc_hd__or2_1$1
XFILLER_78_697 vssd1 vccd1 vccd1 vssd1 sky130_fd_sc_hd__fill_2$1
XTAP_TAPCELL_ROW_109_1941 vccd1 vssd1 sky130_fd_sc_hd__tapvpwrvgnd_1$1
XTAP_TAPCELL_ROW_109_1930 vccd1 vssd1 sky130_fd_sc_hd__tapvpwrvgnd_1$1
XFILLER_92_133 vssd1 vccd1 vccd1 vssd1 sky130_fd_sc_hd__fill_4$1
X_1061_ _1461_/C1 _1060_/X _1079_/A2 hold59/X _1563_/D vssd1 vccd1 vccd1 vssd1 sky130_fd_sc_hd__o211a_1$1
XFILLER_19_753 vssd1 vccd1 vccd1 vssd1 sky130_ef_sc_hd__decap_40_12$1
XFILLER_92_177 vssd1 vccd1 vccd1 vssd1 sky130_ef_sc_hd__decap_40_12$1
XFILLER_61_531 vccd1 vssd1 vccd1 vssd1 sky130_fd_sc_hd__fill_1$1
XFILLER_61_597 vssd1 vccd1 vccd1 vssd1 sky130_ef_sc_hd__decap_40_12$1
XFILLER_21_417 vssd1 vccd1 vccd1 vssd1 sky130_ef_sc_hd__decap_40_12$1
XFILLER_33_277 vssd1 vccd1 vccd1 vssd1 sky130_fd_sc_hd__fill_2$1
XFILLER_119_305 vssd1 vccd1 vccd1 vssd1 sky130_ef_sc_hd__decap_40_12$1
X_0914_ hold88/A hold10/A _0915_/C _1695_/Q _1279_/A vccd1 vssd1 vccd1 vssd1 sky130_fd_sc_hd__a22o_1$1
XFILLER_119_349 vssd1 vccd1 vccd1 vssd1 sky130_ef_sc_hd__decap_40_12$1
X_0845_ _1015_/A _1556_/Q _0844_/X _0845_/X vccd1 vssd1 vccd1 vssd1 sky130_fd_sc_hd__a21o_1$1
XFILLER_127_393 vssd1 vccd1 vccd1 vssd1 sky130_fd_sc_hd__fill_2$1
XFILLER_108_29 vssd1 vccd1 vccd1 vssd1 sky130_ef_sc_hd__decap_40_12$1
X_0776_ _0879_/B1 _0776_/X _0775_/X _1844_/A _0881_/B1 _0774_/X vssd1 vccd1 vccd1
+ vssd1 sky130_fd_sc_hd__a2111o_1$1
XFILLER_115_577 vccd1 vssd1 vccd1 vssd1 sky130_fd_sc_hd__fill_1$1
XFILLER_115_599 vccd1 vssd1 vccd1 vssd1 sky130_fd_sc_hd__fill_1$1
XFILLER_88_417 vssd1 vccd1 vccd1 vssd1 sky130_fd_sc_hd__fill_2$1
XFILLER_102_249 vssd1 vccd1 vccd1 vssd1 sky130_fd_sc_hd__fill_2$1
XFILLER_57_804 vssd1 vccd1 vccd1 vssd1 sky130_fd_sc_hd__fill_4$1
XFILLER_111_783 vccd1 vssd1 vccd1 vssd1 sky130_fd_sc_hd__fill_1$1
XFILLER_84_601 vssd1 vccd1 vccd1 vssd1 sky130_ef_sc_hd__decap_40_12$1
XFILLER_69_675 vccd1 vssd1 vccd1 vssd1 sky130_fd_sc_hd__fill_1$1
XFILLER_68_141 vssd1 vccd1 vccd1 vssd1 sky130_ef_sc_hd__decap_40_12$1
XFILLER_57_826 vssd1 vccd1 vccd1 vssd1 sky130_ef_sc_hd__decap_40_12$1
XFILLER_29_517 vssd1 vccd1 vccd1 vssd1 sky130_ef_sc_hd__decap_40_12$1
X_1328_ hold94/X _1328_/X _1330_/B vssd1 vccd1 vccd1 vssd1 sky130_fd_sc_hd__or2_1$1
XFILLER_84_645 vssd1 vccd1 vccd1 vssd1 sky130_fd_sc_hd__fill_2$1
XFILLER_83_111 vccd1 vssd1 vccd1 vssd1 sky130_fd_sc_hd__fill_1$1
X_1259_ _1463_/C1 _1258_/X _1277_/A2 hold59/X _1659_/D vssd1 vccd1 vccd1 vssd1 sky130_fd_sc_hd__o211a_1$1
XFILLER_17_15 vssd1 vccd1 vccd1 vssd1 sky130_ef_sc_hd__decap_40_12$1
XTAP_TAPCELL_ROW_27_707 vccd1 vssd1 sky130_fd_sc_hd__tapvpwrvgnd_1$1
XFILLER_37_561 vssd1 vccd1 vccd1 vssd1 sky130_ef_sc_hd__decap_40_12$1
XFILLER_71_317 vssd1 vccd1 vccd1 vssd1 sky130_ef_sc_hd__decap_40_12$1
XFILLER_24_233 vssd1 vccd1 vccd1 vssd1 sky130_ef_sc_hd__decap_40_12$1
XFILLER_12_417 vssd1 vccd1 vccd1 vssd1 sky130_fd_sc_hd__fill_2$1
XFILLER_24_277 vssd1 vccd1 vccd1 vssd1 sky130_ef_sc_hd__decap_40_12$1
XFILLER_25_789 vssd1 vccd1 vccd1 vssd1 sky130_fd_sc_hd__fill_2$1
XFILLER_137_113 vssd1 vccd1 vccd1 vssd1 sky130_fd_sc_hd__fill_2$1
XFILLER_137_102 vssd1 vccd1 vccd1 vssd1 sky130_fd_sc_hd__fill_8$1
XFILLER_33_69 vssd1 vccd1 vccd1 vssd1 sky130_ef_sc_hd__decap_40_12$1
XTAP_TAPCELL_ROW_95_1731 vccd1 vssd1 sky130_fd_sc_hd__tapvpwrvgnd_1$1
XTAP_TAPCELL_ROW_95_1720 vccd1 vssd1 sky130_fd_sc_hd__tapvpwrvgnd_1$1
XFILLER_106_533 vssd1 vccd1 vccd1 vssd1 sky130_ef_sc_hd__decap_40_12$1
XFILLER_3_137 vssd1 vccd1 vccd1 vssd1 sky130_ef_sc_hd__decap_40_12$1
XFILLER_121_536 vssd1 vccd1 vccd1 vssd1 sky130_ef_sc_hd__decap_40_12$1
XTAP_TAPCELL_ROW_7_410 vccd1 vssd1 sky130_fd_sc_hd__tapvpwrvgnd_1$1
XFILLER_0_811 vccd1 vssd1 vccd1 vssd1 sky130_fd_sc_hd__fill_1$1
XFILLER_58_77 vssd1 vccd1 vccd1 vssd1 sky130_fd_sc_hd__fill_4$1
XFILLER_101_293 vssd1 vccd1 vccd1 vssd1 sky130_ef_sc_hd__decap_40_12$1
XFILLER_75_645 vssd1 vccd1 vccd1 vssd1 sky130_fd_sc_hd__fill_2$1
XFILLER_114_83 vccd1 vssd1 vccd1 vssd1 sky130_fd_sc_hd__fill_1$1
XFILLER_75_667 vssd1 vccd1 vccd1 vssd1 sky130_fd_sc_hd__fill_4$1
XFILLER_74_133 vssd1 vccd1 vccd1 vssd1 sky130_fd_sc_hd__fill_4$1
XFILLER_16_701 vssd1 vccd1 vccd1 vssd1 sky130_ef_sc_hd__decap_40_12$1
XTAP_TAPCELL_ROW_122_2127 vccd1 vssd1 sky130_fd_sc_hd__tapvpwrvgnd_1$1
XFILLER_90_637 vssd1 vccd1 vccd1 vssd1 sky130_fd_sc_hd__fill_4$1
XFILLER_74_177 vssd1 vccd1 vccd1 vssd1 sky130_ef_sc_hd__decap_40_12$1
XFILLER_74_65 vssd1 vccd1 vccd1 vssd1 sky130_ef_sc_hd__decap_40_12$1
XFILLER_43_553 vssd1 vccd1 vccd1 vssd1 sky130_fd_sc_hd__fill_4$1
XTAP_TAPCELL_ROW_104_1860 vccd1 vssd1 sky130_fd_sc_hd__tapvpwrvgnd_1$1
XFILLER_70_361 vssd1 vccd1 vccd1 vssd1 sky130_fd_sc_hd__fill_2$1
XFILLER_15_277 vssd1 vccd1 vccd1 vssd1 sky130_fd_sc_hd__fill_2$1
XFILLER_90_53 vssd1 vccd1 vccd1 vssd1 sky130_ef_sc_hd__decap_40_12$1
XFILLER_129_614 vssd1 vccd1 vccd1 vssd1 sky130_fd_sc_hd__fill_2$1
XFILLER_90_97 vssd1 vccd1 vccd1 vssd1 sky130_ef_sc_hd__decap_40_12$1
XFILLER_129_669 vssd1 vccd1 vccd1 vssd1 sky130_fd_sc_hd__fill_2$1
XFILLER_11_461 vssd1 vccd1 vccd1 vssd1 sky130_ef_sc_hd__decap_40_12$1
XTAP_TAPCELL_ROW_13_489 vccd1 vssd1 sky130_fd_sc_hd__tapvpwrvgnd_1$1
XFILLER_109_393 vssd1 vccd1 vccd1 vssd1 sky130_fd_sc_hd__fill_2$1
XFILLER_99_51 vssd1 vccd1 vccd1 vssd1 sky130_fd_sc_hd__fill_4$1
XTAP_TAPCELL_ROW_133_2289 vccd1 vssd1 sky130_fd_sc_hd__tapvpwrvgnd_1$1
XFILLER_124_363 vccd1 vssd1 vccd1 vssd1 sky130_fd_sc_hd__fill_1$1
XFILLER_97_225 vssd1 vccd1 vccd1 vssd1 sky130_ef_sc_hd__decap_40_12$1
XFILLER_3_671 vccd1 vssd1 vccd1 vssd1 sky130_fd_sc_hd__fill_1$1
XFILLER_112_569 vssd1 vccd1 vccd1 vssd1 sky130_ef_sc_hd__decap_40_12$1
XFILLER_66_601 vccd1 vssd1 vccd1 vssd1 sky130_fd_sc_hd__fill_1$1
XFILLER_66_645 vssd1 vccd1 vccd1 vssd1 sky130_fd_sc_hd__fill_2$1
XFILLER_65_111 vccd1 vssd1 vccd1 vssd1 sky130_fd_sc_hd__fill_1$1
XFILLER_17_3 vssd1 vccd1 vccd1 vssd1 sky130_ef_sc_hd__decap_40_12$1
XFILLER_39_837 vssd1 vccd1 vccd1 vssd1 sky130_fd_sc_hd__fill_2$1
XFILLER_66_656 vssd1 vccd1 vccd1 vssd1 sky130_ef_sc_hd__decap_40_12$1
X_1113_ _1449_/C1 _1112_/X _1123_/A2 hold90/X _1588_/D vssd1 vccd1 vccd1 vssd1 sky130_fd_sc_hd__o211a_1$1
X_1044_ _1044_/A _1044_/X _1078_/B vssd1 vccd1 vccd1 vssd1 sky130_fd_sc_hd__or2_1$1
XFILLER_53_317 vssd1 vccd1 vccd1 vssd1 sky130_ef_sc_hd__decap_40_12$1
XFILLER_19_561 vssd1 vccd1 vccd1 vssd1 sky130_ef_sc_hd__decap_40_12$1
XTAP_TAPCELL_ROW_49_1029 vccd1 vssd1 sky130_fd_sc_hd__tapvpwrvgnd_1$1
XFILLER_34_531 vccd1 vssd1 vccd1 vssd1 sky130_fd_sc_hd__fill_1$1
XFILLER_61_361 vssd1 vccd1 vccd1 vssd1 sky130_ef_sc_hd__decap_40_12$1
XTAP_TAPCELL_ROW_62_1229 vccd1 vssd1 sky130_fd_sc_hd__tapvpwrvgnd_1$1
XFILLER_21_225 vssd1 vccd1 vccd1 vssd1 sky130_ef_sc_hd__decap_40_12$1
XTAP_TAPCELL_ROW_32_776 vccd1 vssd1 sky130_fd_sc_hd__tapvpwrvgnd_1$1
XFILLER_119_113 vssd1 vccd1 vccd1 vssd1 sky130_ef_sc_hd__decap_40_12$1
XFILLER_108_809 vssd1 vccd1 vccd1 vssd1 sky130_fd_sc_hd__fill_2$1
XFILLER_9_93 vssd1 vccd1 vccd1 vssd1 sky130_ef_sc_hd__decap_40_12$1
XFILLER_30_781 vssd1 vccd1 vccd1 vssd1 sky130_ef_sc_hd__decap_40_12$1
XTAP_TAPCELL_ROW_32_787 vccd1 vssd1 sky130_fd_sc_hd__tapvpwrvgnd_1$1
XFILLER_135_617 vssd1 vccd1 vccd1 vssd1 sky130_ef_sc_hd__decap_40_12$1
XFILLER_119_39 vssd1 vccd1 vccd1 vssd1 sky130_ef_sc_hd__decap_40_12$1
X_0828_ _1713_/Q _0878_/B1 _0828_/X _1553_/Q _1015_/A vccd1 vssd1 vccd1 vssd1 sky130_fd_sc_hd__a22o_1$1
XTAP_TAPCELL_ROW_77_1450 vccd1 vssd1 sky130_fd_sc_hd__tapvpwrvgnd_1$1
XTAP_TAPCELL_ROW_77_1461 vccd1 vssd1 sky130_fd_sc_hd__tapvpwrvgnd_1$1
X_0759_ _0880_/A2 _1477_/D _0756_/X _1421_/C1 _1477_/Q _0758_/X vssd1 vccd1 vccd1
+ vssd1 sky130_fd_sc_hd__o221a_1$1
XFILLER_135_27 vssd1 vccd1 vccd1 vssd1 sky130_ef_sc_hd__decap_40_12$1
XFILLER_115_385 vssd1 vccd1 vccd1 vssd1 sky130_fd_sc_hd__fill_4$1
XFILLER_103_525 vssd1 vccd1 vccd1 vssd1 sky130_ef_sc_hd__decap_40_12$1
XFILLER_103_503 vccd1 vssd1 vccd1 vssd1 sky130_fd_sc_hd__fill_1$1
XFILLER_130_333 vssd1 vccd1 vccd1 vssd1 sky130_ef_sc_hd__decap_40_12$1
XTAP_TAPCELL_ROW_90_1650 vccd1 vssd1 sky130_fd_sc_hd__tapvpwrvgnd_1$1
XFILLER_130_377 vssd1 vccd1 vccd1 vssd1 sky130_ef_sc_hd__decap_40_12$1
XFILLER_57_645 vssd1 vccd1 vccd1 vssd1 sky130_ef_sc_hd__decap_40_12$1
XFILLER_84_453 vssd1 vccd1 vccd1 vssd1 sky130_ef_sc_hd__decap_40_12$1
XFILLER_56_133 vssd1 vccd1 vccd1 vssd1 sky130_fd_sc_hd__fill_4$1
XFILLER_84_497 vssd1 vccd1 vccd1 vssd1 sky130_ef_sc_hd__decap_40_12$1
XFILLER_84_475 vccd1 vssd1 vccd1 vssd1 sky130_fd_sc_hd__fill_1$1
XFILLER_56_177 vssd1 vccd1 vccd1 vssd1 sky130_ef_sc_hd__decap_40_12$1
XFILLER_72_659 vssd1 vccd1 vccd1 vssd1 sky130_ef_sc_hd__decap_40_12$1
XFILLER_71_125 vssd1 vccd1 vccd1 vssd1 sky130_ef_sc_hd__decap_40_12$1
XFILLER_37_391 vccd1 vssd1 vccd1 vssd1 sky130_fd_sc_hd__fill_1$1
XFILLER_71_169 vssd1 vccd1 vccd1 vssd1 sky130_ef_sc_hd__decap_40_12$1
XFILLER_52_361 vssd1 vccd1 vccd1 vssd1 sky130_fd_sc_hd__fill_2$1
XFILLER_25_553 vssd1 vccd1 vccd1 vssd1 sky130_fd_sc_hd__fill_4$1
XFILLER_40_501 vssd1 vccd1 vccd1 vssd1 sky130_ef_sc_hd__decap_40_12$1
XFILLER_80_681 vssd1 vccd1 vccd1 vssd1 sky130_ef_sc_hd__decap_40_12$1
XFILLER_25_597 vssd1 vccd1 vccd1 vssd1 sky130_ef_sc_hd__decap_40_12$1
XFILLER_100_41 vssd1 vccd1 vccd1 vssd1 sky130_ef_sc_hd__decap_40_12$1
XFILLER_100_85 vssd1 vccd1 vccd1 vssd1 sky130_ef_sc_hd__decap_40_12$1
XFILLER_21_781 vssd1 vccd1 vccd1 vssd1 sky130_fd_sc_hd__fill_2$1
XFILLER_40_589 vssd1 vccd1 vccd1 vssd1 sky130_fd_sc_hd__fill_4$1
XFILLER_126_617 vssd1 vccd1 vccd1 vssd1 sky130_ef_sc_hd__decap_40_12$1
XFILLER_121_3 vssd1 vccd1 vccd1 vssd1 sky130_ef_sc_hd__decap_40_12$1
XTAP_TAPCELL_ROW_10_448 vccd1 vssd1 sky130_fd_sc_hd__tapvpwrvgnd_1$1
XFILLER_138_499 vssd1 vccd1 vccd1 vssd1 sky130_fd_sc_hd__fill_4$1
XFILLER_125_105 vssd1 vccd1 vccd1 vssd1 sky130_fd_sc_hd__fill_4$1
XFILLER_4_413 vssd1 vccd1 vccd1 vssd1 sky130_fd_sc_hd__fill_4$1
XFILLER_125_149 vssd1 vccd1 vccd1 vssd1 sky130_ef_sc_hd__decap_40_12$1
XFILLER_4_457 vssd1 vccd1 vccd1 vssd1 sky130_ef_sc_hd__decap_40_12$1
XFILLER_134_661 vssd1 vccd1 vccd1 vssd1 sky130_fd_sc_hd__fill_4$1
XFILLER_106_363 vccd1 vssd1 vccd1 vssd1 sky130_fd_sc_hd__fill_1$1
XFILLER_133_193 vssd1 vccd1 vccd1 vssd1 sky130_ef_sc_hd__decap_40_12$1
XFILLER_121_333 vssd1 vccd1 vccd1 vssd1 sky130_fd_sc_hd__fill_2$1
XFILLER_106_396 vccd1 vssd1 vccd1 vssd1 sky130_fd_sc_hd__fill_1$1
XFILLER_79_225 vssd1 vccd1 vccd1 vssd1 sky130_ef_sc_hd__decap_40_12$1
XFILLER_95_729 vssd1 vccd1 vccd1 vssd1 sky130_ef_sc_hd__decap_40_12$1
XFILLER_125_93 vssd1 vccd1 vccd1 vssd1 sky130_ef_sc_hd__decap_40_12$1
XFILLER_121_388 vssd1 vccd1 vccd1 vssd1 sky130_fd_sc_hd__fill_4$1
XFILLER_75_431 vccd1 vssd1 vccd1 vssd1 sky130_fd_sc_hd__fill_1$1
XFILLER_0_685 vssd1 vccd1 vccd1 vssd1 sky130_fd_sc_hd__fill_2$1
XFILLER_47_111 vccd1 vssd1 vccd1 vssd1 sky130_fd_sc_hd__fill_1$1
XFILLER_48_645 vssd1 vccd1 vccd1 vssd1 sky130_ef_sc_hd__decap_40_12$1
XFILLER_63_604 vssd1 vccd1 vccd1 vssd1 sky130_fd_sc_hd__fill_4$1
XFILLER_63_637 vssd1 vccd1 vccd1 vssd1 sky130_ef_sc_hd__decap_40_12$1
XFILLER_35_317 vssd1 vccd1 vccd1 vssd1 sky130_ef_sc_hd__decap_40_12$1
XFILLER_48_689 vssd1 vccd1 vccd1 vssd1 sky130_fd_sc_hd__fill_2$1
XFILLER_90_445 vssd1 vccd1 vccd1 vssd1 sky130_ef_sc_hd__decap_40_12$1
XFILLER_16_531 vccd1 vssd1 vccd1 vssd1 sky130_fd_sc_hd__fill_1$1
XFILLER_90_489 vssd1 vccd1 vccd1 vssd1 sky130_ef_sc_hd__decap_40_12$1
XFILLER_71_670 vssd1 vccd1 vccd1 vssd1 sky130_fd_sc_hd__fill_2$1
XFILLER_50_309 vssd1 vccd1 vccd1 vssd1 sky130_ef_sc_hd__decap_40_12$1
XFILLER_31_501 vssd1 vccd1 vccd1 vssd1 sky130_fd_sc_hd__fill_2$1
XFILLER_43_361 vssd1 vccd1 vccd1 vssd1 sky130_ef_sc_hd__decap_40_12$1
X_1800_ _1800_/A _1800_/X vssd1 vccd1 vccd1 vssd1 sky130_fd_sc_hd__clkbuf_2$1
XTAP_TAPCELL_ROW_135_2329 vccd1 vssd1 sky130_fd_sc_hd__tapvpwrvgnd_1$1
XTAP_TAPCELL_ROW_135_2318 vccd1 vssd1 sky130_fd_sc_hd__tapvpwrvgnd_1$1
XFILLER_12_781 vssd1 vccd1 vccd1 vssd1 sky130_ef_sc_hd__decap_40_12$1
X_1731_ hold75/A _1761_/CLK _1731_/D vccd1 vssd1 vccd1 vssd1 sky130_fd_sc_hd__dfxtp_1$1
X_1662_ _1662_/Q _1729_/CLK _1662_/D vccd1 vssd1 vccd1 vssd1 sky130_fd_sc_hd__dfxtp_2$1
Xhold207 _1527_/Q _0986_/A vssd1 vccd1 vccd1 vssd1 sky130_fd_sc_hd__dlygate4sd3_1$1
XFILLER_7_273 vssd1 vccd1 vccd1 vssd1 sky130_fd_sc_hd__fill_4$1
XFILLER_125_683 vccd1 vssd1 vccd1 vssd1 sky130_fd_sc_hd__fill_1$1
XFILLER_113_823 vccd1 vssd1 vccd1 vssd1 sky130_fd_sc_hd__fill_1$1
XFILLER_98_501 vssd1 vccd1 vccd1 vssd1 sky130_ef_sc_hd__decap_40_12$1
XTAP_TAPCELL_ROW_59_1191 vccd1 vssd1 sky130_fd_sc_hd__tapvpwrvgnd_1$1
XTAP_TAPCELL_ROW_59_1180 vccd1 vssd1 sky130_fd_sc_hd__tapvpwrvgnd_1$1
X_1593_ _1811_/A _1721_/CLK _1593_/D vccd1 vssd1 vccd1 vssd1 sky130_fd_sc_hd__dfxtp_1$1
XFILLER_124_193 vssd1 vccd1 vccd1 vssd1 sky130_fd_sc_hd__fill_2$1
XFILLER_112_333 vssd1 vccd1 vccd1 vssd1 sky130_ef_sc_hd__decap_40_12$1
XFILLER_86_729 vccd1 vssd1 vccd1 vssd1 sky130_fd_sc_hd__fill_1$1
XFILLER_85_217 vssd1 vccd1 vccd1 vssd1 sky130_fd_sc_hd__fill_4$1
XTAP_TAPCELL_ROW_72_1380 vccd1 vssd1 sky130_fd_sc_hd__tapvpwrvgnd_1$1
XFILLER_38_133 vssd1 vccd1 vccd1 vssd1 sky130_fd_sc_hd__fill_4$1
XFILLER_39_656 vssd1 vccd1 vccd1 vssd1 sky130_ef_sc_hd__decap_40_12$1
XFILLER_93_261 vssd1 vccd1 vccd1 vssd1 sky130_ef_sc_hd__decap_40_12$1
XFILLER_66_475 vccd1 vssd1 vccd1 vssd1 sky130_fd_sc_hd__fill_1$1
XFILLER_38_177 vssd1 vccd1 vccd1 vssd1 sky130_ef_sc_hd__decap_40_12$1
XFILLER_53_125 vssd1 vccd1 vccd1 vssd1 sky130_ef_sc_hd__decap_40_12$1
XFILLER_19_391 vccd1 vssd1 vccd1 vssd1 sky130_fd_sc_hd__fill_1$1
XTAP_TAPCELL_ROW_37_857 vccd1 vssd1 sky130_fd_sc_hd__tapvpwrvgnd_1$1
XFILLER_53_169 vssd1 vccd1 vccd1 vssd1 sky130_ef_sc_hd__decap_40_12$1
XFILLER_22_501 vssd1 vccd1 vccd1 vssd1 sky130_ef_sc_hd__decap_40_12$1
XFILLER_34_361 vssd1 vccd1 vccd1 vssd1 sky130_fd_sc_hd__fill_2$1
X_1027_ _1289_/C1 _1026_/X _1053_/A2 hold30/X _1546_/D vssd1 vccd1 vccd1 vssd1 sky130_fd_sc_hd__o211a_1$1
XFILLER_62_681 vssd1 vccd1 vccd1 vssd1 sky130_ef_sc_hd__decap_40_12$1
XFILLER_50_832 vssd1 vccd1 vccd1 vssd1 sky130_fd_sc_hd__fill_8$1
XFILLER_14_27 vccd1 vssd1 vccd1 vssd1 sky130_fd_sc_hd__fill_1$1
XFILLER_22_545 vssd1 vccd1 vccd1 vssd1 sky130_ef_sc_hd__decap_40_12$1
XFILLER_22_589 vssd1 vccd1 vccd1 vssd1 sky130_ef_sc_hd__decap_40_12$1
XFILLER_107_105 vssd1 vccd1 vccd1 vssd1 sky130_fd_sc_hd__fill_4$1
XFILLER_30_15 vssd1 vccd1 vccd1 vssd1 sky130_ef_sc_hd__decap_40_12$1
XFILLER_116_650 vssd1 vccd1 vccd1 vssd1 sky130_ef_sc_hd__decap_40_12$1
XFILLER_107_149 vssd1 vccd1 vccd1 vssd1 sky130_ef_sc_hd__decap_40_12$1
XFILLER_89_501 vssd1 vccd1 vccd1 vssd1 sky130_fd_sc_hd__fill_2$1
XFILLER_1_405 vssd1 vccd1 vccd1 vssd1 sky130_ef_sc_hd__decap_40_12$1
XFILLER_115_193 vssd1 vccd1 vccd1 vssd1 sky130_ef_sc_hd__decap_40_12$1
XFILLER_103_333 vssd1 vccd1 vccd1 vssd1 sky130_fd_sc_hd__fill_2$1
XFILLER_1_449 vssd1 vccd1 vccd1 vssd1 sky130_ef_sc_hd__decap_40_12$1
XFILLER_131_653 vssd1 vccd1 vccd1 vssd1 sky130_ef_sc_hd__decap_40_12$1
XFILLER_130_141 vssd1 vccd1 vccd1 vssd1 sky130_ef_sc_hd__decap_40_12$1
XFILLER_89_567 vccd1 vssd1 vccd1 vssd1 sky130_fd_sc_hd__fill_1$1
XFILLER_77_729 vssd1 vccd1 vccd1 vssd1 sky130_ef_sc_hd__decap_40_12$1
XFILLER_39_57 vssd1 vccd1 vccd1 vssd1 sky130_ef_sc_hd__decap_40_12$1
XFILLER_131_697 vssd1 vccd1 vccd1 vssd1 sky130_ef_sc_hd__decap_40_12$1
XFILLER_29_111 vccd1 vssd1 vccd1 vssd1 sky130_fd_sc_hd__fill_1$1
XFILLER_72_412 vssd1 vccd1 vccd1 vssd1 sky130_fd_sc_hd__fill_8$1
XFILLER_17_317 vssd1 vccd1 vccd1 vssd1 sky130_ef_sc_hd__decap_40_12$1
XFILLER_72_445 vssd1 vccd1 vccd1 vssd1 sky130_ef_sc_hd__decap_40_12$1
XFILLER_13_501 vssd1 vccd1 vccd1 vssd1 sky130_fd_sc_hd__fill_2$1
XFILLER_25_361 vssd1 vccd1 vccd1 vssd1 sky130_ef_sc_hd__decap_40_12$1
XFILLER_32_309 vssd1 vccd1 vccd1 vssd1 sky130_ef_sc_hd__decap_40_12$1
XFILLER_111_51 vssd1 vccd1 vccd1 vssd1 sky130_fd_sc_hd__fill_4$1
XTAP_TAPCELL_ROW_15_518 vccd1 vssd1 sky130_fd_sc_hd__tapvpwrvgnd_1$1
XTAP_TAPCELL_ROW_15_529 vccd1 vssd1 sky130_fd_sc_hd__tapvpwrvgnd_1$1
XFILLER_71_55 vccd1 vssd1 vccd1 vssd1 sky130_fd_sc_hd__fill_1$1
XFILLER_9_505 vssd1 vccd1 vccd1 vssd1 sky130_ef_sc_hd__decap_40_12$1
XTAP_TAPCELL_ROW_117_2048 vccd1 vssd1 sky130_fd_sc_hd__tapvpwrvgnd_1$1
XTAP_TAPCELL_ROW_117_2059 vccd1 vssd1 sky130_fd_sc_hd__tapvpwrvgnd_1$1
XFILLER_4_221 vssd1 vccd1 vccd1 vssd1 sky130_ef_sc_hd__decap_40_12$1
XTAP_TAPCELL_ROW_130_2248 vccd1 vssd1 sky130_fd_sc_hd__tapvpwrvgnd_1$1
XFILLER_5_777 vssd1 vccd1 vccd1 vssd1 sky130_fd_sc_hd__fill_4$1
XFILLER_4_265 vssd1 vccd1 vccd1 vssd1 sky130_ef_sc_hd__decap_40_12$1
XFILLER_106_193 vssd1 vccd1 vccd1 vssd1 sky130_fd_sc_hd__fill_2$1
XFILLER_20_81 vssd1 vccd1 vccd1 vssd1 sky130_fd_sc_hd__fill_2$1
XFILLER_136_81 vssd1 vccd1 vccd1 vssd1 sky130_fd_sc_hd__fill_2$1
XTAP_TAPCELL_ROW_112_1981 vccd1 vssd1 sky130_fd_sc_hd__tapvpwrvgnd_1$1
XFILLER_96_41 vssd1 vccd1 vccd1 vssd1 sky130_ef_sc_hd__decap_40_12$1
XFILLER_122_697 vssd1 vccd1 vccd1 vssd1 sky130_fd_sc_hd__fill_2$1
XFILLER_110_837 vssd1 vccd1 vccd1 vssd1 sky130_fd_sc_hd__fill_2$1
XFILLER_96_85 vssd1 vccd1 vccd1 vssd1 sky130_ef_sc_hd__decap_40_12$1
XFILLER_67_217 vssd1 vccd1 vccd1 vssd1 sky130_fd_sc_hd__fill_4$1
XFILLER_95_559 vccd1 vssd1 vccd1 vssd1 sky130_fd_sc_hd__fill_1$1
Xhold90 hold90/A hold90/X vssd1 vccd1 vccd1 vssd1 sky130_fd_sc_hd__dlygate4sd3_1$1
XFILLER_82_209 vssd1 vccd1 vccd1 vssd1 sky130_ef_sc_hd__decap_40_12$1
XFILLER_75_261 vssd1 vccd1 vccd1 vssd1 sky130_ef_sc_hd__decap_40_12$1
XFILLER_63_412 vssd1 vccd1 vccd1 vssd1 sky130_ef_sc_hd__decap_40_12$1
XFILLER_36_637 vssd1 vccd1 vccd1 vssd1 sky130_fd_sc_hd__fill_4$1
XFILLER_48_475 vccd1 vssd1 vccd1 vssd1 sky130_fd_sc_hd__fill_1$1
XFILLER_35_125 vssd1 vccd1 vccd1 vssd1 sky130_ef_sc_hd__decap_40_12$1
XFILLER_91_787 vccd1 vssd1 vccd1 vssd1 sky130_fd_sc_hd__fill_1$1
XFILLER_90_253 vssd1 vccd1 vccd1 vssd1 sky130_ef_sc_hd__decap_40_12$1
XFILLER_51_629 vccd1 vssd1 vccd1 vssd1 sky130_fd_sc_hd__fill_1$1
XTAP_TAPCELL_ROW_34_805 vccd1 vssd1 sky130_fd_sc_hd__tapvpwrvgnd_1$1
XTAP_TAPCELL_ROW_34_816 vccd1 vssd1 sky130_fd_sc_hd__tapvpwrvgnd_1$1
XFILLER_35_169 vssd1 vccd1 vccd1 vssd1 sky130_ef_sc_hd__decap_40_12$1
XFILLER_50_139 vccd1 vssd1 vccd1 vssd1 sky130_fd_sc_hd__fill_1$1
XFILLER_16_361 vssd1 vccd1 vccd1 vssd1 sky130_fd_sc_hd__fill_2$1
XFILLER_44_670 vssd1 vccd1 vccd1 vssd1 sky130_ef_sc_hd__decap_40_12$1
XFILLER_84_3 vssd1 vccd1 vccd1 vssd1 sky130_ef_sc_hd__decap_40_12$1
XFILLER_117_414 vssd1 vccd1 vccd1 vssd1 sky130_fd_sc_hd__fill_2$1
X_1714_ _1714_/Q _1719_/CLK hold22/X vccd1 vssd1 vccd1 vssd1 sky130_fd_sc_hd__dfxtp_1$1
XFILLER_117_447 vccd1 vssd1 vccd1 vssd1 sky130_fd_sc_hd__fill_1$1
X_1645_ _1645_/Q clkload2/A _1645_/D vccd1 vssd1 vccd1 vssd1 sky130_fd_sc_hd__dfxtp_2$1
XFILLER_6_83 vccd1 vssd1 vccd1 vssd1 sky130_fd_sc_hd__fill_1$1
XFILLER_125_491 vssd1 vccd1 vccd1 vssd1 sky130_fd_sc_hd__fill_4$1
XFILLER_116_29 vssd1 vccd1 vccd1 vssd1 sky130_ef_sc_hd__decap_40_12$1
X_1576_ _1790_/A _1580_/CLK _1576_/D vccd1 vssd1 vccd1 vssd1 sky130_fd_sc_hd__dfxtp_1$1
XFILLER_112_141 vssd1 vccd1 vccd1 vssd1 sky130_ef_sc_hd__decap_40_12$1
XFILLER_59_729 vssd1 vccd1 vccd1 vssd1 sky130_fd_sc_hd__fill_4$1
XFILLER_113_697 vssd1 vccd1 vccd1 vssd1 sky130_ef_sc_hd__decap_40_12$1
XFILLER_94_581 vssd1 vccd1 vccd1 vssd1 sky130_fd_sc_hd__fill_4$1
XFILLER_27_615 vccd1 vssd1 vccd1 vssd1 sky130_fd_sc_hd__fill_1$1
XFILLER_82_754 vssd1 vccd1 vccd1 vssd1 sky130_fd_sc_hd__fill_2$1
XFILLER_39_497 vssd1 vccd1 vccd1 vssd1 sky130_fd_sc_hd__fill_4$1
XFILLER_82_765 vssd1 vccd1 vccd1 vssd1 sky130_ef_sc_hd__decap_40_12$1
XFILLER_54_489 vssd1 vccd1 vccd1 vssd1 sky130_ef_sc_hd__decap_40_12$1
XFILLER_14_309 vssd1 vccd1 vccd1 vssd1 sky130_ef_sc_hd__decap_40_12$1
XFILLER_25_15 vssd1 vccd1 vccd1 vssd1 sky130_ef_sc_hd__decap_40_12$1
XTAP_TAPCELL_ROW_85_1582 vccd1 vssd1 sky130_fd_sc_hd__tapvpwrvgnd_1$1
XTAP_TAPCELL_ROW_85_1571 vccd1 vssd1 sky130_fd_sc_hd__tapvpwrvgnd_1$1
XFILLER_41_69 vssd1 vccd1 vccd1 vssd1 sky130_ef_sc_hd__decap_40_12$1
XFILLER_108_469 vssd1 vccd1 vccd1 vssd1 sky130_fd_sc_hd__fill_4$1
XTAP_TAPCELL_ROW_20_598 vccd1 vssd1 sky130_fd_sc_hd__tapvpwrvgnd_1$1
XFILLER_135_277 vssd1 vccd1 vccd1 vssd1 sky130_fd_sc_hd__fill_2$1
XFILLER_2_725 vssd1 vccd1 vccd1 vssd1 sky130_ef_sc_hd__decap_40_12$1
XFILLER_2_769 vssd1 vccd1 vccd1 vssd1 sky130_ef_sc_hd__decap_40_12$1
XFILLER_131_494 vssd1 vccd1 vccd1 vssd1 sky130_fd_sc_hd__fill_8$1
XFILLER_104_697 vssd1 vccd1 vccd1 vssd1 sky130_fd_sc_hd__fill_2$1
XFILLER_1_279 vccd1 vssd1 vccd1 vssd1 sky130_fd_sc_hd__fill_1$1
XFILLER_49_217 vssd1 vccd1 vccd1 vssd1 sky130_fd_sc_hd__fill_4$1
XFILLER_58_762 vssd1 vccd1 vccd1 vssd1 sky130_ef_sc_hd__decap_40_12$1
XFILLER_66_77 vssd1 vccd1 vccd1 vssd1 sky130_fd_sc_hd__fill_4$1
XFILLER_64_209 vssd1 vccd1 vccd1 vssd1 sky130_ef_sc_hd__decap_40_12$1
XFILLER_57_261 vssd1 vccd1 vccd1 vssd1 sky130_ef_sc_hd__decap_40_12$1
XFILLER_17_125 vssd1 vccd1 vccd1 vssd1 sky130_ef_sc_hd__decap_40_12$1
XFILLER_18_637 vssd1 vccd1 vccd1 vssd1 sky130_fd_sc_hd__fill_4$1
XFILLER_45_445 vssd1 vccd1 vccd1 vssd1 sky130_fd_sc_hd__fill_2$1
XFILLER_122_83 vccd1 vssd1 vccd1 vssd1 sky130_fd_sc_hd__fill_1$1
XFILLER_73_765 vssd1 vccd1 vccd1 vssd1 sky130_ef_sc_hd__decap_40_12$1
XFILLER_72_253 vssd1 vccd1 vccd1 vssd1 sky130_ef_sc_hd__decap_40_12$1
XFILLER_17_169 vssd1 vccd1 vccd1 vssd1 sky130_ef_sc_hd__decap_40_12$1
XFILLER_82_65 vssd1 vccd1 vccd1 vssd1 sky130_ef_sc_hd__decap_40_12$1
XTAP_TAPCELL_ROW_0_290 vccd1 vssd1 sky130_fd_sc_hd__tapvpwrvgnd_1$1
XFILLER_33_629 vssd1 vccd1 vccd1 vssd1 sky130_ef_sc_hd__decap_40_12$1
XFILLER_32_139 vccd1 vssd1 vccd1 vssd1 sky130_fd_sc_hd__fill_1$1
XFILLER_15_81 vssd1 vccd1 vccd1 vssd1 sky130_ef_sc_hd__decap_40_12$1
XFILLER_41_673 vssd1 vccd1 vccd1 vssd1 sky130_fd_sc_hd__fill_4$1
XFILLER_9_335 vccd1 vssd1 vccd1 vssd1 sky130_fd_sc_hd__fill_1$1
XFILLER_126_233 vssd1 vccd1 vccd1 vssd1 sky130_ef_sc_hd__decap_40_12$1
XFILLER_5_541 vssd1 vccd1 vccd1 vssd1 sky130_ef_sc_hd__decap_40_12$1
XFILLER_127_789 vssd1 vccd1 vccd1 vssd1 sky130_fd_sc_hd__fill_2$1
XFILLER_126_277 vssd1 vccd1 vccd1 vssd1 sky130_ef_sc_hd__decap_40_12$1
Xoutput109 _1813_/X analog_ctrl[42] vssd1 vccd1 vccd1 vssd1 sky130_fd_sc_hd__buf_12$1
X_1430_ _1850_/A _1430_/X _1474_/B vssd1 vccd1 vccd1 vssd1 sky130_fd_sc_hd__or2_1$1
XFILLER_5_585 vssd1 vccd1 vccd1 vssd1 sky130_ef_sc_hd__decap_40_12$1
XFILLER_96_813 vssd1 vccd1 vccd1 vssd1 sky130_ef_sc_hd__decap_40_12$1
X_1361_ _1435_/C1 _1360_/X _1409_/A2 hold199/X _1708_/D vssd1 vccd1 vccd1 vssd1 sky130_fd_sc_hd__o211a_1$1
XFILLER_110_601 vssd1 vccd1 vccd1 vssd1 sky130_ef_sc_hd__decap_40_12$1
Xoutput80 _1787_/X analog_ctrl[16] vssd1 vccd1 vccd1 vssd1 sky130_fd_sc_hd__buf_12$1
Xoutput91 _1797_/X analog_ctrl[26] vssd1 vccd1 vccd1 vssd1 sky130_fd_sc_hd__buf_12$1
XFILLER_110_645 vssd1 vccd1 vccd1 vssd1 sky130_ef_sc_hd__decap_40_12$1
X_1292_ _1292_/A _1292_/X _1342_/B vssd1 vccd1 vccd1 vssd1 sky130_fd_sc_hd__or2_1$1
XFILLER_95_389 vssd1 vccd1 vccd1 vssd1 sky130_fd_sc_hd__fill_2$1
XFILLER_36_401 vssd1 vccd1 vccd1 vssd1 sky130_ef_sc_hd__decap_40_12$1
XFILLER_36_445 vssd1 vccd1 vccd1 vssd1 sky130_ef_sc_hd__decap_40_12$1
XFILLER_51_437 vccd1 vssd1 vccd1 vssd1 sky130_fd_sc_hd__fill_1$1
XFILLER_36_489 vssd1 vccd1 vccd1 vssd1 sky130_ef_sc_hd__decap_40_12$1
Xclkbuf_leaf_3_wb_clk_i _1719_/CLK clkbuf_leaf_9_wb_clk_i/A vssd1 vccd1 vccd1 vssd1
+ sky130_fd_sc_hd__clkbuf_8$1
XFILLER_20_813 vssd1 vccd1 vccd1 vssd1 sky130_fd_sc_hd__fill_8$1
XFILLER_31_161 vssd1 vccd1 vccd1 vssd1 sky130_fd_sc_hd__fill_4$1
XFILLER_118_701 vssd1 vccd1 vccd1 vssd1 sky130_ef_sc_hd__decap_40_12$1
XFILLER_11_39 vssd1 vccd1 vccd1 vssd1 sky130_ef_sc_hd__decap_40_12$1
XFILLER_133_726 vssd1 vccd1 vccd1 vssd1 sky130_fd_sc_hd__fill_2$1
XFILLER_127_39 vssd1 vccd1 vccd1 vssd1 sky130_ef_sc_hd__decap_40_12$1
XFILLER_117_277 vssd1 vccd1 vccd1 vssd1 sky130_fd_sc_hd__fill_2$1
XFILLER_105_417 vssd1 vccd1 vccd1 vssd1 sky130_fd_sc_hd__fill_2$1
X_1628_ hold33/A _1755_/CLK _1628_/D vccd1 vssd1 vccd1 vssd1 sky130_fd_sc_hd__dfxtp_1$1
XFILLER_105_428 vccd1 vssd1 vccd1 vssd1 sky130_fd_sc_hd__fill_1$1
XFILLER_99_662 vssd1 vccd1 vccd1 vssd1 sky130_fd_sc_hd__fill_2$1
XFILLER_113_461 vssd1 vccd1 vccd1 vssd1 sky130_ef_sc_hd__decap_40_12$1
XFILLER_86_301 vssd1 vccd1 vccd1 vssd1 sky130_fd_sc_hd__fill_4$1
X_1559_ _1559_/Q _1716_/CLK _1559_/D vccd1 vssd1 vccd1 vssd1 sky130_fd_sc_hd__dfxtp_1$1
XFILLER_100_133 vssd1 vccd1 vccd1 vssd1 sky130_fd_sc_hd__fill_4$1
XFILLER_86_345 vssd1 vccd1 vccd1 vssd1 sky130_ef_sc_hd__decap_40_12$1
XFILLER_59_559 vccd1 vssd1 vccd1 vssd1 sky130_fd_sc_hd__fill_1$1
XFILLER_100_177 vssd1 vccd1 vccd1 vssd1 sky130_ef_sc_hd__decap_40_12$1
XTAP_TAPCELL_ROW_87_1611 vccd1 vssd1 sky130_fd_sc_hd__tapvpwrvgnd_1$1
XTAP_TAPCELL_ROW_87_1600 vccd1 vssd1 sky130_fd_sc_hd__tapvpwrvgnd_1$1
XFILLER_86_389 vssd1 vccd1 vccd1 vssd1 sky130_ef_sc_hd__decap_40_12$1
XFILLER_39_261 vssd1 vccd1 vccd1 vssd1 sky130_ef_sc_hd__decap_40_12$1
XFILLER_46_209 vssd1 vccd1 vccd1 vssd1 sky130_ef_sc_hd__decap_40_12$1
XFILLER_55_721 vssd1 vccd1 vccd1 vssd1 sky130_fd_sc_hd__fill_4$1
XFILLER_70_713 vssd1 vccd1 vccd1 vssd1 sky130_ef_sc_hd__decap_40_12$1
XFILLER_55_765 vssd1 vccd1 vccd1 vssd1 sky130_ef_sc_hd__decap_40_12$1
XFILLER_54_253 vssd1 vccd1 vccd1 vssd1 sky130_ef_sc_hd__decap_40_12$1
XFILLER_27_445 vssd1 vccd1 vccd1 vssd1 sky130_fd_sc_hd__fill_2$1
XFILLER_15_629 vssd1 vccd1 vccd1 vssd1 sky130_ef_sc_hd__decap_40_12$1
XFILLER_70_757 vssd1 vccd1 vccd1 vssd1 sky130_ef_sc_hd__decap_40_12$1
XFILLER_14_139 vccd1 vssd1 vccd1 vssd1 sky130_fd_sc_hd__fill_1$1
XFILLER_50_470 vssd1 vccd1 vccd1 vssd1 sky130_fd_sc_hd__fill_4$1
XFILLER_10_301 vssd1 vccd1 vccd1 vssd1 sky130_fd_sc_hd__fill_4$1
XFILLER_23_673 vssd1 vccd1 vccd1 vssd1 sky130_ef_sc_hd__decap_40_12$1
XTAP_TAPCELL_ROW_25_668 vccd1 vssd1 sky130_fd_sc_hd__tapvpwrvgnd_1$1
XTAP_TAPCELL_ROW_25_679 vccd1 vssd1 sky130_fd_sc_hd__tapvpwrvgnd_1$1
XFILLER_128_509 vssd1 vccd1 vccd1 vssd1 sky130_fd_sc_hd__fill_2$1
XFILLER_10_345 vssd1 vccd1 vccd1 vssd1 sky130_ef_sc_hd__decap_40_12$1
XFILLER_6_305 vssd1 vccd1 vccd1 vssd1 sky130_fd_sc_hd__fill_2$1
XTAP_TAPCELL_ROW_114_2007 vccd1 vssd1 sky130_fd_sc_hd__tapvpwrvgnd_1$1
XFILLER_108_233 vssd1 vccd1 vccd1 vssd1 sky130_ef_sc_hd__decap_40_12$1
XTAP_TAPCELL_ROW_98_1773 vccd1 vssd1 sky130_fd_sc_hd__tapvpwrvgnd_1$1
XFILLER_10_389 vssd1 vccd1 vccd1 vssd1 sky130_ef_sc_hd__decap_40_12$1
XFILLER_109_789 vssd1 vccd1 vccd1 vssd1 sky130_fd_sc_hd__fill_2$1
XFILLER_108_277 vssd1 vccd1 vccd1 vssd1 sky130_ef_sc_hd__decap_40_12$1
XFILLER_136_597 vccd1 vssd1 vccd1 vssd1 sky130_fd_sc_hd__fill_1$1
XFILLER_123_225 vssd1 vccd1 vccd1 vssd1 sky130_ef_sc_hd__decap_40_12$1
XFILLER_2_533 vssd1 vccd1 vccd1 vssd1 sky130_ef_sc_hd__decap_40_12$1
XFILLER_96_109 vssd1 vccd1 vccd1 vssd1 sky130_ef_sc_hd__decap_40_12$1
XFILLER_78_813 vssd1 vccd1 vccd1 vssd1 sky130_ef_sc_hd__decap_40_12$1
XFILLER_89_161 vssd1 vccd1 vccd1 vssd1 sky130_fd_sc_hd__fill_4$1
XFILLER_77_389 vssd1 vccd1 vccd1 vssd1 sky130_fd_sc_hd__fill_2$1
XFILLER_65_529 vssd1 vccd1 vccd1 vssd1 sky130_ef_sc_hd__decap_40_12$1
XTAP_TAPCELL_ROW_5_382 vccd1 vssd1 sky130_fd_sc_hd__tapvpwrvgnd_1$1
XTAP_TAPCELL_ROW_5_371 vccd1 vssd1 sky130_fd_sc_hd__tapvpwrvgnd_1$1
XFILLER_18_401 vssd1 vccd1 vccd1 vssd1 sky130_ef_sc_hd__decap_40_12$1
XFILLER_46_710 vssd1 vccd1 vccd1 vssd1 sky130_ef_sc_hd__decap_40_12$1
XFILLER_133_93 vssd1 vccd1 vccd1 vssd1 sky130_ef_sc_hd__decap_40_12$1
XTAP_TAPCELL_ROW_125_2169 vccd1 vssd1 sky130_fd_sc_hd__tapvpwrvgnd_1$1
XFILLER_73_551 vssd1 vccd1 vccd1 vssd1 sky130_fd_sc_hd__fill_8$1
XFILLER_18_445 vssd1 vccd1 vccd1 vssd1 sky130_ef_sc_hd__decap_40_12$1
XFILLER_46_754 vssd1 vccd1 vccd1 vssd1 sky130_fd_sc_hd__fill_2$1
XFILLER_73_573 vssd1 vccd1 vccd1 vssd1 sky130_fd_sc_hd__fill_2$1
XFILLER_18_489 vssd1 vccd1 vccd1 vssd1 sky130_ef_sc_hd__decap_40_12$1
XFILLER_60_245 vssd1 vccd1 vccd1 vssd1 sky130_fd_sc_hd__fill_4$1
XTAP_TAPCELL_ROW_44_955 vccd1 vssd1 sky130_fd_sc_hd__tapvpwrvgnd_1$1
XTAP_TAPCELL_ROW_44_966 vccd1 vssd1 sky130_fd_sc_hd__tapvpwrvgnd_1$1
X_0930_ _1538_/Q _0949_/A _0933_/C _1698_/Q hold18/X vccd1 vssd1 vccd1 vssd1 sky130_fd_sc_hd__a22o_1$1
XFILLER_60_289 vssd1 vccd1 vccd1 vssd1 sky130_ef_sc_hd__decap_40_12$1
XFILLER_20_109 vssd1 vccd1 vccd1 vssd1 sky130_ef_sc_hd__decap_40_12$1
XFILLER_119_509 vssd1 vccd1 vccd1 vssd1 sky130_fd_sc_hd__fill_2$1
XFILLER_13_161 vssd1 vccd1 vccd1 vssd1 sky130_fd_sc_hd__fill_4$1
X_0861_ _0879_/B1 _0861_/X _0860_/X _1750_/Q _0881_/B1 _0857_/X vssd1 vccd1 vccd1
+ vssd1 sky130_fd_sc_hd__a2111o_1$1
XFILLER_9_165 vssd1 vccd1 vccd1 vssd1 sky130_fd_sc_hd__fill_2$1
X_0792_ _1797_/A _0879_/A2 _0792_/X input9/X _0826_/B1 vccd1 vssd1 vccd1 vssd1 sky130_fd_sc_hd__a22o_1$1
XFILLER_127_586 vssd1 vccd1 vccd1 vssd1 sky130_fd_sc_hd__fill_2$1
XFILLER_127_553 vssd1 vccd1 vccd1 vssd1 sky130_fd_sc_hd__fill_4$1
XFILLER_115_715 vssd1 vccd1 vccd1 vssd1 sky130_ef_sc_hd__decap_40_12$1
XTAP_TAPCELL_ROW_54_1109 vccd1 vssd1 sky130_fd_sc_hd__tapvpwrvgnd_1$1
XFILLER_87_109 vssd1 vccd1 vccd1 vssd1 sky130_fd_sc_hd__fill_2$1
XFILLER_5_393 vssd1 vccd1 vccd1 vssd1 sky130_ef_sc_hd__decap_40_12$1
XFILLER_47_3 vssd1 vccd1 vccd1 vssd1 sky130_ef_sc_hd__decap_40_12$1
X_1413_ _1421_/C1 _1412_/X _1475_/A2 hold78/X _1733_/D vssd1 vccd1 vccd1 vssd1 sky130_fd_sc_hd__o211a_1$1
XFILLER_68_301 vssd1 vccd1 vccd1 vssd1 sky130_fd_sc_hd__fill_4$1
X_1344_ _1344_/A _1356_/B _1411_/B vccd1 vssd1 vccd1 vssd1 sky130_fd_sc_hd__and2_2$1
XFILLER_68_345 vssd1 vccd1 vccd1 vssd1 sky130_ef_sc_hd__decap_40_12$1
XFILLER_3_51 vssd1 vccd1 vccd1 vssd1 sky130_fd_sc_hd__fill_4$1
X_1275_ _1475_/C1 _1274_/X _1277_/A2 hold64/X _1667_/D vssd1 vccd1 vccd1 vssd1 sky130_fd_sc_hd__o211a_1$1
XFILLER_68_389 vssd1 vccd1 vccd1 vssd1 sky130_ef_sc_hd__decap_40_12$1
XFILLER_28_209 vssd1 vccd1 vccd1 vssd1 sky130_ef_sc_hd__decap_40_12$1
XFILLER_83_337 vssd1 vccd1 vccd1 vssd1 sky130_ef_sc_hd__decap_40_12$1
XTAP_TAPCELL_ROW_69_1330 vccd1 vssd1 sky130_fd_sc_hd__tapvpwrvgnd_1$1
XTAP_TAPCELL_ROW_69_1341 vccd1 vssd1 sky130_fd_sc_hd__tapvpwrvgnd_1$1
XFILLER_36_253 vssd1 vccd1 vccd1 vssd1 sky130_ef_sc_hd__decap_40_12$1
XFILLER_37_765 vssd1 vccd1 vccd1 vssd1 sky130_ef_sc_hd__decap_40_12$1
XFILLER_52_735 vssd1 vccd1 vccd1 vssd1 sky130_ef_sc_hd__decap_40_12$1
XTAP_TAPCELL_ROW_82_1530 vccd1 vssd1 sky130_fd_sc_hd__tapvpwrvgnd_1$1
XFILLER_52_757 vssd1 vccd1 vccd1 vssd1 sky130_ef_sc_hd__decap_40_12$1
XFILLER_51_223 vccd1 vssd1 vccd1 vssd1 sky130_fd_sc_hd__fill_1$1
XFILLER_11_109 vssd1 vccd1 vccd1 vssd1 sky130_fd_sc_hd__fill_2$1
XFILLER_20_643 vccd1 vssd1 vccd1 vssd1 sky130_fd_sc_hd__fill_1$1
XTAP_TAPCELL_ROW_22_627 vccd1 vssd1 sky130_fd_sc_hd__tapvpwrvgnd_1$1
XFILLER_137_328 vssd1 vccd1 vccd1 vssd1 sky130_fd_sc_hd__fill_2$1
XFILLER_22_27 vccd1 vssd1 vccd1 vssd1 sky130_fd_sc_hd__fill_1$1
XFILLER_138_27 vccd1 vssd1 vccd1 vssd1 sky130_fd_sc_hd__fill_1$1
XFILLER_4_809 vssd1 vccd1 vccd1 vssd1 sky130_fd_sc_hd__fill_2$1
XFILLER_105_225 vssd1 vccd1 vccd1 vssd1 sky130_ef_sc_hd__decap_40_12$1
XFILLER_121_729 vssd1 vccd1 vccd1 vssd1 sky130_ef_sc_hd__decap_40_12$1
XFILLER_114_781 vssd1 vccd1 vccd1 vssd1 sky130_ef_sc_hd__decap_40_12$1
XTAP_TAPCELL_ROW_93_1692 vccd1 vssd1 sky130_fd_sc_hd__tapvpwrvgnd_1$1
XFILLER_78_109 vssd1 vccd1 vccd1 vssd1 sky130_ef_sc_hd__decap_40_12$1
XFILLER_87_665 vssd1 vccd1 vccd1 vssd1 sky130_fd_sc_hd__fill_4$1
XFILLER_86_153 vssd1 vccd1 vccd1 vssd1 sky130_ef_sc_hd__decap_40_12$1
XFILLER_86_197 vssd1 vccd1 vccd1 vssd1 sky130_ef_sc_hd__decap_40_12$1
XTAP_TAPCELL_ROW_2_330 vccd1 vssd1 sky130_fd_sc_hd__tapvpwrvgnd_1$1
XFILLER_28_732 vssd1 vccd1 vccd1 vssd1 sky130_ef_sc_hd__decap_40_12$1
XPHY_EDGE_ROW_29_Right_29 vccd1 vssd1 vccd1 vssd1 sky130_fd_sc_hd__decap_3$1
XFILLER_47_57 vssd1 vccd1 vccd1 vssd1 sky130_ef_sc_hd__decap_40_12$1
XFILLER_42_245 vssd1 vccd1 vccd1 vssd1 sky130_fd_sc_hd__fill_4$1
XFILLER_70_587 vccd1 vssd1 vccd1 vssd1 sky130_fd_sc_hd__fill_1$1
XTAP_TAPCELL_ROW_41_914 vccd1 vssd1 sky130_fd_sc_hd__tapvpwrvgnd_1$1
XTAP_TAPCELL_ROW_120_2099 vccd1 vssd1 sky130_fd_sc_hd__tapvpwrvgnd_1$1
XFILLER_8_29 vssd1 vccd1 vccd1 vssd1 sky130_ef_sc_hd__decap_40_12$1
XFILLER_42_289 vssd1 vccd1 vccd1 vssd1 sky130_ef_sc_hd__decap_40_12$1
XFILLER_11_665 vssd1 vccd1 vccd1 vssd1 sky130_fd_sc_hd__fill_4$1
XPHY_EDGE_ROW_38_Right_38 vccd1 vssd1 vccd1 vssd1 sky130_fd_sc_hd__decap_3$1
XFILLER_10_153 vssd1 vccd1 vccd1 vssd1 sky130_ef_sc_hd__decap_40_12$1
XFILLER_136_361 vssd1 vccd1 vccd1 vssd1 sky130_fd_sc_hd__fill_2$1
XFILLER_109_553 vssd1 vccd1 vccd1 vssd1 sky130_fd_sc_hd__fill_4$1
XFILLER_10_197 vssd1 vccd1 vccd1 vssd1 sky130_ef_sc_hd__decap_40_12$1
XFILLER_7_669 vssd1 vccd1 vccd1 vssd1 sky130_fd_sc_hd__fill_2$1
XFILLER_88_53 vssd1 vccd1 vccd1 vssd1 sky130_ef_sc_hd__decap_40_12$1
XFILLER_124_589 vssd1 vccd1 vccd1 vssd1 sky130_fd_sc_hd__fill_8$1
XFILLER_111_217 vssd1 vccd1 vccd1 vssd1 sky130_fd_sc_hd__fill_4$1
XFILLER_88_97 vssd1 vccd1 vccd1 vssd1 sky130_ef_sc_hd__decap_40_12$1
XFILLER_78_621 vssd1 vccd1 vccd1 vssd1 sky130_ef_sc_hd__decap_40_12$1
XFILLER_69_109 vssd1 vccd1 vccd1 vssd1 sky130_fd_sc_hd__fill_2$1
XFILLER_2_363 vccd1 vssd1 vccd1 vssd1 sky130_fd_sc_hd__fill_1$1
XTAP_TAPCELL_ROW_127_2209 vccd1 vssd1 sky130_fd_sc_hd__tapvpwrvgnd_1$1
XFILLER_78_643 vccd1 vssd1 vccd1 vssd1 sky130_fd_sc_hd__fill_1$1
XFILLER_93_613 vssd1 vccd1 vccd1 vssd1 sky130_fd_sc_hd__fill_2$1
XFILLER_66_805 vssd1 vccd1 vccd1 vssd1 sky130_fd_sc_hd__fill_4$1
XFILLER_38_529 vssd1 vccd1 vccd1 vssd1 sky130_fd_sc_hd__fill_2$1
XPHY_EDGE_ROW_47_Right_47 vccd1 vssd1 vccd1 vssd1 sky130_fd_sc_hd__decap_3$1
XTAP_TAPCELL_ROW_109_1931 vccd1 vssd1 sky130_fd_sc_hd__tapvpwrvgnd_1$1
XFILLER_65_337 vssd1 vccd1 vccd1 vssd1 sky130_ef_sc_hd__decap_40_12$1
XFILLER_19_721 vssd1 vccd1 vccd1 vssd1 sky130_fd_sc_hd__fill_4$1
X_1060_ hold79/X _1060_/X _1078_/B vssd1 vccd1 vccd1 vssd1 sky130_fd_sc_hd__or2_1$1
XTAP_TAPCELL_ROW_109_1942 vccd1 vssd1 sky130_fd_sc_hd__tapvpwrvgnd_1$1
XFILLER_80_307 vccd1 vssd1 vccd1 vssd1 sky130_fd_sc_hd__fill_1$1
XFILLER_92_189 vssd1 vccd1 vccd1 vssd1 sky130_fd_sc_hd__fill_4$1
XFILLER_18_253 vssd1 vccd1 vccd1 vssd1 sky130_ef_sc_hd__decap_40_12$1
XFILLER_33_223 vccd1 vssd1 vccd1 vssd1 sky130_fd_sc_hd__fill_1$1
XTAP_TAPCELL_ROW_64_1260 vccd1 vssd1 sky130_fd_sc_hd__tapvpwrvgnd_1$1
XPHY_EDGE_ROW_56_Right_56 vccd1 vssd1 vccd1 vssd1 sky130_fd_sc_hd__decap_3$1
XFILLER_21_429 vssd1 vccd1 vccd1 vssd1 sky130_ef_sc_hd__decap_40_12$1
XFILLER_119_317 vssd1 vccd1 vccd1 vssd1 sky130_ef_sc_hd__decap_40_12$1
X_0913_ _1535_/Q _0949_/A _0915_/B _1663_/Q _1213_/A vccd1 vssd1 vccd1 vssd1 sky130_fd_sc_hd__a22o_1$1
X_0844_ _1524_/Q _0949_/A _0844_/X _1748_/Q _1411_/A vccd1 vssd1 vccd1 vssd1 sky130_fd_sc_hd__a22o_1$1
XFILLER_134_309 vssd1 vccd1 vccd1 vssd1 sky130_ef_sc_hd__decap_40_12$1
XFILLER_127_383 vssd1 vccd1 vccd1 vssd1 sky130_fd_sc_hd__fill_8$1
XFILLER_127_361 vssd1 vccd1 vccd1 vssd1 sky130_fd_sc_hd__fill_4$1
XFILLER_115_523 vccd1 vssd1 vccd1 vssd1 sky130_fd_sc_hd__fill_1$1
X_0775_ _1795_/A _0878_/A2 _0775_/X _1780_/A _0875_/A2 vccd1 vssd1 vccd1 vssd1 sky130_fd_sc_hd__a22o_1$1
XFILLER_103_707 vccd1 vssd1 vccd1 vssd1 sky130_fd_sc_hd__fill_1$1
XFILLER_88_429 vssd1 vccd1 vccd1 vssd1 sky130_ef_sc_hd__decap_40_12$1
XPHY_EDGE_ROW_65_Right_65 vccd1 vssd1 vccd1 vssd1 sky130_fd_sc_hd__decap_3$1
XFILLER_124_29 vssd1 vccd1 vccd1 vssd1 sky130_ef_sc_hd__decap_40_12$1
XFILLER_69_632 vssd1 vccd1 vccd1 vssd1 sky130_ef_sc_hd__decap_40_12$1
XFILLER_96_473 vssd1 vccd1 vccd1 vssd1 sky130_fd_sc_hd__fill_2$1
XFILLER_84_613 vssd1 vccd1 vccd1 vssd1 sky130_ef_sc_hd__decap_40_12$1
XFILLER_68_153 vssd1 vccd1 vccd1 vssd1 sky130_ef_sc_hd__decap_40_12$1
X_1327_ _0739_/D _1326_/X _1331_/A2 hold14/X _1692_/D vssd1 vccd1 vccd1 vssd1 sky130_fd_sc_hd__o211a_1$1
XFILLER_68_197 vssd1 vccd1 vccd1 vssd1 sky130_ef_sc_hd__decap_40_12$1
XFILLER_57_838 vssd1 vccd1 vccd1 vssd1 sky130_fd_sc_hd__fill_2$1
XFILLER_29_529 vssd1 vccd1 vccd1 vssd1 sky130_ef_sc_hd__decap_40_12$1
X_1258_ _1659_/Q _1258_/X _1276_/B vssd1 vccd1 vccd1 vssd1 sky130_fd_sc_hd__or2_1$1
XFILLER_17_27 vssd1 vccd1 vccd1 vssd1 sky130_ef_sc_hd__decap_40_12$1
XTAP_TAPCELL_ROW_27_708 vccd1 vssd1 sky130_fd_sc_hd__tapvpwrvgnd_1$1
XFILLER_83_167 vccd1 vssd1 vccd1 vssd1 sky130_fd_sc_hd__fill_1$1
XFILLER_71_329 vssd1 vccd1 vccd1 vssd1 sky130_fd_sc_hd__fill_4$1
X_1189_ _1387_/C1 _1188_/X _1189_/A2 hold125/X _1625_/D vssd1 vccd1 vccd1 vssd1 sky130_fd_sc_hd__o211a_1$1
XFILLER_37_573 vssd1 vccd1 vccd1 vssd1 sky130_ef_sc_hd__decap_40_12$1
XFILLER_64_381 vssd1 vccd1 vccd1 vssd1 sky130_fd_sc_hd__fill_2$1
XFILLER_24_245 vssd1 vccd1 vccd1 vssd1 sky130_fd_sc_hd__fill_4$1
XPHY_EDGE_ROW_74_Right_74 vccd1 vssd1 vccd1 vssd1 sky130_fd_sc_hd__decap_3$1
XFILLER_52_587 vccd1 vssd1 vccd1 vssd1 sky130_fd_sc_hd__fill_1$1
XFILLER_33_15 vssd1 vccd1 vccd1 vssd1 sky130_ef_sc_hd__decap_40_12$1
XFILLER_24_289 vssd1 vccd1 vccd1 vssd1 sky130_ef_sc_hd__decap_40_12$1
XFILLER_20_473 vssd1 vccd1 vccd1 vssd1 sky130_fd_sc_hd__fill_2$1
XFILLER_137_169 vssd1 vccd1 vccd1 vssd1 sky130_fd_sc_hd__fill_8$1
XTAP_TAPCELL_ROW_95_1721 vccd1 vssd1 sky130_fd_sc_hd__tapvpwrvgnd_1$1
XFILLER_134_810 vssd1 vccd1 vccd1 vssd1 sky130_fd_sc_hd__fill_2$1
XFILLER_118_361 vssd1 vccd1 vccd1 vssd1 sky130_fd_sc_hd__fill_2$1
XFILLER_106_501 vssd1 vccd1 vccd1 vssd1 sky130_ef_sc_hd__decap_40_12$1
XTAP_TAPCELL_ROW_95_1732 vccd1 vssd1 sky130_fd_sc_hd__tapvpwrvgnd_1$1
XFILLER_3_105 vssd1 vccd1 vccd1 vssd1 sky130_fd_sc_hd__fill_4$1
XFILLER_106_545 vssd1 vccd1 vccd1 vssd1 sky130_ef_sc_hd__decap_40_12$1
XPHY_EDGE_ROW_83_Right_83 vccd1 vssd1 vccd1 vssd1 sky130_fd_sc_hd__decap_3$1
XFILLER_3_149 vssd1 vccd1 vccd1 vssd1 sky130_ef_sc_hd__decap_40_12$1
XPHY_EDGE_ROW_18_Left_157 vccd1 vssd1 vccd1 vssd1 sky130_fd_sc_hd__decap_3$1
XFILLER_106_589 vssd1 vccd1 vccd1 vssd1 sky130_ef_sc_hd__decap_40_12$1
XTAP_TAPCELL_ROW_7_411 vccd1 vssd1 sky130_fd_sc_hd__tapvpwrvgnd_1$1
XTAP_TAPCELL_ROW_7_400 vccd1 vssd1 sky130_fd_sc_hd__tapvpwrvgnd_1$1
XFILLER_0_823 vssd1 vccd1 vccd1 vssd1 sky130_ef_sc_hd__decap_40_12$1
XFILLER_121_548 vssd1 vccd1 vccd1 vssd1 sky130_ef_sc_hd__decap_40_12$1
XFILLER_75_613 vssd1 vccd1 vccd1 vssd1 sky130_fd_sc_hd__fill_2$1
XFILLER_101_261 vssd1 vccd1 vccd1 vssd1 sky130_ef_sc_hd__decap_40_12$1
XFILLER_47_337 vssd1 vccd1 vccd1 vssd1 sky130_ef_sc_hd__decap_40_12$1
XTAP_TAPCELL_ROW_122_2128 vccd1 vssd1 sky130_fd_sc_hd__tapvpwrvgnd_1$1
XFILLER_74_189 vssd1 vccd1 vccd1 vssd1 sky130_fd_sc_hd__fill_4$1
XFILLER_74_77 vssd1 vccd1 vccd1 vssd1 sky130_fd_sc_hd__fill_4$1
XFILLER_62_307 vccd1 vssd1 vccd1 vssd1 sky130_fd_sc_hd__fill_1$1
XFILLER_16_713 vssd1 vccd1 vccd1 vssd1 sky130_ef_sc_hd__decap_40_12$1
XPHY_EDGE_ROW_92_Right_92 vccd1 vssd1 vccd1 vssd1 sky130_fd_sc_hd__decap_3$1
XFILLER_71_841 vccd1 vssd1 vccd1 vssd1 sky130_fd_sc_hd__fill_1$1
XFILLER_15_223 vccd1 vssd1 vccd1 vssd1 sky130_fd_sc_hd__fill_1$1
XFILLER_16_757 vssd1 vccd1 vccd1 vssd1 sky130_ef_sc_hd__decap_40_12$1
XPHY_EDGE_ROW_27_Left_166 vccd1 vssd1 vccd1 vssd1 sky130_fd_sc_hd__decap_3$1
XPHY_EDGE_ROW_133_Right_133 vccd1 vssd1 vccd1 vssd1 sky130_fd_sc_hd__decap_3$1
XTAP_TAPCELL_ROW_104_1861 vccd1 vssd1 sky130_fd_sc_hd__tapvpwrvgnd_1$1
XFILLER_31_727 vccd1 vssd1 vccd1 vssd1 sky130_fd_sc_hd__fill_1$1
XFILLER_130_83 vccd1 vssd1 vccd1 vssd1 sky130_fd_sc_hd__fill_1$1
XFILLER_90_65 vssd1 vccd1 vccd1 vssd1 sky130_ef_sc_hd__decap_40_12$1
XTAP_TAPCELL_ROW_137_2360 vccd1 vssd1 sky130_fd_sc_hd__tapvpwrvgnd_1$1
XFILLER_11_473 vssd1 vccd1 vccd1 vssd1 sky130_ef_sc_hd__decap_40_12$1
XFILLER_23_81 vssd1 vccd1 vccd1 vssd1 sky130_ef_sc_hd__decap_40_12$1
XFILLER_116_309 vssd1 vccd1 vccd1 vssd1 sky130_ef_sc_hd__decap_40_12$1
XFILLER_137_681 vssd1 vccd1 vccd1 vssd1 sky130_fd_sc_hd__fill_8$1
XFILLER_109_361 vssd1 vccd1 vccd1 vssd1 sky130_ef_sc_hd__decap_40_12$1
XPHY_EDGE_ROW_36_Left_175 vccd1 vssd1 vccd1 vssd1 sky130_fd_sc_hd__decap_3$1
XFILLER_98_738 vccd1 vssd1 vccd1 vssd1 sky130_fd_sc_hd__fill_1$1
XFILLER_97_237 vssd1 vccd1 vccd1 vssd1 sky130_ef_sc_hd__decap_40_12$1
XFILLER_2_193 vssd1 vccd1 vccd1 vssd1 sky130_fd_sc_hd__fill_2$1
XFILLER_39_805 vssd1 vccd1 vccd1 vssd1 sky130_fd_sc_hd__fill_2$1
XFILLER_120_581 vssd1 vccd1 vccd1 vssd1 sky130_fd_sc_hd__fill_2$1
XFILLER_78_473 vssd1 vccd1 vccd1 vssd1 sky130_fd_sc_hd__fill_2$1
XFILLER_66_668 vssd1 vccd1 vccd1 vssd1 sky130_ef_sc_hd__decap_40_12$1
XFILLER_54_808 vssd1 vccd1 vccd1 vssd1 sky130_fd_sc_hd__fill_4$1
X_1112_ _1806_/A _1112_/X _1122_/B vssd1 vccd1 vccd1 vssd1 sky130_fd_sc_hd__or2_1$1
X_1043_ _1447_/C1 _1042_/X _1053_/A2 hold21/X _1554_/D vssd1 vccd1 vccd1 vssd1 sky130_fd_sc_hd__o211a_1$1
XFILLER_65_167 vccd1 vssd1 vccd1 vssd1 sky130_fd_sc_hd__fill_1$1
XFILLER_53_329 vssd1 vccd1 vccd1 vssd1 sky130_fd_sc_hd__fill_4$1
XFILLER_19_573 vssd1 vccd1 vccd1 vssd1 sky130_ef_sc_hd__decap_40_12$1
XPHY_EDGE_ROW_45_Left_184 vccd1 vssd1 vccd1 vssd1 sky130_fd_sc_hd__decap_3$1
XFILLER_80_137 vssd1 vccd1 vccd1 vssd1 sky130_fd_sc_hd__fill_2$1
XFILLER_0_85 vssd1 vccd1 vccd1 vssd1 sky130_fd_sc_hd__fill_8$1
XFILLER_22_705 vssd1 vccd1 vccd1 vssd1 sky130_fd_sc_hd__fill_2$1
XPHY_EDGE_ROW_100_Right_100 vccd1 vssd1 vccd1 vssd1 sky130_fd_sc_hd__decap_3$1
XFILLER_61_373 vssd1 vccd1 vccd1 vssd1 sky130_ef_sc_hd__decap_40_12$1
XFILLER_21_237 vssd1 vccd1 vccd1 vssd1 sky130_ef_sc_hd__decap_40_12$1
XFILLER_34_587 vccd1 vssd1 vccd1 vssd1 sky130_fd_sc_hd__fill_1$1
XFILLER_119_125 vssd1 vccd1 vccd1 vssd1 sky130_ef_sc_hd__decap_40_12$1
XFILLER_30_793 vssd1 vccd1 vccd1 vssd1 sky130_ef_sc_hd__decap_40_12$1
XTAP_TAPCELL_ROW_32_777 vccd1 vssd1 sky130_fd_sc_hd__tapvpwrvgnd_1$1
XFILLER_119_169 vssd1 vccd1 vccd1 vssd1 sky130_ef_sc_hd__decap_40_12$1
XPHY_EDGE_ROW_54_Left_193 vccd1 vssd1 vccd1 vssd1 sky130_fd_sc_hd__decap_3$1
XFILLER_135_629 vssd1 vccd1 vccd1 vssd1 sky130_fd_sc_hd__fill_4$1
XFILLER_116_821 vssd1 vccd1 vccd1 vssd1 sky130_fd_sc_hd__fill_4$1
X_0827_ _0827_/X _0875_/B1 _1821_/A _1681_/Q _0878_/A2 vssd1 vccd1 _0826_/X vccd1
+ vssd1 sky130_fd_sc_hd__a221o_1$1
XFILLER_134_139 vccd1 vssd1 vccd1 vssd1 sky130_fd_sc_hd__fill_1$1
XTAP_TAPCELL_ROW_77_1462 vccd1 vssd1 sky130_fd_sc_hd__tapvpwrvgnd_1$1
XTAP_TAPCELL_ROW_77_1451 vccd1 vssd1 sky130_fd_sc_hd__tapvpwrvgnd_1$1
X_0758_ _0945_/A _0758_/A _0758_/X _0758_/B _0758_/D vccd1 vssd1 vccd1 vssd1 sky130_fd_sc_hd__or4_1$1
XFILLER_130_301 vssd1 vccd1 vccd1 vssd1 sky130_fd_sc_hd__fill_4$1
XFILLER_89_727 vccd1 vssd1 vccd1 vssd1 sky130_fd_sc_hd__fill_1$1
XFILLER_1_609 vssd1 vccd1 vccd1 vssd1 sky130_fd_sc_hd__fill_4$1
XFILLER_135_39 vssd1 vccd1 vccd1 vssd1 sky130_ef_sc_hd__decap_40_12$1
XFILLER_130_345 vssd1 vccd1 vccd1 vssd1 sky130_ef_sc_hd__decap_40_12$1
XFILLER_103_559 vccd1 vssd1 vccd1 vssd1 sky130_fd_sc_hd__fill_1$1
XFILLER_103_537 vssd1 vccd1 vccd1 vssd1 sky130_ef_sc_hd__decap_40_12$1
XTAP_TAPCELL_ROW_90_1651 vccd1 vssd1 sky130_fd_sc_hd__tapvpwrvgnd_1$1
XFILLER_69_462 vssd1 vccd1 vccd1 vssd1 sky130_ef_sc_hd__decap_40_12$1
XFILLER_130_389 vssd1 vccd1 vccd1 vssd1 sky130_ef_sc_hd__decap_40_12$1
XFILLER_97_782 vssd1 vccd1 vccd1 vssd1 sky130_fd_sc_hd__fill_2$1
XFILLER_84_410 vssd1 vccd1 vccd1 vssd1 sky130_fd_sc_hd__fill_8$1
XFILLER_57_613 vssd1 vccd1 vccd1 vssd1 sky130_fd_sc_hd__fill_2$1
XFILLER_28_15 vssd1 vccd1 vccd1 vssd1 sky130_ef_sc_hd__decap_40_12$1
XFILLER_29_337 vssd1 vccd1 vccd1 vssd1 sky130_ef_sc_hd__decap_40_12$1
XFILLER_84_465 vssd1 vccd1 vccd1 vssd1 sky130_fd_sc_hd__fill_8$1
XFILLER_57_657 vssd1 vccd1 vccd1 vssd1 sky130_ef_sc_hd__decap_40_12$1
XFILLER_56_189 vssd1 vccd1 vccd1 vssd1 sky130_fd_sc_hd__fill_4$1
XFILLER_44_307 vccd1 vssd1 vccd1 vssd1 sky130_fd_sc_hd__fill_1$1
XFILLER_72_649 vccd1 vssd1 vccd1 vssd1 sky130_fd_sc_hd__fill_1$1
XFILLER_71_137 vssd1 vccd1 vccd1 vssd1 sky130_ef_sc_hd__decap_40_12$1
XFILLER_53_841 vccd1 vssd1 vccd1 vssd1 sky130_fd_sc_hd__fill_1$1
XFILLER_80_693 vssd1 vccd1 vccd1 vssd1 sky130_fd_sc_hd__fill_4$1
XFILLER_9_709 vssd1 vccd1 vccd1 vssd1 sky130_ef_sc_hd__decap_40_12$1
XFILLER_13_727 vccd1 vssd1 vccd1 vssd1 sky130_fd_sc_hd__fill_1$1
XFILLER_40_513 vssd1 vccd1 vccd1 vssd1 sky130_ef_sc_hd__decap_40_12$1
XFILLER_100_53 vssd1 vccd1 vccd1 vssd1 sky130_ef_sc_hd__decap_40_12$1
XFILLER_138_423 vccd1 vssd1 vccd1 vssd1 sky130_fd_sc_hd__fill_1$1
XFILLER_100_97 vssd1 vccd1 vccd1 vssd1 sky130_ef_sc_hd__decap_40_12$1
XTAP_TAPCELL_ROW_119_2090 vccd1 vssd1 sky130_fd_sc_hd__tapvpwrvgnd_1$1
XTAP_TAPCELL_ROW_10_449 vccd1 vssd1 sky130_fd_sc_hd__tapvpwrvgnd_1$1
XFILLER_126_629 vssd1 vccd1 vccd1 vssd1 sky130_fd_sc_hd__fill_8$1
XFILLER_114_3 vssd1 vccd1 vccd1 vssd1 sky130_ef_sc_hd__decap_40_12$1
XFILLER_107_821 vssd1 vccd1 vccd1 vssd1 sky130_fd_sc_hd__fill_2$1
XFILLER_109_51 vssd1 vccd1 vccd1 vssd1 sky130_fd_sc_hd__fill_4$1
XFILLER_133_161 vssd1 vccd1 vccd1 vssd1 sky130_fd_sc_hd__fill_4$1
XFILLER_122_813 vssd1 vccd1 vccd1 vssd1 sky130_ef_sc_hd__decap_40_12$1
XFILLER_69_55 vccd1 vssd1 vccd1 vssd1 sky130_fd_sc_hd__fill_1$1
XFILLER_4_469 vssd1 vccd1 vccd1 vssd1 sky130_fd_sc_hd__fill_4$1
XFILLER_79_237 vssd1 vccd1 vccd1 vssd1 sky130_ef_sc_hd__decap_40_12$1
XFILLER_0_631 vssd1 vccd1 vccd1 vssd1 sky130_ef_sc_hd__decap_40_12$1
XFILLER_87_281 vssd1 vccd1 vccd1 vssd1 sky130_ef_sc_hd__decap_40_12$1
XFILLER_48_657 vssd1 vccd1 vccd1 vssd1 sky130_ef_sc_hd__decap_40_12$1
XFILLER_35_329 vssd1 vccd1 vccd1 vssd1 sky130_fd_sc_hd__fill_4$1
XFILLER_47_167 vccd1 vssd1 vccd1 vssd1 sky130_fd_sc_hd__fill_1$1
XFILLER_90_457 vssd1 vccd1 vccd1 vssd1 sky130_ef_sc_hd__decap_40_12$1
XFILLER_63_649 vssd1 vccd1 vccd1 vssd1 sky130_ef_sc_hd__decap_40_12$1
XFILLER_62_137 vssd1 vccd1 vccd1 vssd1 sky130_fd_sc_hd__fill_2$1
XFILLER_18_81 vssd1 vccd1 vccd1 vssd1 sky130_fd_sc_hd__fill_2$1
XFILLER_16_587 vccd1 vssd1 vccd1 vssd1 sky130_fd_sc_hd__fill_1$1
XFILLER_43_373 vssd1 vccd1 vccd1 vssd1 sky130_ef_sc_hd__decap_40_12$1
XFILLER_31_557 vssd1 vccd1 vccd1 vssd1 sky130_fd_sc_hd__fill_2$1
XTAP_TAPCELL_ROW_135_2319 vccd1 vssd1 sky130_fd_sc_hd__tapvpwrvgnd_1$1
X_1730_ _1730_/Q _1762_/CLK _1730_/D vccd1 vssd1 vccd1 vssd1 sky130_fd_sc_hd__dfxtp_1$1
XFILLER_11_281 vssd1 vccd1 vccd1 vssd1 sky130_ef_sc_hd__decap_40_12$1
XFILLER_8_753 vssd1 vccd1 vccd1 vssd1 sky130_fd_sc_hd__fill_2$1
XFILLER_12_793 vssd1 vccd1 vccd1 vssd1 sky130_ef_sc_hd__decap_40_12$1
X_1661_ _1661_/Q _1690_/CLK _1661_/D vccd1 vssd1 vccd1 vssd1 sky130_fd_sc_hd__dfxtp_2$1
Xhold208 _1721_/Q _1386_/A vssd1 vccd1 vccd1 vssd1 sky130_fd_sc_hd__dlygate4sd3_1$1
XFILLER_116_139 vccd1 vssd1 vccd1 vssd1 sky130_fd_sc_hd__fill_1$1
XFILLER_131_109 vssd1 vccd1 vccd1 vssd1 sky130_fd_sc_hd__fill_2$1
XFILLER_125_673 vssd1 vccd1 vccd1 vssd1 sky130_fd_sc_hd__fill_8$1
XFILLER_112_301 vssd1 vccd1 vccd1 vssd1 sky130_fd_sc_hd__fill_4$1
XFILLER_98_513 vssd1 vccd1 vccd1 vssd1 sky130_ef_sc_hd__decap_40_12$1
X_1592_ _1810_/A _1720_/CLK _1592_/D vccd1 vssd1 vccd1 vssd1 sky130_fd_sc_hd__dfxtp_1$1
XTAP_TAPCELL_ROW_59_1192 vccd1 vssd1 sky130_fd_sc_hd__tapvpwrvgnd_1$1
XTAP_TAPCELL_ROW_59_1181 vccd1 vssd1 sky130_fd_sc_hd__tapvpwrvgnd_1$1
XFILLER_112_345 vssd1 vccd1 vccd1 vssd1 sky130_ef_sc_hd__decap_40_12$1
XFILLER_79_771 vssd1 vccd1 vccd1 vssd1 sky130_ef_sc_hd__decap_40_12$1
XTAP_TAPCELL_ROW_72_1381 vccd1 vssd1 sky130_fd_sc_hd__tapvpwrvgnd_1$1
XFILLER_66_421 vssd1 vccd1 vccd1 vssd1 sky130_ef_sc_hd__decap_40_12$1
XFILLER_39_624 vssd1 vccd1 vccd1 vssd1 sky130_fd_sc_hd__fill_4$1
XFILLER_39_668 vssd1 vccd1 vccd1 vssd1 sky130_fd_sc_hd__fill_4$1
XFILLER_93_273 vssd1 vccd1 vccd1 vssd1 sky130_fd_sc_hd__fill_4$1
XFILLER_26_307 vccd1 vssd1 vccd1 vssd1 sky130_fd_sc_hd__fill_1$1
XFILLER_53_137 vssd1 vccd1 vccd1 vssd1 sky130_ef_sc_hd__decap_40_12$1
XFILLER_35_841 vccd1 vssd1 vccd1 vssd1 sky130_fd_sc_hd__fill_1$1
XTAP_TAPCELL_ROW_37_858 vccd1 vssd1 sky130_fd_sc_hd__tapvpwrvgnd_1$1
XFILLER_38_189 vssd1 vccd1 vccd1 vssd1 sky130_fd_sc_hd__fill_4$1
X_1026_ _1777_/A _1026_/X _1052_/B vssd1 vccd1 vccd1 vssd1 sky130_fd_sc_hd__or2_1$1
XFILLER_62_693 vssd1 vccd1 vccd1 vssd1 sky130_fd_sc_hd__fill_4$1
XTAP_TAPCELL_ROW_17_560 vccd1 vssd1 sky130_fd_sc_hd__tapvpwrvgnd_1$1
XFILLER_22_513 vssd1 vccd1 vccd1 vssd1 sky130_ef_sc_hd__decap_40_12$1
XFILLER_61_181 vssd1 vccd1 vccd1 vssd1 sky130_ef_sc_hd__decap_40_12$1
XFILLER_22_557 vssd1 vccd1 vccd1 vssd1 sky130_ef_sc_hd__decap_40_12$1
XPHY_EDGE_ROW_62_Left_201 vccd1 vssd1 vccd1 vssd1 sky130_fd_sc_hd__decap_3$1
XFILLER_30_27 vccd1 vssd1 vccd1 vssd1 sky130_fd_sc_hd__fill_1$1
XFILLER_122_109 vssd1 vccd1 vccd1 vssd1 sky130_ef_sc_hd__decap_40_12$1
XFILLER_116_662 vssd1 vccd1 vccd1 vssd1 sky130_fd_sc_hd__fill_8$1
XFILLER_104_813 vssd1 vccd1 vccd1 vssd1 sky130_ef_sc_hd__decap_40_12$1
XFILLER_1_417 vssd1 vccd1 vccd1 vssd1 sky130_ef_sc_hd__decap_40_12$1
XFILLER_115_161 vssd1 vccd1 vccd1 vssd1 sky130_fd_sc_hd__fill_4$1
XFILLER_89_557 vssd1 vccd1 vccd1 vssd1 sky130_fd_sc_hd__fill_2$1
XFILLER_131_665 vssd1 vccd1 vccd1 vssd1 sky130_fd_sc_hd__fill_4$1
XFILLER_130_153 vssd1 vccd1 vccd1 vssd1 sky130_ef_sc_hd__decap_40_12$1
XPHY_EDGE_ROW_71_Left_210 vccd1 vssd1 vccd1 vssd1 sky130_fd_sc_hd__decap_3$1
XFILLER_39_69 vssd1 vccd1 vccd1 vssd1 sky130_ef_sc_hd__decap_40_12$1
XFILLER_130_197 vssd1 vccd1 vccd1 vssd1 sky130_ef_sc_hd__decap_40_12$1
XFILLER_69_281 vssd1 vccd1 vccd1 vssd1 sky130_ef_sc_hd__decap_40_12$1
XFILLER_85_785 vssd1 vccd1 vccd1 vssd1 sky130_ef_sc_hd__decap_40_12$1
XFILLER_84_251 vccd1 vssd1 vccd1 vssd1 sky130_fd_sc_hd__fill_1$1
XFILLER_29_167 vccd1 vssd1 vccd1 vssd1 sky130_fd_sc_hd__fill_1$1
XFILLER_55_57 vssd1 vccd1 vccd1 vssd1 sky130_ef_sc_hd__decap_40_12$1
XFILLER_17_329 vssd1 vccd1 vccd1 vssd1 sky130_fd_sc_hd__fill_4$1
XFILLER_44_137 vssd1 vccd1 vccd1 vssd1 sky130_fd_sc_hd__fill_2$1
XFILLER_72_457 vssd1 vccd1 vccd1 vssd1 sky130_ef_sc_hd__decap_40_12$1
XFILLER_53_671 vccd1 vssd1 vccd1 vssd1 sky130_fd_sc_hd__fill_1$1
XTAP_TAPCELL_ROW_15_519 vccd1 vssd1 sky130_fd_sc_hd__tapvpwrvgnd_1$1
XFILLER_25_373 vssd1 vccd1 vccd1 vssd1 sky130_ef_sc_hd__decap_40_12$1
XTAP_TAPCELL_ROW_101_1820 vccd1 vssd1 sky130_fd_sc_hd__tapvpwrvgnd_1$1
Xclkbuf_leaf_27_wb_clk_i clkload8/A clkload1/A vssd1 vccd1 vccd1 vssd1 sky130_fd_sc_hd__clkbuf_8$1
XFILLER_9_517 vssd1 vccd1 vccd1 vssd1 sky130_ef_sc_hd__decap_40_12$1
XFILLER_13_557 vssd1 vccd1 vccd1 vssd1 sky130_fd_sc_hd__fill_2$1
XFILLER_40_321 vssd1 vccd1 vccd1 vssd1 sky130_ef_sc_hd__decap_40_12$1
XFILLER_40_365 vssd1 vccd1 vccd1 vssd1 sky130_ef_sc_hd__decap_40_12$1
XFILLER_138_253 vssd1 vccd1 vccd1 vssd1 sky130_fd_sc_hd__fill_2$1
XFILLER_126_415 vssd1 vccd1 vccd1 vssd1 sky130_fd_sc_hd__fill_4$1
XTAP_TAPCELL_ROW_117_2049 vccd1 vssd1 sky130_fd_sc_hd__tapvpwrvgnd_1$1
XFILLER_126_459 vccd1 vssd1 vccd1 vssd1 sky130_fd_sc_hd__fill_1$1
XFILLER_4_233 vssd1 vccd1 vccd1 vssd1 sky130_ef_sc_hd__decap_40_12$1
XTAP_TAPCELL_ROW_130_2249 vccd1 vssd1 sky130_fd_sc_hd__tapvpwrvgnd_1$1
XFILLER_113_109 vssd1 vccd1 vccd1 vssd1 sky130_fd_sc_hd__fill_2$1
XFILLER_107_673 vssd1 vccd1 vccd1 vssd1 sky130_ef_sc_hd__decap_40_12$1
XFILLER_122_643 vccd1 vssd1 vccd1 vssd1 sky130_fd_sc_hd__fill_1$1
XFILLER_4_277 vssd1 vccd1 vccd1 vssd1 sky130_ef_sc_hd__decap_40_12$1
XFILLER_96_53 vssd1 vccd1 vccd1 vssd1 sky130_ef_sc_hd__decap_40_12$1
XFILLER_95_505 vssd1 vccd1 vccd1 vssd1 sky130_ef_sc_hd__decap_40_12$1
XTAP_TAPCELL_ROW_112_1982 vccd1 vssd1 sky130_fd_sc_hd__tapvpwrvgnd_1$1
XFILLER_0_461 vssd1 vccd1 vccd1 vssd1 sky130_ef_sc_hd__decap_40_12$1
XFILLER_96_97 vssd1 vccd1 vccd1 vssd1 sky130_ef_sc_hd__decap_40_12$1
XFILLER_48_421 vssd1 vccd1 vccd1 vssd1 sky130_ef_sc_hd__decap_40_12$1
Xhold80 wbs_dat_i[25] hold80/X vssd1 vccd1 vccd1 vssd1 sky130_fd_sc_hd__dlygate4sd3_1$1
Xhold91 hold91/A hold91/X vssd1 vccd1 vccd1 vssd1 sky130_fd_sc_hd__dlygate4sd3_1$1
XFILLER_75_273 vssd1 vccd1 vccd1 vssd1 sky130_fd_sc_hd__fill_4$1
XFILLER_36_605 vssd1 vccd1 vccd1 vssd1 sky130_ef_sc_hd__decap_40_12$1
XFILLER_90_221 vssd1 vccd1 vccd1 vssd1 sky130_ef_sc_hd__decap_40_12$1
XFILLER_63_446 vssd1 vccd1 vccd1 vssd1 sky130_fd_sc_hd__fill_2$1
XFILLER_63_424 vssd1 vccd1 vccd1 vssd1 sky130_ef_sc_hd__decap_40_12$1
XFILLER_17_841 vccd1 vssd1 vccd1 vssd1 sky130_fd_sc_hd__fill_1$1
XFILLER_35_137 vssd1 vccd1 vccd1 vssd1 sky130_ef_sc_hd__decap_40_12$1
XFILLER_90_265 vssd1 vccd1 vccd1 vssd1 sky130_ef_sc_hd__decap_40_12$1
XFILLER_32_800 vssd1 vccd1 vccd1 vssd1 sky130_fd_sc_hd__fill_4$1
XTAP_TAPCELL_ROW_34_806 vccd1 vssd1 sky130_fd_sc_hd__tapvpwrvgnd_1$1
XTAP_TAPCELL_ROW_34_817 vccd1 vssd1 sky130_fd_sc_hd__tapvpwrvgnd_1$1
XFILLER_44_682 vssd1 vccd1 vccd1 vssd1 sky130_ef_sc_hd__decap_40_12$1
XFILLER_43_181 vssd1 vccd1 vccd1 vssd1 sky130_ef_sc_hd__decap_40_12$1
XFILLER_77_3 vssd1 vccd1 vccd1 vssd1 sky130_ef_sc_hd__decap_40_12$1
X_1713_ _1713_/Q _1740_/CLK _1713_/D vccd1 vssd1 vccd1 vssd1 sky130_fd_sc_hd__dfxtp_1$1
XFILLER_132_407 vssd1 vccd1 vccd1 vssd1 sky130_ef_sc_hd__decap_40_12$1
XFILLER_104_109 vssd1 vccd1 vccd1 vssd1 sky130_ef_sc_hd__decap_40_12$1
X_1644_ _1644_/Q clkload8/A _1644_/D vccd1 vssd1 vccd1 vssd1 sky130_fd_sc_hd__dfxtp_2$1
XTAP_TAPCELL_ROW_74_1410 vccd1 vssd1 sky130_fd_sc_hd__tapvpwrvgnd_1$1
XFILLER_98_321 vssd1 vccd1 vccd1 vssd1 sky130_ef_sc_hd__decap_40_12$1
X_1575_ _1789_/A _1575_/CLK _1575_/D vccd1 vssd1 vccd1 vssd1 sky130_fd_sc_hd__dfxtp_1$1
XFILLER_101_805 vssd1 vccd1 vccd1 vssd1 sky130_fd_sc_hd__fill_2$1
XFILLER_98_365 vssd1 vccd1 vccd1 vssd1 sky130_ef_sc_hd__decap_40_12$1
XFILLER_112_153 vssd1 vccd1 vccd1 vssd1 sky130_ef_sc_hd__decap_40_12$1
XFILLER_112_197 vssd1 vccd1 vccd1 vssd1 sky130_ef_sc_hd__decap_40_12$1
XFILLER_67_741 vccd1 vssd1 vccd1 vssd1 sky130_fd_sc_hd__fill_1$1
XFILLER_132_29 vssd1 vccd1 vccd1 vssd1 sky130_ef_sc_hd__decap_40_12$1
XFILLER_67_785 vssd1 vccd1 vccd1 vssd1 sky130_ef_sc_hd__decap_40_12$1
XFILLER_66_251 vccd1 vssd1 vccd1 vssd1 sky130_fd_sc_hd__fill_1$1
XFILLER_81_221 vssd1 vccd1 vccd1 vssd1 sky130_fd_sc_hd__fill_2$1
XFILLER_54_446 vssd1 vccd1 vccd1 vssd1 sky130_ef_sc_hd__decap_40_12$1
XFILLER_26_137 vssd1 vccd1 vccd1 vssd1 sky130_fd_sc_hd__fill_2$1
XFILLER_82_777 vssd1 vccd1 vccd1 vssd1 sky130_ef_sc_hd__decap_40_12$1
XFILLER_25_27 vssd1 vccd1 vccd1 vssd1 sky130_ef_sc_hd__decap_40_12$1
X_1009_ _1441_/C1 _1008_/X _1013_/A2 hold109/X _1538_/D vssd1 vccd1 vccd1 vssd1 sky130_fd_sc_hd__o211a_1$1
XTAP_TAPCELL_ROW_85_1572 vccd1 vssd1 sky130_fd_sc_hd__tapvpwrvgnd_1$1
XFILLER_22_321 vssd1 vccd1 vccd1 vssd1 sky130_ef_sc_hd__decap_40_12$1
XFILLER_22_365 vssd1 vccd1 vccd1 vssd1 sky130_ef_sc_hd__decap_40_12$1
XFILLER_41_15 vssd1 vccd1 vccd1 vssd1 sky130_ef_sc_hd__decap_40_12$1
XFILLER_136_713 vssd1 vccd1 vccd1 vssd1 sky130_ef_sc_hd__decap_40_12$1
XFILLER_136_757 vssd1 vccd1 vccd1 vssd1 sky130_ef_sc_hd__decap_40_12$1
XFILLER_135_223 vccd1 vssd1 vccd1 vssd1 sky130_fd_sc_hd__fill_1$1
XTAP_TAPCELL_ROW_20_599 vccd1 vssd1 sky130_fd_sc_hd__tapvpwrvgnd_1$1
XFILLER_2_737 vssd1 vccd1 vccd1 vssd1 sky130_ef_sc_hd__decap_40_12$1
XFILLER_1_225 vssd1 vccd1 vccd1 vssd1 sky130_ef_sc_hd__decap_40_12$1
XFILLER_104_643 vccd1 vssd1 vccd1 vssd1 sky130_fd_sc_hd__fill_1$1
XFILLER_106_41 vssd1 vccd1 vccd1 vssd1 sky130_ef_sc_hd__decap_40_12$1
XFILLER_106_85 vssd1 vccd1 vccd1 vssd1 sky130_ef_sc_hd__decap_40_12$1
XFILLER_58_774 vssd1 vccd1 vccd1 vssd1 sky130_ef_sc_hd__decap_40_12$1
XFILLER_72_221 vssd1 vccd1 vccd1 vssd1 sky130_ef_sc_hd__decap_40_12$1
XFILLER_58_796 vccd1 vssd1 vccd1 vssd1 sky130_fd_sc_hd__fill_1$1
XFILLER_57_273 vssd1 vccd1 vccd1 vssd1 sky130_fd_sc_hd__fill_4$1
XFILLER_17_137 vssd1 vccd1 vccd1 vssd1 sky130_ef_sc_hd__decap_40_12$1
XFILLER_73_777 vssd1 vccd1 vccd1 vssd1 sky130_fd_sc_hd__fill_4$1
XFILLER_72_265 vssd1 vccd1 vccd1 vssd1 sky130_ef_sc_hd__decap_40_12$1
XTAP_TAPCELL_ROW_0_280 vccd1 vssd1 sky130_fd_sc_hd__tapvpwrvgnd_1$1
XFILLER_14_811 vccd1 vssd1 vccd1 vssd1 sky130_fd_sc_hd__fill_1$1
XFILLER_82_77 vssd1 vccd1 vccd1 vssd1 sky130_fd_sc_hd__fill_4$1
XTAP_TAPCELL_ROW_0_291 vccd1 vssd1 sky130_fd_sc_hd__tapvpwrvgnd_1$1
XFILLER_25_181 vssd1 vccd1 vccd1 vssd1 sky130_ef_sc_hd__decap_40_12$1
XFILLER_15_93 vssd1 vccd1 vccd1 vssd1 sky130_ef_sc_hd__decap_40_12$1
XFILLER_41_685 vssd1 vccd1 vccd1 vssd1 sky130_ef_sc_hd__decap_40_12$1
XFILLER_40_195 vccd1 vssd1 vccd1 vssd1 sky130_fd_sc_hd__fill_1$1
XFILLER_126_245 vssd1 vccd1 vccd1 vssd1 sky130_fd_sc_hd__fill_4$1
XFILLER_5_553 vssd1 vccd1 vccd1 vssd1 sky130_fd_sc_hd__fill_4$1
XFILLER_31_81 vssd1 vccd1 vccd1 vssd1 sky130_ef_sc_hd__decap_40_12$1
XFILLER_126_289 vssd1 vccd1 vccd1 vssd1 sky130_ef_sc_hd__decap_40_12$1
XTAP_TAPCELL_ROW_56_1140 vccd1 vssd1 sky130_fd_sc_hd__tapvpwrvgnd_1$1
XFILLER_5_597 vssd1 vccd1 vccd1 vssd1 sky130_ef_sc_hd__decap_40_12$1
Xoutput70 _1851_/X analog_ctrl[118] vssd1 vccd1 vccd1 vssd1 sky130_fd_sc_hd__buf_12$1
XFILLER_122_440 vssd1 vccd1 vccd1 vssd1 sky130_ef_sc_hd__decap_40_12$1
X_1360_ _1831_/A _1360_/X _1408_/B vssd1 vccd1 vccd1 vssd1 sky130_fd_sc_hd__or2_1$1
XFILLER_110_613 vssd1 vccd1 vccd1 vssd1 sky130_ef_sc_hd__decap_40_12$1
XFILLER_96_825 vccd1 vssd1 vccd1 vssd1 sky130_fd_sc_hd__fill_1$1
XFILLER_1_781 vssd1 vccd1 vccd1 vssd1 sky130_fd_sc_hd__fill_2$1
Xoutput81 _1788_/X analog_ctrl[17] vssd1 vccd1 vccd1 vssd1 sky130_fd_sc_hd__buf_12$1
Xoutput92 _1798_/X analog_ctrl[27] vssd1 vccd1 vccd1 vssd1 sky130_fd_sc_hd__buf_12$1
XFILLER_110_657 vssd1 vccd1 vccd1 vssd1 sky130_ef_sc_hd__decap_40_12$1
X_1291_ _1417_/C1 _1290_/X _1343_/A2 hold30/X _1674_/D vssd1 vccd1 vccd1 vssd1 sky130_fd_sc_hd__o211a_1$1
XFILLER_95_335 vccd1 vssd1 vccd1 vssd1 sky130_fd_sc_hd__fill_1$1
XFILLER_49_741 vssd1 vccd1 vccd1 vssd1 sky130_ef_sc_hd__decap_40_12$1
XFILLER_49_785 vssd1 vccd1 vccd1 vssd1 sky130_ef_sc_hd__decap_40_12$1
XFILLER_48_251 vccd1 vssd1 vccd1 vssd1 sky130_fd_sc_hd__fill_1$1
XFILLER_63_221 vssd1 vccd1 vccd1 vssd1 sky130_fd_sc_hd__fill_2$1
XFILLER_36_413 vssd1 vccd1 vccd1 vssd1 sky130_fd_sc_hd__fill_4$1
XFILLER_91_541 vssd1 vccd1 vccd1 vssd1 sky130_ef_sc_hd__decap_40_12$1
XFILLER_64_755 vccd1 vssd1 vccd1 vssd1 sky130_fd_sc_hd__fill_1$1
XFILLER_36_457 vssd1 vccd1 vccd1 vssd1 sky130_ef_sc_hd__decap_40_12$1
XFILLER_51_405 vssd1 vccd1 vccd1 vssd1 sky130_ef_sc_hd__decap_40_12$1
XFILLER_17_671 vccd1 vssd1 vccd1 vssd1 sky130_fd_sc_hd__fill_1$1
XFILLER_51_449 vssd1 vccd1 vccd1 vssd1 sky130_ef_sc_hd__decap_40_12$1
XFILLER_118_713 vssd1 vccd1 vccd1 vssd1 sky130_ef_sc_hd__decap_40_12$1
XFILLER_118_757 vssd1 vccd1 vccd1 vssd1 sky130_fd_sc_hd__fill_4$1
XFILLER_117_223 vccd1 vssd1 vccd1 vssd1 sky130_fd_sc_hd__fill_1$1
X_1627_ hold62/A _1752_/CLK _1627_/D vccd1 vssd1 vccd1 vssd1 sky130_fd_sc_hd__dfxtp_1$1
XFILLER_113_473 vssd1 vccd1 vccd1 vssd1 sky130_ef_sc_hd__decap_40_12$1
XFILLER_101_613 vssd1 vccd1 vccd1 vssd1 sky130_fd_sc_hd__fill_2$1
X_1558_ _1558_/Q clkload2/A _1558_/D vccd1 vssd1 vccd1 vssd1 sky130_fd_sc_hd__dfxtp_1$1
XFILLER_59_505 vssd1 vccd1 vccd1 vssd1 sky130_ef_sc_hd__decap_40_12$1
XFILLER_98_195 vccd1 vssd1 vccd1 vssd1 sky130_fd_sc_hd__fill_1$1
XFILLER_86_357 vssd1 vccd1 vccd1 vssd1 sky130_fd_sc_hd__fill_4$1
X_1489_ _1489_/Q _1740_/CLK _1489_/D vccd1 vssd1 vccd1 vssd1 sky130_fd_sc_hd__dfxtp_2$1
XTAP_TAPCELL_ROW_87_1612 vccd1 vssd1 sky130_fd_sc_hd__tapvpwrvgnd_1$1
XTAP_TAPCELL_ROW_87_1601 vccd1 vssd1 sky130_fd_sc_hd__tapvpwrvgnd_1$1
XFILLER_100_189 vssd1 vccd1 vccd1 vssd1 sky130_fd_sc_hd__fill_4$1
XFILLER_54_221 vssd1 vccd1 vccd1 vssd1 sky130_ef_sc_hd__decap_40_12$1
XFILLER_36_15 vssd1 vccd1 vccd1 vssd1 sky130_ef_sc_hd__decap_40_12$1
XFILLER_39_273 vssd1 vccd1 vccd1 vssd1 sky130_fd_sc_hd__fill_4$1
XFILLER_55_777 vssd1 vccd1 vccd1 vssd1 sky130_fd_sc_hd__fill_4$1
XFILLER_82_585 vssd1 vccd1 vccd1 vssd1 sky130_fd_sc_hd__fill_2$1
XFILLER_70_725 vssd1 vccd1 vccd1 vssd1 sky130_ef_sc_hd__decap_40_12$1
XFILLER_54_265 vssd1 vccd1 vccd1 vssd1 sky130_ef_sc_hd__decap_40_12$1
XFILLER_70_769 vssd1 vccd1 vccd1 vssd1 sky130_ef_sc_hd__decap_40_12$1
XFILLER_70_747 vssd1 vccd1 vccd1 vssd1 sky130_fd_sc_hd__fill_8$1
XFILLER_23_641 vssd1 vccd1 vccd1 vssd1 sky130_ef_sc_hd__decap_40_12$1
XFILLER_23_685 vssd1 vccd1 vccd1 vssd1 sky130_ef_sc_hd__decap_40_12$1
XTAP_TAPCELL_ROW_25_669 vccd1 vssd1 sky130_fd_sc_hd__tapvpwrvgnd_1$1
XFILLER_136_510 vssd1 vccd1 vccd1 vssd1 sky130_ef_sc_hd__decap_40_12$1
XFILLER_10_357 vssd1 vccd1 vccd1 vssd1 sky130_fd_sc_hd__fill_4$1
XFILLER_22_195 vccd1 vssd1 vccd1 vssd1 sky130_fd_sc_hd__fill_1$1
XTAP_TAPCELL_ROW_114_2008 vccd1 vssd1 sky130_fd_sc_hd__tapvpwrvgnd_1$1
XTAP_TAPCELL_ROW_98_1774 vccd1 vssd1 sky130_fd_sc_hd__tapvpwrvgnd_1$1
XTAP_TAPCELL_ROW_98_1763 vccd1 vssd1 sky130_fd_sc_hd__tapvpwrvgnd_1$1
XFILLER_108_245 vssd1 vccd1 vccd1 vssd1 sky130_fd_sc_hd__fill_4$1
XFILLER_136_587 vccd1 vssd1 vccd1 vssd1 sky130_fd_sc_hd__fill_1$1
XFILLER_108_289 vssd1 vccd1 vccd1 vssd1 sky130_ef_sc_hd__decap_40_12$1
XFILLER_2_501 vssd1 vccd1 vccd1 vssd1 sky130_ef_sc_hd__decap_40_12$1
XFILLER_123_237 vssd1 vccd1 vccd1 vssd1 sky130_ef_sc_hd__decap_40_12$1
XFILLER_117_51 vssd1 vccd1 vccd1 vssd1 sky130_fd_sc_hd__fill_4$1
XFILLER_7_3 vssd1 vccd1 vccd1 vssd1 sky130_ef_sc_hd__decap_40_12$1
XFILLER_2_545 vssd1 vccd1 vccd1 vssd1 sky130_ef_sc_hd__decap_40_12$1
XFILLER_78_825 vccd1 vssd1 vccd1 vssd1 sky130_fd_sc_hd__fill_1$1
XFILLER_77_55 vccd1 vssd1 vccd1 vssd1 sky130_fd_sc_hd__fill_1$1
XFILLER_2_589 vssd1 vccd1 vccd1 vssd1 sky130_ef_sc_hd__decap_40_12$1
XFILLER_131_281 vssd1 vccd1 vccd1 vssd1 sky130_ef_sc_hd__decap_40_12$1
XTAP_TAPCELL_ROW_129_2240 vccd1 vssd1 sky130_fd_sc_hd__tapvpwrvgnd_1$1
XFILLER_77_335 vccd1 vssd1 vccd1 vssd1 sky130_fd_sc_hd__fill_1$1
XFILLER_92_305 vssd1 vccd1 vccd1 vssd1 sky130_fd_sc_hd__fill_2$1
XTAP_TAPCELL_ROW_51_1070 vccd1 vssd1 sky130_fd_sc_hd__tapvpwrvgnd_1$1
XTAP_TAPCELL_ROW_5_372 vccd1 vssd1 sky130_fd_sc_hd__tapvpwrvgnd_1$1
XFILLER_18_413 vssd1 vccd1 vccd1 vssd1 sky130_fd_sc_hd__fill_4$1
XFILLER_46_722 vssd1 vccd1 vccd1 vssd1 sky130_ef_sc_hd__decap_40_12$1
XFILLER_18_457 vssd1 vccd1 vccd1 vssd1 sky130_ef_sc_hd__decap_40_12$1
XFILLER_45_221 vssd1 vccd1 vccd1 vssd1 sky130_fd_sc_hd__fill_2$1
Xclkbuf_leaf_42_wb_clk_i clkload5/A clkload0/A vssd1 vccd1 vccd1 vssd1 sky130_fd_sc_hd__clkbuf_8$1
XFILLER_33_405 vssd1 vccd1 vccd1 vssd1 sky130_ef_sc_hd__decap_40_12$1
XFILLER_14_641 vssd1 vccd1 vccd1 vssd1 sky130_fd_sc_hd__fill_2$1
XFILLER_26_81 vssd1 vccd1 vccd1 vssd1 sky130_fd_sc_hd__fill_2$1
XFILLER_33_449 vssd1 vccd1 vccd1 vssd1 sky130_ef_sc_hd__decap_40_12$1
XTAP_TAPCELL_ROW_44_956 vccd1 vssd1 sky130_fd_sc_hd__tapvpwrvgnd_1$1
XTAP_TAPCELL_ROW_44_967 vccd1 vssd1 sky130_fd_sc_hd__tapvpwrvgnd_1$1
XFILLER_9_111 vccd1 vssd1 vccd1 vssd1 sky130_fd_sc_hd__fill_1$1
X_0860_ _1526_/Q _0875_/A2 _0860_/X _1718_/Q _0878_/B1 vccd1 vssd1 vccd1 vssd1 sky130_fd_sc_hd__a22o_1$1
X_0791_ _0791_/X _0875_/B1 _1830_/A _1675_/Q _0878_/B1 vssd1 vccd1 _0790_/X vccd1
+ vssd1 sky130_fd_sc_hd__a221o_1$1
XFILLER_115_727 vccd1 vssd1 vccd1 vssd1 sky130_fd_sc_hd__fill_1$1
XFILLER_5_361 vssd1 vccd1 vccd1 vssd1 sky130_ef_sc_hd__decap_40_12$1
X_1412_ _1841_/A _1412_/X _1474_/B vssd1 vccd1 vccd1 vssd1 sky130_fd_sc_hd__or2_1$1
X_1343_ _1475_/C1 _1342_/X _1343_/A2 hold2/X hold19/A vssd1 vccd1 vccd1 vssd1 sky130_fd_sc_hd__o211a_1$1
X_1274_ _1667_/Q _1274_/X _1276_/B vssd1 vccd1 vccd1 vssd1 sky130_fd_sc_hd__or2_1$1
XFILLER_96_699 vccd1 vssd1 vccd1 vssd1 sky130_fd_sc_hd__fill_1$1
XFILLER_95_165 vssd1 vccd1 vccd1 vssd1 sky130_fd_sc_hd__fill_2$1
XFILLER_83_305 vssd1 vccd1 vccd1 vssd1 sky130_ef_sc_hd__decap_40_12$1
XFILLER_68_357 vssd1 vccd1 vccd1 vssd1 sky130_fd_sc_hd__fill_4$1
XFILLER_83_349 vssd1 vccd1 vccd1 vssd1 sky130_ef_sc_hd__decap_40_12$1
XTAP_TAPCELL_ROW_69_1331 vccd1 vssd1 sky130_fd_sc_hd__tapvpwrvgnd_1$1
XTAP_TAPCELL_ROW_69_1342 vccd1 vssd1 sky130_fd_sc_hd__tapvpwrvgnd_1$1
XFILLER_36_221 vssd1 vccd1 vccd1 vssd1 sky130_ef_sc_hd__decap_40_12$1
XFILLER_37_777 vssd1 vccd1 vccd1 vssd1 sky130_fd_sc_hd__fill_4$1
XFILLER_52_725 vssd1 vccd1 vccd1 vssd1 sky130_fd_sc_hd__fill_2$1
XFILLER_36_265 vssd1 vccd1 vccd1 vssd1 sky130_ef_sc_hd__decap_40_12$1
XFILLER_91_393 vssd1 vccd1 vccd1 vssd1 sky130_ef_sc_hd__decap_40_12$1
XTAP_TAPCELL_ROW_82_1531 vccd1 vssd1 sky130_fd_sc_hd__tapvpwrvgnd_1$1
XFILLER_52_747 vssd1 vccd1 vccd1 vssd1 sky130_fd_sc_hd__fill_8$1
XFILLER_52_769 vssd1 vccd1 vccd1 vssd1 sky130_ef_sc_hd__decap_40_12$1
XFILLER_51_279 vccd1 vssd1 vccd1 vssd1 sky130_fd_sc_hd__fill_1$1
XTAP_TAPCELL_ROW_22_628 vccd1 vssd1 sky130_fd_sc_hd__tapvpwrvgnd_1$1
XFILLER_137_307 vccd1 vssd1 vccd1 vssd1 sky130_fd_sc_hd__fill_1$1
XFILLER_138_39 vssd1 vccd1 vccd1 vssd1 sky130_fd_sc_hd__fill_4$1
X_0989_ _1455_/C1 _0988_/X _1013_/A2 hold120/X _1528_/D vssd1 vccd1 vccd1 vssd1 sky130_fd_sc_hd__o211a_1$1
XFILLER_20_699 vccd1 vssd1 vccd1 vssd1 sky130_fd_sc_hd__fill_1$1
XFILLER_118_587 vccd1 vssd1 vccd1 vssd1 sky130_fd_sc_hd__fill_1$1
XFILLER_105_237 vssd1 vccd1 vccd1 vssd1 sky130_ef_sc_hd__decap_40_12$1
XTAP_TAPCELL_ROW_93_1693 vccd1 vssd1 sky130_fd_sc_hd__tapvpwrvgnd_1$1
XFILLER_114_793 vssd1 vccd1 vccd1 vssd1 sky130_ef_sc_hd__decap_40_12$1
XFILLER_113_281 vssd1 vccd1 vccd1 vssd1 sky130_ef_sc_hd__decap_40_12$1
XFILLER_86_121 vssd1 vccd1 vccd1 vssd1 sky130_ef_sc_hd__decap_40_12$1
XFILLER_59_335 vccd1 vssd1 vccd1 vssd1 sky130_fd_sc_hd__fill_1$1
XFILLER_86_165 vssd1 vccd1 vccd1 vssd1 sky130_ef_sc_hd__decap_40_12$1
XFILLER_74_305 vssd1 vccd1 vccd1 vssd1 sky130_fd_sc_hd__fill_2$1
XFILLER_47_519 vssd1 vccd1 vccd1 vssd1 sky130_fd_sc_hd__fill_2$1
XPHY_EDGE_ROW_114_Right_114 vccd1 vssd1 vccd1 vssd1 sky130_fd_sc_hd__decap_3$1
XTAP_TAPCELL_ROW_2_331 vccd1 vssd1 sky130_fd_sc_hd__tapvpwrvgnd_1$1
XFILLER_47_69 vssd1 vccd1 vccd1 vssd1 sky130_ef_sc_hd__decap_40_12$1
XFILLER_27_221 vssd1 vccd1 vccd1 vssd1 sky130_fd_sc_hd__fill_2$1
XFILLER_28_744 vssd1 vccd1 vccd1 vssd1 sky130_ef_sc_hd__decap_40_12$1
XFILLER_55_585 vssd1 vccd1 vccd1 vssd1 sky130_fd_sc_hd__fill_2$1
XFILLER_15_405 vssd1 vccd1 vccd1 vssd1 sky130_ef_sc_hd__decap_40_12$1
XFILLER_70_533 vssd1 vccd1 vccd1 vssd1 sky130_ef_sc_hd__decap_40_12$1
XFILLER_63_57 vssd1 vccd1 vccd1 vssd1 sky130_ef_sc_hd__decap_40_12$1
XFILLER_55_596 vssd1 vccd1 vccd1 vssd1 sky130_ef_sc_hd__decap_40_12$1
XFILLER_15_449 vssd1 vccd1 vccd1 vssd1 sky130_ef_sc_hd__decap_40_12$1
XFILLER_30_419 vccd1 vssd1 vccd1 vssd1 sky130_fd_sc_hd__fill_1$1
XTAP_TAPCELL_ROW_41_915 vccd1 vssd1 sky130_fd_sc_hd__tapvpwrvgnd_1$1
XFILLER_128_307 vccd1 vssd1 vccd1 vssd1 sky130_fd_sc_hd__fill_1$1
XFILLER_10_121 vssd1 vccd1 vccd1 vssd1 sky130_ef_sc_hd__decap_40_12$1
XFILLER_7_615 vccd1 vssd1 vccd1 vssd1 sky130_fd_sc_hd__fill_1$1
XFILLER_137_841 vccd1 vssd1 vccd1 vssd1 sky130_fd_sc_hd__fill_1$1
XFILLER_10_165 vssd1 vccd1 vccd1 vssd1 sky130_ef_sc_hd__decap_40_12$1
XFILLER_109_598 vssd1 vccd1 vccd1 vssd1 sky130_fd_sc_hd__fill_2$1
XFILLER_12_83 vccd1 vssd1 vccd1 vssd1 sky130_fd_sc_hd__fill_1$1
XFILLER_3_821 vssd1 vccd1 vccd1 vssd1 sky130_ef_sc_hd__decap_40_12$1
XFILLER_128_83 vccd1 vssd1 vccd1 vssd1 sky130_fd_sc_hd__fill_1$1
XFILLER_88_65 vssd1 vccd1 vccd1 vssd1 sky130_ef_sc_hd__decap_40_12$1
XFILLER_78_633 vssd1 vccd1 vccd1 vssd1 sky130_fd_sc_hd__fill_8$1
XFILLER_77_165 vssd1 vccd1 vccd1 vssd1 sky130_fd_sc_hd__fill_2$1
XFILLER_65_305 vssd1 vccd1 vccd1 vssd1 sky130_ef_sc_hd__decap_40_12$1
XFILLER_120_785 vssd1 vccd1 vccd1 vssd1 sky130_ef_sc_hd__decap_40_12$1
XFILLER_78_699 vccd1 vssd1 vccd1 vssd1 sky130_fd_sc_hd__fill_1$1
XTAP_TAPCELL_ROW_109_1932 vccd1 vssd1 sky130_fd_sc_hd__tapvpwrvgnd_1$1
XFILLER_81_809 vssd1 vccd1 vccd1 vssd1 sky130_ef_sc_hd__decap_40_12$1
XFILLER_65_349 vssd1 vccd1 vccd1 vssd1 sky130_ef_sc_hd__decap_40_12$1
XFILLER_18_221 vssd1 vccd1 vccd1 vssd1 sky130_ef_sc_hd__decap_40_12$1
XFILLER_73_371 vccd1 vssd1 vccd1 vssd1 sky130_fd_sc_hd__fill_1$1
XFILLER_18_265 vssd1 vccd1 vccd1 vssd1 sky130_ef_sc_hd__decap_40_12$1
XFILLER_46_585 vssd1 vccd1 vccd1 vssd1 sky130_fd_sc_hd__fill_2$1
XFILLER_73_393 vccd1 vssd1 vccd1 vssd1 sky130_fd_sc_hd__fill_1$1
XTAP_TAPCELL_ROW_64_1261 vccd1 vssd1 sky130_fd_sc_hd__tapvpwrvgnd_1$1
XFILLER_33_279 vccd1 vssd1 vccd1 vssd1 sky130_fd_sc_hd__fill_1$1
X_0912_ _0912_/X _1015_/A _1631_/Q _1567_/Q _1147_/A vssd1 vccd1 _0911_/X vccd1 vssd1
+ sky130_fd_sc_hd__a221o_1$1
XFILLER_119_329 vssd1 vccd1 vccd1 vssd1 sky130_fd_sc_hd__fill_4$1
X_0843_ _0880_/A2 _1491_/D _0839_/X _1443_/C1 _1491_/Q _0842_/X vssd1 vccd1 vccd1
+ vssd1 sky130_fd_sc_hd__o221a_1$1
XFILLER_115_513 vssd1 vccd1 vccd1 vssd1 sky130_fd_sc_hd__fill_2$1
X_0774_ _1827_/A _0878_/B1 _0774_/X _1775_/A _0866_/B1 vccd1 vssd1 vccd1 vssd1 sky130_fd_sc_hd__a22o_1$1
XFILLER_6_681 vssd1 vccd1 vccd1 vssd1 sky130_ef_sc_hd__decap_40_12$1
XFILLER_88_419 vccd1 vssd1 vccd1 vssd1 sky130_fd_sc_hd__fill_1$1
XFILLER_123_590 vssd1 vccd1 vccd1 vssd1 sky130_ef_sc_hd__decap_40_12$1
XFILLER_69_644 vssd1 vccd1 vccd1 vssd1 sky130_ef_sc_hd__decap_40_12$1
XFILLER_68_121 vssd1 vccd1 vccd1 vssd1 sky130_ef_sc_hd__decap_40_12$1
X_1326_ hold35/X _1326_/X _1330_/B vssd1 vccd1 vccd1 vssd1 sky130_fd_sc_hd__or2_1$1
XFILLER_110_251 vccd1 vssd1 vccd1 vssd1 sky130_fd_sc_hd__fill_1$1
XFILLER_56_305 vssd1 vccd1 vccd1 vssd1 sky130_fd_sc_hd__fill_2$1
XFILLER_111_785 vccd1 vssd1 vccd1 vssd1 sky130_fd_sc_hd__fill_1$1
XFILLER_84_647 vccd1 vssd1 vccd1 vssd1 sky130_fd_sc_hd__fill_1$1
XFILLER_84_625 vssd1 vccd1 vccd1 vssd1 sky130_fd_sc_hd__fill_2$1
XFILLER_83_113 vssd1 vccd1 vccd1 vssd1 sky130_ef_sc_hd__decap_40_12$1
XFILLER_69_699 vssd1 vccd1 vccd1 vssd1 sky130_ef_sc_hd__decap_40_12$1
XFILLER_68_165 vssd1 vccd1 vccd1 vssd1 sky130_ef_sc_hd__decap_40_12$1
X_1257_ _1437_/C1 _1256_/X _1273_/A2 hold107/X _1658_/D vssd1 vccd1 vccd1 vssd1 sky130_fd_sc_hd__o211a_1$1
XTAP_TAPCELL_ROW_27_709 vccd1 vssd1 sky130_fd_sc_hd__tapvpwrvgnd_1$1
XFILLER_37_541 vssd1 vccd1 vccd1 vssd1 sky130_fd_sc_hd__fill_8$1
X_1188_ _1188_/A _1188_/X _1188_/B vssd1 vccd1 vccd1 vssd1 sky130_fd_sc_hd__or2_1$1
XFILLER_17_39 vssd1 vccd1 vccd1 vssd1 sky130_ef_sc_hd__decap_40_12$1
XFILLER_37_585 vssd1 vccd1 vccd1 vssd1 sky130_ef_sc_hd__decap_40_12$1
XFILLER_52_533 vssd1 vccd1 vccd1 vssd1 sky130_ef_sc_hd__decap_40_12$1
XFILLER_12_419 vccd1 vssd1 vccd1 vssd1 sky130_fd_sc_hd__fill_1$1
XFILLER_33_27 vssd1 vccd1 vccd1 vssd1 sky130_ef_sc_hd__decap_40_12$1
XFILLER_33_791 vssd1 vccd1 vccd1 vssd1 sky130_fd_sc_hd__fill_4$1
XFILLER_119_841 vccd1 vssd1 vccd1 vssd1 sky130_fd_sc_hd__fill_1$1
XTAP_TAPCELL_ROW_95_1722 vccd1 vssd1 sky130_fd_sc_hd__tapvpwrvgnd_1$1
XFILLER_106_513 vssd1 vccd1 vccd1 vssd1 sky130_fd_sc_hd__fill_4$1
XFILLER_106_557 vssd1 vccd1 vccd1 vssd1 sky130_ef_sc_hd__decap_40_12$1
XFILLER_133_365 vccd1 vssd1 vccd1 vssd1 sky130_fd_sc_hd__fill_1$1
XFILLER_121_505 vssd1 vccd1 vccd1 vssd1 sky130_fd_sc_hd__fill_2$1
XTAP_TAPCELL_ROW_7_412 vccd1 vssd1 sky130_fd_sc_hd__tapvpwrvgnd_1$1
XTAP_TAPCELL_ROW_7_401 vccd1 vssd1 sky130_fd_sc_hd__tapvpwrvgnd_1$1
XFILLER_0_813 vssd1 vccd1 vccd1 vssd1 sky130_fd_sc_hd__fill_4$1
XFILLER_0_835 vssd1 vccd1 vccd1 vssd1 sky130_fd_sc_hd__fill_4$1
XFILLER_114_41 vssd1 vccd1 vccd1 vssd1 sky130_ef_sc_hd__decap_40_12$1
XFILLER_101_273 vssd1 vccd1 vccd1 vssd1 sky130_fd_sc_hd__fill_4$1
XFILLER_59_165 vssd1 vccd1 vccd1 vssd1 sky130_fd_sc_hd__fill_2$1
XFILLER_47_305 vssd1 vccd1 vccd1 vssd1 sky130_ef_sc_hd__decap_40_12$1
XFILLER_114_85 vssd1 vccd1 vccd1 vssd1 sky130_ef_sc_hd__decap_40_12$1
XFILLER_47_349 vssd1 vccd1 vccd1 vssd1 sky130_ef_sc_hd__decap_40_12$1
XTAP_TAPCELL_ROW_122_2129 vccd1 vssd1 sky130_fd_sc_hd__tapvpwrvgnd_1$1
XFILLER_16_725 vssd1 vccd1 vccd1 vssd1 sky130_fd_sc_hd__fill_2$1
XFILLER_28_585 vssd1 vccd1 vccd1 vssd1 sky130_fd_sc_hd__fill_2$1
XTAP_TAPCELL_ROW_104_1862 vccd1 vssd1 sky130_fd_sc_hd__tapvpwrvgnd_1$1
XFILLER_70_363 vccd1 vssd1 vccd1 vssd1 sky130_fd_sc_hd__fill_1$1
XFILLER_16_769 vssd1 vccd1 vccd1 vssd1 sky130_ef_sc_hd__decap_40_12$1
XFILLER_15_279 vccd1 vssd1 vccd1 vssd1 sky130_fd_sc_hd__fill_1$1
XFILLER_90_77 vssd1 vccd1 vccd1 vssd1 sky130_fd_sc_hd__fill_4$1
XFILLER_11_441 vssd1 vccd1 vccd1 vssd1 sky130_fd_sc_hd__fill_4$1
XFILLER_30_249 vssd1 vccd1 vccd1 vssd1 sky130_fd_sc_hd__fill_2$1
XTAP_TAPCELL_ROW_137_2361 vccd1 vssd1 sky130_fd_sc_hd__tapvpwrvgnd_1$1
XTAP_TAPCELL_ROW_137_2350 vccd1 vssd1 sky130_fd_sc_hd__tapvpwrvgnd_1$1
XFILLER_128_137 vssd1 vccd1 vccd1 vssd1 sky130_fd_sc_hd__fill_2$1
XFILLER_11_485 vssd1 vccd1 vccd1 vssd1 sky130_ef_sc_hd__decap_40_12$1
XFILLER_7_445 vssd1 vccd1 vccd1 vssd1 sky130_fd_sc_hd__fill_2$1
XFILLER_23_93 vssd1 vccd1 vccd1 vssd1 sky130_ef_sc_hd__decap_40_12$1
XFILLER_109_373 vssd1 vccd1 vccd1 vssd1 sky130_ef_sc_hd__decap_40_12$1
XFILLER_124_321 vssd1 vccd1 vccd1 vssd1 sky130_ef_sc_hd__decap_40_12$1
XFILLER_124_365 vssd1 vccd1 vccd1 vssd1 sky130_ef_sc_hd__decap_40_12$1
XFILLER_97_205 vssd1 vccd1 vccd1 vssd1 sky130_ef_sc_hd__decap_40_12$1
XFILLER_3_673 vssd1 vccd1 vccd1 vssd1 sky130_ef_sc_hd__decap_40_12$1
XFILLER_97_249 vssd1 vccd1 vccd1 vssd1 sky130_ef_sc_hd__decap_40_12$1
XFILLER_78_441 vssd1 vccd1 vccd1 vssd1 sky130_ef_sc_hd__decap_40_12$1
XFILLER_93_411 vssd1 vccd1 vccd1 vssd1 sky130_ef_sc_hd__decap_40_12$1
XFILLER_78_485 vssd1 vccd1 vccd1 vssd1 sky130_fd_sc_hd__fill_2$1
XFILLER_65_113 vssd1 vccd1 vccd1 vssd1 sky130_ef_sc_hd__decap_40_12$1
XFILLER_38_305 vssd1 vccd1 vccd1 vssd1 sky130_fd_sc_hd__fill_2$1
XFILLER_39_839 vccd1 vssd1 vccd1 vssd1 sky130_fd_sc_hd__fill_1$1
X_1111_ _1441_/C1 _1110_/X _1145_/A2 hold172/X _1587_/D vssd1 vccd1 vccd1 vssd1 sky130_fd_sc_hd__o211a_1$1
XFILLER_81_606 vssd1 vccd1 vccd1 vssd1 sky130_fd_sc_hd__fill_2$1
XFILLER_66_647 vccd1 vssd1 vccd1 vssd1 sky130_fd_sc_hd__fill_1$1
XFILLER_19_541 vssd1 vccd1 vccd1 vssd1 sky130_ef_sc_hd__decap_40_12$1
X_1042_ _1042_/A _1042_/X _1052_/B vssd1 vccd1 vccd1 vssd1 sky130_fd_sc_hd__or2_1$1
XFILLER_19_585 vssd1 vccd1 vccd1 vssd1 sky130_ef_sc_hd__decap_40_12$1
XFILLER_34_533 vssd1 vccd1 vccd1 vssd1 sky130_ef_sc_hd__decap_40_12$1
XFILLER_0_97 vssd1 vccd1 vccd1 vssd1 sky130_ef_sc_hd__decap_40_12$1
XFILLER_61_385 vssd1 vccd1 vccd1 vssd1 sky130_fd_sc_hd__fill_4$1
XFILLER_21_205 vssd1 vccd1 vccd1 vssd1 sky130_ef_sc_hd__decap_40_12$1
XFILLER_22_739 vccd1 vssd1 vccd1 vssd1 sky130_fd_sc_hd__fill_1$1
XFILLER_9_51 vssd1 vccd1 vccd1 vssd1 sky130_fd_sc_hd__fill_4$1
XFILLER_21_249 vssd1 vccd1 vccd1 vssd1 sky130_ef_sc_hd__decap_40_12$1
XTAP_TAPCELL_ROW_32_778 vccd1 vssd1 sky130_fd_sc_hd__tapvpwrvgnd_1$1
XFILLER_119_137 vssd1 vccd1 vccd1 vssd1 sky130_ef_sc_hd__decap_40_12$1
XTAP_TAPCELL_ROW_12_480 vccd1 vssd1 sky130_fd_sc_hd__tapvpwrvgnd_1$1
X_0826_ _1803_/A hold10/A _0826_/X input13/X _0826_/B1 vccd1 vssd1 vccd1 vssd1 sky130_fd_sc_hd__a22o_1$1
XFILLER_127_181 vssd1 vccd1 vccd1 vssd1 sky130_ef_sc_hd__decap_40_12$1
XTAP_TAPCELL_ROW_77_1452 vccd1 vssd1 sky130_fd_sc_hd__tapvpwrvgnd_1$1
X_0757_ _1837_/A _0875_/B1 _0758_/D _1772_/A _0866_/B1 vccd1 vssd1 vccd1 vssd1 sky130_fd_sc_hd__a22o_1$1
XFILLER_131_814 vssd1 vccd1 vccd1 vssd1 sky130_fd_sc_hd__fill_2$1
XFILLER_0_109 vssd1 vccd1 vccd1 vssd1 sky130_fd_sc_hd__fill_2$1
XFILLER_103_549 vssd1 vccd1 vccd1 vssd1 sky130_fd_sc_hd__fill_8$1
XTAP_TAPCELL_ROW_90_1652 vccd1 vssd1 sky130_fd_sc_hd__tapvpwrvgnd_1$1
XFILLER_88_249 vssd1 vccd1 vccd1 vssd1 sky130_fd_sc_hd__fill_2$1
XFILLER_130_357 vssd1 vccd1 vccd1 vssd1 sky130_fd_sc_hd__fill_4$1
XFILLER_69_474 vssd1 vccd1 vccd1 vssd1 sky130_ef_sc_hd__decap_40_12$1
XFILLER_28_27 vccd1 vssd1 vccd1 vssd1 sky130_fd_sc_hd__fill_1$1
XFILLER_29_305 vssd1 vccd1 vccd1 vssd1 sky130_ef_sc_hd__decap_40_12$1
X_1309_ _1443_/C1 _1308_/X _1331_/A2 hold172/X _1683_/D vssd1 vccd1 vccd1 vssd1 sky130_fd_sc_hd__o211a_1$1
XFILLER_57_669 vssd1 vccd1 vccd1 vssd1 sky130_fd_sc_hd__fill_2$1
XFILLER_29_349 vssd1 vccd1 vccd1 vssd1 sky130_ef_sc_hd__decap_40_12$1
XFILLER_84_477 vssd1 vccd1 vccd1 vssd1 sky130_fd_sc_hd__fill_4$1
XFILLER_72_606 vssd1 vccd1 vccd1 vssd1 sky130_ef_sc_hd__decap_40_12$1
XFILLER_71_105 vssd1 vccd1 vccd1 vssd1 sky130_fd_sc_hd__fill_4$1
XFILLER_71_149 vssd1 vccd1 vccd1 vssd1 sky130_ef_sc_hd__decap_40_12$1
XFILLER_37_393 vssd1 vccd1 vccd1 vssd1 sky130_ef_sc_hd__decap_40_12$1
XFILLER_44_15 vssd1 vccd1 vccd1 vssd1 sky130_ef_sc_hd__decap_40_12$1
XFILLER_52_363 vccd1 vssd1 vccd1 vssd1 sky130_fd_sc_hd__fill_1$1
XFILLER_40_525 vssd1 vccd1 vccd1 vssd1 sky130_fd_sc_hd__fill_4$1
XFILLER_8_209 vssd1 vccd1 vccd1 vssd1 sky130_ef_sc_hd__decap_40_12$1
XFILLER_12_249 vssd1 vccd1 vccd1 vssd1 sky130_fd_sc_hd__fill_2$1
XFILLER_100_65 vssd1 vccd1 vccd1 vssd1 sky130_ef_sc_hd__decap_40_12$1
XFILLER_21_783 vccd1 vssd1 vccd1 vssd1 sky130_fd_sc_hd__fill_1$1
XFILLER_126_608 vccd1 vssd1 vccd1 vssd1 sky130_fd_sc_hd__fill_1$1
XTAP_TAPCELL_ROW_119_2080 vccd1 vssd1 sky130_fd_sc_hd__tapvpwrvgnd_1$1
XTAP_TAPCELL_ROW_119_2091 vccd1 vssd1 sky130_fd_sc_hd__tapvpwrvgnd_1$1
XFILLER_119_671 vccd1 vssd1 vccd1 vssd1 sky130_fd_sc_hd__fill_1$1
XFILLER_134_630 vccd1 vssd1 vccd1 vssd1 sky130_fd_sc_hd__fill_1$1
XFILLER_107_3 vssd1 vccd1 vccd1 vssd1 sky130_ef_sc_hd__decap_40_12$1
XFILLER_106_321 vssd1 vccd1 vccd1 vssd1 sky130_ef_sc_hd__decap_40_12$1
XFILLER_134_685 vssd1 vccd1 vccd1 vssd1 sky130_fd_sc_hd__fill_2$1
XTAP_TAPCELL_ROW_132_2280 vccd1 vssd1 sky130_fd_sc_hd__tapvpwrvgnd_1$1
XFILLER_122_825 vccd1 vssd1 vccd1 vssd1 sky130_fd_sc_hd__fill_1$1
XFILLER_106_365 vssd1 vccd1 vccd1 vssd1 sky130_ef_sc_hd__decap_40_12$1
XFILLER_79_205 vssd1 vccd1 vccd1 vssd1 sky130_ef_sc_hd__decap_40_12$1
XFILLER_121_335 vccd1 vssd1 vccd1 vssd1 sky130_fd_sc_hd__fill_1$1
XFILLER_79_249 vssd1 vccd1 vccd1 vssd1 sky130_ef_sc_hd__decap_40_12$1
XFILLER_125_51 vssd1 vccd1 vccd1 vssd1 sky130_fd_sc_hd__fill_4$1
XFILLER_95_709 vssd1 vccd1 vccd1 vssd1 sky130_fd_sc_hd__fill_4$1
XFILLER_88_761 vssd1 vccd1 vccd1 vssd1 sky130_ef_sc_hd__decap_40_12$1
XFILLER_0_643 vccd1 vssd1 vccd1 vssd1 sky130_fd_sc_hd__fill_1$1
XFILLER_0_698 vssd1 vccd1 vccd1 vssd1 sky130_fd_sc_hd__fill_2$1
XFILLER_47_113 vssd1 vccd1 vccd1 vssd1 sky130_ef_sc_hd__decap_40_12$1
XFILLER_48_614 vssd1 vccd1 vccd1 vssd1 sky130_fd_sc_hd__fill_2$1
XFILLER_87_293 vssd1 vccd1 vccd1 vssd1 sky130_ef_sc_hd__decap_40_12$1
XFILLER_85_55 vccd1 vssd1 vccd1 vssd1 sky130_fd_sc_hd__fill_1$1
XFILLER_48_669 vssd1 vccd1 vccd1 vssd1 sky130_ef_sc_hd__decap_40_12$1
XFILLER_16_533 vssd1 vccd1 vccd1 vssd1 sky130_ef_sc_hd__decap_40_12$1
XTAP_TAPCELL_ROW_48_1020 vccd1 vssd1 sky130_fd_sc_hd__tapvpwrvgnd_1$1
XFILLER_90_469 vssd1 vccd1 vccd1 vssd1 sky130_fd_sc_hd__fill_4$1
XFILLER_71_650 vssd1 vccd1 vccd1 vssd1 sky130_ef_sc_hd__decap_40_12$1
XFILLER_31_503 vccd1 vssd1 vccd1 vssd1 sky130_fd_sc_hd__fill_1$1
XFILLER_43_385 vssd1 vccd1 vccd1 vssd1 sky130_fd_sc_hd__fill_4$1
XFILLER_70_193 vssd1 vccd1 vccd1 vssd1 sky130_fd_sc_hd__fill_2$1
XTAP_TAPCELL_ROW_61_1220 vccd1 vssd1 sky130_fd_sc_hd__tapvpwrvgnd_1$1
XFILLER_34_81 vssd1 vccd1 vccd1 vssd1 sky130_fd_sc_hd__fill_2$1
XFILLER_11_293 vssd1 vccd1 vccd1 vssd1 sky130_ef_sc_hd__decap_40_12$1
X_1660_ _1660_/Q _1752_/CLK _1660_/D vccd1 vssd1 vccd1 vssd1 sky130_fd_sc_hd__dfxtp_2$1
Xhold209 wbs_dat_i[11] input22/A vssd1 vccd1 vccd1 vssd1 sky130_fd_sc_hd__dlygate4sd3_1$1
XFILLER_125_641 vssd1 vccd1 vccd1 vssd1 sky130_fd_sc_hd__fill_2$1
XFILLER_109_181 vssd1 vccd1 vccd1 vssd1 sky130_ef_sc_hd__decap_40_12$1
X_1591_ _1809_/A _1716_/CLK _1591_/D vccd1 vssd1 vccd1 vssd1 sky130_fd_sc_hd__dfxtp_1$1
XTAP_TAPCELL_ROW_59_1182 vccd1 vssd1 sky130_fd_sc_hd__tapvpwrvgnd_1$1
XFILLER_98_525 vssd1 vccd1 vccd1 vssd1 sky130_fd_sc_hd__fill_4$1
XFILLER_124_195 vccd1 vssd1 vccd1 vssd1 sky130_fd_sc_hd__fill_1$1
XFILLER_112_357 vssd1 vccd1 vccd1 vssd1 sky130_fd_sc_hd__fill_4$1
XFILLER_79_783 vccd1 vssd1 vccd1 vssd1 sky130_fd_sc_hd__fill_1$1
XTAP_TAPCELL_ROW_72_1382 vccd1 vssd1 sky130_fd_sc_hd__tapvpwrvgnd_1$1
XPHY_EDGE_ROW_0_Left_139 vccd1 vssd1 vccd1 vssd1 sky130_fd_sc_hd__decap_3$1
XFILLER_22_3 vssd1 vccd1 vccd1 vssd1 sky130_ef_sc_hd__decap_40_12$1
XFILLER_66_433 vssd1 vccd1 vccd1 vssd1 sky130_ef_sc_hd__decap_40_12$1
XFILLER_27_809 vssd1 vccd1 vccd1 vssd1 sky130_ef_sc_hd__decap_40_12$1
XFILLER_66_477 vssd1 vccd1 vccd1 vssd1 sky130_fd_sc_hd__fill_4$1
XFILLER_54_606 vssd1 vccd1 vccd1 vssd1 sky130_ef_sc_hd__decap_40_12$1
XFILLER_53_105 vssd1 vccd1 vccd1 vssd1 sky130_fd_sc_hd__fill_4$1
XFILLER_19_393 vssd1 vccd1 vccd1 vssd1 sky130_ef_sc_hd__decap_40_12$1
XTAP_TAPCELL_ROW_37_848 vccd1 vssd1 sky130_fd_sc_hd__tapvpwrvgnd_1$1
XFILLER_53_149 vssd1 vccd1 vccd1 vssd1 sky130_ef_sc_hd__decap_40_12$1
X_1025_ _1091_/C1 _1024_/X _1053_/A2 hold61/X _1545_/D vssd1 vccd1 vccd1 vssd1 sky130_fd_sc_hd__o211a_1$1
XTAP_TAPCELL_ROW_37_859 vccd1 vssd1 sky130_fd_sc_hd__tapvpwrvgnd_1$1
XTAP_TAPCELL_ROW_17_550 vccd1 vssd1 sky130_fd_sc_hd__tapvpwrvgnd_1$1
XTAP_TAPCELL_ROW_17_561 vccd1 vssd1 sky130_fd_sc_hd__tapvpwrvgnd_1$1
XFILLER_22_525 vssd1 vccd1 vccd1 vssd1 sky130_fd_sc_hd__fill_4$1
XFILLER_34_363 vccd1 vssd1 vccd1 vssd1 sky130_fd_sc_hd__fill_1$1
XFILLER_61_193 vssd1 vccd1 vccd1 vssd1 sky130_ef_sc_hd__decap_40_12$1
XFILLER_14_29 vssd1 vccd1 vccd1 vssd1 sky130_ef_sc_hd__decap_40_12$1
XFILLER_22_569 vssd1 vccd1 vccd1 vssd1 sky130_ef_sc_hd__decap_40_12$1
XFILLER_108_608 vssd1 vccd1 vccd1 vssd1 sky130_fd_sc_hd__fill_2$1
XFILLER_135_427 vssd1 vccd1 vccd1 vssd1 sky130_fd_sc_hd__fill_2$1
XFILLER_135_449 vccd1 vssd1 vccd1 vssd1 sky130_fd_sc_hd__fill_1$1
XFILLER_116_641 vssd1 vccd1 vccd1 vssd1 sky130_fd_sc_hd__fill_2$1
X_0809_ _0809_/X _0906_/B1 _1800_/A _1646_/Q _0879_/A2 vssd1 vccd1 _0808_/X vccd1
+ vssd1 sky130_fd_sc_hd__a221o_1$1
XFILLER_89_503 vccd1 vssd1 vccd1 vssd1 sky130_fd_sc_hd__fill_1$1
X_1789_ vccd1 vssd1 _1789_/X _1789_/A vccd1 vssd1 sky130_fd_sc_hd__buf_1$1
XFILLER_104_825 vccd1 vssd1 vccd1 vssd1 sky130_fd_sc_hd__fill_1$1
XFILLER_1_429 vssd1 vccd1 vccd1 vssd1 sky130_ef_sc_hd__decap_40_12$1
XFILLER_39_15 vssd1 vccd1 vccd1 vssd1 sky130_ef_sc_hd__decap_40_12$1
XFILLER_130_121 vssd1 vccd1 vccd1 vssd1 sky130_ef_sc_hd__decap_40_12$1
XFILLER_103_335 vccd1 vssd1 vccd1 vssd1 sky130_fd_sc_hd__fill_1$1
XFILLER_77_709 vssd1 vccd1 vccd1 vssd1 sky130_ef_sc_hd__decap_40_12$1
XFILLER_130_165 vssd1 vccd1 vccd1 vssd1 sky130_ef_sc_hd__decap_40_12$1
XFILLER_97_580 vssd1 vccd1 vccd1 vssd1 sky130_ef_sc_hd__decap_40_12$1
XFILLER_111_390 vssd1 vccd1 vccd1 vssd1 sky130_fd_sc_hd__fill_2$1
XFILLER_69_293 vssd1 vccd1 vccd1 vssd1 sky130_ef_sc_hd__decap_40_12$1
XFILLER_18_809 vssd1 vccd1 vccd1 vssd1 sky130_fd_sc_hd__fill_2$1
XFILLER_29_113 vssd1 vccd1 vccd1 vssd1 sky130_ef_sc_hd__decap_40_12$1
XFILLER_85_797 vssd1 vccd1 vccd1 vssd1 sky130_fd_sc_hd__fill_2$1
XFILLER_57_477 vssd1 vccd1 vccd1 vssd1 sky130_fd_sc_hd__fill_4$1
XFILLER_45_617 vssd1 vccd1 vccd1 vssd1 sky130_ef_sc_hd__decap_40_12$1
XFILLER_55_69 vssd1 vccd1 vccd1 vssd1 sky130_ef_sc_hd__decap_40_12$1
XFILLER_72_469 vssd1 vccd1 vccd1 vssd1 sky130_fd_sc_hd__fill_4$1
XFILLER_53_661 vssd1 vccd1 vccd1 vssd1 sky130_fd_sc_hd__fill_2$1
XFILLER_13_503 vccd1 vssd1 vccd1 vssd1 sky130_fd_sc_hd__fill_1$1
XFILLER_25_385 vssd1 vccd1 vccd1 vssd1 sky130_fd_sc_hd__fill_4$1
XTAP_TAPCELL_ROW_101_1821 vccd1 vssd1 sky130_fd_sc_hd__tapvpwrvgnd_1$1
XTAP_TAPCELL_ROW_101_1810 vccd1 vssd1 sky130_fd_sc_hd__tapvpwrvgnd_1$1
XFILLER_52_193 vssd1 vccd1 vccd1 vssd1 sky130_fd_sc_hd__fill_2$1
XFILLER_40_333 vssd1 vccd1 vccd1 vssd1 sky130_ef_sc_hd__decap_40_12$1
XFILLER_71_57 vssd1 vccd1 vccd1 vssd1 sky130_ef_sc_hd__decap_40_12$1
XFILLER_9_529 vssd1 vccd1 vccd1 vssd1 sky130_ef_sc_hd__decap_40_12$1
XFILLER_40_377 vssd1 vccd1 vccd1 vssd1 sky130_ef_sc_hd__decap_40_12$1
XFILLER_107_641 vssd1 vccd1 vccd1 vssd1 sky130_ef_sc_hd__decap_40_12$1
XFILLER_4_245 vssd1 vccd1 vccd1 vssd1 sky130_fd_sc_hd__fill_4$1
XFILLER_107_685 vssd1 vccd1 vccd1 vssd1 sky130_ef_sc_hd__decap_40_12$1
XFILLER_4_289 vssd1 vccd1 vccd1 vssd1 sky130_ef_sc_hd__decap_40_12$1
XFILLER_20_83 vccd1 vssd1 vccd1 vssd1 sky130_fd_sc_hd__fill_1$1
XFILLER_136_83 vccd1 vssd1 vccd1 vssd1 sky130_fd_sc_hd__fill_1$1
XFILLER_106_195 vccd1 vssd1 vccd1 vssd1 sky130_fd_sc_hd__fill_1$1
XFILLER_122_699 vccd1 vssd1 vccd1 vssd1 sky130_fd_sc_hd__fill_1$1
XFILLER_121_165 vssd1 vccd1 vccd1 vssd1 sky130_fd_sc_hd__fill_2$1
XTAP_TAPCELL_ROW_112_1983 vccd1 vssd1 sky130_fd_sc_hd__tapvpwrvgnd_1$1
XFILLER_96_65 vssd1 vccd1 vccd1 vssd1 sky130_ef_sc_hd__decap_40_12$1
XFILLER_95_517 vssd1 vccd1 vccd1 vssd1 sky130_fd_sc_hd__fill_2$1
XFILLER_0_473 vssd1 vccd1 vccd1 vssd1 sky130_fd_sc_hd__fill_2$1
XFILLER_76_753 vssd1 vccd1 vccd1 vssd1 sky130_fd_sc_hd__fill_2$1
XFILLER_48_433 vssd1 vccd1 vccd1 vssd1 sky130_fd_sc_hd__fill_2$1
Xhold70 wbs_dat_i[2] hold70/X vssd1 vccd1 vccd1 vssd1 sky130_fd_sc_hd__dlygate4sd3_1$1
Xhold81 hold81/A hold81/X vssd1 vccd1 vccd1 vssd1 sky130_fd_sc_hd__dlygate4sd3_1$1
Xhold92 hold92/A hold92/X vssd1 vccd1 vccd1 vssd1 sky130_fd_sc_hd__dlygate4sd3_1$1
XFILLER_29_81 vssd1 vccd1 vccd1 vssd1 sky130_ef_sc_hd__decap_40_12$1
XFILLER_36_617 vccd1 vssd1 vccd1 vssd1 sky130_fd_sc_hd__fill_1$1
XFILLER_48_477 vssd1 vccd1 vccd1 vssd1 sky130_ef_sc_hd__decap_40_12$1
XFILLER_91_745 vssd1 vccd1 vccd1 vssd1 sky130_ef_sc_hd__decap_40_12$1
XFILLER_63_436 vccd1 vssd1 vccd1 vssd1 sky130_fd_sc_hd__fill_1$1
XFILLER_35_105 vssd1 vccd1 vccd1 vssd1 sky130_fd_sc_hd__fill_4$1
XFILLER_90_233 vssd1 vccd1 vccd1 vssd1 sky130_ef_sc_hd__decap_40_12$1
XTAP_TAPCELL_ROW_34_807 vccd1 vssd1 sky130_fd_sc_hd__tapvpwrvgnd_1$1
XFILLER_35_149 vssd1 vccd1 vccd1 vssd1 sky130_ef_sc_hd__decap_40_12$1
XFILLER_90_277 vssd1 vccd1 vccd1 vssd1 sky130_ef_sc_hd__decap_40_12$1
XFILLER_16_363 vccd1 vssd1 vccd1 vssd1 sky130_fd_sc_hd__fill_1$1
XFILLER_44_694 vssd1 vccd1 vccd1 vssd1 sky130_fd_sc_hd__fill_4$1
XFILLER_71_480 vssd1 vccd1 vccd1 vssd1 sky130_ef_sc_hd__decap_40_12$1
XFILLER_31_333 vssd1 vccd1 vccd1 vssd1 sky130_fd_sc_hd__fill_2$1
XFILLER_43_193 vssd1 vccd1 vccd1 vssd1 sky130_ef_sc_hd__decap_40_12$1
XFILLER_129_221 vssd1 vccd1 vccd1 vssd1 sky130_fd_sc_hd__fill_2$1
XFILLER_129_254 vssd1 vccd1 vccd1 vssd1 sky130_ef_sc_hd__decap_40_12$1
X_1712_ _1712_/Q clkload6/A _1712_/D vccd1 vssd1 vccd1 vssd1 sky130_fd_sc_hd__dfxtp_1$1
XFILLER_117_449 vssd1 vccd1 vccd1 vssd1 sky130_fd_sc_hd__fill_4$1
XANTENNA_1 _1422_/B vssd1 vccd1 vccd1 vssd1 sky130_fd_sc_hd__diode_2$1
X_1643_ _1643_/Q clkload9/A _1643_/D vccd1 vssd1 vccd1 vssd1 sky130_fd_sc_hd__dfxtp_2$1
XFILLER_6_41 vssd1 vccd1 vccd1 vssd1 sky130_ef_sc_hd__decap_40_12$1
XFILLER_132_419 vccd1 vssd1 vccd1 vssd1 sky130_fd_sc_hd__fill_1$1
XFILLER_99_801 vssd1 vccd1 vccd1 vssd1 sky130_fd_sc_hd__fill_4$1
XTAP_TAPCELL_ROW_74_1411 vccd1 vssd1 sky130_fd_sc_hd__tapvpwrvgnd_1$1
XFILLER_6_85 vssd1 vccd1 vccd1 vssd1 sky130_ef_sc_hd__decap_40_12$1
X_1574_ _1788_/A _1579_/CLK _1574_/D vccd1 vssd1 vccd1 vssd1 sky130_fd_sc_hd__dfxtp_1$1
XFILLER_112_121 vssd1 vccd1 vccd1 vssd1 sky130_ef_sc_hd__decap_40_12$1
XFILLER_98_333 vssd1 vccd1 vccd1 vssd1 sky130_ef_sc_hd__decap_40_12$1
XFILLER_112_165 vssd1 vccd1 vccd1 vssd1 sky130_ef_sc_hd__decap_40_12$1
XFILLER_100_305 vssd1 vccd1 vccd1 vssd1 sky130_fd_sc_hd__fill_2$1
XFILLER_98_377 vssd1 vccd1 vccd1 vssd1 sky130_fd_sc_hd__fill_2$1
XFILLER_82_701 vssd1 vccd1 vccd1 vssd1 sky130_fd_sc_hd__fill_4$1
XFILLER_27_617 vssd1 vccd1 vccd1 vssd1 sky130_ef_sc_hd__decap_40_12$1
XFILLER_67_797 vssd1 vccd1 vccd1 vssd1 sky130_fd_sc_hd__fill_8$1
XFILLER_82_789 vssd1 vccd1 vccd1 vssd1 sky130_fd_sc_hd__fill_2$1
XFILLER_54_458 vssd1 vccd1 vccd1 vssd1 sky130_ef_sc_hd__decap_40_12$1
X_1008_ _1008_/A _1008_/X _1012_/B vssd1 vccd1 vccd1 vssd1 sky130_fd_sc_hd__or2_1$1
XTAP_TAPCELL_ROW_85_1573 vccd1 vssd1 sky130_fd_sc_hd__tapvpwrvgnd_1$1
XFILLER_81_277 vssd1 vccd1 vccd1 vssd1 sky130_fd_sc_hd__fill_2$1
XFILLER_25_39 vssd1 vccd1 vccd1 vssd1 sky130_ef_sc_hd__decap_40_12$1
XFILLER_50_642 vssd1 vccd1 vccd1 vssd1 sky130_fd_sc_hd__fill_2$1
XFILLER_22_333 vssd1 vccd1 vccd1 vssd1 sky130_ef_sc_hd__decap_40_12$1
XFILLER_34_193 vssd1 vccd1 vccd1 vssd1 sky130_fd_sc_hd__fill_2$1
XFILLER_22_377 vssd1 vccd1 vccd1 vssd1 sky130_ef_sc_hd__decap_40_12$1
XFILLER_50_697 vssd1 vccd1 vccd1 vssd1 sky130_fd_sc_hd__fill_2$1
XFILLER_41_27 vssd1 vccd1 vccd1 vssd1 sky130_ef_sc_hd__decap_40_12$1
XFILLER_136_725 vssd1 vccd1 vccd1 vssd1 sky130_ef_sc_hd__decap_40_12$1
XFILLER_136_769 vssd1 vccd1 vccd1 vssd1 sky130_ef_sc_hd__decap_40_12$1
XFILLER_135_279 vccd1 vssd1 vccd1 vssd1 sky130_fd_sc_hd__fill_1$1
XFILLER_123_419 vssd1 vccd1 vccd1 vssd1 sky130_ef_sc_hd__decap_40_12$1
XFILLER_2_749 vssd1 vccd1 vccd1 vssd1 sky130_fd_sc_hd__fill_4$1
XFILLER_89_333 vssd1 vccd1 vccd1 vssd1 sky130_fd_sc_hd__fill_2$1
XFILLER_1_237 vssd1 vccd1 vccd1 vssd1 sky130_ef_sc_hd__decap_40_12$1
XFILLER_106_53 vssd1 vccd1 vccd1 vssd1 sky130_ef_sc_hd__decap_40_12$1
XFILLER_104_699 vccd1 vssd1 vccd1 vssd1 sky130_fd_sc_hd__fill_1$1
XFILLER_103_165 vssd1 vccd1 vccd1 vssd1 sky130_fd_sc_hd__fill_2$1
XFILLER_58_731 vccd1 vssd1 vccd1 vssd1 sky130_fd_sc_hd__fill_1$1
XFILLER_106_97 vssd1 vccd1 vccd1 vssd1 sky130_ef_sc_hd__decap_40_12$1
XFILLER_85_561 vssd1 vccd1 vccd1 vssd1 sky130_ef_sc_hd__decap_40_12$1
XFILLER_58_786 vssd1 vccd1 vccd1 vssd1 sky130_fd_sc_hd__fill_8$1
XFILLER_122_41 vssd1 vccd1 vccd1 vssd1 sky130_ef_sc_hd__decap_40_12$1
XFILLER_17_105 vssd1 vccd1 vccd1 vssd1 sky130_fd_sc_hd__fill_4$1
XFILLER_72_233 vssd1 vccd1 vccd1 vssd1 sky130_ef_sc_hd__decap_40_12$1
XFILLER_17_149 vssd1 vccd1 vccd1 vssd1 sky130_ef_sc_hd__decap_40_12$1
XFILLER_33_609 vssd1 vccd1 vccd1 vssd1 sky130_fd_sc_hd__fill_4$1
XFILLER_45_447 vccd1 vssd1 vccd1 vssd1 sky130_fd_sc_hd__fill_1$1
XFILLER_122_85 vssd1 vccd1 vccd1 vssd1 sky130_ef_sc_hd__decap_40_12$1
XFILLER_72_277 vssd1 vccd1 vccd1 vssd1 sky130_ef_sc_hd__decap_40_12$1
XFILLER_60_417 vssd1 vccd1 vccd1 vssd1 sky130_fd_sc_hd__fill_2$1
XTAP_TAPCELL_ROW_0_281 vccd1 vssd1 sky130_fd_sc_hd__tapvpwrvgnd_1$1
XTAP_TAPCELL_ROW_0_292 vccd1 vssd1 sky130_fd_sc_hd__tapvpwrvgnd_1$1
XFILLER_13_333 vssd1 vccd1 vccd1 vssd1 sky130_fd_sc_hd__fill_2$1
XFILLER_25_193 vssd1 vccd1 vccd1 vssd1 sky130_ef_sc_hd__decap_40_12$1
XFILLER_40_141 vssd1 vccd1 vccd1 vssd1 sky130_ef_sc_hd__decap_40_12$1
XFILLER_9_337 vssd1 vccd1 vccd1 vssd1 sky130_ef_sc_hd__decap_40_12$1
XFILLER_41_697 vssd1 vccd1 vccd1 vssd1 sky130_ef_sc_hd__decap_40_12$1
XFILLER_31_93 vssd1 vccd1 vccd1 vssd1 sky130_ef_sc_hd__decap_40_12$1
XFILLER_135_780 vssd1 vccd1 vccd1 vssd1 sky130_fd_sc_hd__fill_4$1
XPHY_EDGE_ROW_128_Right_128 vccd1 vssd1 vccd1 vssd1 sky130_fd_sc_hd__decap_3$1
XTAP_TAPCELL_ROW_56_1141 vccd1 vssd1 sky130_fd_sc_hd__tapvpwrvgnd_1$1
Xoutput60 _1842_/X analog_ctrl[109] vssd1 vccd1 vccd1 vssd1 sky130_fd_sc_hd__buf_12$1
Xoutput71 _1852_/X analog_ctrl[119] vssd1 vccd1 vccd1 vssd1 sky130_fd_sc_hd__buf_12$1
XFILLER_122_452 vssd1 vccd1 vccd1 vssd1 sky130_ef_sc_hd__decap_40_12$1
XFILLER_110_625 vssd1 vccd1 vccd1 vssd1 sky130_ef_sc_hd__decap_40_12$1
Xoutput82 _1789_/X analog_ctrl[18] vssd1 vccd1 vccd1 vssd1 sky130_fd_sc_hd__buf_12$1
Xoutput93 _1799_/X analog_ctrl[28] vssd1 vccd1 vccd1 vssd1 sky130_fd_sc_hd__buf_12$1
X_1290_ _1836_/A _1290_/X _1342_/B vssd1 vccd1 vccd1 vssd1 sky130_fd_sc_hd__or2_1$1
XFILLER_0_281 vssd1 vccd1 vccd1 vssd1 sky130_fd_sc_hd__fill_8$1
XFILLER_110_669 vssd1 vccd1 vccd1 vssd1 sky130_fd_sc_hd__fill_2$1
XFILLER_64_701 vssd1 vccd1 vccd1 vssd1 sky130_ef_sc_hd__decap_40_12$1
XFILLER_49_753 vssd1 vccd1 vccd1 vssd1 sky130_fd_sc_hd__fill_4$1
XFILLER_49_797 vssd1 vccd1 vccd1 vssd1 sky130_fd_sc_hd__fill_4$1
XFILLER_91_553 vssd1 vccd1 vccd1 vssd1 sky130_fd_sc_hd__fill_4$1
XPHY_EDGE_ROW_90_Left_229 vccd1 vssd1 vccd1 vssd1 sky130_fd_sc_hd__decap_3$1
XFILLER_36_469 vssd1 vccd1 vccd1 vssd1 sky130_fd_sc_hd__fill_4$1
XFILLER_63_277 vssd1 vccd1 vccd1 vssd1 sky130_fd_sc_hd__fill_2$1
XFILLER_51_417 vssd1 vccd1 vccd1 vssd1 sky130_ef_sc_hd__decap_40_12$1
XTAP_TAPCELL_ROW_47_998 vccd1 vssd1 sky130_fd_sc_hd__tapvpwrvgnd_1$1
XFILLER_16_193 vssd1 vccd1 vccd1 vssd1 sky130_fd_sc_hd__fill_2$1
XFILLER_20_804 vssd1 vccd1 vccd1 vssd1 sky130_fd_sc_hd__fill_8$1
XFILLER_32_664 vssd1 vccd1 vccd1 vssd1 sky130_ef_sc_hd__decap_40_12$1
XFILLER_118_725 vssd1 vccd1 vccd1 vssd1 sky130_ef_sc_hd__decap_40_12$1
XFILLER_117_279 vccd1 vssd1 vccd1 vssd1 sky130_fd_sc_hd__fill_1$1
XFILLER_105_419 vccd1 vssd1 vccd1 vssd1 sky130_fd_sc_hd__fill_1$1
X_1626_ _1626_/Q _1690_/CLK _1626_/D vccd1 vssd1 vccd1 vssd1 sky130_fd_sc_hd__dfxtp_1$1
X_1557_ hold51/A _1717_/CLK _1557_/D vccd1 vssd1 vccd1 vssd1 sky130_fd_sc_hd__dfxtp_1$1
XFILLER_132_249 vssd1 vccd1 vccd1 vssd1 sky130_fd_sc_hd__fill_2$1
XFILLER_113_441 vssd1 vccd1 vccd1 vssd1 sky130_fd_sc_hd__fill_4$1
XFILLER_99_664 vccd1 vssd1 vccd1 vssd1 sky130_fd_sc_hd__fill_1$1
XFILLER_87_804 vccd1 vssd1 vccd1 vssd1 sky130_fd_sc_hd__fill_1$1
XFILLER_98_141 vssd1 vccd1 vccd1 vssd1 sky130_ef_sc_hd__decap_40_12$1
XFILLER_59_517 vssd1 vccd1 vccd1 vssd1 sky130_ef_sc_hd__decap_40_12$1
XFILLER_113_485 vssd1 vccd1 vccd1 vssd1 sky130_ef_sc_hd__decap_40_12$1
X_1488_ _1488_/Q clkload6/A _1488_/D vccd1 vssd1 vccd1 vssd1 sky130_fd_sc_hd__dfxtp_2$1
XPHY_EDGE_ROW_129_Left_268 vccd1 vssd1 vccd1 vssd1 sky130_fd_sc_hd__decap_3$1
XTAP_TAPCELL_ROW_87_1602 vccd1 vssd1 sky130_fd_sc_hd__tapvpwrvgnd_1$1
XFILLER_67_561 vssd1 vccd1 vccd1 vssd1 sky130_ef_sc_hd__decap_40_12$1
XFILLER_36_27 vccd1 vssd1 vccd1 vssd1 sky130_fd_sc_hd__fill_1$1
XFILLER_54_233 vssd1 vccd1 vccd1 vssd1 sky130_ef_sc_hd__decap_40_12$1
XFILLER_15_609 vssd1 vccd1 vccd1 vssd1 sky130_fd_sc_hd__fill_4$1
XFILLER_27_447 vccd1 vssd1 vccd1 vssd1 sky130_fd_sc_hd__fill_1$1
XFILLER_70_737 vssd1 vccd1 vccd1 vssd1 sky130_fd_sc_hd__fill_2$1
XFILLER_55_789 vssd1 vccd1 vccd1 vssd1 sky130_fd_sc_hd__fill_2$1
XFILLER_54_277 vssd1 vccd1 vccd1 vssd1 sky130_ef_sc_hd__decap_40_12$1
XFILLER_42_417 vssd1 vccd1 vccd1 vssd1 sky130_fd_sc_hd__fill_2$1
XFILLER_52_15 vssd1 vccd1 vccd1 vssd1 sky130_ef_sc_hd__decap_40_12$1
XFILLER_50_461 vccd1 vssd1 vccd1 vssd1 sky130_fd_sc_hd__fill_1$1
XFILLER_22_141 vssd1 vccd1 vccd1 vssd1 sky130_ef_sc_hd__decap_40_12$1
XFILLER_23_653 vssd1 vccd1 vccd1 vssd1 sky130_ef_sc_hd__decap_40_12$1
XFILLER_23_697 vssd1 vccd1 vccd1 vssd1 sky130_ef_sc_hd__decap_40_12$1
XPHY_EDGE_ROW_138_Left_277 vccd1 vssd1 vccd1 vssd1 sky130_fd_sc_hd__decap_3$1
XFILLER_6_307 vccd1 vssd1 vccd1 vssd1 sky130_fd_sc_hd__fill_1$1
XFILLER_136_533 vssd1 vccd1 vccd1 vssd1 sky130_ef_sc_hd__decap_40_12$1
XFILLER_136_522 vssd1 vccd1 vccd1 vssd1 sky130_fd_sc_hd__fill_8$1
XTAP_TAPCELL_ROW_114_2009 vccd1 vssd1 sky130_fd_sc_hd__tapvpwrvgnd_1$1
XFILLER_109_758 vssd1 vccd1 vccd1 vssd1 sky130_ef_sc_hd__decap_40_12$1
XTAP_TAPCELL_ROW_98_1764 vccd1 vssd1 sky130_fd_sc_hd__tapvpwrvgnd_1$1
XTAP_TAPCELL_ROW_98_1775 vccd1 vssd1 sky130_fd_sc_hd__tapvpwrvgnd_1$1
XFILLER_123_205 vssd1 vccd1 vccd1 vssd1 sky130_ef_sc_hd__decap_40_12$1
XFILLER_2_513 vssd1 vccd1 vccd1 vssd1 sky130_ef_sc_hd__decap_40_12$1
XFILLER_123_249 vssd1 vccd1 vccd1 vssd1 sky130_ef_sc_hd__decap_40_12$1
XFILLER_2_557 vssd1 vccd1 vccd1 vssd1 sky130_ef_sc_hd__decap_40_12$1
XFILLER_104_474 vssd1 vccd1 vccd1 vssd1 sky130_fd_sc_hd__fill_2$1
XFILLER_131_293 vssd1 vccd1 vccd1 vssd1 sky130_ef_sc_hd__decap_40_12$1
XTAP_TAPCELL_ROW_129_2241 vccd1 vssd1 sky130_fd_sc_hd__tapvpwrvgnd_1$1
XTAP_TAPCELL_ROW_129_2230 vccd1 vssd1 sky130_fd_sc_hd__tapvpwrvgnd_1$1
XTAP_TAPCELL_ROW_51_1071 vccd1 vssd1 sky130_fd_sc_hd__tapvpwrvgnd_1$1
XTAP_TAPCELL_ROW_51_1060 vccd1 vssd1 sky130_fd_sc_hd__tapvpwrvgnd_1$1
XTAP_TAPCELL_ROW_5_373 vccd1 vssd1 sky130_fd_sc_hd__tapvpwrvgnd_1$1
XFILLER_46_701 vssd1 vccd1 vccd1 vssd1 sky130_fd_sc_hd__fill_2$1
XFILLER_133_51 vssd1 vccd1 vccd1 vssd1 sky130_fd_sc_hd__fill_4$1
XFILLER_100_680 vssd1 vccd1 vccd1 vssd1 sky130_fd_sc_hd__fill_2$1
XFILLER_46_734 vssd1 vccd1 vccd1 vssd1 sky130_ef_sc_hd__decap_40_12$1
XFILLER_100_691 vssd1 vccd1 vccd1 vssd1 sky130_fd_sc_hd__fill_8$1
XFILLER_93_55 vccd1 vssd1 vccd1 vssd1 sky130_fd_sc_hd__fill_1$1
XFILLER_85_391 vccd1 vssd1 vccd1 vssd1 sky130_fd_sc_hd__fill_1$1
XFILLER_18_469 vssd1 vccd1 vccd1 vssd1 sky130_fd_sc_hd__fill_4$1
XFILLER_73_575 vccd1 vssd1 vccd1 vssd1 sky130_fd_sc_hd__fill_1$1
XFILLER_61_726 vssd1 vccd1 vccd1 vssd1 sky130_fd_sc_hd__fill_2$1
XFILLER_33_417 vssd1 vccd1 vccd1 vssd1 sky130_ef_sc_hd__decap_40_12$1
XFILLER_45_277 vssd1 vccd1 vccd1 vssd1 sky130_fd_sc_hd__fill_2$1
XTAP_TAPCELL_ROW_44_957 vccd1 vssd1 sky130_fd_sc_hd__tapvpwrvgnd_1$1
Xclkbuf_leaf_11_wb_clk_i _1752_/CLK clkbuf_leaf_9_wb_clk_i/A vssd1 vccd1 vccd1 vssd1
+ sky130_fd_sc_hd__clkbuf_8$1
XFILLER_14_697 vssd1 vccd1 vccd1 vssd1 sky130_fd_sc_hd__fill_2$1
XFILLER_41_461 vssd1 vccd1 vccd1 vssd1 sky130_ef_sc_hd__decap_40_12$1
XFILLER_9_167 vccd1 vssd1 vccd1 vssd1 sky130_fd_sc_hd__fill_1$1
X_0790_ _1815_/A _0878_/A2 _0790_/X _1847_/A _0881_/B1 vccd1 vssd1 vccd1 vssd1 sky130_fd_sc_hd__a22o_1$1
XFILLER_42_81 vssd1 vccd1 vccd1 vssd1 sky130_fd_sc_hd__fill_2$1
XFILLER_6_841 vccd1 vssd1 vccd1 vssd1 sky130_fd_sc_hd__fill_1$1
XFILLER_127_588 vccd1 vssd1 vccd1 vssd1 sky130_fd_sc_hd__fill_1$1
XFILLER_5_373 vssd1 vccd1 vccd1 vssd1 sky130_ef_sc_hd__decap_40_12$1
X_1411_ _1411_/Y _1411_/A _1411_/B vssd1 vccd1 vccd1 vssd1 sky130_fd_sc_hd__nand2_4$1
XFILLER_114_249 vssd1 vccd1 vccd1 vssd1 sky130_fd_sc_hd__fill_2$1
XFILLER_123_783 vccd1 vssd1 vccd1 vssd1 sky130_fd_sc_hd__fill_1$1
XFILLER_110_400 vssd1 vccd1 vccd1 vssd1 sky130_ef_sc_hd__decap_40_12$1
XFILLER_96_612 vssd1 vccd1 vccd1 vssd1 sky130_ef_sc_hd__decap_40_12$1
XFILLER_69_804 vssd1 vccd1 vccd1 vssd1 sky130_ef_sc_hd__decap_40_12$1
X_1342_ _1700_/Q _1342_/X _1342_/B vssd1 vccd1 vccd1 vssd1 sky130_fd_sc_hd__or2_1$1
XFILLER_96_645 vssd1 vccd1 vccd1 vssd1 sky130_ef_sc_hd__decap_40_12$1
XFILLER_95_111 vccd1 vssd1 vccd1 vssd1 sky130_fd_sc_hd__fill_1$1
X_1273_ _1441_/C1 _1272_/X _1273_/A2 hold109/X _1666_/D vssd1 vccd1 vccd1 vssd1 sky130_fd_sc_hd__o211a_1$1
XFILLER_49_561 vssd1 vccd1 vccd1 vssd1 sky130_ef_sc_hd__decap_40_12$1
XFILLER_83_317 vssd1 vccd1 vccd1 vssd1 sky130_ef_sc_hd__decap_40_12$1
XTAP_TAPCELL_ROW_69_1332 vccd1 vssd1 sky130_fd_sc_hd__tapvpwrvgnd_1$1
XFILLER_64_531 vccd1 vssd1 vccd1 vssd1 sky130_fd_sc_hd__fill_1$1
XFILLER_36_233 vssd1 vccd1 vccd1 vssd1 sky130_ef_sc_hd__decap_40_12$1
XFILLER_91_361 vssd1 vccd1 vccd1 vssd1 sky130_ef_sc_hd__decap_40_12$1
XFILLER_24_417 vssd1 vccd1 vccd1 vssd1 sky130_fd_sc_hd__fill_2$1
XFILLER_36_277 vssd1 vccd1 vccd1 vssd1 sky130_ef_sc_hd__decap_40_12$1
XTAP_TAPCELL_ROW_82_1532 vccd1 vssd1 sky130_fd_sc_hd__tapvpwrvgnd_1$1
XFILLER_51_225 vssd1 vccd1 vccd1 vssd1 sky130_ef_sc_hd__decap_40_12$1
XFILLER_60_781 vssd1 vccd1 vccd1 vssd1 sky130_ef_sc_hd__decap_40_12$1
XFILLER_20_601 vssd1 vccd1 vccd1 vssd1 sky130_ef_sc_hd__decap_40_12$1
XTAP_TAPCELL_ROW_22_629 vccd1 vssd1 sky130_fd_sc_hd__tapvpwrvgnd_1$1
XFILLER_118_500 vssd1 vccd1 vccd1 vssd1 sky130_ef_sc_hd__decap_40_12$1
XFILLER_20_645 vssd1 vccd1 vccd1 vssd1 sky130_ef_sc_hd__decap_40_12$1
XFILLER_22_29 vssd1 vccd1 vccd1 vssd1 sky130_ef_sc_hd__decap_40_12$1
XFILLER_118_533 vssd1 vccd1 vccd1 vssd1 sky130_ef_sc_hd__decap_40_12$1
X_0988_ _0988_/A _0988_/X _1012_/B vssd1 vccd1 vccd1 vssd1 sky130_fd_sc_hd__or2_1$1
XFILLER_133_503 vccd1 vssd1 vccd1 vssd1 sky130_fd_sc_hd__fill_1$1
XFILLER_105_205 vssd1 vccd1 vccd1 vssd1 sky130_ef_sc_hd__decap_40_12$1
XFILLER_133_558 vssd1 vccd1 vccd1 vssd1 sky130_fd_sc_hd__fill_2$1
XFILLER_121_709 vssd1 vccd1 vccd1 vssd1 sky130_ef_sc_hd__decap_40_12$1
XFILLER_105_249 vssd1 vccd1 vccd1 vssd1 sky130_ef_sc_hd__decap_40_12$1
XFILLER_99_461 vssd1 vccd1 vccd1 vssd1 sky130_ef_sc_hd__decap_40_12$1
XTAP_TAPCELL_ROW_93_1694 vccd1 vssd1 sky130_fd_sc_hd__tapvpwrvgnd_1$1
X_1609_ _1813_/A _1671_/CLK _1609_/D vccd1 vssd1 vccd1 vssd1 sky130_fd_sc_hd__dfxtp_1$1
XFILLER_113_293 vssd1 vccd1 vccd1 vssd1 sky130_ef_sc_hd__decap_40_12$1
XFILLER_86_133 vssd1 vccd1 vccd1 vssd1 sky130_fd_sc_hd__fill_4$1
XFILLER_47_15 vssd1 vccd1 vccd1 vssd1 sky130_ef_sc_hd__decap_40_12$1
XFILLER_47_509 vssd1 vccd1 vccd1 vssd1 sky130_fd_sc_hd__fill_2$1
XFILLER_101_488 vssd1 vccd1 vccd1 vssd1 sky130_fd_sc_hd__fill_2$1
XFILLER_86_177 vssd1 vccd1 vccd1 vssd1 sky130_ef_sc_hd__decap_40_12$1
XTAP_TAPCELL_ROW_2_332 vccd1 vssd1 sky130_fd_sc_hd__tapvpwrvgnd_1$1
XFILLER_28_701 vssd1 vccd1 vccd1 vssd1 sky130_fd_sc_hd__fill_8$1
XFILLER_67_391 vccd1 vssd1 vccd1 vssd1 sky130_fd_sc_hd__fill_1$1
XTAP_TAPCELL_ROW_124_2160 vccd1 vssd1 sky130_fd_sc_hd__tapvpwrvgnd_1$1
XFILLER_82_361 vssd1 vccd1 vccd1 vssd1 sky130_fd_sc_hd__fill_2$1
XFILLER_15_417 vssd1 vccd1 vccd1 vssd1 sky130_ef_sc_hd__decap_40_12$1
XFILLER_27_277 vssd1 vccd1 vccd1 vssd1 sky130_fd_sc_hd__fill_2$1
XFILLER_82_383 vssd1 vccd1 vccd1 vssd1 sky130_fd_sc_hd__fill_4$1
XFILLER_70_545 vssd1 vccd1 vccd1 vssd1 sky130_ef_sc_hd__decap_40_12$1
XFILLER_43_737 vccd1 vssd1 vccd1 vssd1 sky130_fd_sc_hd__fill_1$1
XFILLER_43_759 vssd1 vccd1 vccd1 vssd1 sky130_ef_sc_hd__decap_40_12$1
XFILLER_63_69 vssd1 vccd1 vccd1 vssd1 sky130_ef_sc_hd__decap_40_12$1
XTAP_TAPCELL_ROW_41_916 vccd1 vssd1 sky130_fd_sc_hd__tapvpwrvgnd_1$1
XFILLER_70_589 vssd1 vccd1 vccd1 vssd1 sky130_ef_sc_hd__decap_40_12$1
XFILLER_23_461 vssd1 vccd1 vccd1 vssd1 sky130_ef_sc_hd__decap_40_12$1
XFILLER_137_3 vssd1 vccd1 vccd1 vssd1 sky130_ef_sc_hd__decap_40_12$1
XFILLER_10_133 vssd1 vccd1 vccd1 vssd1 sky130_fd_sc_hd__fill_4$1
XFILLER_137_820 vssd1 vccd1 vccd1 vssd1 sky130_fd_sc_hd__fill_4$1
XFILLER_10_177 vssd1 vccd1 vccd1 vssd1 sky130_ef_sc_hd__decap_40_12$1
XFILLER_109_566 vssd1 vccd1 vccd1 vssd1 sky130_ef_sc_hd__decap_40_12$1
XFILLER_6_137 vssd1 vccd1 vccd1 vssd1 sky130_fd_sc_hd__fill_2$1
XFILLER_136_363 vccd1 vssd1 vccd1 vssd1 sky130_fd_sc_hd__fill_1$1
XFILLER_3_833 vssd1 vccd1 vccd1 vssd1 sky130_fd_sc_hd__fill_4$1
XFILLER_2_321 vssd1 vccd1 vccd1 vssd1 sky130_ef_sc_hd__decap_40_12$1
XFILLER_88_77 vssd1 vccd1 vccd1 vssd1 sky130_fd_sc_hd__fill_4$1
XTAP_TAPCELL_ROW_53_1100 vccd1 vssd1 sky130_fd_sc_hd__tapvpwrvgnd_1$1
XFILLER_2_365 vssd1 vccd1 vccd1 vssd1 sky130_ef_sc_hd__decap_40_12$1
XFILLER_105_783 vccd1 vssd1 vccd1 vssd1 sky130_fd_sc_hd__fill_1$1
XFILLER_78_645 vssd1 vccd1 vccd1 vssd1 sky130_ef_sc_hd__decap_40_12$1
XFILLER_77_111 vccd1 vssd1 vccd1 vssd1 sky130_fd_sc_hd__fill_1$1
XFILLER_120_753 vssd1 vccd1 vccd1 vssd1 sky130_fd_sc_hd__fill_2$1
XFILLER_120_797 vssd1 vccd1 vccd1 vssd1 sky130_fd_sc_hd__fill_2$1
XFILLER_93_615 vccd1 vssd1 vccd1 vssd1 sky130_fd_sc_hd__fill_1$1
XFILLER_65_317 vssd1 vccd1 vccd1 vssd1 sky130_ef_sc_hd__decap_40_12$1
XTAP_TAPCELL_ROW_109_1933 vccd1 vssd1 sky130_fd_sc_hd__tapvpwrvgnd_1$1
XFILLER_93_659 vssd1 vccd1 vccd1 vssd1 sky130_ef_sc_hd__decap_40_12$1
XFILLER_18_233 vssd1 vccd1 vccd1 vssd1 sky130_ef_sc_hd__decap_40_12$1
XTAP_TAPCELL_ROW_29_740 vccd1 vssd1 sky130_fd_sc_hd__tapvpwrvgnd_1$1
XFILLER_80_309 vssd1 vccd1 vccd1 vssd1 sky130_ef_sc_hd__decap_40_12$1
XFILLER_73_361 vssd1 vccd1 vccd1 vssd1 sky130_fd_sc_hd__fill_8$1
XFILLER_61_501 vssd1 vccd1 vccd1 vssd1 sky130_fd_sc_hd__fill_2$1
XFILLER_18_277 vssd1 vccd1 vccd1 vssd1 sky130_ef_sc_hd__decap_40_12$1
XFILLER_19_789 vssd1 vccd1 vccd1 vssd1 sky130_fd_sc_hd__fill_2$1
XFILLER_37_81 vssd1 vccd1 vccd1 vssd1 sky130_ef_sc_hd__decap_40_12$1
XFILLER_33_225 vssd1 vccd1 vccd1 vssd1 sky130_ef_sc_hd__decap_40_12$1
XFILLER_46_597 vssd1 vccd1 vccd1 vssd1 sky130_fd_sc_hd__fill_2$1
XFILLER_61_556 vssd1 vccd1 vccd1 vssd1 sky130_fd_sc_hd__fill_4$1
XTAP_TAPCELL_ROW_64_1262 vccd1 vssd1 sky130_fd_sc_hd__tapvpwrvgnd_1$1
X_0911_ _1727_/Q _1344_/A _0911_/X _1759_/Q _1411_/A vccd1 vssd1 vccd1 vssd1 sky130_fd_sc_hd__a22o_1$1
X_0842_ _0750_/X _0842_/X _0841_/X _1823_/A _1147_/A _0840_/X vssd1 vccd1 vccd1 vssd1
+ sky130_fd_sc_hd__a2111o_1$1
X_0773_ _0773_/X _0906_/B1 _1840_/A _1640_/Q _0875_/B1 vssd1 vccd1 _0772_/X vccd1
+ vssd1 sky130_fd_sc_hd__a221o_1$1
XFILLER_52_3 vssd1 vccd1 vccd1 vssd1 sky130_ef_sc_hd__decap_40_12$1
XFILLER_6_693 vssd1 vccd1 vccd1 vssd1 sky130_fd_sc_hd__fill_4$1
XFILLER_5_181 vssd1 vccd1 vccd1 vssd1 sky130_ef_sc_hd__decap_40_12$1
XFILLER_130_528 vssd1 vccd1 vccd1 vssd1 sky130_fd_sc_hd__fill_4$1
X_1325_ _1463_/C1 _1324_/X _1331_/A2 hold59/X _1691_/D vssd1 vccd1 vccd1 vssd1 sky130_fd_sc_hd__o211a_1$1
XFILLER_69_656 vssd1 vccd1 vccd1 vssd1 sky130_ef_sc_hd__decap_40_12$1
XFILLER_68_133 vssd1 vccd1 vccd1 vssd1 sky130_fd_sc_hd__fill_4$1
XFILLER_96_475 vccd1 vssd1 vccd1 vssd1 sky130_fd_sc_hd__fill_1$1
XFILLER_68_177 vssd1 vccd1 vccd1 vssd1 sky130_ef_sc_hd__decap_40_12$1
X_1256_ _1658_/Q _1256_/X _1270_/B vssd1 vccd1 vccd1 vssd1 sky130_fd_sc_hd__or2_1$1
XFILLER_84_659 vccd1 vssd1 vccd1 vssd1 sky130_fd_sc_hd__fill_1$1
XFILLER_83_125 vssd1 vccd1 vccd1 vssd1 sky130_ef_sc_hd__decap_40_12$1
XFILLER_49_391 vccd1 vssd1 vccd1 vssd1 sky130_fd_sc_hd__fill_1$1
X_1187_ _1455_/C1 _1186_/X _1211_/A2 hold120/X _1624_/D vssd1 vccd1 vccd1 vssd1 sky130_fd_sc_hd__o211a_1$1
XFILLER_83_169 vssd1 vccd1 vccd1 vssd1 sky130_ef_sc_hd__decap_40_12$1
XFILLER_64_361 vssd1 vccd1 vccd1 vssd1 sky130_fd_sc_hd__fill_2$1
XFILLER_25_726 vssd1 vccd1 vccd1 vssd1 sky130_fd_sc_hd__fill_2$1
XFILLER_92_681 vssd1 vccd1 vccd1 vssd1 sky130_ef_sc_hd__decap_40_12$1
XFILLER_80_821 vccd1 vssd1 vccd1 vssd1 sky130_fd_sc_hd__fill_1$1
XFILLER_52_545 vssd1 vccd1 vccd1 vssd1 sky130_ef_sc_hd__decap_40_12$1
XFILLER_25_737 vccd1 vssd1 vccd1 vssd1 sky130_fd_sc_hd__fill_1$1
XFILLER_25_759 vssd1 vccd1 vccd1 vssd1 sky130_ef_sc_hd__decap_40_12$1
XFILLER_37_597 vssd1 vccd1 vccd1 vssd1 sky130_ef_sc_hd__decap_40_12$1
XFILLER_52_589 vssd1 vccd1 vccd1 vssd1 sky130_ef_sc_hd__decap_40_12$1
XFILLER_33_39 vssd1 vccd1 vccd1 vssd1 sky130_ef_sc_hd__decap_40_12$1
XFILLER_138_617 vssd1 vccd1 vccd1 vssd1 sky130_fd_sc_hd__fill_2$1
XFILLER_20_475 vccd1 vssd1 vccd1 vssd1 sky130_fd_sc_hd__fill_1$1
XFILLER_118_363 vccd1 vssd1 vccd1 vssd1 sky130_fd_sc_hd__fill_1$1
XTAP_TAPCELL_ROW_95_1723 vccd1 vssd1 sky130_fd_sc_hd__tapvpwrvgnd_1$1
XFILLER_133_333 vssd1 vccd1 vccd1 vssd1 sky130_fd_sc_hd__fill_2$1
XFILLER_118_385 vssd1 vccd1 vccd1 vssd1 sky130_ef_sc_hd__decap_40_12$1
XTAP_TAPCELL_ROW_7_402 vccd1 vssd1 sky130_fd_sc_hd__tapvpwrvgnd_1$1
XFILLER_133_399 vssd1 vccd1 vccd1 vssd1 sky130_ef_sc_hd__decap_40_12$1
XFILLER_59_111 vccd1 vssd1 vccd1 vssd1 sky130_fd_sc_hd__fill_1$1
XFILLER_75_615 vccd1 vssd1 vccd1 vssd1 sky130_fd_sc_hd__fill_1$1
XFILLER_47_317 vssd1 vccd1 vccd1 vssd1 sky130_ef_sc_hd__decap_40_12$1
XFILLER_114_53 vssd1 vccd1 vccd1 vssd1 sky130_ef_sc_hd__decap_40_12$1
XFILLER_28_531 vccd1 vssd1 vccd1 vssd1 sky130_fd_sc_hd__fill_1$1
XFILLER_114_97 vssd1 vccd1 vccd1 vssd1 sky130_ef_sc_hd__decap_40_12$1
XFILLER_62_309 vssd1 vccd1 vccd1 vssd1 sky130_ef_sc_hd__decap_40_12$1
XFILLER_55_361 vssd1 vccd1 vccd1 vssd1 sky130_ef_sc_hd__decap_40_12$1
XFILLER_15_225 vssd1 vccd1 vccd1 vssd1 sky130_ef_sc_hd__decap_40_12$1
XFILLER_130_41 vssd1 vccd1 vccd1 vssd1 sky130_ef_sc_hd__decap_40_12$1
XFILLER_43_567 vssd1 vccd1 vccd1 vssd1 sky130_ef_sc_hd__decap_40_12$1
XFILLER_130_85 vssd1 vccd1 vccd1 vssd1 sky130_ef_sc_hd__decap_40_12$1
XTAP_TAPCELL_ROW_104_1863 vccd1 vssd1 sky130_fd_sc_hd__tapvpwrvgnd_1$1
XFILLER_24_781 vssd1 vccd1 vccd1 vssd1 sky130_fd_sc_hd__fill_4$1
XFILLER_31_729 vssd1 vccd1 vccd1 vssd1 sky130_ef_sc_hd__decap_40_12$1
XFILLER_129_617 vssd1 vccd1 vccd1 vssd1 sky130_ef_sc_hd__decap_40_12$1
XTAP_TAPCELL_ROW_137_2362 vccd1 vssd1 sky130_fd_sc_hd__tapvpwrvgnd_1$1
XTAP_TAPCELL_ROW_137_2351 vccd1 vssd1 sky130_fd_sc_hd__tapvpwrvgnd_1$1
XFILLER_11_497 vssd1 vccd1 vccd1 vssd1 sky130_fd_sc_hd__fill_4$1
XFILLER_136_193 vssd1 vccd1 vccd1 vssd1 sky130_fd_sc_hd__fill_2$1
XFILLER_124_333 vssd1 vccd1 vccd1 vssd1 sky130_ef_sc_hd__decap_40_12$1
XFILLER_109_385 vssd1 vccd1 vccd1 vssd1 sky130_fd_sc_hd__fill_4$1
XFILLER_124_377 vssd1 vccd1 vccd1 vssd1 sky130_ef_sc_hd__decap_40_12$1
XFILLER_3_641 vssd1 vccd1 vccd1 vssd1 sky130_ef_sc_hd__decap_40_12$1
XFILLER_97_217 vssd1 vccd1 vccd1 vssd1 sky130_fd_sc_hd__fill_4$1
XFILLER_3_685 vssd1 vccd1 vccd1 vssd1 sky130_ef_sc_hd__decap_40_12$1
XFILLER_78_453 vssd1 vccd1 vccd1 vssd1 sky130_ef_sc_hd__decap_40_12$1
XFILLER_2_195 vccd1 vssd1 vccd1 vssd1 sky130_fd_sc_hd__fill_1$1
XFILLER_93_423 vssd1 vccd1 vccd1 vssd1 sky130_ef_sc_hd__decap_40_12$1
X_1110_ _1805_/A _1110_/X _1144_/B vssd1 vccd1 vccd1 vssd1 sky130_fd_sc_hd__or2_1$1
XFILLER_78_475 vccd1 vssd1 vccd1 vssd1 sky130_fd_sc_hd__fill_1$1
XFILLER_39_829 vssd1 vccd1 vccd1 vssd1 sky130_fd_sc_hd__fill_8$1
XFILLER_65_125 vssd1 vccd1 vccd1 vssd1 sky130_ef_sc_hd__decap_40_12$1
X_1041_ _1437_/C1 _1040_/X _1079_/A2 hold55/X hold56/A vssd1 vccd1 vccd1 vssd1 sky130_fd_sc_hd__o211a_1$1
XFILLER_65_169 vssd1 vccd1 vccd1 vssd1 sky130_ef_sc_hd__decap_40_12$1
XFILLER_62_810 vssd1 vccd1 vccd1 vssd1 sky130_fd_sc_hd__fill_2$1
XFILLER_19_553 vssd1 vccd1 vccd1 vssd1 sky130_fd_sc_hd__fill_4$1
XFILLER_34_501 vssd1 vccd1 vccd1 vssd1 sky130_ef_sc_hd__decap_40_12$1
XFILLER_46_361 vssd1 vccd1 vccd1 vssd1 sky130_fd_sc_hd__fill_2$1
XFILLER_80_139 vccd1 vssd1 vccd1 vssd1 sky130_fd_sc_hd__fill_1$1
XFILLER_74_681 vssd1 vccd1 vccd1 vssd1 sky130_ef_sc_hd__decap_40_12$1
XFILLER_62_821 vssd1 vccd1 vccd1 vssd1 sky130_fd_sc_hd__fill_2$1
XFILLER_19_597 vssd1 vccd1 vccd1 vssd1 sky130_ef_sc_hd__decap_40_12$1
XFILLER_34_545 vssd1 vccd1 vccd1 vssd1 sky130_ef_sc_hd__decap_40_12$1
XFILLER_21_217 vssd1 vccd1 vccd1 vssd1 sky130_fd_sc_hd__fill_4$1
XFILLER_34_589 vssd1 vccd1 vccd1 vssd1 sky130_ef_sc_hd__decap_40_12$1
XFILLER_119_105 vssd1 vccd1 vccd1 vssd1 sky130_fd_sc_hd__fill_4$1
XTAP_TAPCELL_ROW_32_779 vccd1 vssd1 sky130_fd_sc_hd__tapvpwrvgnd_1$1
XFILLER_119_149 vssd1 vccd1 vccd1 vssd1 sky130_ef_sc_hd__decap_40_12$1
XTAP_TAPCELL_ROW_12_481 vccd1 vssd1 sky130_fd_sc_hd__tapvpwrvgnd_1$1
X_0825_ _0880_/A2 _1488_/D _0821_/X _1449_/C1 _1488_/Q _0824_/X vssd1 vccd1 vccd1
+ vssd1 sky130_fd_sc_hd__o221a_1$1
XFILLER_127_193 vssd1 vccd1 vccd1 vssd1 sky130_ef_sc_hd__decap_40_12$1
XFILLER_115_333 vssd1 vccd1 vccd1 vssd1 sky130_fd_sc_hd__fill_2$1
XTAP_TAPCELL_ROW_77_1453 vccd1 vssd1 sky130_fd_sc_hd__tapvpwrvgnd_1$1
X_0756_ _0906_/B1 _1637_/Q _0755_/X _0756_/X vccd1 vssd1 vccd1 vssd1 sky130_fd_sc_hd__a21o_1$1
XFILLER_89_729 vssd1 vccd1 vccd1 vssd1 sky130_ef_sc_hd__decap_40_12$1
XTAP_TAPCELL_ROW_90_1653 vccd1 vssd1 sky130_fd_sc_hd__tapvpwrvgnd_1$1
XFILLER_111_561 vssd1 vccd1 vccd1 vssd1 sky130_ef_sc_hd__decap_40_12$1
XFILLER_69_486 vssd1 vccd1 vccd1 vssd1 sky130_ef_sc_hd__decap_40_12$1
XFILLER_57_615 vccd1 vssd1 vccd1 vssd1 sky130_fd_sc_hd__fill_1$1
XFILLER_29_317 vssd1 vccd1 vccd1 vssd1 sky130_ef_sc_hd__decap_40_12$1
X_1308_ _1308_/A _1308_/X _1330_/B vssd1 vccd1 vccd1 vssd1 sky130_fd_sc_hd__or2_1$1
X_1239_ _1437_/C1 _1238_/X _1273_/A2 hold55/X _1649_/D vssd1 vccd1 vccd1 vssd1 sky130_fd_sc_hd__o211a_1$1
XFILLER_72_618 vccd1 vssd1 vccd1 vssd1 sky130_fd_sc_hd__fill_1$1
XFILLER_25_501 vssd1 vccd1 vccd1 vssd1 sky130_fd_sc_hd__fill_2$1
XFILLER_44_309 vssd1 vccd1 vccd1 vssd1 sky130_ef_sc_hd__decap_40_12$1
XFILLER_37_361 vssd1 vccd1 vccd1 vssd1 sky130_ef_sc_hd__decap_40_12$1
XFILLER_44_27 vccd1 vssd1 vccd1 vssd1 sky130_fd_sc_hd__fill_1$1
XFILLER_13_729 vssd1 vccd1 vccd1 vssd1 sky130_ef_sc_hd__decap_40_12$1
XFILLER_40_537 vssd1 vccd1 vccd1 vssd1 sky130_fd_sc_hd__fill_2$1
XFILLER_40_548 vssd1 vccd1 vccd1 vssd1 sky130_ef_sc_hd__decap_40_12$1
XFILLER_100_77 vssd1 vccd1 vccd1 vssd1 sky130_fd_sc_hd__fill_4$1
XFILLER_60_15 vssd1 vccd1 vccd1 vssd1 sky130_ef_sc_hd__decap_40_12$1
XTAP_TAPCELL_ROW_119_2081 vccd1 vssd1 sky130_fd_sc_hd__tapvpwrvgnd_1$1
XTAP_TAPCELL_ROW_119_2092 vccd1 vssd1 sky130_fd_sc_hd__tapvpwrvgnd_1$1
XFILLER_107_823 vccd1 vssd1 vccd1 vssd1 sky130_fd_sc_hd__fill_1$1
XFILLER_118_193 vssd1 vccd1 vccd1 vssd1 sky130_fd_sc_hd__fill_2$1
XFILLER_106_333 vssd1 vccd1 vccd1 vssd1 sky130_ef_sc_hd__decap_40_12$1
XTAP_TAPCELL_ROW_132_2281 vccd1 vssd1 sky130_fd_sc_hd__tapvpwrvgnd_1$1
XFILLER_69_57 vssd1 vccd1 vccd1 vssd1 sky130_ef_sc_hd__decap_40_12$1
XFILLER_106_377 vssd1 vccd1 vccd1 vssd1 sky130_ef_sc_hd__decap_40_12$1
XFILLER_79_217 vssd1 vccd1 vccd1 vssd1 sky130_fd_sc_hd__fill_4$1
XFILLER_102_561 vssd1 vccd1 vccd1 vssd1 sky130_ef_sc_hd__decap_40_12$1
XFILLER_94_209 vssd1 vccd1 vccd1 vssd1 sky130_ef_sc_hd__decap_40_12$1
XFILLER_88_773 vssd1 vccd1 vccd1 vssd1 sky130_ef_sc_hd__decap_40_12$1
XFILLER_87_261 vssd1 vccd1 vccd1 vssd1 sky130_ef_sc_hd__decap_40_12$1
XFILLER_47_125 vssd1 vccd1 vccd1 vssd1 sky130_ef_sc_hd__decap_40_12$1
XFILLER_47_169 vssd1 vccd1 vccd1 vssd1 sky130_ef_sc_hd__decap_40_12$1
XFILLER_62_139 vccd1 vssd1 vccd1 vssd1 sky130_fd_sc_hd__fill_1$1
XFILLER_56_681 vssd1 vccd1 vccd1 vssd1 sky130_ef_sc_hd__decap_40_12$1
XFILLER_16_501 vssd1 vccd1 vccd1 vssd1 sky130_ef_sc_hd__decap_40_12$1
XFILLER_18_83 vccd1 vssd1 vccd1 vssd1 sky130_fd_sc_hd__fill_1$1
XFILLER_28_361 vssd1 vccd1 vccd1 vssd1 sky130_fd_sc_hd__fill_2$1
XTAP_TAPCELL_ROW_39_890 vccd1 vssd1 sky130_fd_sc_hd__tapvpwrvgnd_1$1
XTAP_TAPCELL_ROW_48_1021 vccd1 vssd1 sky130_fd_sc_hd__tapvpwrvgnd_1$1
XFILLER_71_662 vssd1 vccd1 vccd1 vssd1 sky130_fd_sc_hd__fill_8$1
XFILLER_16_545 vssd1 vccd1 vccd1 vssd1 sky130_ef_sc_hd__decap_40_12$1
XFILLER_71_673 vssd1 vccd1 vccd1 vssd1 sky130_ef_sc_hd__decap_40_12$1
XFILLER_16_589 vssd1 vccd1 vccd1 vssd1 sky130_ef_sc_hd__decap_40_12$1
XTAP_TAPCELL_ROW_61_1221 vccd1 vssd1 sky130_fd_sc_hd__tapvpwrvgnd_1$1
XTAP_TAPCELL_ROW_61_1210 vccd1 vssd1 sky130_fd_sc_hd__tapvpwrvgnd_1$1
XFILLER_31_559 vccd1 vssd1 vccd1 vssd1 sky130_fd_sc_hd__fill_1$1
XFILLER_11_261 vssd1 vccd1 vccd1 vssd1 sky130_ef_sc_hd__decap_40_12$1
XFILLER_8_755 vccd1 vssd1 vccd1 vssd1 sky130_fd_sc_hd__fill_1$1
XFILLER_7_221 vssd1 vccd1 vccd1 vssd1 sky130_fd_sc_hd__fill_2$1
XFILLER_50_81 vssd1 vccd1 vccd1 vssd1 sky130_fd_sc_hd__fill_2$1
X_1590_ _1808_/A _1721_/CLK _1590_/D vccd1 vssd1 vccd1 vssd1 sky130_fd_sc_hd__dfxtp_1$1
XFILLER_124_141 vssd1 vccd1 vccd1 vssd1 sky130_ef_sc_hd__decap_40_12$1
XFILLER_109_193 vssd1 vccd1 vccd1 vssd1 sky130_ef_sc_hd__decap_40_12$1
XTAP_TAPCELL_ROW_59_1183 vccd1 vssd1 sky130_fd_sc_hd__tapvpwrvgnd_1$1
XFILLER_98_559 vccd1 vssd1 vccd1 vssd1 sky130_fd_sc_hd__fill_1$1
XTAP_TAPCELL_ROW_72_1383 vccd1 vssd1 sky130_fd_sc_hd__tapvpwrvgnd_1$1
XFILLER_39_615 vccd1 vssd1 vccd1 vssd1 sky130_fd_sc_hd__fill_1$1
XFILLER_66_445 vssd1 vccd1 vccd1 vssd1 sky130_ef_sc_hd__decap_40_12$1
XFILLER_15_3 vssd1 vccd1 vccd1 vssd1 sky130_ef_sc_hd__decap_40_12$1
XFILLER_54_618 vssd1 vccd1 vccd1 vssd1 sky130_ef_sc_hd__decap_40_12$1
XFILLER_26_309 vssd1 vccd1 vccd1 vssd1 sky130_ef_sc_hd__decap_40_12$1
XFILLER_19_361 vssd1 vccd1 vccd1 vssd1 sky130_ef_sc_hd__decap_40_12$1
X_1024_ _1776_/A _1024_/X _1052_/B vssd1 vccd1 vccd1 vssd1 sky130_fd_sc_hd__or2_1$1
XTAP_TAPCELL_ROW_37_849 vccd1 vssd1 sky130_fd_sc_hd__tapvpwrvgnd_1$1
XFILLER_61_161 vssd1 vccd1 vccd1 vssd1 sky130_fd_sc_hd__fill_4$1
XTAP_TAPCELL_ROW_17_551 vccd1 vssd1 sky130_fd_sc_hd__tapvpwrvgnd_1$1
XTAP_TAPCELL_ROW_17_562 vccd1 vssd1 sky130_fd_sc_hd__tapvpwrvgnd_1$1
XFILLER_30_581 vssd1 vccd1 vccd1 vssd1 sky130_fd_sc_hd__fill_4$1
XFILLER_30_29 vssd1 vccd1 vccd1 vssd1 sky130_ef_sc_hd__decap_40_12$1
X_0808_ input12/X _0744_/Y _0808_/X _1850_/A _0881_/B1 vccd1 vssd1 vccd1 vssd1 sky130_fd_sc_hd__a22o_1$1
X_1788_ vccd1 vssd1 _1788_/X _1788_/A vccd1 vssd1 sky130_fd_sc_hd__buf_1$1
X_0739_ _0947_/C _1476_/Q _1476_/D _0739_/D _0947_/B vssd1 vccd1 vccd1 vssd1 sky130_fd_sc_hd__and4b_1$1
XFILLER_130_133 vssd1 vccd1 vccd1 vssd1 sky130_fd_sc_hd__fill_4$1
XFILLER_89_559 vccd1 vssd1 vccd1 vssd1 sky130_fd_sc_hd__fill_1$1
XFILLER_39_27 vssd1 vccd1 vccd1 vssd1 sky130_ef_sc_hd__decap_40_12$1
XFILLER_130_177 vssd1 vccd1 vccd1 vssd1 sky130_ef_sc_hd__decap_40_12$1
XPHY_EDGE_ROW_110_Left_249 vccd1 vssd1 vccd1 vssd1 sky130_fd_sc_hd__decap_3$1
XFILLER_76_209 vssd1 vccd1 vccd1 vssd1 sky130_ef_sc_hd__decap_40_12$1
XFILLER_69_261 vssd1 vccd1 vccd1 vssd1 sky130_ef_sc_hd__decap_40_12$1
XFILLER_97_592 vssd1 vccd1 vccd1 vssd1 sky130_fd_sc_hd__fill_2$1
XFILLER_29_125 vssd1 vccd1 vccd1 vssd1 sky130_ef_sc_hd__decap_40_12$1
XFILLER_84_253 vssd1 vccd1 vccd1 vssd1 sky130_ef_sc_hd__decap_40_12$1
XFILLER_55_15 vssd1 vccd1 vccd1 vssd1 sky130_ef_sc_hd__decap_40_12$1
XFILLER_29_169 vssd1 vccd1 vccd1 vssd1 sky130_ef_sc_hd__decap_40_12$1
XFILLER_26_821 vssd1 vccd1 vccd1 vssd1 sky130_fd_sc_hd__fill_2$1
XFILLER_38_681 vssd1 vccd1 vccd1 vssd1 sky130_ef_sc_hd__decap_40_12$1
XFILLER_45_629 vssd1 vccd1 vccd1 vssd1 sky130_ef_sc_hd__decap_40_12$1
XFILLER_44_139 vccd1 vssd1 vccd1 vssd1 sky130_fd_sc_hd__fill_1$1
XFILLER_40_301 vssd1 vccd1 vccd1 vssd1 sky130_fd_sc_hd__fill_4$1
XTAP_TAPCELL_ROW_101_1822 vccd1 vssd1 sky130_fd_sc_hd__tapvpwrvgnd_1$1
XTAP_TAPCELL_ROW_101_1811 vccd1 vssd1 sky130_fd_sc_hd__tapvpwrvgnd_1$1
XFILLER_13_559 vccd1 vssd1 vccd1 vssd1 sky130_fd_sc_hd__fill_1$1
XFILLER_71_69 vssd1 vccd1 vccd1 vssd1 sky130_ef_sc_hd__decap_40_12$1
XFILLER_40_345 vssd1 vccd1 vccd1 vssd1 sky130_ef_sc_hd__decap_40_12$1
XTAP_TAPCELL_ROW_134_2310 vccd1 vssd1 sky130_fd_sc_hd__tapvpwrvgnd_1$1
XPHY_EDGE_ROW_109_Right_109 vccd1 vssd1 vccd1 vssd1 sky130_fd_sc_hd__decap_3$1
XFILLER_40_389 vssd1 vccd1 vccd1 vssd1 sky130_ef_sc_hd__decap_40_12$1
XFILLER_138_255 vccd1 vssd1 vccd1 vssd1 sky130_fd_sc_hd__fill_1$1
XFILLER_5_725 vssd1 vccd1 vccd1 vssd1 sky130_fd_sc_hd__fill_2$1
XFILLER_106_141 vssd1 vccd1 vccd1 vssd1 sky130_ef_sc_hd__decap_40_12$1
XFILLER_122_601 vssd1 vccd1 vccd1 vssd1 sky130_ef_sc_hd__decap_40_12$1
XFILLER_107_697 vssd1 vccd1 vccd1 vssd1 sky130_ef_sc_hd__decap_40_12$1
XFILLER_122_645 vssd1 vccd1 vccd1 vssd1 sky130_ef_sc_hd__decap_40_12$1
XFILLER_121_111 vccd1 vssd1 vccd1 vssd1 sky130_fd_sc_hd__fill_1$1
Xclkbuf_leaf_36_wb_clk_i _1585_/CLK clkload1/A vssd1 vccd1 vccd1 vssd1 sky130_fd_sc_hd__clkbuf_8$1
XTAP_TAPCELL_ROW_112_1984 vccd1 vssd1 sky130_fd_sc_hd__tapvpwrvgnd_1$1
XTAP_TAPCELL_ROW_112_1973 vccd1 vssd1 sky130_fd_sc_hd__tapvpwrvgnd_1$1
XFILLER_96_77 vssd1 vccd1 vccd1 vssd1 sky130_fd_sc_hd__fill_4$1
XFILLER_48_401 vssd1 vccd1 vccd1 vssd1 sky130_ef_sc_hd__decap_40_12$1
Xhold82 wbs_dat_i[26] hold82/X vssd1 vccd1 vccd1 vssd1 sky130_fd_sc_hd__dlygate4sd3_1$1
Xhold60 wbs_dat_i[4] hold60/X vssd1 vccd1 vccd1 vssd1 sky130_fd_sc_hd__dlygate4sd3_1$1
Xhold71 hold71/X vccd1 vssd1 hold71/A vccd1 vssd1 sky130_fd_sc_hd__buf_4$1
XFILLER_29_93 vssd1 vccd1 vccd1 vssd1 sky130_ef_sc_hd__decap_40_12$1
XFILLER_48_467 vssd1 vccd1 vccd1 vssd1 sky130_fd_sc_hd__fill_2$1
Xhold93 hold93/A hold93/X vssd1 vccd1 vccd1 vssd1 sky130_fd_sc_hd__dlygate4sd3_1$1
XFILLER_48_489 vssd1 vccd1 vccd1 vssd1 sky130_ef_sc_hd__decap_40_12$1
XFILLER_91_757 vssd1 vccd1 vccd1 vssd1 sky130_ef_sc_hd__decap_40_12$1
XFILLER_90_245 vssd1 vccd1 vccd1 vssd1 sky130_fd_sc_hd__fill_4$1
XTAP_TAPCELL_ROW_34_808 vccd1 vssd1 sky130_fd_sc_hd__tapvpwrvgnd_1$1
XFILLER_90_289 vssd1 vccd1 vccd1 vssd1 sky130_ef_sc_hd__decap_40_12$1
XFILLER_50_109 vssd1 vccd1 vccd1 vssd1 sky130_ef_sc_hd__decap_40_12$1
XFILLER_32_824 vssd1 vccd1 vccd1 vssd1 sky130_fd_sc_hd__fill_2$1
XFILLER_43_161 vssd1 vccd1 vccd1 vssd1 sky130_fd_sc_hd__fill_4$1
XFILLER_45_81 vssd1 vccd1 vccd1 vssd1 sky130_ef_sc_hd__decap_40_12$1
XFILLER_71_492 vssd1 vccd1 vccd1 vssd1 sky130_ef_sc_hd__decap_40_12$1
XTAP_TAPCELL_ROW_14_510 vccd1 vssd1 sky130_fd_sc_hd__tapvpwrvgnd_1$1
XFILLER_12_581 vssd1 vccd1 vccd1 vssd1 sky130_fd_sc_hd__fill_4$1
XFILLER_31_389 vssd1 vccd1 vccd1 vssd1 sky130_fd_sc_hd__fill_2$1
XFILLER_129_266 vssd1 vccd1 vccd1 vssd1 sky130_ef_sc_hd__decap_40_12$1
X_1711_ _1834_/A clkload8/A _1711_/D vccd1 vssd1 vccd1 vssd1 sky130_fd_sc_hd__dfxtp_1$1
XANTENNA_2 _0749_/X vssd1 vccd1 vccd1 vssd1 sky130_fd_sc_hd__diode_2$1
X_1642_ _1642_/Q _1736_/CLK _1642_/D vccd1 vssd1 vccd1 vssd1 sky130_fd_sc_hd__dfxtp_2$1
XFILLER_8_585 vssd1 vccd1 vccd1 vssd1 sky130_fd_sc_hd__fill_2$1
XTAP_TAPCELL_ROW_74_1412 vccd1 vssd1 sky130_fd_sc_hd__tapvpwrvgnd_1$1
XFILLER_6_53 vssd1 vccd1 vccd1 vssd1 sky130_ef_sc_hd__decap_40_12$1
XFILLER_98_301 vssd1 vccd1 vccd1 vssd1 sky130_fd_sc_hd__fill_4$1
XFILLER_6_97 vssd1 vccd1 vccd1 vssd1 sky130_ef_sc_hd__decap_40_12$1
X_1573_ _1787_/A _1575_/CLK _1573_/D vccd1 vssd1 vccd1 vssd1 sky130_fd_sc_hd__dfxtp_1$1
XFILLER_112_133 vssd1 vccd1 vccd1 vssd1 sky130_fd_sc_hd__fill_4$1
XFILLER_101_807 vccd1 vssd1 vccd1 vssd1 sky130_fd_sc_hd__fill_1$1
XFILLER_98_345 vssd1 vccd1 vccd1 vssd1 sky130_ef_sc_hd__decap_40_12$1
XFILLER_112_177 vssd1 vccd1 vccd1 vssd1 sky130_ef_sc_hd__decap_40_12$1
XFILLER_58_209 vssd1 vccd1 vccd1 vssd1 sky130_ef_sc_hd__decap_40_12$1
XFILLER_66_253 vssd1 vccd1 vccd1 vssd1 sky130_ef_sc_hd__decap_40_12$1
XFILLER_39_445 vssd1 vccd1 vccd1 vssd1 sky130_fd_sc_hd__fill_2$1
XFILLER_54_437 vssd1 vccd1 vccd1 vssd1 sky130_fd_sc_hd__fill_2$1
XFILLER_27_629 vssd1 vccd1 vccd1 vssd1 sky130_ef_sc_hd__decap_40_12$1
XFILLER_82_757 vssd1 vccd1 vccd1 vssd1 sky130_fd_sc_hd__fill_4$1
XFILLER_81_223 vccd1 vssd1 vccd1 vssd1 sky130_fd_sc_hd__fill_1$1
XFILLER_26_139 vccd1 vssd1 vccd1 vssd1 sky130_fd_sc_hd__fill_1$1
X_1007_ _1475_/C1 _1006_/X _1013_/A2 hold49/X _1537_/D vssd1 vccd1 vccd1 vssd1 sky130_fd_sc_hd__o211a_1$1
XTAP_TAPCELL_ROW_85_1574 vccd1 vssd1 sky130_fd_sc_hd__tapvpwrvgnd_1$1
XFILLER_22_301 vssd1 vccd1 vccd1 vssd1 sky130_fd_sc_hd__fill_4$1
XFILLER_41_109 vssd1 vccd1 vccd1 vssd1 sky130_fd_sc_hd__fill_2$1
XFILLER_50_621 vssd1 vccd1 vccd1 vssd1 sky130_fd_sc_hd__fill_2$1
XFILLER_22_345 vssd1 vccd1 vccd1 vssd1 sky130_ef_sc_hd__decap_40_12$1
XFILLER_10_529 vssd1 vccd1 vccd1 vssd1 sky130_fd_sc_hd__fill_2$1
XFILLER_22_389 vssd1 vccd1 vccd1 vssd1 sky130_ef_sc_hd__decap_40_12$1
XFILLER_41_39 vssd1 vccd1 vccd1 vssd1 sky130_ef_sc_hd__decap_40_12$1
XFILLER_108_417 vssd1 vccd1 vccd1 vssd1 sky130_fd_sc_hd__fill_2$1
XFILLER_136_737 vccd1 vssd1 vccd1 vssd1 sky130_fd_sc_hd__fill_1$1
XFILLER_135_225 vssd1 vccd1 vccd1 vssd1 sky130_ef_sc_hd__decap_40_12$1
XTAP_TAPCELL_ROW_116_2040 vccd1 vssd1 sky130_fd_sc_hd__tapvpwrvgnd_1$1
XFILLER_104_601 vssd1 vccd1 vccd1 vssd1 sky130_ef_sc_hd__decap_40_12$1
XFILLER_1_205 vssd1 vccd1 vccd1 vssd1 sky130_ef_sc_hd__decap_40_12$1
XFILLER_131_420 vssd1 vccd1 vccd1 vssd1 sky130_fd_sc_hd__fill_4$1
XFILLER_104_645 vccd1 vssd1 vccd1 vssd1 sky130_fd_sc_hd__fill_1$1
XFILLER_103_111 vccd1 vssd1 vccd1 vssd1 sky130_fd_sc_hd__fill_1$1
XFILLER_1_249 vssd1 vccd1 vccd1 vssd1 sky130_ef_sc_hd__decap_40_12$1
XFILLER_77_529 vssd1 vccd1 vccd1 vssd1 sky130_fd_sc_hd__fill_2$1
XFILLER_106_65 vssd1 vccd1 vccd1 vssd1 sky130_ef_sc_hd__decap_40_12$1
XFILLER_58_721 vssd1 vccd1 vccd1 vssd1 sky130_fd_sc_hd__fill_8$1
XFILLER_58_754 vssd1 vccd1 vccd1 vssd1 sky130_fd_sc_hd__fill_2$1
XFILLER_85_573 vssd1 vccd1 vccd1 vssd1 sky130_ef_sc_hd__decap_40_12$1
XFILLER_122_53 vssd1 vccd1 vccd1 vssd1 sky130_ef_sc_hd__decap_40_12$1
XFILLER_72_245 vssd1 vccd1 vccd1 vssd1 sky130_fd_sc_hd__fill_4$1
XFILLER_122_97 vssd1 vccd1 vccd1 vssd1 sky130_ef_sc_hd__decap_40_12$1
XFILLER_72_289 vssd1 vccd1 vccd1 vssd1 sky130_ef_sc_hd__decap_40_12$1
XFILLER_14_813 vssd1 vccd1 vccd1 vssd1 sky130_ef_sc_hd__decap_40_12$1
XFILLER_32_109 vssd1 vccd1 vccd1 vssd1 sky130_ef_sc_hd__decap_40_12$1
XFILLER_53_481 vssd1 vccd1 vccd1 vssd1 sky130_fd_sc_hd__fill_2$1
XTAP_TAPCELL_ROW_0_282 vccd1 vssd1 sky130_fd_sc_hd__tapvpwrvgnd_1$1
XTAP_TAPCELL_ROW_0_293 vccd1 vssd1 sky130_fd_sc_hd__tapvpwrvgnd_1$1
XFILLER_25_161 vssd1 vccd1 vccd1 vssd1 sky130_fd_sc_hd__fill_4$1
XFILLER_9_305 vssd1 vccd1 vccd1 vssd1 sky130_ef_sc_hd__decap_40_12$1
XFILLER_15_51 vssd1 vccd1 vccd1 vssd1 sky130_fd_sc_hd__fill_4$1
XFILLER_40_153 vssd1 vccd1 vccd1 vssd1 sky130_ef_sc_hd__decap_40_12$1
XFILLER_9_349 vssd1 vccd1 vccd1 vssd1 sky130_ef_sc_hd__decap_40_12$1
XFILLER_13_389 vssd1 vccd1 vccd1 vssd1 sky130_fd_sc_hd__fill_2$1
XFILLER_127_726 vssd1 vccd1 vccd1 vssd1 sky130_fd_sc_hd__fill_2$1
XFILLER_40_197 vssd1 vccd1 vccd1 vssd1 sky130_ef_sc_hd__decap_40_12$1
XFILLER_127_759 vssd1 vccd1 vccd1 vssd1 sky130_ef_sc_hd__decap_40_12$1
XFILLER_127_737 vccd1 vssd1 vccd1 vssd1 sky130_fd_sc_hd__fill_1$1
XFILLER_99_109 vssd1 vccd1 vccd1 vssd1 sky130_fd_sc_hd__fill_2$1
XTAP_TAPCELL_ROW_56_1142 vccd1 vssd1 sky130_fd_sc_hd__tapvpwrvgnd_1$1
Xoutput61 _1781_/X analog_ctrl[10] vssd1 vccd1 vccd1 vssd1 sky130_fd_sc_hd__buf_12$1
XFILLER_122_464 vssd1 vccd1 vccd1 vssd1 sky130_ef_sc_hd__decap_40_12$1
Xoutput72 _1782_/X analog_ctrl[11] vssd1 vccd1 vccd1 vssd1 sky130_fd_sc_hd__buf_12$1
Xoutput83 _1790_/X analog_ctrl[19] vssd1 vccd1 vccd1 vssd1 sky130_fd_sc_hd__buf_12$1
Xoutput94 _1800_/X analog_ctrl[29] vssd1 vccd1 vccd1 vssd1 sky130_fd_sc_hd__buf_12$1
XFILLER_110_637 vssd1 vccd1 vccd1 vssd1 sky130_fd_sc_hd__fill_4$1
XFILLER_95_337 vssd1 vccd1 vccd1 vssd1 sky130_ef_sc_hd__decap_40_12$1
XFILLER_1_783 vccd1 vssd1 vccd1 vssd1 sky130_fd_sc_hd__fill_1$1
XFILLER_48_253 vssd1 vccd1 vccd1 vssd1 sky130_ef_sc_hd__decap_40_12$1
XFILLER_64_713 vssd1 vccd1 vccd1 vssd1 sky130_ef_sc_hd__decap_40_12$1
XFILLER_64_757 vssd1 vccd1 vccd1 vssd1 sky130_ef_sc_hd__decap_40_12$1
XFILLER_63_223 vccd1 vssd1 vccd1 vssd1 sky130_fd_sc_hd__fill_1$1
XFILLER_91_565 vccd1 vssd1 vccd1 vssd1 sky130_fd_sc_hd__fill_1$1
XFILLER_51_429 vssd1 vccd1 vccd1 vssd1 sky130_fd_sc_hd__fill_8$1
XFILLER_17_673 vssd1 vccd1 vccd1 vssd1 sky130_ef_sc_hd__decap_40_12$1
XFILLER_23_109 vssd1 vccd1 vccd1 vssd1 sky130_fd_sc_hd__fill_2$1
XTAP_TAPCELL_ROW_47_999 vccd1 vssd1 sky130_fd_sc_hd__tapvpwrvgnd_1$1
XFILLER_91_598 vssd1 vccd1 vccd1 vssd1 sky130_ef_sc_hd__decap_40_12$1
XFILLER_32_643 vccd1 vssd1 vccd1 vssd1 sky130_fd_sc_hd__fill_1$1
XFILLER_32_676 vssd1 vccd1 vccd1 vssd1 sky130_ef_sc_hd__decap_40_12$1
XFILLER_82_3 vssd1 vccd1 vccd1 vssd1 sky130_ef_sc_hd__decap_40_12$1
XTAP_TAPCELL_ROW_80_1493 vccd1 vssd1 sky130_fd_sc_hd__tapvpwrvgnd_1$1
XFILLER_118_737 vssd1 vccd1 vccd1 vssd1 sky130_ef_sc_hd__decap_40_12$1
XFILLER_117_225 vssd1 vccd1 vccd1 vssd1 sky130_ef_sc_hd__decap_40_12$1
XFILLER_133_729 vssd1 vccd1 vccd1 vssd1 sky130_ef_sc_hd__decap_40_12$1
X_1625_ _1625_/Q _1721_/CLK _1625_/D vccd1 vssd1 vccd1 vssd1 sky130_fd_sc_hd__dfxtp_1$1
X_1556_ _1556_/Q _1748_/CLK hold91/X vccd1 vssd1 vccd1 vssd1 sky130_fd_sc_hd__dfxtp_1$1
XFILLER_99_654 vssd1 vccd1 vccd1 vssd1 sky130_fd_sc_hd__fill_8$1
XFILLER_101_615 vccd1 vssd1 vccd1 vssd1 sky130_fd_sc_hd__fill_1$1
XFILLER_98_153 vssd1 vccd1 vccd1 vssd1 sky130_ef_sc_hd__decap_40_12$1
XFILLER_59_529 vssd1 vccd1 vccd1 vssd1 sky130_ef_sc_hd__decap_40_12$1
XFILLER_113_497 vssd1 vccd1 vccd1 vssd1 sky130_fd_sc_hd__fill_4$1
XFILLER_98_197 vssd1 vccd1 vccd1 vssd1 sky130_ef_sc_hd__decap_40_12$1
X_1487_ _1487_/D clkload9/A _1487_/Q vssd1 vccd1 vccd1 vssd1 sky130_fd_sc_hd__dfxtp_4$1
XTAP_TAPCELL_ROW_87_1603 vccd1 vssd1 sky130_fd_sc_hd__tapvpwrvgnd_1$1
XFILLER_67_573 vssd1 vccd1 vccd1 vssd1 sky130_ef_sc_hd__decap_40_12$1
XFILLER_54_245 vssd1 vccd1 vccd1 vssd1 sky130_fd_sc_hd__fill_4$1
XFILLER_82_587 vccd1 vssd1 vccd1 vssd1 sky130_fd_sc_hd__fill_1$1
XFILLER_14_109 vssd1 vccd1 vccd1 vssd1 sky130_ef_sc_hd__decap_40_12$1
XFILLER_63_790 vssd1 vccd1 vccd1 vssd1 sky130_fd_sc_hd__fill_8$1
XFILLER_54_289 vssd1 vccd1 vccd1 vssd1 sky130_ef_sc_hd__decap_40_12$1
XFILLER_52_27 vccd1 vssd1 vccd1 vssd1 sky130_fd_sc_hd__fill_1$1
XFILLER_23_665 vssd1 vccd1 vccd1 vssd1 sky130_fd_sc_hd__fill_4$1
XFILLER_22_153 vssd1 vccd1 vccd1 vssd1 sky130_ef_sc_hd__decap_40_12$1
XFILLER_7_809 vssd1 vccd1 vccd1 vssd1 sky130_ef_sc_hd__decap_40_12$1
XFILLER_22_197 vssd1 vccd1 vccd1 vssd1 sky130_ef_sc_hd__decap_40_12$1
XTAP_TAPCELL_ROW_98_1765 vccd1 vssd1 sky130_fd_sc_hd__tapvpwrvgnd_1$1
XFILLER_136_545 vssd1 vccd1 vccd1 vssd1 sky130_ef_sc_hd__decap_40_12$1
XTAP_TAPCELL_ROW_98_1776 vccd1 vssd1 sky130_fd_sc_hd__tapvpwrvgnd_1$1
XFILLER_136_589 vssd1 vccd1 vccd1 vssd1 sky130_fd_sc_hd__fill_8$1
XFILLER_123_217 vssd1 vccd1 vccd1 vssd1 sky130_fd_sc_hd__fill_4$1
XFILLER_2_525 vssd1 vccd1 vccd1 vssd1 sky130_fd_sc_hd__fill_4$1
XFILLER_78_805 vssd1 vccd1 vccd1 vssd1 sky130_fd_sc_hd__fill_4$1
XFILLER_2_569 vssd1 vccd1 vccd1 vssd1 sky130_ef_sc_hd__decap_40_12$1
XFILLER_131_261 vssd1 vccd1 vccd1 vssd1 sky130_ef_sc_hd__decap_40_12$1
XTAP_TAPCELL_ROW_129_2242 vccd1 vssd1 sky130_fd_sc_hd__tapvpwrvgnd_1$1
XTAP_TAPCELL_ROW_129_2231 vccd1 vssd1 sky130_fd_sc_hd__tapvpwrvgnd_1$1
XFILLER_77_337 vssd1 vccd1 vccd1 vssd1 sky130_ef_sc_hd__decap_40_12$1
XFILLER_77_57 vssd1 vccd1 vccd1 vssd1 sky130_ef_sc_hd__decap_40_12$1
XFILLER_93_819 vssd1 vccd1 vccd1 vssd1 sky130_fd_sc_hd__fill_4$1
XFILLER_92_307 vccd1 vssd1 vccd1 vssd1 sky130_fd_sc_hd__fill_1$1
XTAP_TAPCELL_ROW_51_1061 vccd1 vssd1 sky130_fd_sc_hd__tapvpwrvgnd_1$1
XFILLER_100_670 vssd1 vccd1 vccd1 vssd1 sky130_fd_sc_hd__fill_2$1
XTAP_TAPCELL_ROW_51_1072 vccd1 vssd1 sky130_fd_sc_hd__tapvpwrvgnd_1$1
XTAP_TAPCELL_ROW_5_374 vccd1 vssd1 sky130_fd_sc_hd__tapvpwrvgnd_1$1
XFILLER_45_223 vccd1 vssd1 vccd1 vssd1 sky130_fd_sc_hd__fill_1$1
XFILLER_46_757 vssd1 vccd1 vccd1 vssd1 sky130_ef_sc_hd__decap_40_12$1
XFILLER_46_746 vssd1 vccd1 vccd1 vssd1 sky130_fd_sc_hd__fill_8$1
XFILLER_26_83 vccd1 vssd1 vccd1 vssd1 sky130_fd_sc_hd__fill_1$1
XFILLER_33_429 vssd1 vccd1 vccd1 vssd1 sky130_ef_sc_hd__decap_40_12$1
XTAP_TAPCELL_ROW_44_958 vccd1 vssd1 sky130_fd_sc_hd__tapvpwrvgnd_1$1
XFILLER_14_643 vccd1 vssd1 vccd1 vssd1 sky130_fd_sc_hd__fill_1$1
XFILLER_9_113 vssd1 vccd1 vccd1 vssd1 sky130_ef_sc_hd__decap_40_12$1
XTAP_TAPCELL_ROW_24_660 vccd1 vssd1 sky130_fd_sc_hd__tapvpwrvgnd_1$1
XFILLER_41_473 vssd1 vccd1 vccd1 vssd1 sky130_ef_sc_hd__decap_40_12$1
XFILLER_115_729 vssd1 vccd1 vccd1 vssd1 sky130_fd_sc_hd__fill_2$1
X_1410_ _1411_/A _1422_/B _1411_/B vccd1 vssd1 vccd1 vssd1 sky130_fd_sc_hd__and2_2$1
XFILLER_5_385 vssd1 vccd1 vccd1 vssd1 sky130_fd_sc_hd__fill_4$1
XFILLER_123_751 vssd1 vccd1 vccd1 vssd1 sky130_ef_sc_hd__decap_40_12$1
XFILLER_69_816 vssd1 vccd1 vccd1 vssd1 sky130_fd_sc_hd__fill_8$1
X_1341_ _1475_/C1 _1340_/X _1343_/A2 hold64/X _1699_/D vssd1 vccd1 vccd1 vssd1 sky130_fd_sc_hd__o211a_1$1
XFILLER_110_412 vssd1 vccd1 vccd1 vssd1 sky130_fd_sc_hd__fill_8$1
XFILLER_96_624 vssd1 vccd1 vccd1 vssd1 sky130_ef_sc_hd__decap_40_12$1
X_1272_ _1666_/Q _1272_/X _1272_/B vssd1 vccd1 vccd1 vssd1 sky130_fd_sc_hd__or2_1$1
XFILLER_96_657 vssd1 vccd1 vccd1 vssd1 sky130_ef_sc_hd__decap_40_12$1
XFILLER_95_167 vccd1 vssd1 vccd1 vssd1 sky130_fd_sc_hd__fill_1$1
XFILLER_83_329 vssd1 vccd1 vccd1 vssd1 sky130_fd_sc_hd__fill_4$1
XFILLER_49_573 vssd1 vccd1 vccd1 vssd1 sky130_ef_sc_hd__decap_40_12$1
XFILLER_37_702 vssd1 vccd1 vccd1 vssd1 sky130_ef_sc_hd__decap_40_12$1
XTAP_TAPCELL_ROW_69_1333 vccd1 vssd1 sky130_fd_sc_hd__tapvpwrvgnd_1$1
XFILLER_52_727 vccd1 vssd1 vccd1 vssd1 sky130_fd_sc_hd__fill_1$1
XFILLER_36_245 vssd1 vccd1 vccd1 vssd1 sky130_fd_sc_hd__fill_4$1
XFILLER_91_373 vssd1 vccd1 vccd1 vssd1 sky130_ef_sc_hd__decap_40_12$1
XTAP_TAPCELL_ROW_82_1533 vccd1 vssd1 sky130_fd_sc_hd__tapvpwrvgnd_1$1
XFILLER_51_237 vssd1 vccd1 vccd1 vssd1 sky130_ef_sc_hd__decap_40_12$1
XFILLER_36_289 vssd1 vccd1 vccd1 vssd1 sky130_ef_sc_hd__decap_40_12$1
XFILLER_60_793 vssd1 vccd1 vccd1 vssd1 sky130_ef_sc_hd__decap_40_12$1
XFILLER_20_613 vssd1 vccd1 vccd1 vssd1 sky130_ef_sc_hd__decap_40_12$1
XFILLER_32_473 vssd1 vccd1 vccd1 vssd1 sky130_fd_sc_hd__fill_2$1
XFILLER_20_657 vssd1 vccd1 vccd1 vssd1 sky130_ef_sc_hd__decap_40_12$1
XFILLER_118_512 vssd1 vccd1 vccd1 vssd1 sky130_ef_sc_hd__decap_40_12$1
X_0987_ _1449_/C1 _0986_/X _0991_/A2 hold98/X _1527_/D vssd1 vccd1 vccd1 vssd1 sky130_fd_sc_hd__o211a_1$1
XFILLER_118_545 vssd1 vccd1 vccd1 vssd1 sky130_ef_sc_hd__decap_40_12$1
XFILLER_118_589 vssd1 vccd1 vccd1 vssd1 sky130_ef_sc_hd__decap_40_12$1
XFILLER_105_217 vssd1 vccd1 vccd1 vssd1 sky130_fd_sc_hd__fill_4$1
X_1608_ _1795_/A _1608_/CLK _1608_/D vccd1 vssd1 vccd1 vssd1 sky130_fd_sc_hd__dfxtp_1$1
XFILLER_120_209 vssd1 vccd1 vccd1 vssd1 sky130_ef_sc_hd__decap_40_12$1
XTAP_TAPCELL_ROW_93_1695 vccd1 vssd1 sky130_fd_sc_hd__tapvpwrvgnd_1$1
XFILLER_87_602 vssd1 vccd1 vccd1 vssd1 sky130_ef_sc_hd__decap_40_12$1
X_1539_ hold69/A _1761_/CLK _1539_/D vccd1 vssd1 vccd1 vssd1 sky130_fd_sc_hd__dfxtp_1$1
XFILLER_113_261 vssd1 vccd1 vccd1 vssd1 sky130_ef_sc_hd__decap_40_12$1
XFILLER_99_473 vssd1 vccd1 vccd1 vssd1 sky130_ef_sc_hd__decap_40_12$1
XFILLER_59_337 vssd1 vccd1 vccd1 vssd1 sky130_ef_sc_hd__decap_40_12$1
XFILLER_47_27 vssd1 vccd1 vccd1 vssd1 sky130_ef_sc_hd__decap_40_12$1
XFILLER_86_189 vssd1 vccd1 vccd1 vssd1 sky130_fd_sc_hd__fill_4$1
XFILLER_74_307 vccd1 vssd1 vccd1 vssd1 sky130_fd_sc_hd__fill_1$1
XFILLER_83_841 vccd1 vssd1 vccd1 vssd1 sky130_fd_sc_hd__fill_1$1
XFILLER_55_521 vccd1 vssd1 vccd1 vssd1 sky130_fd_sc_hd__fill_1$1
XTAP_TAPCELL_ROW_2_333 vccd1 vssd1 sky130_fd_sc_hd__tapvpwrvgnd_1$1
XFILLER_27_223 vccd1 vssd1 vccd1 vssd1 sky130_fd_sc_hd__fill_1$1
XFILLER_28_757 vssd1 vccd1 vccd1 vssd1 sky130_ef_sc_hd__decap_40_12$1
XTAP_TAPCELL_ROW_124_2161 vccd1 vssd1 sky130_fd_sc_hd__tapvpwrvgnd_1$1
XFILLER_103_55 vccd1 vssd1 vccd1 vssd1 sky130_fd_sc_hd__fill_1$1
XFILLER_63_15 vssd1 vccd1 vccd1 vssd1 sky130_ef_sc_hd__decap_40_12$1
XFILLER_43_727 vccd1 vssd1 vccd1 vssd1 sky130_fd_sc_hd__fill_1$1
XFILLER_55_587 vccd1 vssd1 vccd1 vssd1 sky130_fd_sc_hd__fill_1$1
XFILLER_15_429 vssd1 vccd1 vccd1 vssd1 sky130_ef_sc_hd__decap_40_12$1
XFILLER_70_557 vssd1 vccd1 vccd1 vssd1 sky130_ef_sc_hd__decap_40_12$1
XFILLER_11_613 vssd1 vccd1 vccd1 vssd1 sky130_fd_sc_hd__fill_2$1
XFILLER_23_473 vssd1 vccd1 vccd1 vssd1 sky130_ef_sc_hd__decap_40_12$1
XTAP_TAPCELL_ROW_41_917 vccd1 vssd1 sky130_fd_sc_hd__tapvpwrvgnd_1$1
XFILLER_128_309 vssd1 vccd1 vccd1 vssd1 sky130_ef_sc_hd__decap_40_12$1
XFILLER_7_617 vssd1 vccd1 vccd1 vssd1 sky130_ef_sc_hd__decap_40_12$1
XFILLER_12_41 vssd1 vccd1 vccd1 vssd1 sky130_ef_sc_hd__decap_40_12$1
XFILLER_10_189 vssd1 vccd1 vccd1 vssd1 sky130_fd_sc_hd__fill_4$1
XFILLER_128_41 vssd1 vccd1 vccd1 vssd1 sky130_ef_sc_hd__decap_40_12$1
XFILLER_124_504 vccd1 vssd1 vccd1 vssd1 sky130_fd_sc_hd__fill_1$1
XFILLER_109_578 vssd1 vccd1 vccd1 vssd1 sky130_ef_sc_hd__decap_40_12$1
XFILLER_12_85 vssd1 vccd1 vccd1 vssd1 sky130_ef_sc_hd__decap_40_12$1
XFILLER_128_85 vssd1 vccd1 vccd1 vssd1 sky130_ef_sc_hd__decap_40_12$1
XTAP_TAPCELL_ROW_53_1101 vccd1 vssd1 sky130_fd_sc_hd__tapvpwrvgnd_1$1
XFILLER_2_333 vssd1 vccd1 vccd1 vssd1 sky130_ef_sc_hd__decap_40_12$1
XFILLER_132_581 vssd1 vccd1 vccd1 vssd1 sky130_fd_sc_hd__fill_4$1
Xhold190 _1716_/Q _1376_/A vssd1 vccd1 vccd1 vssd1 sky130_fd_sc_hd__dlygate4sd3_1$1
XFILLER_2_377 vssd1 vccd1 vccd1 vssd1 sky130_ef_sc_hd__decap_40_12$1
XFILLER_78_657 vssd1 vccd1 vccd1 vssd1 sky130_ef_sc_hd__decap_40_12$1
XFILLER_77_167 vccd1 vssd1 vccd1 vssd1 sky130_fd_sc_hd__fill_1$1
XFILLER_65_329 vssd1 vccd1 vccd1 vssd1 sky130_fd_sc_hd__fill_4$1
XTAP_TAPCELL_ROW_109_1934 vccd1 vssd1 sky130_fd_sc_hd__tapvpwrvgnd_1$1
XFILLER_92_137 vssd1 vccd1 vccd1 vssd1 sky130_fd_sc_hd__fill_2$1
XFILLER_58_381 vssd1 vccd1 vccd1 vssd1 sky130_fd_sc_hd__fill_2$1
XTAP_TAPCELL_ROW_29_730 vccd1 vssd1 sky130_fd_sc_hd__tapvpwrvgnd_1$1
XFILLER_46_521 vssd1 vccd1 vccd1 vssd1 sky130_fd_sc_hd__fill_2$1
XPHY_EDGE_ROW_16_Right_16 vccd1 vssd1 vccd1 vssd1 sky130_fd_sc_hd__decap_3$1
XFILLER_18_245 vssd1 vccd1 vccd1 vssd1 sky130_fd_sc_hd__fill_4$1
XTAP_TAPCELL_ROW_29_741 vccd1 vssd1 sky130_fd_sc_hd__tapvpwrvgnd_1$1
XFILLER_37_93 vssd1 vccd1 vccd1 vssd1 sky130_ef_sc_hd__decap_40_12$1
XFILLER_18_289 vssd1 vccd1 vccd1 vssd1 sky130_ef_sc_hd__decap_40_12$1
XFILLER_34_727 vssd1 vccd1 vccd1 vssd1 sky130_ef_sc_hd__decap_40_12$1
XFILLER_46_587 vccd1 vssd1 vccd1 vssd1 sky130_fd_sc_hd__fill_1$1
XFILLER_33_237 vssd1 vccd1 vccd1 vssd1 sky130_ef_sc_hd__decap_40_12$1
X_0910_ _0752_/A _1502_/D _0906_/X _1471_/C1 _1502_/Q _0909_/X vssd1 vccd1 vccd1 vssd1
+ sky130_fd_sc_hd__o221a_1$1
XTAP_TAPCELL_ROW_64_1263 vccd1 vssd1 sky130_fd_sc_hd__tapvpwrvgnd_1$1
XFILLER_53_81 vssd1 vccd1 vccd1 vssd1 sky130_ef_sc_hd__decap_40_12$1
XFILLER_14_473 vssd1 vccd1 vccd1 vssd1 sky130_fd_sc_hd__fill_2$1
XFILLER_41_281 vssd1 vccd1 vccd1 vssd1 sky130_ef_sc_hd__decap_40_12$1
XFILLER_128_810 vssd1 vccd1 vccd1 vssd1 sky130_fd_sc_hd__fill_2$1
X_0841_ _1523_/Q wire252/X _0841_/X _1855_/A _0881_/B1 vccd1 vssd1 vccd1 vssd1 sky130_fd_sc_hd__a22o_1$1
XPHY_EDGE_ROW_25_Right_25 vccd1 vssd1 vccd1 vssd1 sky130_fd_sc_hd__decap_3$1
X_0772_ _1790_/A _0879_/A2 _0772_/X input6/X _0826_/B1 vccd1 vssd1 vccd1 vssd1 sky130_fd_sc_hd__a22o_1$1
XFILLER_115_515 vccd1 vssd1 vccd1 vssd1 sky130_fd_sc_hd__fill_1$1
XFILLER_102_209 vssd1 vccd1 vccd1 vssd1 sky130_ef_sc_hd__decap_40_12$1
XFILLER_5_193 vssd1 vccd1 vccd1 vssd1 sky130_ef_sc_hd__decap_40_12$1
XFILLER_45_3 vssd1 vccd1 vccd1 vssd1 sky130_ef_sc_hd__decap_40_12$1
XFILLER_96_421 vssd1 vccd1 vccd1 vssd1 sky130_ef_sc_hd__decap_40_12$1
XFILLER_69_613 vssd1 vccd1 vccd1 vssd1 sky130_fd_sc_hd__fill_2$1
X_1324_ _1324_/A _1324_/X _1330_/B vssd1 vccd1 vccd1 vssd1 sky130_fd_sc_hd__or2_1$1
XFILLER_69_668 vssd1 vccd1 vccd1 vssd1 sky130_fd_sc_hd__fill_4$1
XFILLER_57_808 vssd1 vccd1 vccd1 vssd1 sky130_fd_sc_hd__fill_2$1
XFILLER_110_253 vssd1 vccd1 vccd1 vssd1 sky130_ef_sc_hd__decap_40_12$1
XFILLER_96_465 vssd1 vccd1 vccd1 vssd1 sky130_fd_sc_hd__fill_8$1
XFILLER_68_189 vssd1 vccd1 vccd1 vssd1 sky130_fd_sc_hd__fill_4$1
XFILLER_56_307 vccd1 vssd1 vccd1 vssd1 sky130_fd_sc_hd__fill_1$1
X_1255_ _1455_/C1 _1254_/X _1277_/A2 hold125/X _1657_/D vssd1 vccd1 vccd1 vssd1 sky130_fd_sc_hd__o211a_1$1
XFILLER_83_137 vssd1 vccd1 vccd1 vssd1 sky130_ef_sc_hd__decap_40_12$1
XFILLER_65_841 vccd1 vssd1 vccd1 vssd1 sky130_fd_sc_hd__fill_1$1
XPHY_EDGE_ROW_34_Right_34 vccd1 vssd1 vccd1 vssd1 sky130_fd_sc_hd__decap_3$1
X_1186_ _1186_/A _1186_/X _1210_/B vssd1 vccd1 vccd1 vssd1 sky130_fd_sc_hd__or2_1$1
XFILLER_80_811 vccd1 vssd1 vccd1 vssd1 sky130_fd_sc_hd__fill_1$1
XFILLER_52_502 vssd1 vccd1 vccd1 vssd1 sky130_ef_sc_hd__decap_40_12$1
XFILLER_92_693 vssd1 vccd1 vccd1 vssd1 sky130_fd_sc_hd__fill_4$1
XFILLER_91_181 vssd1 vccd1 vccd1 vssd1 sky130_ef_sc_hd__decap_40_12$1
XFILLER_52_557 vssd1 vccd1 vccd1 vssd1 sky130_ef_sc_hd__decap_40_12$1
XFILLER_33_782 vssd1 vccd1 vccd1 vssd1 sky130_fd_sc_hd__fill_2$1
XFILLER_20_421 vssd1 vccd1 vccd1 vssd1 sky130_ef_sc_hd__decap_40_12$1
XFILLER_119_821 vssd1 vccd1 vccd1 vssd1 sky130_fd_sc_hd__fill_2$1
XPHY_EDGE_ROW_43_Right_43 vccd1 vssd1 vccd1 vssd1 sky130_fd_sc_hd__decap_3$1
XFILLER_134_813 vssd1 vccd1 vccd1 vssd1 sky130_ef_sc_hd__decap_40_12$1
XTAP_TAPCELL_ROW_95_1724 vccd1 vssd1 sky130_fd_sc_hd__tapvpwrvgnd_1$1
XFILLER_118_397 vssd1 vccd1 vccd1 vssd1 sky130_ef_sc_hd__decap_40_12$1
XFILLER_121_507 vccd1 vssd1 vccd1 vssd1 sky130_fd_sc_hd__fill_1$1
XTAP_TAPCELL_ROW_7_403 vccd1 vssd1 sky130_fd_sc_hd__tapvpwrvgnd_1$1
XFILLER_99_281 vssd1 vccd1 vccd1 vssd1 sky130_ef_sc_hd__decap_40_12$1
XFILLER_58_15 vssd1 vccd1 vccd1 vssd1 sky130_ef_sc_hd__decap_40_12$1
XFILLER_102_754 vssd1 vccd1 vccd1 vssd1 sky130_fd_sc_hd__fill_2$1
XFILLER_59_167 vccd1 vssd1 vccd1 vssd1 sky130_fd_sc_hd__fill_1$1
XPHY_EDGE_ROW_52_Right_52 vccd1 vssd1 vccd1 vssd1 sky130_fd_sc_hd__decap_3$1
XFILLER_47_329 vssd1 vccd1 vccd1 vssd1 sky130_fd_sc_hd__fill_4$1
XFILLER_114_65 vssd1 vccd1 vccd1 vssd1 sky130_ef_sc_hd__decap_40_12$1
XFILLER_74_137 vssd1 vccd1 vccd1 vssd1 sky130_fd_sc_hd__fill_2$1
XFILLER_43_502 vssd1 vccd1 vccd1 vssd1 sky130_fd_sc_hd__fill_2$1
XFILLER_70_321 vssd1 vccd1 vccd1 vssd1 sky130_ef_sc_hd__decap_40_12$1
XFILLER_55_373 vssd1 vccd1 vccd1 vssd1 sky130_ef_sc_hd__decap_40_12$1
XFILLER_28_587 vccd1 vssd1 vccd1 vssd1 sky130_fd_sc_hd__fill_1$1
XFILLER_130_53 vssd1 vccd1 vccd1 vssd1 sky130_ef_sc_hd__decap_40_12$1
XFILLER_15_237 vssd1 vccd1 vccd1 vssd1 sky130_ef_sc_hd__decap_40_12$1
XFILLER_43_557 vssd1 vccd1 vccd1 vssd1 sky130_fd_sc_hd__fill_2$1
XFILLER_130_97 vssd1 vccd1 vccd1 vssd1 sky130_ef_sc_hd__decap_40_12$1
XTAP_TAPCELL_ROW_104_1864 vccd1 vssd1 sky130_fd_sc_hd__tapvpwrvgnd_1$1
XTAP_TAPCELL_ROW_104_1853 vccd1 vssd1 sky130_fd_sc_hd__tapvpwrvgnd_1$1
XFILLER_70_365 vssd1 vccd1 vccd1 vssd1 sky130_ef_sc_hd__decap_40_12$1
XFILLER_43_579 vssd1 vccd1 vccd1 vssd1 sky130_ef_sc_hd__decap_40_12$1
XPHY_EDGE_ROW_61_Right_61 vccd1 vssd1 vccd1 vssd1 sky130_fd_sc_hd__decap_3$1
XFILLER_23_281 vssd1 vccd1 vccd1 vssd1 sky130_ef_sc_hd__decap_40_12$1
XTAP_TAPCELL_ROW_137_2352 vccd1 vssd1 sky130_fd_sc_hd__tapvpwrvgnd_1$1
XFILLER_129_629 vssd1 vccd1 vccd1 vssd1 sky130_ef_sc_hd__decap_40_12$1
XFILLER_23_51 vssd1 vccd1 vccd1 vssd1 sky130_fd_sc_hd__fill_4$1
XFILLER_128_139 vccd1 vssd1 vccd1 vssd1 sky130_fd_sc_hd__fill_1$1
XFILLER_7_447 vccd1 vssd1 vccd1 vssd1 sky130_fd_sc_hd__fill_1$1
XFILLER_124_301 vssd1 vccd1 vccd1 vssd1 sky130_fd_sc_hd__fill_4$1
XFILLER_99_55 vccd1 vssd1 vccd1 vssd1 sky130_fd_sc_hd__fill_1$1
XFILLER_137_695 vssd1 vccd1 vccd1 vssd1 sky130_ef_sc_hd__decap_40_12$1
XFILLER_124_345 vssd1 vccd1 vccd1 vssd1 sky130_ef_sc_hd__decap_40_12$1
XFILLER_3_653 vssd1 vccd1 vccd1 vssd1 sky130_ef_sc_hd__decap_40_12$1
XFILLER_124_389 vssd1 vccd1 vccd1 vssd1 sky130_ef_sc_hd__decap_40_12$1
XFILLER_112_529 vssd1 vccd1 vccd1 vssd1 sky130_fd_sc_hd__fill_2$1
XFILLER_78_421 vssd1 vccd1 vccd1 vssd1 sky130_ef_sc_hd__decap_40_12$1
XPHY_EDGE_ROW_70_Right_70 vccd1 vssd1 vccd1 vssd1 sky130_fd_sc_hd__decap_3$1
XFILLER_3_697 vssd1 vccd1 vccd1 vssd1 sky130_ef_sc_hd__decap_40_12$1
XFILLER_2_141 vssd1 vccd1 vccd1 vssd1 sky130_ef_sc_hd__decap_40_12$1
XFILLER_78_465 vssd1 vccd1 vccd1 vssd1 sky130_fd_sc_hd__fill_8$1
XFILLER_38_307 vccd1 vssd1 vccd1 vssd1 sky130_fd_sc_hd__fill_1$1
XFILLER_93_435 vssd1 vccd1 vccd1 vssd1 sky130_ef_sc_hd__decap_40_12$1
XFILLER_65_137 vssd1 vccd1 vccd1 vssd1 sky130_ef_sc_hd__decap_40_12$1
XFILLER_47_841 vccd1 vssd1 vccd1 vssd1 sky130_fd_sc_hd__fill_1$1
XFILLER_48_81 vssd1 vccd1 vccd1 vssd1 sky130_fd_sc_hd__fill_2$1
X_1040_ _1553_/Q _1040_/X _1078_/B vssd1 vccd1 vccd1 vssd1 sky130_fd_sc_hd__or2_1$1
XFILLER_74_693 vssd1 vccd1 vccd1 vssd1 sky130_fd_sc_hd__fill_4$1
XFILLER_0_55 vccd1 vssd1 vccd1 vssd1 sky130_fd_sc_hd__fill_1$1
XFILLER_34_513 vssd1 vccd1 vccd1 vssd1 sky130_ef_sc_hd__decap_40_12$1
XFILLER_73_181 vssd1 vccd1 vccd1 vssd1 sky130_ef_sc_hd__decap_40_12$1
XFILLER_34_557 vssd1 vccd1 vccd1 vssd1 sky130_ef_sc_hd__decap_40_12$1
XPHY_EDGE_ROW_14_Left_153 vccd1 vssd1 vccd1 vssd1 sky130_fd_sc_hd__decap_3$1
X_0824_ _0879_/B1 _0824_/X _0823_/X _1520_/Q _0875_/A2 _0822_/X vssd1 vccd1 vccd1
+ vssd1 sky130_fd_sc_hd__a2111o_1$1
XFILLER_134_109 vssd1 vccd1 vccd1 vssd1 sky130_ef_sc_hd__decap_40_12$1
XTAP_TAPCELL_ROW_12_482 vccd1 vssd1 sky130_fd_sc_hd__tapvpwrvgnd_1$1
XFILLER_127_161 vssd1 vccd1 vccd1 vssd1 sky130_fd_sc_hd__fill_4$1
XTAP_TAPCELL_ROW_77_1454 vccd1 vssd1 sky130_fd_sc_hd__tapvpwrvgnd_1$1
X_0755_ _1792_/A _0878_/A2 _0755_/X _1841_/A _0881_/B1 vccd1 vssd1 vccd1 vssd1 sky130_fd_sc_hd__a22o_1$1
XPHY_EDGE_ROW_23_Left_162 vccd1 vssd1 vccd1 vssd1 sky130_fd_sc_hd__decap_3$1
XFILLER_115_389 vssd1 vccd1 vccd1 vssd1 sky130_fd_sc_hd__fill_2$1
XTAP_TAPCELL_ROW_90_1643 vccd1 vssd1 sky130_fd_sc_hd__tapvpwrvgnd_1$1
XFILLER_97_741 vssd1 vccd1 vccd1 vssd1 sky130_fd_sc_hd__fill_8$1
XTAP_TAPCELL_ROW_90_1654 vccd1 vssd1 sky130_fd_sc_hd__tapvpwrvgnd_1$1
XFILLER_111_573 vssd1 vccd1 vccd1 vssd1 sky130_ef_sc_hd__decap_40_12$1
XFILLER_97_785 vssd1 vccd1 vccd1 vssd1 sky130_fd_sc_hd__fill_8$1
XFILLER_96_251 vccd1 vssd1 vccd1 vssd1 sky130_fd_sc_hd__fill_1$1
XFILLER_28_29 vssd1 vccd1 vccd1 vssd1 sky130_ef_sc_hd__decap_40_12$1
X_1307_ _1443_/C1 _1306_/X _1331_/A2 hold21/X _1682_/D vssd1 vccd1 vccd1 vssd1 sky130_fd_sc_hd__o211a_1$1
XFILLER_69_498 vssd1 vccd1 vccd1 vssd1 sky130_fd_sc_hd__fill_4$1
XFILLER_56_137 vssd1 vccd1 vccd1 vssd1 sky130_fd_sc_hd__fill_2$1
XFILLER_29_329 vssd1 vccd1 vccd1 vssd1 sky130_fd_sc_hd__fill_4$1
X_1238_ _1649_/Q _1238_/X _1270_/B vssd1 vccd1 vccd1 vssd1 sky130_fd_sc_hd__or2_1$1
XTAP_TAPCELL_ROW_121_2120 vccd1 vssd1 sky130_fd_sc_hd__tapvpwrvgnd_1$1
XFILLER_65_671 vccd1 vssd1 vccd1 vssd1 sky130_fd_sc_hd__fill_1$1
XFILLER_37_373 vssd1 vccd1 vccd1 vssd1 sky130_ef_sc_hd__decap_40_12$1
X_1169_ _1431_/C1 _1168_/X _1189_/A2 hold142/X _1615_/D vssd1 vccd1 vccd1 vssd1 sky130_fd_sc_hd__o211a_1$1
XFILLER_52_321 vssd1 vccd1 vccd1 vssd1 sky130_ef_sc_hd__decap_40_12$1
XFILLER_25_557 vssd1 vccd1 vccd1 vssd1 sky130_fd_sc_hd__fill_2$1
XPHY_EDGE_ROW_32_Left_171 vccd1 vssd1 vccd1 vssd1 sky130_fd_sc_hd__decap_3$1
XFILLER_52_365 vssd1 vccd1 vccd1 vssd1 sky130_ef_sc_hd__decap_40_12$1
XFILLER_21_741 vssd1 vccd1 vccd1 vssd1 sky130_ef_sc_hd__decap_40_12$1
XFILLER_60_27 vccd1 vssd1 vccd1 vssd1 sky130_fd_sc_hd__fill_1$1
XFILLER_20_251 vccd1 vssd1 vccd1 vssd1 sky130_fd_sc_hd__fill_1$1
XFILLER_21_785 vssd1 vccd1 vccd1 vssd1 sky130_ef_sc_hd__decap_40_12$1
XFILLER_125_109 vssd1 vccd1 vccd1 vssd1 sky130_fd_sc_hd__fill_2$1
XFILLER_119_673 vssd1 vccd1 vccd1 vssd1 sky130_fd_sc_hd__fill_2$1
XTAP_TAPCELL_ROW_119_2082 vccd1 vssd1 sky130_fd_sc_hd__tapvpwrvgnd_1$1
XFILLER_106_301 vssd1 vccd1 vccd1 vssd1 sky130_fd_sc_hd__fill_4$1
XFILLER_4_417 vssd1 vccd1 vccd1 vssd1 sky130_fd_sc_hd__fill_2$1
XPHY_EDGE_ROW_41_Left_180 vccd1 vssd1 vccd1 vssd1 sky130_fd_sc_hd__decap_3$1
XFILLER_134_665 vssd1 vccd1 vccd1 vssd1 sky130_fd_sc_hd__fill_2$1
XTAP_TAPCELL_ROW_132_2282 vccd1 vssd1 sky130_fd_sc_hd__tapvpwrvgnd_1$1
XFILLER_122_805 vssd1 vccd1 vccd1 vssd1 sky130_fd_sc_hd__fill_4$1
XFILLER_106_345 vssd1 vccd1 vccd1 vssd1 sky130_ef_sc_hd__decap_40_12$1
XFILLER_106_389 vccd1 vssd1 vccd1 vssd1 sky130_fd_sc_hd__fill_1$1
XFILLER_69_69 vssd1 vccd1 vccd1 vssd1 sky130_ef_sc_hd__decap_40_12$1
XFILLER_0_601 vssd1 vccd1 vccd1 vssd1 sky130_ef_sc_hd__decap_40_12$1
XFILLER_121_337 vssd1 vccd1 vccd1 vssd1 sky130_ef_sc_hd__decap_40_12$1
XFILLER_0_645 vssd1 vccd1 vccd1 vssd1 sky130_ef_sc_hd__decap_40_12$1
XFILLER_102_573 vssd1 vccd1 vccd1 vssd1 sky130_ef_sc_hd__decap_40_12$1
XFILLER_88_785 vssd1 vccd1 vccd1 vssd1 sky130_ef_sc_hd__decap_40_12$1
XFILLER_48_616 vccd1 vssd1 vccd1 vssd1 sky130_fd_sc_hd__fill_1$1
XFILLER_87_273 vssd1 vccd1 vccd1 vssd1 sky130_fd_sc_hd__fill_4$1
XFILLER_85_57 vssd1 vccd1 vccd1 vssd1 sky130_ef_sc_hd__decap_40_12$1
XFILLER_29_841 vccd1 vssd1 vccd1 vssd1 sky130_fd_sc_hd__fill_1$1
XFILLER_47_137 vssd1 vccd1 vccd1 vssd1 sky130_ef_sc_hd__decap_40_12$1
XFILLER_63_608 vccd1 vssd1 vccd1 vssd1 sky130_fd_sc_hd__fill_1$1
XFILLER_56_693 vssd1 vccd1 vccd1 vssd1 sky130_fd_sc_hd__fill_4$1
XFILLER_16_513 vssd1 vccd1 vccd1 vssd1 sky130_ef_sc_hd__decap_40_12$1
XTAP_TAPCELL_ROW_39_880 vccd1 vssd1 sky130_fd_sc_hd__tapvpwrvgnd_1$1
XTAP_TAPCELL_ROW_48_1022 vccd1 vssd1 sky130_fd_sc_hd__tapvpwrvgnd_1$1
XFILLER_55_181 vssd1 vccd1 vccd1 vssd1 sky130_ef_sc_hd__decap_40_12$1
XFILLER_16_557 vssd1 vccd1 vccd1 vssd1 sky130_ef_sc_hd__decap_40_12$1
XTAP_TAPCELL_ROW_39_891 vccd1 vssd1 sky130_fd_sc_hd__tapvpwrvgnd_1$1
XFILLER_71_685 vssd1 vccd1 vccd1 vssd1 sky130_fd_sc_hd__fill_4$1
XFILLER_31_505 vssd1 vccd1 vccd1 vssd1 sky130_ef_sc_hd__decap_40_12$1
XFILLER_70_195 vccd1 vssd1 vccd1 vssd1 sky130_fd_sc_hd__fill_1$1
XTAP_TAPCELL_ROW_61_1222 vccd1 vssd1 sky130_fd_sc_hd__tapvpwrvgnd_1$1
XTAP_TAPCELL_ROW_61_1211 vccd1 vssd1 sky130_fd_sc_hd__tapvpwrvgnd_1$1
XFILLER_8_701 vssd1 vccd1 vccd1 vssd1 sky130_ef_sc_hd__decap_40_12$1
XFILLER_34_83 vccd1 vssd1 vccd1 vssd1 sky130_fd_sc_hd__fill_1$1
XFILLER_11_273 vssd1 vccd1 vccd1 vssd1 sky130_fd_sc_hd__fill_4$1
XFILLER_116_109 vssd1 vccd1 vccd1 vssd1 sky130_ef_sc_hd__decap_40_12$1
XFILLER_109_161 vssd1 vccd1 vccd1 vssd1 sky130_fd_sc_hd__fill_4$1
XFILLER_7_277 vssd1 vccd1 vccd1 vssd1 sky130_fd_sc_hd__fill_2$1
XTAP_TAPCELL_ROW_59_1184 vccd1 vssd1 sky130_fd_sc_hd__tapvpwrvgnd_1$1
XFILLER_124_153 vssd1 vccd1 vccd1 vssd1 sky130_ef_sc_hd__decap_40_12$1
XFILLER_3_461 vssd1 vccd1 vccd1 vssd1 sky130_ef_sc_hd__decap_40_12$1
XFILLER_124_197 vssd1 vccd1 vccd1 vssd1 sky130_ef_sc_hd__decap_40_12$1
XFILLER_79_785 vssd1 vccd1 vccd1 vssd1 sky130_fd_sc_hd__fill_2$1
XFILLER_78_251 vccd1 vssd1 vccd1 vssd1 sky130_fd_sc_hd__fill_1$1
XTAP_TAPCELL_ROW_72_1384 vccd1 vssd1 sky130_fd_sc_hd__tapvpwrvgnd_1$1
XTAP_TAPCELL_ROW_72_1373 vccd1 vssd1 sky130_fd_sc_hd__tapvpwrvgnd_1$1
XFILLER_120_381 vssd1 vccd1 vccd1 vssd1 sky130_ef_sc_hd__decap_40_12$1
XFILLER_93_221 vssd1 vccd1 vccd1 vssd1 sky130_fd_sc_hd__fill_2$1
XFILLER_38_137 vssd1 vccd1 vccd1 vssd1 sky130_fd_sc_hd__fill_2$1
XFILLER_66_457 vssd1 vccd1 vccd1 vssd1 sky130_ef_sc_hd__decap_40_12$1
XFILLER_19_373 vssd1 vccd1 vccd1 vssd1 sky130_ef_sc_hd__decap_40_12$1
X_1023_ _1091_/C1 _1022_/X _1053_/A2 hold67/X _1544_/D vssd1 vccd1 vccd1 vssd1 sky130_fd_sc_hd__o211a_1$1
XFILLER_47_693 vccd1 vssd1 vccd1 vssd1 sky130_fd_sc_hd__fill_1$1
XFILLER_47_671 vccd1 vssd1 vccd1 vssd1 sky130_fd_sc_hd__fill_1$1
XFILLER_81_449 vssd1 vccd1 vccd1 vssd1 sky130_ef_sc_hd__decap_40_12$1
XFILLER_62_641 vssd1 vccd1 vccd1 vssd1 sky130_fd_sc_hd__fill_2$1
XFILLER_34_321 vssd1 vccd1 vccd1 vssd1 sky130_ef_sc_hd__decap_40_12$1
XTAP_TAPCELL_ROW_17_552 vccd1 vssd1 sky130_fd_sc_hd__tapvpwrvgnd_1$1
XFILLER_34_365 vssd1 vccd1 vccd1 vssd1 sky130_ef_sc_hd__decap_40_12$1
Xclkbuf_leaf_6_wb_clk_i _1717_/CLK clkbuf_leaf_9_wb_clk_i/A vssd1 vccd1 vccd1 vssd1
+ sky130_fd_sc_hd__clkbuf_8$1
XFILLER_107_109 vssd1 vccd1 vccd1 vssd1 sky130_fd_sc_hd__fill_2$1
XFILLER_116_621 vccd1 vssd1 vccd1 vssd1 sky130_fd_sc_hd__fill_1$1
X_0807_ _0880_/A2 _1485_/D _0803_/X _1447_/C1 _1485_/Q _0806_/X vssd1 vccd1 vccd1
+ vssd1 sky130_fd_sc_hd__o221a_1$1
X_1787_ vccd1 vssd1 _1787_/X _1787_/A vccd1 vssd1 sky130_fd_sc_hd__buf_1$1
X_0738_ _0738_/A _0738_/Y vccd1 vssd1 vccd1 vssd1 sky130_fd_sc_hd__inv_2$1
XFILLER_116_643 vccd1 vssd1 vccd1 vssd1 sky130_fd_sc_hd__fill_1$1
XFILLER_89_505 vssd1 vccd1 vccd1 vssd1 sky130_ef_sc_hd__decap_40_12$1
XFILLER_131_613 vssd1 vccd1 vccd1 vssd1 sky130_fd_sc_hd__fill_2$1
XFILLER_116_698 vssd1 vccd1 vccd1 vssd1 sky130_fd_sc_hd__fill_2$1
XFILLER_103_337 vssd1 vccd1 vccd1 vssd1 sky130_ef_sc_hd__decap_40_12$1
XFILLER_39_39 vssd1 vccd1 vccd1 vssd1 sky130_ef_sc_hd__decap_40_12$1
XFILLER_57_402 vssd1 vccd1 vccd1 vssd1 sky130_ef_sc_hd__decap_40_12$1
XFILLER_130_189 vssd1 vccd1 vccd1 vssd1 sky130_fd_sc_hd__fill_4$1
XFILLER_84_221 vssd1 vccd1 vccd1 vssd1 sky130_ef_sc_hd__decap_40_12$1
XFILLER_69_273 vssd1 vccd1 vccd1 vssd1 sky130_fd_sc_hd__fill_4$1
XFILLER_57_446 vssd1 vccd1 vccd1 vssd1 sky130_fd_sc_hd__fill_2$1
XPHY_EDGE_ROW_2_Right_2 vccd1 vssd1 vccd1 vssd1 sky130_fd_sc_hd__decap_3$1
XFILLER_29_137 vssd1 vccd1 vccd1 vssd1 sky130_ef_sc_hd__decap_40_12$1
XFILLER_84_265 vssd1 vccd1 vccd1 vssd1 sky130_ef_sc_hd__decap_40_12$1
XFILLER_55_27 vssd1 vccd1 vccd1 vssd1 sky130_ef_sc_hd__decap_40_12$1
XFILLER_26_811 vccd1 vssd1 vccd1 vssd1 sky130_fd_sc_hd__fill_1$1
XFILLER_53_641 vssd1 vccd1 vccd1 vssd1 sky130_ef_sc_hd__decap_40_12$1
XFILLER_37_181 vssd1 vccd1 vccd1 vssd1 sky130_ef_sc_hd__decap_40_12$1
XFILLER_38_693 vssd1 vccd1 vccd1 vssd1 sky130_fd_sc_hd__fill_4$1
XFILLER_111_55 vccd1 vssd1 vccd1 vssd1 sky130_fd_sc_hd__fill_1$1
XFILLER_80_460 vssd1 vccd1 vccd1 vssd1 sky130_ef_sc_hd__decap_40_12$1
XFILLER_13_505 vssd1 vccd1 vccd1 vssd1 sky130_ef_sc_hd__decap_40_12$1
XTAP_TAPCELL_ROW_101_1812 vccd1 vssd1 sky130_fd_sc_hd__tapvpwrvgnd_1$1
XFILLER_71_15 vssd1 vccd1 vccd1 vssd1 sky130_ef_sc_hd__decap_40_12$1
XFILLER_52_195 vccd1 vssd1 vccd1 vssd1 sky130_fd_sc_hd__fill_1$1
XFILLER_40_357 vssd1 vccd1 vccd1 vssd1 sky130_fd_sc_hd__fill_4$1
XTAP_TAPCELL_ROW_134_2311 vccd1 vssd1 sky130_fd_sc_hd__tapvpwrvgnd_1$1
XFILLER_126_429 vssd1 vccd1 vccd1 vssd1 sky130_fd_sc_hd__fill_2$1
XFILLER_112_3 vssd1 vccd1 vccd1 vssd1 sky130_ef_sc_hd__decap_40_12$1
XFILLER_107_610 vccd1 vssd1 vccd1 vssd1 sky130_fd_sc_hd__fill_1$1
XFILLER_20_41 vssd1 vccd1 vccd1 vssd1 sky130_ef_sc_hd__decap_40_12$1
XFILLER_136_41 vssd1 vccd1 vccd1 vssd1 sky130_ef_sc_hd__decap_40_12$1
XFILLER_134_462 vssd1 vccd1 vccd1 vssd1 sky130_fd_sc_hd__fill_2$1
XFILLER_122_613 vssd1 vccd1 vccd1 vssd1 sky130_ef_sc_hd__decap_40_12$1
XFILLER_106_153 vssd1 vccd1 vccd1 vssd1 sky130_ef_sc_hd__decap_40_12$1
XFILLER_20_85 vssd1 vccd1 vccd1 vssd1 sky130_ef_sc_hd__decap_40_12$1
XFILLER_136_85 vssd1 vccd1 vccd1 vssd1 sky130_fd_sc_hd__fill_4$1
XFILLER_122_657 vssd1 vccd1 vccd1 vssd1 sky130_ef_sc_hd__decap_40_12$1
XFILLER_106_197 vssd1 vccd1 vccd1 vssd1 sky130_ef_sc_hd__decap_40_12$1
XFILLER_121_167 vccd1 vssd1 vccd1 vssd1 sky130_fd_sc_hd__fill_1$1
XTAP_TAPCELL_ROW_112_1985 vccd1 vssd1 sky130_fd_sc_hd__tapvpwrvgnd_1$1
XTAP_TAPCELL_ROW_112_1974 vccd1 vssd1 sky130_fd_sc_hd__tapvpwrvgnd_1$1
XFILLER_95_519 vccd1 vssd1 vccd1 vssd1 sky130_fd_sc_hd__fill_1$1
Xhold50 hold50/A hold50/X vssd1 vccd1 vccd1 vssd1 sky130_fd_sc_hd__dlygate4sd3_1$1
XFILLER_75_221 vssd1 vccd1 vccd1 vssd1 sky130_fd_sc_hd__fill_2$1
XFILLER_0_475 vccd1 vssd1 vccd1 vssd1 sky130_fd_sc_hd__fill_1$1
XFILLER_48_413 vssd1 vccd1 vccd1 vssd1 sky130_fd_sc_hd__fill_4$1
XFILLER_48_435 vccd1 vssd1 vccd1 vssd1 sky130_fd_sc_hd__fill_1$1
Xhold72 hold72/A hold72/X vssd1 vccd1 vccd1 vssd1 sky130_fd_sc_hd__dlygate4sd3_1$1
Xhold83 hold83/A hold83/X vssd1 vccd1 vccd1 vssd1 sky130_fd_sc_hd__dlygate4sd3_1$1
Xhold61 hold61/A hold61/X vssd1 vccd1 vccd1 vssd1 sky130_fd_sc_hd__dlygate4sd3_1$1
XFILLER_76_755 vccd1 vssd1 vccd1 vssd1 sky130_fd_sc_hd__fill_1$1
Xhold94 hold94/A hold94/X vssd1 vccd1 vccd1 vssd1 sky130_fd_sc_hd__dlygate4sd3_1$1
XFILLER_29_671 vccd1 vssd1 vccd1 vssd1 sky130_fd_sc_hd__fill_1$1
XFILLER_91_769 vssd1 vccd1 vccd1 vssd1 sky130_ef_sc_hd__decap_40_12$1
XFILLER_63_449 vssd1 vccd1 vccd1 vssd1 sky130_ef_sc_hd__decap_40_12$1
XFILLER_16_321 vssd1 vccd1 vccd1 vssd1 sky130_ef_sc_hd__decap_40_12$1
XFILLER_44_641 vssd1 vccd1 vccd1 vssd1 sky130_fd_sc_hd__fill_2$1
XFILLER_16_365 vssd1 vccd1 vccd1 vssd1 sky130_ef_sc_hd__decap_40_12$1
XTAP_TAPCELL_ROW_34_809 vccd1 vssd1 sky130_fd_sc_hd__tapvpwrvgnd_1$1
XFILLER_71_471 vccd1 vssd1 vccd1 vssd1 sky130_fd_sc_hd__fill_1$1
XTAP_TAPCELL_ROW_14_511 vccd1 vssd1 sky130_fd_sc_hd__tapvpwrvgnd_1$1
XFILLER_31_335 vccd1 vssd1 vccd1 vssd1 sky130_fd_sc_hd__fill_1$1
XFILLER_45_93 vssd1 vccd1 vccd1 vssd1 sky130_ef_sc_hd__decap_40_12$1
XFILLER_129_223 vccd1 vssd1 vccd1 vssd1 sky130_fd_sc_hd__fill_1$1
XFILLER_8_531 vccd1 vssd1 vccd1 vssd1 sky130_fd_sc_hd__fill_1$1
XFILLER_129_245 vccd1 vssd1 vccd1 vssd1 sky130_fd_sc_hd__fill_1$1
X_1710_ _1833_/A _1742_/CLK _1710_/D vccd1 vssd1 vccd1 vssd1 sky130_fd_sc_hd__dfxtp_1$1
XFILLER_61_81 vssd1 vccd1 vccd1 vssd1 sky130_ef_sc_hd__decap_40_12$1
XFILLER_129_278 vssd1 vccd1 vccd1 vssd1 sky130_fd_sc_hd__fill_2$1
XANTENNA_3 _0842_/X vssd1 vccd1 vccd1 vssd1 sky130_fd_sc_hd__diode_2$1
X_1641_ _1641_/Q _1736_/CLK _1641_/D vccd1 vssd1 vccd1 vssd1 sky130_fd_sc_hd__dfxtp_1$1
XTAP_TAPCELL_ROW_74_1413 vccd1 vssd1 sky130_fd_sc_hd__tapvpwrvgnd_1$1
XFILLER_6_65 vssd1 vccd1 vccd1 vssd1 sky130_ef_sc_hd__decap_40_12$1
X_1572_ hold15/A _1764_/CLK _1572_/D vccd1 vssd1 vccd1 vssd1 sky130_fd_sc_hd__dfxtp_1$1
XFILLER_113_613 vssd1 vccd1 vccd1 vssd1 sky130_fd_sc_hd__fill_2$1
XFILLER_125_495 vccd1 vssd1 vccd1 vssd1 sky130_fd_sc_hd__fill_1$1
XFILLER_98_357 vssd1 vccd1 vccd1 vssd1 sky130_fd_sc_hd__fill_4$1
XFILLER_4_781 vssd1 vccd1 vccd1 vssd1 sky130_ef_sc_hd__decap_40_12$1
XFILLER_100_307 vccd1 vssd1 vccd1 vssd1 sky130_fd_sc_hd__fill_1$1
XFILLER_98_379 vccd1 vssd1 vccd1 vssd1 sky130_fd_sc_hd__fill_1$1
XFILLER_112_189 vssd1 vccd1 vccd1 vssd1 sky130_fd_sc_hd__fill_4$1
XFILLER_94_530 vssd1 vccd1 vccd1 vssd1 sky130_fd_sc_hd__fill_2$1
XFILLER_66_221 vssd1 vccd1 vccd1 vssd1 sky130_ef_sc_hd__decap_40_12$1
XFILLER_94_585 vssd1 vccd1 vccd1 vssd1 sky130_fd_sc_hd__fill_2$1
XFILLER_82_714 vssd1 vccd1 vccd1 vssd1 sky130_ef_sc_hd__decap_40_12$1
XFILLER_66_265 vssd1 vccd1 vccd1 vssd1 sky130_ef_sc_hd__decap_40_12$1
XFILLER_19_181 vssd1 vccd1 vccd1 vssd1 sky130_ef_sc_hd__decap_40_12$1
X_1006_ _1006_/A _1006_/X _1012_/B vssd1 vccd1 vccd1 vssd1 sky130_fd_sc_hd__or2_1$1
XTAP_TAPCELL_ROW_85_1575 vccd1 vssd1 sky130_fd_sc_hd__tapvpwrvgnd_1$1
XFILLER_81_279 vccd1 vssd1 vccd1 vssd1 sky130_fd_sc_hd__fill_1$1
XFILLER_50_677 vssd1 vccd1 vccd1 vssd1 sky130_fd_sc_hd__fill_2$1
XFILLER_22_357 vssd1 vccd1 vccd1 vssd1 sky130_fd_sc_hd__fill_4$1
XFILLER_34_195 vccd1 vssd1 vccd1 vssd1 sky130_fd_sc_hd__fill_1$1
XFILLER_50_699 vccd1 vssd1 vccd1 vssd1 sky130_fd_sc_hd__fill_1$1
XTAP_TAPCELL_ROW_116_2041 vccd1 vssd1 sky130_fd_sc_hd__tapvpwrvgnd_1$1
X_1839_ _1839_/A _1839_/X vssd1 vccd1 vccd1 vssd1 sky130_fd_sc_hd__clkbuf_2$1
XFILLER_135_237 vssd1 vccd1 vccd1 vssd1 sky130_ef_sc_hd__decap_40_12$1
XFILLER_104_613 vssd1 vccd1 vccd1 vssd1 sky130_ef_sc_hd__decap_40_12$1
XFILLER_104_657 vssd1 vccd1 vccd1 vssd1 sky130_ef_sc_hd__decap_40_12$1
XFILLER_89_335 vccd1 vssd1 vccd1 vssd1 sky130_fd_sc_hd__fill_1$1
XFILLER_1_217 vssd1 vccd1 vccd1 vssd1 sky130_fd_sc_hd__fill_4$1
XFILLER_103_167 vccd1 vssd1 vccd1 vssd1 sky130_fd_sc_hd__fill_1$1
XFILLER_106_77 vssd1 vccd1 vccd1 vssd1 sky130_fd_sc_hd__fill_4$1
XFILLER_66_15 vssd1 vccd1 vccd1 vssd1 sky130_ef_sc_hd__decap_40_12$1
XFILLER_100_841 vccd1 vssd1 vccd1 vssd1 sky130_fd_sc_hd__fill_1$1
XFILLER_85_541 vssd1 vccd1 vccd1 vssd1 sky130_ef_sc_hd__decap_40_12$1
XFILLER_57_221 vssd1 vccd1 vccd1 vssd1 sky130_fd_sc_hd__fill_2$1
XFILLER_85_585 vssd1 vccd1 vccd1 vssd1 sky130_ef_sc_hd__decap_40_12$1
XFILLER_45_405 vssd1 vccd1 vccd1 vssd1 sky130_ef_sc_hd__decap_40_12$1
XFILLER_122_65 vssd1 vccd1 vccd1 vssd1 sky130_ef_sc_hd__decap_40_12$1
XFILLER_26_641 vssd1 vccd1 vccd1 vssd1 sky130_fd_sc_hd__fill_2$1
XFILLER_45_449 vssd1 vccd1 vccd1 vssd1 sky130_fd_sc_hd__fill_4$1
XFILLER_60_419 vccd1 vssd1 vccd1 vssd1 sky130_fd_sc_hd__fill_1$1
XTAP_TAPCELL_ROW_0_283 vccd1 vssd1 sky130_fd_sc_hd__tapvpwrvgnd_1$1
XTAP_TAPCELL_ROW_0_294 vccd1 vssd1 sky130_fd_sc_hd__tapvpwrvgnd_1$1
XFILLER_14_825 vccd1 vssd1 vccd1 vssd1 sky130_fd_sc_hd__fill_1$1
XFILLER_13_335 vccd1 vssd1 vccd1 vssd1 sky130_fd_sc_hd__fill_1$1
XFILLER_40_121 vssd1 vccd1 vccd1 vssd1 sky130_ef_sc_hd__decap_40_12$1
XFILLER_41_677 vccd1 vssd1 vccd1 vssd1 sky130_fd_sc_hd__fill_1$1
XFILLER_9_317 vssd1 vccd1 vccd1 vssd1 sky130_ef_sc_hd__decap_40_12$1
XFILLER_40_165 vssd1 vccd1 vccd1 vssd1 sky130_ef_sc_hd__decap_40_12$1
XFILLER_5_501 vssd1 vccd1 vccd1 vssd1 sky130_fd_sc_hd__fill_2$1
XFILLER_31_51 vssd1 vccd1 vccd1 vssd1 sky130_fd_sc_hd__fill_4$1
XTAP_TAPCELL_ROW_56_1143 vccd1 vssd1 sky130_fd_sc_hd__tapvpwrvgnd_1$1
Xoutput73 _1853_/X analog_ctrl[120] vssd1 vccd1 vccd1 vssd1 sky130_fd_sc_hd__buf_12$1
Xoutput62 _1843_/X analog_ctrl[110] vssd1 vccd1 vccd1 vssd1 sky130_fd_sc_hd__buf_12$1
XFILLER_95_305 vssd1 vccd1 vccd1 vssd1 sky130_ef_sc_hd__decap_40_12$1
Xoutput84 _1773_/X analog_ctrl[1] vssd1 vccd1 vccd1 vssd1 sky130_fd_sc_hd__buf_12$1
XFILLER_122_487 vssd1 vccd1 vccd1 vssd1 sky130_ef_sc_hd__decap_40_12$1
XFILLER_49_711 vssd1 vccd1 vccd1 vssd1 sky130_ef_sc_hd__decap_40_12$1
Xoutput95 _1774_/X analog_ctrl[2] vssd1 vccd1 vccd1 vssd1 sky130_fd_sc_hd__buf_12$1
XFILLER_95_349 vssd1 vccd1 vccd1 vssd1 sky130_ef_sc_hd__decap_40_12$1
XFILLER_76_530 vssd1 vccd1 vccd1 vssd1 sky130_fd_sc_hd__fill_2$1
XFILLER_48_221 vssd1 vccd1 vccd1 vssd1 sky130_ef_sc_hd__decap_40_12$1
XFILLER_64_725 vssd1 vccd1 vccd1 vssd1 sky130_ef_sc_hd__decap_40_12$1
XFILLER_48_265 vssd1 vccd1 vccd1 vssd1 sky130_ef_sc_hd__decap_40_12$1
XFILLER_64_769 vssd1 vccd1 vccd1 vssd1 sky130_ef_sc_hd__decap_40_12$1
XFILLER_56_81 vssd1 vccd1 vccd1 vssd1 sky130_fd_sc_hd__fill_2$1
XFILLER_17_641 vssd1 vccd1 vccd1 vssd1 sky130_ef_sc_hd__decap_40_12$1
XFILLER_63_279 vccd1 vssd1 vccd1 vssd1 sky130_fd_sc_hd__fill_1$1
XFILLER_17_685 vssd1 vccd1 vccd1 vssd1 sky130_ef_sc_hd__decap_40_12$1
XFILLER_32_633 vssd1 vccd1 vccd1 vssd1 sky130_fd_sc_hd__fill_2$1
XFILLER_16_195 vccd1 vssd1 vccd1 vssd1 sky130_fd_sc_hd__fill_1$1
XFILLER_31_165 vssd1 vccd1 vccd1 vssd1 sky130_fd_sc_hd__fill_2$1
XFILLER_32_688 vssd1 vccd1 vccd1 vssd1 sky130_ef_sc_hd__decap_40_12$1
XTAP_TAPCELL_ROW_80_1494 vccd1 vssd1 sky130_fd_sc_hd__tapvpwrvgnd_1$1
XFILLER_75_3 vssd1 vccd1 vccd1 vssd1 sky130_ef_sc_hd__decap_40_12$1
XFILLER_118_749 vssd1 vccd1 vccd1 vssd1 sky130_fd_sc_hd__fill_4$1
XFILLER_8_361 vssd1 vccd1 vccd1 vssd1 sky130_fd_sc_hd__fill_2$1
XFILLER_117_237 vssd1 vccd1 vccd1 vssd1 sky130_ef_sc_hd__decap_40_12$1
X_1624_ _1624_/Q _1752_/CLK _1624_/D vccd1 vssd1 vccd1 vssd1 sky130_fd_sc_hd__dfxtp_1$1
XFILLER_125_281 vssd1 vccd1 vccd1 vssd1 sky130_ef_sc_hd__decap_40_12$1
XFILLER_113_432 vccd1 vssd1 vccd1 vssd1 sky130_fd_sc_hd__fill_1$1
XPHY_EDGE_ROW_99_Right_99 vccd1 vssd1 vccd1 vssd1 sky130_fd_sc_hd__decap_3$1
XFILLER_98_121 vssd1 vccd1 vccd1 vssd1 sky130_ef_sc_hd__decap_40_12$1
X_1555_ _1555_/Q _1719_/CLK _1555_/D vccd1 vssd1 vccd1 vssd1 sky130_fd_sc_hd__dfxtp_1$1
XFILLER_98_165 vssd1 vccd1 vccd1 vssd1 sky130_ef_sc_hd__decap_40_12$1
XFILLER_86_305 vssd1 vccd1 vccd1 vssd1 sky130_fd_sc_hd__fill_2$1
X_1486_ _1486_/Q _1742_/CLK _1486_/D vccd1 vssd1 vccd1 vssd1 sky130_fd_sc_hd__dfxtp_2$1
XFILLER_100_137 vssd1 vccd1 vccd1 vssd1 sky130_fd_sc_hd__fill_2$1
XFILLER_39_221 vssd1 vccd1 vccd1 vssd1 sky130_fd_sc_hd__fill_2$1
XTAP_TAPCELL_ROW_87_1604 vccd1 vssd1 sky130_fd_sc_hd__tapvpwrvgnd_1$1
XFILLER_67_585 vssd1 vccd1 vccd1 vssd1 sky130_ef_sc_hd__decap_40_12$1
XFILLER_55_725 vssd1 vccd1 vccd1 vssd1 sky130_fd_sc_hd__fill_2$1
XFILLER_27_405 vssd1 vccd1 vccd1 vssd1 sky130_ef_sc_hd__decap_40_12$1
XPHY_EDGE_ROW_6_Left_145 vccd1 vssd1 vccd1 vssd1 sky130_fd_sc_hd__decap_3$1
XFILLER_27_449 vssd1 vccd1 vccd1 vssd1 sky130_ef_sc_hd__decap_40_12$1
XFILLER_36_29 vssd1 vccd1 vccd1 vssd1 sky130_ef_sc_hd__decap_40_12$1
XFILLER_42_419 vccd1 vssd1 vccd1 vssd1 sky130_fd_sc_hd__fill_1$1
XFILLER_22_121 vssd1 vccd1 vccd1 vssd1 sky130_ef_sc_hd__decap_40_12$1
XFILLER_50_485 vssd1 vccd1 vccd1 vssd1 sky130_fd_sc_hd__fill_2$1
XFILLER_50_474 vssd1 vccd1 vccd1 vssd1 sky130_fd_sc_hd__fill_2$1
XFILLER_10_305 vssd1 vccd1 vccd1 vssd1 sky130_fd_sc_hd__fill_2$1
XFILLER_22_165 vssd1 vccd1 vccd1 vssd1 sky130_ef_sc_hd__decap_40_12$1
XFILLER_109_749 vccd1 vssd1 vccd1 vssd1 sky130_fd_sc_hd__fill_1$1
XFILLER_6_309 vssd1 vccd1 vccd1 vssd1 sky130_ef_sc_hd__decap_40_12$1
XFILLER_136_557 vssd1 vccd1 vccd1 vssd1 sky130_ef_sc_hd__decap_40_12$1
XTAP_TAPCELL_ROW_98_1777 vccd1 vssd1 sky130_fd_sc_hd__tapvpwrvgnd_1$1
XTAP_TAPCELL_ROW_98_1766 vccd1 vssd1 sky130_fd_sc_hd__tapvpwrvgnd_1$1
XFILLER_117_760 vssd1 vccd1 vccd1 vssd1 sky130_ef_sc_hd__decap_40_12$1
XFILLER_132_752 vssd1 vccd1 vccd1 vssd1 sky130_fd_sc_hd__fill_4$1
XFILLER_104_465 vccd1 vssd1 vccd1 vssd1 sky130_fd_sc_hd__fill_1$1
XFILLER_77_305 vssd1 vccd1 vccd1 vssd1 sky130_ef_sc_hd__decap_40_12$1
XFILLER_131_273 vssd1 vccd1 vccd1 vssd1 sky130_fd_sc_hd__fill_4$1
XTAP_TAPCELL_ROW_129_2232 vccd1 vssd1 sky130_fd_sc_hd__tapvpwrvgnd_1$1
XFILLER_89_165 vssd1 vccd1 vccd1 vssd1 sky130_fd_sc_hd__fill_2$1
XFILLER_77_69 vssd1 vccd1 vccd1 vssd1 sky130_ef_sc_hd__decap_40_12$1
XFILLER_77_349 vssd1 vccd1 vccd1 vssd1 sky130_ef_sc_hd__decap_40_12$1
XFILLER_58_541 vssd1 vccd1 vccd1 vssd1 sky130_ef_sc_hd__decap_40_12$1
XTAP_TAPCELL_ROW_51_1062 vccd1 vssd1 sky130_fd_sc_hd__tapvpwrvgnd_1$1
XFILLER_58_585 vssd1 vccd1 vccd1 vssd1 sky130_fd_sc_hd__fill_2$1
XTAP_TAPCELL_ROW_5_375 vccd1 vssd1 sky130_fd_sc_hd__tapvpwrvgnd_1$1
XFILLER_46_703 vccd1 vssd1 vccd1 vssd1 sky130_fd_sc_hd__fill_1$1
XFILLER_100_682 vccd1 vssd1 vccd1 vssd1 sky130_fd_sc_hd__fill_1$1
XFILLER_93_57 vssd1 vccd1 vccd1 vssd1 sky130_ef_sc_hd__decap_40_12$1
XFILLER_85_393 vssd1 vccd1 vccd1 vssd1 sky130_ef_sc_hd__decap_40_12$1
XFILLER_73_533 vccd1 vssd1 vccd1 vssd1 sky130_fd_sc_hd__fill_1$1
XFILLER_46_769 vssd1 vccd1 vccd1 vssd1 sky130_fd_sc_hd__fill_2$1
XFILLER_45_279 vccd1 vssd1 vccd1 vssd1 sky130_fd_sc_hd__fill_1$1
XFILLER_60_249 vssd1 vccd1 vccd1 vssd1 sky130_fd_sc_hd__fill_2$1
XFILLER_41_441 vssd1 vccd1 vccd1 vssd1 sky130_fd_sc_hd__fill_4$1
XTAP_TAPCELL_ROW_44_959 vccd1 vssd1 sky130_fd_sc_hd__tapvpwrvgnd_1$1
XFILLER_9_125 vssd1 vccd1 vccd1 vssd1 sky130_ef_sc_hd__decap_40_12$1
XFILLER_13_165 vssd1 vccd1 vccd1 vssd1 sky130_fd_sc_hd__fill_2$1
XFILLER_14_699 vccd1 vssd1 vccd1 vssd1 sky130_fd_sc_hd__fill_1$1
XTAP_TAPCELL_ROW_24_661 vccd1 vssd1 sky130_fd_sc_hd__tapvpwrvgnd_1$1
XFILLER_41_485 vssd1 vccd1 vccd1 vssd1 sky130_ef_sc_hd__decap_40_12$1
XFILLER_127_502 vssd1 vccd1 vccd1 vssd1 sky130_fd_sc_hd__fill_2$1
XFILLER_9_169 vssd1 vccd1 vccd1 vssd1 sky130_ef_sc_hd__decap_40_12$1
XFILLER_42_83 vccd1 vssd1 vccd1 vssd1 sky130_fd_sc_hd__fill_1$1
XFILLER_127_557 vssd1 vccd1 vccd1 vssd1 sky130_fd_sc_hd__fill_2$1
XFILLER_107_281 vssd1 vccd1 vccd1 vssd1 sky130_ef_sc_hd__decap_40_12$1
XFILLER_123_763 vssd1 vccd1 vccd1 vssd1 sky130_ef_sc_hd__decap_40_12$1
X_1340_ hold76/X _1340_/X _1342_/B vssd1 vccd1 vccd1 vssd1 sky130_fd_sc_hd__or2_1$1
Xclkbuf_leaf_20_wb_clk_i _1764_/CLK clkbuf_2_3__f_wb_clk_i/X vssd1 vccd1 vccd1 vssd1
+ sky130_fd_sc_hd__clkbuf_8$1
XFILLER_123_785 vssd1 vccd1 vccd1 vssd1 sky130_ef_sc_hd__decap_40_12$1
XFILLER_122_251 vccd1 vssd1 vccd1 vssd1 sky130_fd_sc_hd__fill_1$1
XFILLER_96_636 vssd1 vccd1 vccd1 vssd1 sky130_fd_sc_hd__fill_8$1
XFILLER_95_113 vssd1 vccd1 vccd1 vssd1 sky130_ef_sc_hd__decap_40_12$1
XFILLER_68_305 vssd1 vccd1 vccd1 vssd1 sky130_fd_sc_hd__fill_2$1
XFILLER_3_55 vccd1 vssd1 vccd1 vssd1 sky130_fd_sc_hd__fill_1$1
X_1271_ _1475_/C1 _1270_/X _1273_/A2 hold49/X _1665_/D vssd1 vccd1 vccd1 vssd1 sky130_fd_sc_hd__o211a_1$1
XFILLER_96_669 vssd1 vccd1 vccd1 vssd1 sky130_ef_sc_hd__decap_40_12$1
XFILLER_49_530 vssd1 vccd1 vccd1 vssd1 sky130_fd_sc_hd__fill_2$1
XFILLER_49_585 vssd1 vccd1 vccd1 vssd1 sky130_ef_sc_hd__decap_40_12$1
XFILLER_37_714 vssd1 vccd1 vccd1 vssd1 sky130_ef_sc_hd__decap_40_12$1
XTAP_TAPCELL_ROW_69_1334 vccd1 vssd1 sky130_fd_sc_hd__tapvpwrvgnd_1$1
XFILLER_64_533 vssd1 vccd1 vccd1 vssd1 sky130_ef_sc_hd__decap_40_12$1
XFILLER_91_385 vssd1 vccd1 vccd1 vssd1 sky130_fd_sc_hd__fill_4$1
XTAP_TAPCELL_ROW_82_1523 vccd1 vssd1 sky130_fd_sc_hd__tapvpwrvgnd_1$1
XFILLER_51_205 vssd1 vccd1 vccd1 vssd1 sky130_ef_sc_hd__decap_40_12$1
XFILLER_24_419 vccd1 vssd1 vccd1 vssd1 sky130_fd_sc_hd__fill_1$1
XTAP_TAPCELL_ROW_82_1534 vccd1 vssd1 sky130_fd_sc_hd__tapvpwrvgnd_1$1
XFILLER_51_249 vssd1 vccd1 vccd1 vssd1 sky130_ef_sc_hd__decap_40_12$1
XFILLER_20_625 vssd1 vccd1 vccd1 vssd1 sky130_ef_sc_hd__decap_40_12$1
XFILLER_118_524 vssd1 vccd1 vccd1 vssd1 sky130_fd_sc_hd__fill_8$1
X_0986_ _0986_/A _0986_/X _0990_/B vssd1 vccd1 vccd1 vssd1 sky130_fd_sc_hd__or2_1$1
XFILLER_20_669 vssd1 vccd1 vccd1 vssd1 sky130_ef_sc_hd__decap_40_12$1
XFILLER_118_557 vssd1 vccd1 vccd1 vssd1 sky130_ef_sc_hd__decap_40_12$1
XTAP_TAPCELL_ROW_113_2000 vccd1 vssd1 sky130_fd_sc_hd__tapvpwrvgnd_1$1
XFILLER_133_505 vssd1 vccd1 vccd1 vssd1 sky130_fd_sc_hd__fill_4$1
X_1607_ _1794_/A _1671_/CLK _1607_/D vccd1 vssd1 vccd1 vssd1 sky130_fd_sc_hd__dfxtp_1$1
XFILLER_113_273 vssd1 vccd1 vccd1 vssd1 sky130_fd_sc_hd__fill_4$1
X_1538_ _1538_/Q _1747_/CLK _1538_/D vccd1 vssd1 vccd1 vssd1 sky130_fd_sc_hd__dfxtp_1$1
XFILLER_99_485 vssd1 vccd1 vccd1 vssd1 sky130_ef_sc_hd__decap_40_12$1
XTAP_TAPCELL_ROW_93_1696 vccd1 vssd1 sky130_fd_sc_hd__tapvpwrvgnd_1$1
XFILLER_87_614 vssd1 vccd1 vccd1 vssd1 sky130_fd_sc_hd__fill_2$1
XFILLER_59_305 vssd1 vccd1 vccd1 vssd1 sky130_ef_sc_hd__decap_40_12$1
X_1469_ _1475_/C1 _1468_/X _1475_/A2 hold49/X hold50/A vssd1 vccd1 vccd1 vssd1 sky130_fd_sc_hd__o211a_1$1
XFILLER_87_669 vssd1 vccd1 vccd1 vssd1 sky130_fd_sc_hd__fill_2$1
XFILLER_75_809 vssd1 vccd1 vccd1 vssd1 sky130_ef_sc_hd__decap_40_12$1
XFILLER_59_349 vssd1 vccd1 vccd1 vssd1 sky130_ef_sc_hd__decap_40_12$1
XTAP_TAPCELL_ROW_2_323 vccd1 vssd1 sky130_fd_sc_hd__tapvpwrvgnd_1$1
XFILLER_47_39 vssd1 vccd1 vccd1 vssd1 sky130_ef_sc_hd__decap_40_12$1
XFILLER_67_393 vssd1 vccd1 vccd1 vssd1 sky130_ef_sc_hd__decap_40_12$1
XTAP_TAPCELL_ROW_2_334 vccd1 vssd1 sky130_fd_sc_hd__tapvpwrvgnd_1$1
XTAP_TAPCELL_ROW_124_2162 vccd1 vssd1 sky130_fd_sc_hd__tapvpwrvgnd_1$1
XFILLER_82_363 vccd1 vssd1 vccd1 vssd1 sky130_fd_sc_hd__fill_1$1
XFILLER_55_555 vssd1 vccd1 vccd1 vssd1 sky130_fd_sc_hd__fill_4$1
XFILLER_28_769 vssd1 vccd1 vccd1 vssd1 sky130_ef_sc_hd__decap_40_12$1
XFILLER_43_706 vssd1 vccd1 vccd1 vssd1 sky130_ef_sc_hd__decap_40_12$1
XFILLER_63_27 vssd1 vccd1 vccd1 vssd1 sky130_ef_sc_hd__decap_40_12$1
XFILLER_27_279 vccd1 vssd1 vccd1 vssd1 sky130_fd_sc_hd__fill_1$1
XFILLER_70_569 vssd1 vccd1 vccd1 vssd1 sky130_ef_sc_hd__decap_40_12$1
XFILLER_23_441 vssd1 vccd1 vccd1 vssd1 sky130_fd_sc_hd__fill_4$1
XFILLER_42_249 vssd1 vccd1 vccd1 vssd1 sky130_fd_sc_hd__fill_2$1
XFILLER_51_772 vssd1 vccd1 vccd1 vssd1 sky130_ef_sc_hd__decap_40_12$1
XTAP_TAPCELL_ROW_41_918 vccd1 vssd1 sky130_fd_sc_hd__tapvpwrvgnd_1$1
XTAP_TAPCELL_ROW_21_620 vccd1 vssd1 sky130_fd_sc_hd__tapvpwrvgnd_1$1
XFILLER_23_485 vssd1 vccd1 vccd1 vssd1 sky130_ef_sc_hd__decap_40_12$1
XFILLER_137_811 vccd1 vssd1 vccd1 vssd1 sky130_fd_sc_hd__fill_1$1
XFILLER_11_669 vssd1 vccd1 vccd1 vssd1 sky130_fd_sc_hd__fill_2$1
XFILLER_7_629 vssd1 vccd1 vccd1 vssd1 sky130_ef_sc_hd__decap_40_12$1
XFILLER_136_321 vccd1 vssd1 vccd1 vssd1 sky130_fd_sc_hd__fill_1$1
XFILLER_109_557 vssd1 vccd1 vccd1 vssd1 sky130_fd_sc_hd__fill_2$1
XFILLER_12_53 vssd1 vccd1 vccd1 vssd1 sky130_ef_sc_hd__decap_40_12$1
XFILLER_6_139 vccd1 vssd1 vccd1 vssd1 sky130_fd_sc_hd__fill_1$1
XFILLER_136_365 vssd1 vccd1 vccd1 vssd1 sky130_ef_sc_hd__decap_40_12$1
XFILLER_128_53 vssd1 vccd1 vccd1 vssd1 sky130_ef_sc_hd__decap_40_12$1
XFILLER_12_97 vssd1 vccd1 vccd1 vssd1 sky130_ef_sc_hd__decap_40_12$1
XFILLER_128_97 vssd1 vccd1 vccd1 vssd1 sky130_ef_sc_hd__decap_40_12$1
XFILLER_124_549 vssd1 vccd1 vccd1 vssd1 sky130_fd_sc_hd__fill_4$1
XFILLER_117_590 vssd1 vccd1 vccd1 vssd1 sky130_ef_sc_hd__decap_40_12$1
XFILLER_2_301 vssd1 vccd1 vccd1 vssd1 sky130_fd_sc_hd__fill_4$1
Xhold180 _1683_/Q _1308_/A vssd1 vccd1 vccd1 vssd1 sky130_fd_sc_hd__dlygate4sd3_1$1
XTAP_TAPCELL_ROW_53_1102 vccd1 vssd1 sky130_fd_sc_hd__tapvpwrvgnd_1$1
XFILLER_5_3 vssd1 vccd1 vccd1 vssd1 sky130_ef_sc_hd__decap_40_12$1
XFILLER_2_345 vssd1 vccd1 vccd1 vssd1 sky130_ef_sc_hd__decap_40_12$1
XFILLER_105_785 vssd1 vccd1 vccd1 vssd1 sky130_ef_sc_hd__decap_40_12$1
XFILLER_104_251 vccd1 vssd1 vccd1 vssd1 sky130_fd_sc_hd__fill_1$1
XFILLER_77_113 vssd1 vccd1 vccd1 vssd1 sky130_ef_sc_hd__decap_40_12$1
Xhold191 _1518_/Q _0968_/A vssd1 vccd1 vccd1 vssd1 sky130_fd_sc_hd__dlygate4sd3_1$1
XFILLER_2_389 vssd1 vccd1 vccd1 vssd1 sky130_ef_sc_hd__decap_40_12$1
XFILLER_120_755 vccd1 vssd1 vccd1 vssd1 sky130_fd_sc_hd__fill_1$1
XFILLER_78_669 vssd1 vccd1 vccd1 vssd1 sky130_ef_sc_hd__decap_40_12$1
XFILLER_66_809 vssd1 vccd1 vccd1 vssd1 sky130_fd_sc_hd__fill_2$1
XFILLER_93_617 vssd1 vccd1 vccd1 vssd1 sky130_fd_sc_hd__fill_4$1
XPHY_EDGE_ROW_69_Left_208 vccd1 vssd1 vccd1 vssd1 sky130_fd_sc_hd__decap_3$1
XTAP_TAPCELL_ROW_109_1935 vccd1 vssd1 sky130_fd_sc_hd__tapvpwrvgnd_1$1
XFILLER_19_725 vssd1 vccd1 vccd1 vssd1 sky130_fd_sc_hd__fill_2$1
XTAP_TAPCELL_ROW_29_731 vccd1 vssd1 sky130_fd_sc_hd__tapvpwrvgnd_1$1
XFILLER_46_533 vssd1 vccd1 vccd1 vssd1 sky130_ef_sc_hd__decap_40_12$1
XFILLER_61_503 vccd1 vssd1 vccd1 vssd1 sky130_fd_sc_hd__fill_1$1
XFILLER_19_769 vssd1 vccd1 vccd1 vssd1 sky130_ef_sc_hd__decap_40_12$1
XTAP_TAPCELL_ROW_29_742 vccd1 vssd1 sky130_fd_sc_hd__tapvpwrvgnd_1$1
XFILLER_33_205 vssd1 vccd1 vccd1 vssd1 sky130_ef_sc_hd__decap_40_12$1
XFILLER_34_739 vssd1 vccd1 vccd1 vssd1 sky130_fd_sc_hd__fill_4$1
XFILLER_46_599 vccd1 vssd1 vccd1 vssd1 sky130_fd_sc_hd__fill_1$1
XFILLER_33_249 vssd1 vccd1 vccd1 vssd1 sky130_ef_sc_hd__decap_40_12$1
XTAP_TAPCELL_ROW_64_1264 vccd1 vssd1 sky130_fd_sc_hd__tapvpwrvgnd_1$1
XTAP_TAPCELL_ROW_64_1253 vccd1 vssd1 sky130_fd_sc_hd__tapvpwrvgnd_1$1
XPHY_EDGE_ROW_78_Left_217 vccd1 vssd1 vccd1 vssd1 sky130_fd_sc_hd__decap_3$1
XFILLER_53_93 vssd1 vccd1 vccd1 vssd1 sky130_ef_sc_hd__decap_40_12$1
XFILLER_41_293 vssd1 vccd1 vccd1 vssd1 sky130_ef_sc_hd__decap_40_12$1
X_0840_ _1805_/A hold10/A _0840_/X _1651_/Q _0906_/B1 vccd1 vssd1 vccd1 vssd1 sky130_fd_sc_hd__a22o_1$1
X_0771_ _0880_/A2 _1479_/D _0767_/X _1421_/C1 _1479_/Q _0770_/X vssd1 vccd1 vccd1
+ vssd1 sky130_fd_sc_hd__o221a_1$1
XFILLER_127_365 vccd1 vssd1 vccd1 vssd1 sky130_fd_sc_hd__fill_1$1
XFILLER_5_161 vssd1 vccd1 vccd1 vssd1 sky130_fd_sc_hd__fill_4$1
XPHY_EDGE_ROW_87_Left_226 vccd1 vssd1 vccd1 vssd1 sky130_fd_sc_hd__decap_3$1
XFILLER_69_625 vssd1 vccd1 vccd1 vssd1 sky130_fd_sc_hd__fill_2$1
XFILLER_38_3 vssd1 vccd1 vccd1 vssd1 sky130_ef_sc_hd__decap_40_12$1
XFILLER_111_733 vssd1 vccd1 vccd1 vssd1 sky130_fd_sc_hd__fill_2$1
XFILLER_110_221 vssd1 vccd1 vccd1 vssd1 sky130_ef_sc_hd__decap_40_12$1
X_1323_ _1417_/C1 _1322_/X _1331_/A2 hold107/X _1690_/D vssd1 vccd1 vccd1 vssd1 sky130_fd_sc_hd__o211a_1$1
XFILLER_96_433 vccd1 vssd1 vccd1 vssd1 sky130_fd_sc_hd__fill_1$1
XFILLER_110_265 vssd1 vccd1 vccd1 vssd1 sky130_ef_sc_hd__decap_40_12$1
X_1254_ _1657_/Q _1254_/X _1276_/B vssd1 vccd1 vccd1 vssd1 sky130_fd_sc_hd__or2_1$1
XFILLER_83_105 vssd1 vccd1 vccd1 vssd1 sky130_fd_sc_hd__fill_4$1
XFILLER_49_393 vssd1 vccd1 vccd1 vssd1 sky130_ef_sc_hd__decap_40_12$1
X_1185_ _1443_/C1 _1184_/X _1211_/A2 hold98/X hold99/A vssd1 vccd1 vccd1 vssd1 sky130_fd_sc_hd__o211a_1$1
XFILLER_83_149 vssd1 vccd1 vccd1 vssd1 sky130_ef_sc_hd__decap_40_12$1
XFILLER_64_363 vccd1 vssd1 vccd1 vssd1 sky130_fd_sc_hd__fill_1$1
XFILLER_52_514 vssd1 vccd1 vccd1 vssd1 sky130_ef_sc_hd__decap_40_12$1
XFILLER_91_193 vssd1 vccd1 vccd1 vssd1 sky130_ef_sc_hd__decap_40_12$1
XFILLER_52_569 vssd1 vccd1 vccd1 vssd1 sky130_ef_sc_hd__decap_40_12$1
XFILLER_24_249 vssd1 vccd1 vccd1 vssd1 sky130_fd_sc_hd__fill_2$1
XPHY_EDGE_ROW_96_Left_235 vccd1 vssd1 vccd1 vssd1 sky130_fd_sc_hd__decap_3$1
XFILLER_20_433 vssd1 vccd1 vccd1 vssd1 sky130_ef_sc_hd__decap_40_12$1
XFILLER_118_321 vssd1 vccd1 vccd1 vssd1 sky130_ef_sc_hd__decap_40_12$1
X_0969_ _1387_/C1 _0968_/X _0991_/A2 hold155/X _1518_/D vssd1 vccd1 vccd1 vssd1 sky130_fd_sc_hd__o211a_1$1
XFILLER_20_477 vssd1 vccd1 vccd1 vssd1 sky130_ef_sc_hd__decap_40_12$1
XFILLER_134_825 vssd1 vccd1 vccd1 vssd1 sky130_ef_sc_hd__decap_40_12$1
XFILLER_118_365 vssd1 vccd1 vccd1 vssd1 sky130_fd_sc_hd__fill_2$1
XTAP_TAPCELL_ROW_95_1725 vccd1 vssd1 sky130_fd_sc_hd__tapvpwrvgnd_1$1
XFILLER_133_335 vccd1 vssd1 vccd1 vssd1 sky130_fd_sc_hd__fill_1$1
XFILLER_3_109 vssd1 vccd1 vccd1 vssd1 sky130_fd_sc_hd__fill_2$1
XTAP_TAPCELL_ROW_7_404 vccd1 vssd1 sky130_fd_sc_hd__tapvpwrvgnd_1$1
XFILLER_58_27 vccd1 vssd1 vccd1 vssd1 sky130_fd_sc_hd__fill_1$1
XFILLER_101_221 vssd1 vccd1 vccd1 vssd1 sky130_fd_sc_hd__fill_2$1
XFILLER_99_293 vssd1 vccd1 vccd1 vssd1 sky130_ef_sc_hd__decap_40_12$1
XFILLER_87_444 vssd1 vccd1 vccd1 vssd1 sky130_fd_sc_hd__fill_4$1
XFILLER_59_113 vssd1 vccd1 vccd1 vssd1 sky130_ef_sc_hd__decap_40_12$1
XFILLER_75_617 vssd1 vccd1 vccd1 vssd1 sky130_ef_sc_hd__decap_40_12$1
XFILLER_102_799 vssd1 vccd1 vccd1 vssd1 sky130_fd_sc_hd__fill_2$1
XFILLER_74_15 vssd1 vccd1 vccd1 vssd1 sky130_ef_sc_hd__decap_40_12$1
XFILLER_56_820 vssd1 vccd1 vccd1 vssd1 sky130_fd_sc_hd__fill_2$1
XFILLER_28_533 vssd1 vccd1 vccd1 vssd1 sky130_ef_sc_hd__decap_40_12$1
XFILLER_114_77 vssd1 vccd1 vccd1 vssd1 sky130_fd_sc_hd__fill_4$1
XFILLER_71_801 vssd1 vccd1 vccd1 vssd1 sky130_fd_sc_hd__fill_8$1
XFILLER_71_823 vccd1 vssd1 vccd1 vssd1 sky130_fd_sc_hd__fill_1$1
XFILLER_15_205 vssd1 vccd1 vccd1 vssd1 sky130_ef_sc_hd__decap_40_12$1
XFILLER_82_193 vssd1 vccd1 vccd1 vssd1 sky130_fd_sc_hd__fill_2$1
XFILLER_70_333 vssd1 vccd1 vccd1 vssd1 sky130_ef_sc_hd__decap_40_12$1
XFILLER_15_249 vssd1 vccd1 vccd1 vssd1 sky130_ef_sc_hd__decap_40_12$1
XFILLER_31_709 vssd1 vccd1 vccd1 vssd1 sky130_ef_sc_hd__decap_40_12$1
XFILLER_130_65 vssd1 vccd1 vccd1 vssd1 sky130_ef_sc_hd__decap_40_12$1
XTAP_TAPCELL_ROW_104_1865 vccd1 vssd1 sky130_fd_sc_hd__tapvpwrvgnd_1$1
XTAP_TAPCELL_ROW_104_1854 vccd1 vssd1 sky130_fd_sc_hd__tapvpwrvgnd_1$1
XFILLER_70_377 vssd1 vccd1 vccd1 vssd1 sky130_ef_sc_hd__decap_40_12$1
XFILLER_24_750 vssd1 vccd1 vccd1 vssd1 sky130_fd_sc_hd__fill_4$1
XFILLER_24_794 vssd1 vccd1 vccd1 vssd1 sky130_fd_sc_hd__fill_2$1
XTAP_TAPCELL_ROW_137_2353 vccd1 vssd1 sky130_fd_sc_hd__tapvpwrvgnd_1$1
XFILLER_23_293 vssd1 vccd1 vccd1 vssd1 sky130_ef_sc_hd__decap_40_12$1
XFILLER_137_652 vssd1 vccd1 vccd1 vssd1 sky130_ef_sc_hd__decap_40_12$1
XFILLER_136_195 vccd1 vssd1 vccd1 vssd1 sky130_fd_sc_hd__fill_1$1
XFILLER_124_357 vssd1 vccd1 vccd1 vssd1 sky130_fd_sc_hd__fill_4$1
XFILLER_3_665 vssd1 vccd1 vccd1 vssd1 sky130_fd_sc_hd__fill_4$1
XFILLER_2_153 vssd1 vccd1 vccd1 vssd1 sky130_ef_sc_hd__decap_40_12$1
XFILLER_2_197 vssd1 vccd1 vccd1 vssd1 sky130_ef_sc_hd__decap_40_12$1
XFILLER_78_477 vssd1 vccd1 vccd1 vssd1 sky130_fd_sc_hd__fill_8$1
XFILLER_65_105 vssd1 vccd1 vccd1 vssd1 sky130_fd_sc_hd__fill_4$1
XFILLER_93_447 vccd1 vssd1 vccd1 vssd1 sky130_fd_sc_hd__fill_1$1
XFILLER_65_149 vssd1 vccd1 vccd1 vssd1 sky130_ef_sc_hd__decap_40_12$1
XFILLER_34_525 vssd1 vccd1 vccd1 vssd1 sky130_fd_sc_hd__fill_4$1
XFILLER_46_363 vccd1 vssd1 vccd1 vssd1 sky130_fd_sc_hd__fill_1$1
XFILLER_73_193 vssd1 vccd1 vccd1 vssd1 sky130_ef_sc_hd__decap_40_12$1
XFILLER_64_81 vssd1 vccd1 vccd1 vssd1 sky130_fd_sc_hd__fill_2$1
XFILLER_61_333 vssd1 vccd1 vccd1 vssd1 sky130_fd_sc_hd__fill_2$1
XFILLER_15_772 vssd1 vccd1 vccd1 vssd1 sky130_ef_sc_hd__decap_40_12$1
XFILLER_34_569 vssd1 vccd1 vccd1 vssd1 sky130_ef_sc_hd__decap_40_12$1
XFILLER_30_753 vssd1 vccd1 vccd1 vssd1 sky130_fd_sc_hd__fill_2$1
X_0823_ _1680_/Q _0875_/B1 _0823_/X _1648_/Q _0906_/B1 vccd1 vssd1 vccd1 vssd1 sky130_fd_sc_hd__a22o_1$1
XFILLER_128_663 vssd1 vccd1 vccd1 vssd1 sky130_ef_sc_hd__decap_40_12$1
XTAP_TAPCELL_ROW_12_483 vccd1 vssd1 sky130_fd_sc_hd__tapvpwrvgnd_1$1
X_0754_ hold5/A hold17/A hold8/A hold6/A hold24/A vssd1 vccd1 vccd1 vssd1 sky130_fd_sc_hd__and4bb_4$1
XFILLER_116_825 vccd1 vssd1 vccd1 vssd1 sky130_fd_sc_hd__fill_1$1
XTAP_TAPCELL_ROW_77_1455 vccd1 vssd1 sky130_fd_sc_hd__tapvpwrvgnd_1$1
XFILLER_115_335 vccd1 vssd1 vccd1 vssd1 sky130_fd_sc_hd__fill_1$1
XFILLER_89_709 vssd1 vccd1 vccd1 vssd1 sky130_ef_sc_hd__decap_40_12$1
XFILLER_130_305 vssd1 vccd1 vccd1 vssd1 sky130_fd_sc_hd__fill_2$1
XTAP_TAPCELL_ROW_90_1655 vccd1 vssd1 sky130_fd_sc_hd__tapvpwrvgnd_1$1
XTAP_TAPCELL_ROW_90_1644 vccd1 vssd1 sky130_fd_sc_hd__tapvpwrvgnd_1$1
X_1306_ hold44/X _1306_/X _1330_/B vssd1 vccd1 vccd1 vssd1 sky130_fd_sc_hd__or2_1$1
XFILLER_111_585 vssd1 vccd1 vccd1 vssd1 sky130_ef_sc_hd__decap_40_12$1
X_1237_ _1447_/C1 _1236_/X _1277_/A2 hold210/X _1648_/D vssd1 vccd1 vccd1 vssd1 sky130_fd_sc_hd__o211a_1$1
XTAP_TAPCELL_ROW_121_2110 vccd1 vssd1 sky130_fd_sc_hd__tapvpwrvgnd_1$1
X_1168_ _1819_/A _1168_/X _1188_/B vssd1 vccd1 vccd1 vssd1 sky130_fd_sc_hd__or2_1$1
XFILLER_25_503 vccd1 vssd1 vccd1 vssd1 sky130_fd_sc_hd__fill_1$1
XFILLER_37_385 vssd1 vccd1 vccd1 vssd1 sky130_fd_sc_hd__fill_4$1
XTAP_TAPCELL_ROW_121_2121 vccd1 vssd1 sky130_fd_sc_hd__tapvpwrvgnd_1$1
XFILLER_64_193 vssd1 vccd1 vccd1 vssd1 sky130_fd_sc_hd__fill_2$1
XFILLER_52_333 vssd1 vccd1 vccd1 vssd1 sky130_ef_sc_hd__decap_40_12$1
XFILLER_44_29 vssd1 vccd1 vccd1 vssd1 sky130_ef_sc_hd__decap_40_12$1
XFILLER_52_377 vssd1 vccd1 vccd1 vssd1 sky130_ef_sc_hd__decap_40_12$1
XFILLER_13_709 vssd1 vccd1 vccd1 vssd1 sky130_ef_sc_hd__decap_40_12$1
X_1099_ _1387_/C1 _1098_/X _1123_/A2 hold183/X _1581_/D vssd1 vccd1 vccd1 vssd1 sky130_fd_sc_hd__o211a_1$1
XFILLER_80_697 vssd1 vccd1 vccd1 vssd1 sky130_fd_sc_hd__fill_2$1
XFILLER_40_539 vccd1 vssd1 vccd1 vssd1 sky130_fd_sc_hd__fill_1$1
XFILLER_21_753 vssd1 vccd1 vccd1 vssd1 sky130_ef_sc_hd__decap_40_12$1
XFILLER_138_449 vssd1 vccd1 vccd1 vssd1 sky130_fd_sc_hd__fill_2$1
XFILLER_21_797 vssd1 vccd1 vccd1 vssd1 sky130_ef_sc_hd__decap_40_12$1
XTAP_TAPCELL_ROW_31_770 vccd1 vssd1 sky130_fd_sc_hd__tapvpwrvgnd_1$1
XFILLER_119_641 vssd1 vccd1 vccd1 vssd1 sky130_ef_sc_hd__decap_40_12$1
XTAP_TAPCELL_ROW_119_2083 vccd1 vssd1 sky130_fd_sc_hd__tapvpwrvgnd_1$1
XFILLER_109_55 vccd1 vssd1 vccd1 vssd1 sky130_fd_sc_hd__fill_1$1
XTAP_TAPCELL_ROW_132_2283 vccd1 vssd1 sky130_fd_sc_hd__tapvpwrvgnd_1$1
XFILLER_118_195 vccd1 vssd1 vccd1 vssd1 sky130_fd_sc_hd__fill_1$1
XFILLER_106_357 vssd1 vccd1 vccd1 vssd1 sky130_fd_sc_hd__fill_4$1
XFILLER_69_15 vssd1 vccd1 vccd1 vssd1 sky130_ef_sc_hd__decap_40_12$1
XFILLER_134_677 vssd1 vccd1 vccd1 vssd1 sky130_fd_sc_hd__fill_8$1
XFILLER_133_165 vssd1 vccd1 vccd1 vssd1 sky130_fd_sc_hd__fill_2$1
XFILLER_121_305 vssd1 vccd1 vccd1 vssd1 sky130_ef_sc_hd__decap_40_12$1
XFILLER_0_613 vssd1 vccd1 vccd1 vssd1 sky130_fd_sc_hd__fill_2$1
XFILLER_121_349 vssd1 vccd1 vccd1 vssd1 sky130_ef_sc_hd__decap_40_12$1
XFILLER_88_753 vssd1 vccd1 vccd1 vssd1 sky130_fd_sc_hd__fill_2$1
XFILLER_0_657 vssd1 vccd1 vccd1 vssd1 sky130_ef_sc_hd__decap_40_12$1
XFILLER_102_585 vssd1 vccd1 vccd1 vssd1 sky130_fd_sc_hd__fill_2$1
XFILLER_88_797 vssd1 vccd1 vccd1 vssd1 sky130_ef_sc_hd__decap_40_12$1
XFILLER_47_105 vssd1 vccd1 vccd1 vssd1 sky130_fd_sc_hd__fill_4$1
XFILLER_85_69 vssd1 vccd1 vccd1 vssd1 sky130_ef_sc_hd__decap_40_12$1
XFILLER_18_41 vssd1 vccd1 vccd1 vssd1 sky130_ef_sc_hd__decap_40_12$1
XFILLER_47_149 vssd1 vccd1 vccd1 vssd1 sky130_ef_sc_hd__decap_40_12$1
XFILLER_16_525 vssd1 vccd1 vccd1 vssd1 sky130_fd_sc_hd__fill_4$1
XFILLER_18_85 vssd1 vccd1 vccd1 vssd1 sky130_ef_sc_hd__decap_40_12$1
XFILLER_28_363 vccd1 vssd1 vccd1 vssd1 sky130_fd_sc_hd__fill_1$1
XTAP_TAPCELL_ROW_39_881 vccd1 vssd1 sky130_fd_sc_hd__tapvpwrvgnd_1$1
XFILLER_83_491 vssd1 vccd1 vccd1 vssd1 sky130_fd_sc_hd__fill_2$1
XFILLER_55_193 vssd1 vccd1 vccd1 vssd1 sky130_ef_sc_hd__decap_40_12$1
XTAP_TAPCELL_ROW_39_892 vccd1 vssd1 sky130_fd_sc_hd__tapvpwrvgnd_1$1
XFILLER_43_333 vssd1 vccd1 vccd1 vssd1 sky130_fd_sc_hd__fill_2$1
XTAP_TAPCELL_ROW_48_1023 vccd1 vssd1 sky130_fd_sc_hd__tapvpwrvgnd_1$1
XFILLER_70_141 vssd1 vccd1 vccd1 vssd1 sky130_ef_sc_hd__decap_40_12$1
XFILLER_16_569 vssd1 vccd1 vccd1 vssd1 sky130_ef_sc_hd__decap_40_12$1
XFILLER_31_517 vssd1 vccd1 vccd1 vssd1 sky130_ef_sc_hd__decap_40_12$1
XTAP_TAPCELL_ROW_61_1212 vccd1 vssd1 sky130_fd_sc_hd__tapvpwrvgnd_1$1
XFILLER_129_405 vssd1 vccd1 vccd1 vssd1 sky130_ef_sc_hd__decap_40_12$1
XFILLER_8_713 vssd1 vccd1 vccd1 vssd1 sky130_ef_sc_hd__decap_40_12$1
XFILLER_12_753 vssd1 vccd1 vccd1 vssd1 sky130_fd_sc_hd__fill_2$1
XFILLER_129_449 vssd1 vccd1 vccd1 vssd1 sky130_ef_sc_hd__decap_40_12$1
XFILLER_7_223 vccd1 vssd1 vccd1 vssd1 sky130_fd_sc_hd__fill_1$1
XFILLER_8_757 vssd1 vccd1 vccd1 vssd1 sky130_ef_sc_hd__decap_40_12$1
XFILLER_50_83 vccd1 vssd1 vccd1 vssd1 sky130_fd_sc_hd__fill_1$1
XFILLER_124_121 vssd1 vccd1 vccd1 vssd1 sky130_ef_sc_hd__decap_40_12$1
XFILLER_124_165 vssd1 vccd1 vccd1 vssd1 sky130_ef_sc_hd__decap_40_12$1
XFILLER_112_305 vssd1 vccd1 vccd1 vssd1 sky130_fd_sc_hd__fill_2$1
XFILLER_98_539 vssd1 vccd1 vccd1 vssd1 sky130_ef_sc_hd__decap_40_12$1
XTAP_TAPCELL_ROW_59_1185 vccd1 vssd1 sky130_fd_sc_hd__tapvpwrvgnd_1$1
XFILLER_3_473 vssd1 vccd1 vccd1 vssd1 sky130_ef_sc_hd__decap_40_12$1
XFILLER_94_701 vssd1 vccd1 vccd1 vssd1 sky130_ef_sc_hd__decap_40_12$1
XTAP_TAPCELL_ROW_72_1385 vccd1 vssd1 sky130_fd_sc_hd__tapvpwrvgnd_1$1
XTAP_TAPCELL_ROW_72_1374 vccd1 vssd1 sky130_fd_sc_hd__tapvpwrvgnd_1$1
XFILLER_59_81 vssd1 vccd1 vccd1 vssd1 sky130_ef_sc_hd__decap_40_12$1
XFILLER_39_617 vssd1 vccd1 vccd1 vssd1 sky130_fd_sc_hd__fill_2$1
XFILLER_94_745 vssd1 vccd1 vccd1 vssd1 sky130_fd_sc_hd__fill_2$1
XFILLER_120_393 vssd1 vccd1 vccd1 vssd1 sky130_ef_sc_hd__decap_40_12$1
XFILLER_66_469 vssd1 vccd1 vccd1 vssd1 sky130_fd_sc_hd__fill_4$1
XFILLER_93_277 vssd1 vccd1 vccd1 vssd1 sky130_fd_sc_hd__fill_2$1
X_1022_ _1775_/A _1022_/X _1052_/B vssd1 vccd1 vccd1 vssd1 sky130_fd_sc_hd__or2_1$1
XFILLER_19_385 vssd1 vccd1 vccd1 vssd1 sky130_fd_sc_hd__fill_4$1
XFILLER_34_333 vssd1 vccd1 vccd1 vssd1 sky130_ef_sc_hd__decap_40_12$1
XFILLER_46_193 vssd1 vccd1 vccd1 vssd1 sky130_fd_sc_hd__fill_2$1
XTAP_TAPCELL_ROW_17_553 vccd1 vssd1 sky130_fd_sc_hd__tapvpwrvgnd_1$1
XFILLER_34_377 vssd1 vccd1 vccd1 vssd1 sky130_ef_sc_hd__decap_40_12$1
XFILLER_62_697 vssd1 vccd1 vccd1 vssd1 sky130_fd_sc_hd__fill_2$1
X_1855_ _1855_/A _1855_/X vssd1 vccd1 vccd1 vssd1 sky130_fd_sc_hd__clkbuf_2$1
X_0806_ _0879_/B1 _0806_/X _0805_/X _1849_/A _0881_/B1 _0804_/X vssd1 vccd1 vccd1
+ vssd1 sky130_fd_sc_hd__a2111o_1$1
X_1786_ vccd1 vssd1 _1786_/X _1786_/A vccd1 vssd1 sky130_fd_sc_hd__buf_1$1
XPHY_EDGE_ROW_123_Right_123 vccd1 vssd1 vccd1 vssd1 sky130_fd_sc_hd__decap_3$1
XFILLER_115_165 vssd1 vccd1 vccd1 vssd1 sky130_fd_sc_hd__fill_2$1
XFILLER_103_305 vssd1 vccd1 vccd1 vssd1 sky130_ef_sc_hd__decap_40_12$1
XFILLER_89_517 vssd1 vccd1 vccd1 vssd1 sky130_ef_sc_hd__decap_40_12$1
XFILLER_103_349 vssd1 vccd1 vccd1 vssd1 sky130_ef_sc_hd__decap_40_12$1
XFILLER_131_669 vssd1 vccd1 vccd1 vssd1 sky130_fd_sc_hd__fill_2$1
XFILLER_97_561 vssd1 vccd1 vccd1 vssd1 sky130_fd_sc_hd__fill_2$1
XFILLER_97_594 vccd1 vssd1 vccd1 vssd1 sky130_fd_sc_hd__fill_1$1
XFILLER_57_414 vssd1 vccd1 vccd1 vssd1 sky130_ef_sc_hd__decap_40_12$1
XFILLER_29_105 vssd1 vccd1 vccd1 vssd1 sky130_fd_sc_hd__fill_4$1
XFILLER_84_233 vssd1 vccd1 vccd1 vssd1 sky130_ef_sc_hd__decap_40_12$1
XFILLER_29_149 vssd1 vccd1 vccd1 vssd1 sky130_ef_sc_hd__decap_40_12$1
XFILLER_84_277 vssd1 vccd1 vccd1 vssd1 sky130_ef_sc_hd__decap_40_12$1
XFILLER_55_39 vssd1 vccd1 vccd1 vssd1 sky130_ef_sc_hd__decap_40_12$1
XFILLER_25_333 vssd1 vccd1 vccd1 vssd1 sky130_fd_sc_hd__fill_2$1
XFILLER_37_193 vssd1 vccd1 vccd1 vssd1 sky130_ef_sc_hd__decap_40_12$1
XFILLER_53_653 vssd1 vccd1 vccd1 vssd1 sky130_fd_sc_hd__fill_8$1
XFILLER_52_141 vssd1 vccd1 vccd1 vssd1 sky130_ef_sc_hd__decap_40_12$1
XFILLER_13_517 vssd1 vccd1 vccd1 vssd1 sky130_ef_sc_hd__decap_40_12$1
XTAP_TAPCELL_ROW_36_840 vccd1 vssd1 sky130_fd_sc_hd__tapvpwrvgnd_1$1
XTAP_TAPCELL_ROW_101_1813 vccd1 vssd1 sky130_fd_sc_hd__tapvpwrvgnd_1$1
XFILLER_80_472 vssd1 vccd1 vccd1 vssd1 sky130_fd_sc_hd__fill_4$1
XFILLER_71_27 vssd1 vccd1 vccd1 vssd1 sky130_ef_sc_hd__decap_40_12$1
XFILLER_21_561 vssd1 vccd1 vccd1 vssd1 sky130_ef_sc_hd__decap_40_12$1
XTAP_TAPCELL_ROW_134_2312 vccd1 vssd1 sky130_fd_sc_hd__tapvpwrvgnd_1$1
XFILLER_126_419 vccd1 vssd1 vccd1 vssd1 sky130_fd_sc_hd__fill_1$1
XFILLER_5_727 vccd1 vssd1 vccd1 vssd1 sky130_fd_sc_hd__fill_1$1
XFILLER_106_121 vssd1 vccd1 vccd1 vssd1 sky130_ef_sc_hd__decap_40_12$1
XFILLER_105_3 vssd1 vccd1 vccd1 vssd1 sky130_ef_sc_hd__decap_40_12$1
XFILLER_136_53 vssd1 vccd1 vccd1 vssd1 sky130_ef_sc_hd__decap_40_12$1
XFILLER_106_165 vssd1 vccd1 vccd1 vssd1 sky130_ef_sc_hd__decap_40_12$1
XFILLER_20_53 vssd1 vccd1 vccd1 vssd1 sky130_ef_sc_hd__decap_40_12$1
XFILLER_122_625 vssd1 vccd1 vccd1 vssd1 sky130_ef_sc_hd__decap_40_12$1
XFILLER_121_113 vssd1 vccd1 vccd1 vssd1 sky130_ef_sc_hd__decap_40_12$1
XFILLER_0_421 vssd1 vccd1 vccd1 vssd1 sky130_fd_sc_hd__fill_2$1
XFILLER_20_97 vssd1 vccd1 vccd1 vssd1 sky130_ef_sc_hd__decap_40_12$1
XFILLER_122_669 vssd1 vccd1 vccd1 vssd1 sky130_ef_sc_hd__decap_40_12$1
XTAP_TAPCELL_ROW_112_1986 vccd1 vssd1 sky130_fd_sc_hd__tapvpwrvgnd_1$1
XTAP_TAPCELL_ROW_112_1975 vccd1 vssd1 sky130_fd_sc_hd__tapvpwrvgnd_1$1
XFILLER_88_550 vssd1 vccd1 vccd1 vssd1 sky130_ef_sc_hd__decap_40_12$1
XFILLER_76_701 vssd1 vccd1 vccd1 vssd1 sky130_ef_sc_hd__decap_40_12$1
Xhold40 hold40/A hold40/X vssd1 vccd1 vccd1 vssd1 sky130_fd_sc_hd__dlygate4sd3_1$1
XFILLER_88_594 vssd1 vccd1 vccd1 vssd1 sky130_ef_sc_hd__decap_40_12$1
XFILLER_76_745 vssd1 vccd1 vccd1 vssd1 sky130_fd_sc_hd__fill_8$1
XFILLER_29_51 vssd1 vccd1 vccd1 vssd1 sky130_fd_sc_hd__fill_4$1
Xhold51 hold51/A hold51/X vssd1 vccd1 vccd1 vssd1 sky130_fd_sc_hd__dlygate4sd3_1$1
Xhold62 hold62/A hold62/X vssd1 vccd1 vccd1 vssd1 sky130_fd_sc_hd__dlygate4sd3_1$1
Xhold73 hold73/X vccd1 vssd1 hold73/A vccd1 vssd1 sky130_fd_sc_hd__buf_4$1
XFILLER_48_447 vssd1 vccd1 vccd1 vssd1 sky130_fd_sc_hd__fill_4$1
Xhold95 hold95/A hold95/X vssd1 vccd1 vccd1 vssd1 sky130_fd_sc_hd__dlygate4sd3_1$1
Xhold84 hold84/A hold84/X vssd1 vccd1 vccd1 vssd1 sky130_fd_sc_hd__dlygate4sd3_1$1
XFILLER_75_277 vssd1 vccd1 vccd1 vssd1 sky130_fd_sc_hd__fill_2$1
XFILLER_16_333 vssd1 vccd1 vccd1 vssd1 sky130_ef_sc_hd__decap_40_12$1
XFILLER_28_193 vssd1 vccd1 vccd1 vssd1 sky130_fd_sc_hd__fill_2$1
XFILLER_71_461 vssd1 vccd1 vccd1 vssd1 sky130_fd_sc_hd__fill_8$1
Xclkbuf_leaf_45_wb_clk_i clkload7/A clkload0/A vssd1 vccd1 vccd1 vssd1 sky130_fd_sc_hd__clkbuf_8$1
XFILLER_44_653 vccd1 vssd1 vccd1 vssd1 sky130_fd_sc_hd__fill_1$1
XTAP_TAPCELL_ROW_14_512 vccd1 vssd1 sky130_fd_sc_hd__tapvpwrvgnd_1$1
XFILLER_16_377 vssd1 vccd1 vccd1 vssd1 sky130_ef_sc_hd__decap_40_12$1
XFILLER_61_93 vssd1 vccd1 vccd1 vssd1 sky130_ef_sc_hd__decap_40_12$1
X_1640_ _1640_/Q _1736_/CLK _1640_/D vccd1 vssd1 vccd1 vssd1 sky130_fd_sc_hd__dfxtp_1$1
XFILLER_8_587 vccd1 vssd1 vccd1 vssd1 sky130_fd_sc_hd__fill_1$1
X_1571_ hold68/A _1761_/CLK _1571_/D vccd1 vssd1 vccd1 vssd1 sky130_fd_sc_hd__dfxtp_1$1
XANTENNA_4 _1140_/B vssd1 vccd1 vccd1 vssd1 sky130_fd_sc_hd__diode_2$1
XFILLER_125_441 vssd1 vccd1 vccd1 vssd1 sky130_fd_sc_hd__fill_4$1
XTAP_TAPCELL_ROW_74_1403 vccd1 vssd1 sky130_fd_sc_hd__tapvpwrvgnd_1$1
XTAP_TAPCELL_ROW_74_1414 vccd1 vssd1 sky130_fd_sc_hd__tapvpwrvgnd_1$1
XFILLER_6_77 vssd1 vccd1 vccd1 vssd1 sky130_fd_sc_hd__fill_4$1
XFILLER_113_625 vssd1 vccd1 vccd1 vssd1 sky130_ef_sc_hd__decap_40_12$1
XFILLER_4_793 vssd1 vccd1 vccd1 vssd1 sky130_ef_sc_hd__decap_40_12$1
XFILLER_3_281 vssd1 vccd1 vccd1 vssd1 sky130_ef_sc_hd__decap_40_12$1
XFILLER_113_669 vssd1 vccd1 vccd1 vssd1 sky130_fd_sc_hd__fill_2$1
XFILLER_79_561 vssd1 vccd1 vccd1 vssd1 sky130_ef_sc_hd__decap_40_12$1
XFILLER_67_712 vssd1 vccd1 vccd1 vssd1 sky130_ef_sc_hd__decap_40_12$1
XPHY_EDGE_ROW_60_Left_199 vccd1 vssd1 vccd1 vssd1 sky130_fd_sc_hd__decap_3$1
XFILLER_20_3 vssd1 vccd1 vccd1 vssd1 sky130_ef_sc_hd__decap_40_12$1
XFILLER_66_233 vssd1 vccd1 vccd1 vssd1 sky130_ef_sc_hd__decap_40_12$1
XFILLER_27_609 vssd1 vccd1 vccd1 vssd1 sky130_fd_sc_hd__fill_4$1
XFILLER_39_447 vccd1 vssd1 vccd1 vssd1 sky130_fd_sc_hd__fill_1$1
XFILLER_82_726 vssd1 vccd1 vccd1 vssd1 sky130_ef_sc_hd__decap_40_12$1
XFILLER_66_277 vssd1 vccd1 vccd1 vssd1 sky130_ef_sc_hd__decap_40_12$1
XFILLER_81_225 vssd1 vccd1 vccd1 vssd1 sky130_ef_sc_hd__decap_40_12$1
X_1005_ _1417_/C1 _1004_/X _1013_/A2 hold146/X _1536_/D vssd1 vccd1 vccd1 vssd1 sky130_fd_sc_hd__o211a_1$1
XTAP_TAPCELL_ROW_85_1576 vccd1 vssd1 sky130_fd_sc_hd__tapvpwrvgnd_1$1
XFILLER_50_601 vssd1 vccd1 vccd1 vssd1 sky130_ef_sc_hd__decap_40_12$1
XFILLER_19_193 vssd1 vccd1 vccd1 vssd1 sky130_ef_sc_hd__decap_40_12$1
XFILLER_34_141 vssd1 vccd1 vccd1 vssd1 sky130_ef_sc_hd__decap_40_12$1
XFILLER_90_781 vssd1 vccd1 vccd1 vssd1 sky130_ef_sc_hd__decap_40_12$1
XFILLER_50_623 vccd1 vssd1 vccd1 vssd1 sky130_fd_sc_hd__fill_1$1
XFILLER_50_645 vssd1 vccd1 vccd1 vssd1 sky130_ef_sc_hd__decap_40_12$1
XFILLER_135_205 vssd1 vccd1 vccd1 vssd1 sky130_ef_sc_hd__decap_40_12$1
XTAP_TAPCELL_ROW_116_2042 vccd1 vssd1 sky130_fd_sc_hd__tapvpwrvgnd_1$1
XFILLER_108_419 vccd1 vssd1 vccd1 vssd1 sky130_fd_sc_hd__fill_1$1
X_1838_ _1838_/A _1838_/X vssd1 vccd1 vccd1 vssd1 sky130_fd_sc_hd__clkbuf_2$1
XFILLER_135_249 vssd1 vccd1 vccd1 vssd1 sky130_ef_sc_hd__decap_40_12$1
XFILLER_104_625 vssd1 vccd1 vccd1 vssd1 sky130_ef_sc_hd__decap_40_12$1
XFILLER_103_113 vssd1 vccd1 vccd1 vssd1 sky130_ef_sc_hd__decap_40_12$1
XFILLER_104_669 vssd1 vccd1 vccd1 vssd1 sky130_ef_sc_hd__decap_40_12$1
XFILLER_66_27 vccd1 vssd1 vccd1 vssd1 sky130_fd_sc_hd__fill_1$1
XFILLER_85_553 vssd1 vccd1 vccd1 vssd1 sky130_fd_sc_hd__fill_4$1
XFILLER_57_277 vssd1 vccd1 vccd1 vssd1 sky130_fd_sc_hd__fill_2$1
XFILLER_45_417 vssd1 vccd1 vccd1 vssd1 sky130_ef_sc_hd__decap_40_12$1
XFILLER_85_597 vssd1 vccd1 vccd1 vssd1 sky130_ef_sc_hd__decap_40_12$1
XFILLER_122_77 vssd1 vccd1 vccd1 vssd1 sky130_fd_sc_hd__fill_4$1
XFILLER_82_15 vssd1 vccd1 vccd1 vssd1 sky130_ef_sc_hd__decap_40_12$1
XFILLER_26_653 vccd1 vssd1 vccd1 vssd1 sky130_fd_sc_hd__fill_1$1
XFILLER_81_781 vssd1 vccd1 vccd1 vssd1 sky130_fd_sc_hd__fill_2$1
XFILLER_53_483 vccd1 vssd1 vccd1 vssd1 sky130_fd_sc_hd__fill_1$1
XFILLER_53_461 vssd1 vccd1 vccd1 vssd1 sky130_ef_sc_hd__decap_40_12$1
XTAP_TAPCELL_ROW_0_284 vccd1 vssd1 sky130_fd_sc_hd__tapvpwrvgnd_1$1
XTAP_TAPCELL_ROW_0_295 vccd1 vssd1 sky130_fd_sc_hd__tapvpwrvgnd_1$1
XFILLER_40_133 vssd1 vccd1 vccd1 vssd1 sky130_fd_sc_hd__fill_4$1
XFILLER_9_329 vssd1 vccd1 vccd1 vssd1 sky130_fd_sc_hd__fill_4$1
XFILLER_40_177 vssd1 vccd1 vccd1 vssd1 sky130_ef_sc_hd__decap_40_12$1
XFILLER_21_391 vccd1 vssd1 vccd1 vssd1 sky130_fd_sc_hd__fill_1$1
XFILLER_126_249 vssd1 vccd1 vccd1 vssd1 sky130_fd_sc_hd__fill_2$1
XFILLER_107_441 vssd1 vccd1 vccd1 vssd1 sky130_fd_sc_hd__fill_4$1
XFILLER_5_557 vssd1 vccd1 vccd1 vssd1 sky130_fd_sc_hd__fill_2$1
XTAP_TAPCELL_ROW_56_1144 vccd1 vssd1 sky130_fd_sc_hd__tapvpwrvgnd_1$1
XTAP_TAPCELL_ROW_56_1133 vccd1 vssd1 sky130_fd_sc_hd__tapvpwrvgnd_1$1
Xoutput74 _1854_/X analog_ctrl[121] vssd1 vccd1 vccd1 vssd1 sky130_fd_sc_hd__buf_12$1
Xoutput63 _1844_/X analog_ctrl[111] vssd1 vccd1 vccd1 vssd1 sky130_fd_sc_hd__buf_12$1
XFILLER_68_509 vccd1 vssd1 vccd1 vssd1 sky130_fd_sc_hd__fill_1$1
XFILLER_1_741 vssd1 vccd1 vccd1 vssd1 sky130_ef_sc_hd__decap_40_12$1
Xoutput85 _1791_/X analog_ctrl[20] vssd1 vccd1 vccd1 vssd1 sky130_fd_sc_hd__buf_12$1
XFILLER_122_499 vssd1 vccd1 vccd1 vssd1 sky130_fd_sc_hd__fill_8$1
XFILLER_122_477 vssd1 vccd1 vccd1 vssd1 sky130_fd_sc_hd__fill_4$1
XFILLER_95_317 vssd1 vccd1 vccd1 vssd1 sky130_ef_sc_hd__decap_40_12$1
XFILLER_49_723 vssd1 vccd1 vccd1 vssd1 sky130_fd_sc_hd__fill_4$1
XFILLER_0_251 vccd1 vssd1 vccd1 vssd1 sky130_fd_sc_hd__fill_1$1
XFILLER_1_785 vssd1 vccd1 vccd1 vssd1 sky130_ef_sc_hd__decap_40_12$1
Xoutput96 _1801_/X analog_ctrl[30] vssd1 vccd1 vccd1 vssd1 sky130_fd_sc_hd__buf_12$1
XFILLER_49_767 vssd1 vccd1 vccd1 vssd1 sky130_ef_sc_hd__decap_40_12$1
XFILLER_0_295 vssd1 vccd1 vccd1 vssd1 sky130_ef_sc_hd__decap_40_12$1
XFILLER_48_233 vssd1 vccd1 vccd1 vssd1 sky130_ef_sc_hd__decap_40_12$1
XFILLER_91_501 vssd1 vccd1 vccd1 vssd1 sky130_fd_sc_hd__fill_2$1
XFILLER_36_417 vssd1 vccd1 vccd1 vssd1 sky130_fd_sc_hd__fill_2$1
XFILLER_48_277 vssd1 vccd1 vccd1 vssd1 sky130_ef_sc_hd__decap_40_12$1
XFILLER_64_737 vssd1 vccd1 vccd1 vssd1 sky130_ef_sc_hd__decap_40_12$1
XFILLER_63_225 vssd1 vccd1 vccd1 vssd1 sky130_ef_sc_hd__decap_40_12$1
XFILLER_16_141 vssd1 vccd1 vccd1 vssd1 sky130_ef_sc_hd__decap_40_12$1
XFILLER_17_653 vssd1 vccd1 vccd1 vssd1 sky130_ef_sc_hd__decap_40_12$1
XFILLER_72_792 vssd1 vccd1 vccd1 vssd1 sky130_ef_sc_hd__decap_40_12$1
XFILLER_17_697 vssd1 vccd1 vccd1 vssd1 sky130_ef_sc_hd__decap_40_12$1
XFILLER_32_601 vssd1 vccd1 vccd1 vssd1 sky130_ef_sc_hd__decap_40_12$1
XFILLER_31_111 vccd1 vssd1 vccd1 vssd1 sky130_fd_sc_hd__fill_1$1
XFILLER_72_81 vssd1 vccd1 vccd1 vssd1 sky130_fd_sc_hd__fill_2$1
XTAP_TAPCELL_ROW_80_1495 vccd1 vssd1 sky130_fd_sc_hd__tapvpwrvgnd_1$1
XFILLER_9_841 vccd1 vssd1 vccd1 vssd1 sky130_fd_sc_hd__fill_1$1
XFILLER_117_205 vssd1 vccd1 vccd1 vssd1 sky130_ef_sc_hd__decap_40_12$1
XFILLER_117_249 vssd1 vccd1 vccd1 vssd1 sky130_ef_sc_hd__decap_40_12$1
XFILLER_68_3 vssd1 vccd1 vccd1 vssd1 sky130_ef_sc_hd__decap_40_12$1
X_1623_ _1623_/Q _1719_/CLK hold99/X vccd1 vssd1 vccd1 vssd1 sky130_fd_sc_hd__dfxtp_1$1
X_1554_ _1554_/Q clkload6/A _1554_/D vccd1 vssd1 vccd1 vssd1 sky130_fd_sc_hd__dfxtp_1$1
XFILLER_125_293 vssd1 vccd1 vccd1 vssd1 sky130_ef_sc_hd__decap_40_12$1
XFILLER_99_689 vssd1 vccd1 vccd1 vssd1 sky130_ef_sc_hd__decap_40_12$1
XFILLER_98_133 vssd1 vccd1 vccd1 vssd1 sky130_fd_sc_hd__fill_4$1
X_1485_ _1485_/Q clkload2/A _1485_/D vccd1 vssd1 vccd1 vssd1 sky130_fd_sc_hd__dfxtp_2$1
XFILLER_101_617 vssd1 vccd1 vccd1 vssd1 sky130_ef_sc_hd__decap_40_12$1
XFILLER_98_177 vssd1 vccd1 vccd1 vssd1 sky130_ef_sc_hd__decap_40_12$1
.ends

.subckt CF_BUF_HIZ_core tp vpb_a vnb vgnd_a clk2_boost clk1_boostr vpwr_a ion iop
+ e_pd en_pd vinp_n vinn_n vinp_na vinn_na vinn_p vinp_p e_na_boost e_n_boost vbpt
+ vbpcis vbncis vout vbpci vbnt ibias vbnci vbpcid vbptd vbnc vbpc vbpb li_0_0#
R0 e_n_boost vnb 0.000000
R1 e_n_boost vinp_na 0.000000
R2 vbpb ibias 0.000000
R3 e_n_boost vpb_a 0.000000
R4 e_n_boost vinn_n 0.000000
R5 vbpb vbnt 0.000000
R6 e_n_boost tp 0.000000
R7 e_n_boost vinp_n 0.000000
R8 vbpb vbpci 0.000000
R9 e_n_boost en_pd 0.000000
R10 vbpb vout 0.000000
R11 e_n_boost e_pd 0.000000
R12 vbpb vbncis 0.000000
R13 e_n_boost ion 0.000000
R14 e_n_boost iop 0.000000
R15 vbpb vbpt 0.000000
R16 vbpb vbpcis 0.000000
R17 vbpb vbpc 0.000000
R18 e_n_boost e_na_boost 0.000000
R19 vbpb vbnc 0.000000
R20 vbpb vbptd 0.000000
R21 e_n_boost clk1_boostr 0.000000
R22 e_n_boost vpwr_a 0.000000
R23 e_n_boost vinp_p 0.000000
R24 e_n_boost clk2_boost 0.000000
R25 e_n_boost vinn_p 0.000000
R26 vbpb vbpcid 0.000000
R27 e_n_boost vgnd_a 0.000000
R28 e_n_boost vinn_na 0.000000
R29 vbpb vbnci 0.000000
.ends

.subckt CF_BUF_HIZ iop vbpcis vbncis ibias vbnt w_400_400# clk2_boost vbpt vout vbnc
+ vbpc vpwr vinp_p tp e_pd
XCF_BUF_HIZ_core_0 tp vpwr vpwr vpwr clk2_boost tp vpwr iop iop e_pd e_pd vinp_p vinp_p
+ vinp_p vinp_p vinp_p vinp_p tp tp vbpt vbpcis vbncis vout vpwr vbnt ibias vbnt vpwr
+ vpwr vbnc vbpc vpwr li_23652_26371# CF_BUF_HIZ_core
.ends

.subckt user_project_wrapper analog_io[12] analog_io[8] io_in[15] io_in[16] io_in[17]
+ io_in[18] io_in[19] io_oeb[15] io_oeb[16] io_oeb[17] io_oeb[18] io_out[15] io_out[16]
+ io_out[17] io_out[18] analog_io[16] analog_io[13] analog_io[15] io_oeb[19] io_oeb[20]
+ io_oeb[21] io_oeb[22] io_oeb[23] io_in[20] io_in[21] io_in[22] io_in[23] io_out[19]
+ io_out[20] io_out[21] io_out[22] io_out[23] wb_clk_i wb_rst_i wbs_ack_o wbs_adr_i[0]
+ wbs_adr_i[10] wbs_adr_i[11] wbs_adr_i[12] wbs_adr_i[13] wbs_adr_i[14] wbs_adr_i[15]
+ wbs_adr_i[16] wbs_adr_i[17] wbs_adr_i[1] wbs_adr_i[2] wbs_adr_i[3] wbs_adr_i[4]
+ wbs_adr_i[5] wbs_adr_i[6] wbs_adr_i[7] wbs_adr_i[8] wbs_adr_i[9] wbs_cyc_i wbs_dat_i[0]
+ wbs_dat_i[10] wbs_dat_i[11] wbs_dat_i[12] wbs_dat_i[13] wbs_dat_i[14] wbs_dat_i[15]
+ wbs_dat_i[16] wbs_dat_i[1] wbs_dat_i[2] wbs_dat_i[3] wbs_dat_i[4] wbs_dat_i[5] wbs_dat_i[6]
+ wbs_dat_i[7] wbs_dat_i[8] wbs_dat_i[9] wbs_dat_o[0] wbs_dat_o[10] wbs_dat_o[11]
+ wbs_dat_o[12] wbs_dat_o[13] wbs_dat_o[14] wbs_dat_o[15] wbs_dat_o[16] wbs_dat_o[1]
+ wbs_dat_o[2] wbs_dat_o[3] wbs_dat_o[4] wbs_dat_o[5] wbs_dat_o[6] wbs_dat_o[7] wbs_dat_o[8]
+ wbs_dat_o[9] wbs_sel_i[0] wbs_sel_i[1] wbs_sel_i[2] wbs_sel_i[3] wbs_stb_i wbs_we_i
+ wbs_dat_i[17] wbs_dat_i[18] wbs_dat_i[19] wbs_adr_i[18] wbs_dat_i[20] wbs_dat_i[21]
+ wbs_dat_i[22] wbs_dat_i[23] wbs_dat_i[24] wbs_dat_i[25] wbs_dat_i[26] wbs_dat_i[27]
+ wbs_dat_i[28] wbs_dat_i[29] wbs_adr_i[19] wbs_dat_i[30] wbs_dat_i[31] la_oenb[0]
+ wbs_adr_i[20] wbs_adr_i[21] wbs_adr_i[22] wbs_adr_i[23] wbs_adr_i[24] wbs_adr_i[25]
+ wbs_adr_i[26] wbs_adr_i[27] wbs_adr_i[28] wbs_adr_i[29] la_oenb[1] wbs_adr_i[30]
+ wbs_adr_i[31] la_oenb[2] wbs_dat_o[17] wbs_dat_o[18] wbs_dat_o[19] la_oenb[3] wbs_dat_o[20]
+ wbs_dat_o[21] wbs_dat_o[22] wbs_dat_o[23] wbs_dat_o[24] wbs_dat_o[25] wbs_dat_o[26]
+ wbs_dat_o[27] wbs_dat_o[28] wbs_dat_o[29] la_oenb[4] wbs_dat_o[30] wbs_dat_o[31]
+ la_oenb[5] la_data_in[0] la_data_in[1] la_data_in[2] la_data_in[3] la_data_in[4]
+ la_data_in[5] la_data_out[0] la_data_out[1] la_data_out[2] la_data_out[3] la_data_out[4]
+ la_data_out[5] la_data_in[23] la_data_in[24] la_data_in[25] la_oenb[6] la_oenb[7]
+ la_oenb[8] la_oenb[9] la_data_in[26] la_data_in[11] la_data_in[12] la_data_in[13]
+ la_data_in[14] la_data_in[6] la_data_in[7] la_data_in[8] la_data_in[9] la_data_in[15]
+ la_data_out[10] la_data_out[11] la_data_out[12] la_data_out[13] la_data_out[14]
+ la_data_out[15] la_data_out[16] la_data_out[17] la_data_out[18] la_data_out[19]
+ la_data_in[16] la_data_out[20] la_data_out[21] la_data_out[22] la_data_out[23] la_data_out[24]
+ la_data_out[25] la_data_in[17] la_data_in[18] la_data_in[19] la_data_in[10] la_data_out[6]
+ la_data_out[7] la_data_out[8] la_data_out[9] la_data_in[20] la_oenb[10] la_oenb[11]
+ la_oenb[12] la_oenb[13] la_oenb[14] la_oenb[15] la_oenb[16] la_oenb[17] la_oenb[18]
+ la_oenb[19] la_data_in[21] la_oenb[20] la_oenb[21] la_oenb[22] la_oenb[23] la_oenb[24]
+ la_oenb[25] la_data_in[22] la_data_in[39] la_oenb[45] la_data_in[40] la_data_out[26]
+ la_data_out[27] la_data_out[28] la_data_out[29] la_data_in[41] la_data_out[30] la_data_out[31]
+ la_data_out[32] la_data_out[33] la_data_out[34] la_data_out[35] la_data_out[36]
+ la_data_out[37] la_data_out[38] la_data_out[39] la_data_in[42] la_data_out[40] la_data_out[41]
+ la_data_out[42] la_data_out[43] la_data_out[44] la_data_out[45] la_data_out[46]
+ la_data_in[43] la_data_in[44] la_data_in[45] la_data_in[46] la_oenb[46] la_oenb[38]
+ la_oenb[39] la_oenb[37] la_oenb[40] la_oenb[41] la_oenb[42] la_oenb[43] la_data_in[27]
+ la_data_in[28] la_data_in[29] la_oenb[44] la_data_in[30] la_data_in[31] la_data_in[32]
+ la_data_in[33] la_data_in[34] la_data_in[35] la_data_in[36] la_data_in[37] la_oenb[26]
+ la_oenb[27] la_oenb[28] la_oenb[29] la_data_in[38] la_oenb[30] la_oenb[31] la_oenb[32]
+ la_oenb[33] la_oenb[34] la_oenb[35] la_oenb[36] la_oenb[47] la_oenb[48] la_oenb[49]
+ la_oenb[50] la_oenb[51] la_oenb[52] la_oenb[53] la_oenb[54] la_oenb[55] la_oenb[56]
+ la_oenb[57] la_oenb[58] la_oenb[59] la_oenb[60] la_oenb[61] la_oenb[62] la_oenb[63]
+ la_oenb[64] la_oenb[65] la_oenb[66] la_data_in[47] la_data_in[48] la_data_in[49]
+ la_data_in[50] la_data_in[51] la_data_in[52] la_data_in[53] la_data_in[54] la_data_in[55]
+ la_data_in[56] la_data_in[57] la_data_in[58] la_data_in[59] la_data_in[60] la_data_in[61]
+ la_data_in[62] la_data_in[63] la_data_out[47] la_data_out[48] la_data_out[49] la_data_in[64]
+ la_data_out[50] la_data_out[51] la_data_out[52] la_data_out[53] la_data_out[54]
+ la_data_out[55] la_data_out[56] la_data_out[57] la_data_out[58] la_data_out[59]
+ la_data_in[65] la_data_out[60] la_data_out[61] la_data_out[62] la_data_out[63] la_data_out[64]
+ la_data_out[65] la_data_out[66] la_data_out[67] la_data_in[66] la_data_in[67] la_data_in[72]
+ la_data_in[73] la_data_in[74] la_data_in[75] la_data_in[76] la_data_in[77] la_data_in[78]
+ la_data_in[79] la_data_in[80] la_data_in[81] la_data_in[82] la_data_in[83] la_data_in[84]
+ la_data_in[85] la_data_in[86] la_data_in[87] la_data_in[69] la_oenb[67] la_oenb[68]
+ la_oenb[69] la_oenb[70] la_oenb[71] la_oenb[72] la_oenb[73] la_oenb[74] la_oenb[75]
+ la_oenb[76] la_oenb[77] la_oenb[78] la_oenb[79] la_oenb[80] la_oenb[81] la_oenb[82]
+ la_oenb[83] la_oenb[84] la_oenb[85] la_oenb[86] la_oenb[87] la_data_out[68] la_data_out[69]
+ la_data_in[70] la_data_out[70] la_data_out[71] la_data_out[72] la_data_out[73] la_data_out[74]
+ la_data_out[75] la_data_out[76] la_data_out[77] la_data_out[78] la_data_out[79]
+ la_data_in[71] la_data_out[80] la_data_out[81] la_data_out[82] la_data_out[83] la_data_out[84]
+ la_data_out[85] la_data_out[86] la_data_out[87] la_data_in[68] la_oenb[88] la_oenb[89]
+ la_oenb[90] la_oenb[91] la_oenb[92] la_oenb[93] la_oenb[94] la_oenb[95] la_oenb[96]
+ la_oenb[97] la_oenb[98] la_oenb[99] la_data_in[101] la_data_in[102] la_data_in[103]
+ la_data_in[104] la_data_in[105] la_data_in[106] la_data_in[107] la_data_in[108]
+ la_data_in[100] la_data_in[90] la_data_in[91] la_data_in[92] la_data_in[93] la_data_in[94]
+ la_data_in[95] la_data_in[96] la_data_in[97] la_data_in[98] la_data_in[99] la_data_out[100]
+ la_data_out[101] la_data_out[102] la_data_out[103] la_data_out[104] la_data_out[105]
+ la_data_out[93] la_data_out[106] la_data_out[94] la_data_out[107] la_data_out[95]
+ la_data_out[96] la_data_out[108] la_data_out[97] la_data_out[98] la_data_out[99]
+ la_data_out[92] la_oenb[100] la_oenb[101] la_oenb[102] la_oenb[103] la_oenb[104]
+ la_oenb[105] la_oenb[106] la_oenb[107] la_data_in[88] la_data_in[89] la_data_out[88]
+ la_data_out[89] la_data_out[90] la_data_out[91] la_data_in[119] la_data_out[120]
+ la_data_out[121] la_data_out[122] la_data_in[116] la_data_in[117] la_data_out[123]
+ la_data_in[112] la_data_out[124] la_data_out[125] la_data_out[126] la_data_out[127]
+ la_data_in[118] la_oenb[109] la_data_in[120] la_oenb[110] la_data_in[121] la_oenb[111]
+ la_oenb[112] la_oenb[113] la_oenb[114] la_oenb[115] la_oenb[116] la_oenb[117] la_oenb[118]
+ la_oenb[119] la_data_in[122] la_data_in[123] la_oenb[120] la_oenb[121] la_oenb[122]
+ la_oenb[123] la_oenb[124] la_oenb[125] la_oenb[126] la_oenb[127] la_data_in[124]
+ la_data_in[125] la_data_in[126] la_data_in[127] la_data_out[110] user_clock2 user_irq[0]
+ la_data_in[113] user_irq[1] la_data_in[114] user_irq[2] la_data_out[111] la_data_out[112]
+ la_data_out[109] la_data_in[109] la_data_out[113] la_data_in[110] la_data_out[114]
+ la_oenb[108] la_data_out[115] la_data_out[116] la_data_in[111] la_data_out[117]
+ la_data_in[115] la_data_out[118] la_data_out[119] analog_io[7] io_in[10] io_in[11]
+ io_in[12] io_in[13] io_in[14] io_in[9] io_oeb[10] io_oeb[11] io_oeb[12] io_oeb[13]
+ io_oeb[14] io_oeb[8] io_oeb[9] io_out[10] io_out[11] io_out[12] io_out[13] io_out[14]
+ io_out[8] io_out[9] analog_io[22] analog_io[23] analog_io[17] io_oeb[24] io_oeb[25]
+ io_oeb[26] io_oeb[27] io_oeb[28] io_oeb[29] analog_io[20] io_in[24] io_in[25] io_in[26]
+ io_in[27] io_in[28] io_in[29] io_out[24] io_out[25] io_out[26] io_out[27] io_out[28]
+ io_out[29] io_out[30] io_in[30] analog_io[21] io_oeb[34] io_oeb[35] io_oeb[36] io_oeb[37]
+ analog_io[27] analog_io[28] analog_io[24] analog_io[25] analog_io[26] io_in[31]
+ io_in[32] io_in[33] io_in[34] io_in[35] io_in[36] io_in[37] io_oeb[30] io_oeb[31]
+ io_out[31] io_out[32] io_out[33] io_out[34] io_out[35] io_out[36] io_out[37] io_oeb[32]
+ io_oeb[33] io_in[8] io_oeb[2] io_oeb[0] io_out[1] io_in[2] analog_io[0] io_in[1]
+ io_in[0] io_in[3] io_oeb[1] io_out[2] io_in[4] io_oeb[3] io_oeb[4] io_oeb[5] io_oeb[6]
+ io_oeb[7] io_in[5] io_in[6] io_out[3] io_out[4] io_out[5] io_out[6] io_out[7] io_out[0]
+ io_in[7] vccd1 vccd2 vdda1 vdda2 vssa1 vssa2 vssd2
Xafe_wb_0 wbs_adr_i[15] wbs_adr_i[16] wbs_adr_i[17] wbs_adr_i[18] wbs_adr_i[19] wbs_adr_i[20]
+ wbs_adr_i[21] wbs_adr_i[22] wbs_adr_i[23] wbs_adr_i[24] wbs_adr_i[25] wbs_adr_i[26]
+ wbs_adr_i[27] wbs_adr_i[28] wbs_adr_i[29] wbs_adr_i[30] wbs_adr_i[31] wbs_dat_i[14]
+ wbs_dat_i[15] wbs_dat_i[16] wbs_dat_i[17] wbs_dat_i[18] wbs_dat_i[19] wbs_dat_i[20]
+ wbs_dat_i[21] wbs_dat_i[22] wbs_dat_i[23] wbs_dat_i[24] wbs_dat_i[25] wbs_dat_i[26]
+ wbs_dat_i[27] wbs_dat_i[28] wbs_dat_i[29] wbs_dat_i[30] wbs_dat_i[31] wbs_dat_o[14]
+ wbs_dat_o[15] wbs_dat_o[16] wbs_dat_o[17] wbs_dat_o[18] wbs_dat_o[19] wbs_dat_o[20]
+ wbs_dat_o[21] wbs_dat_o[22] wbs_dat_o[23] wbs_dat_o[24] wbs_dat_o[25] wbs_dat_o[26]
+ wbs_dat_o[27] wbs_dat_o[28] wbs_dat_o[29] wbs_dat_o[30] wbs_dat_o[31] wbs_adr_i[3]
+ wbs_adr_i[4] wbs_adr_i[5] wbs_adr_i[6] wbs_adr_i[7] wbs_dat_i[2] wbs_adr_i[8] wbs_adr_i[9]
+ wbs_dat_i[3] wbs_dat_i[4] wbs_dat_i[5] wbs_dat_i[6] wbs_dat_i[7] wbs_dat_i[8] wbs_dat_i[9]
+ wbs_dat_o[0] wbs_dat_o[10] wbs_dat_o[11] wbs_dat_o[12] wbs_dat_o[13] wbs_cyc_i wbs_dat_i[0]
+ wbs_dat_i[10] wbs_dat_i[11] wbs_dat_i[12] wbs_dat_i[13] wbs_dat_o[1] wbs_adr_i[13]
+ wbs_adr_i[14] wb_clk_i wb_rst_i wbs_ack_o wbs_adr_i[0] wbs_dat_i[1] wbs_adr_i[10]
+ wbs_adr_i[1] wbs_adr_i[2] wbs_dat_o[2] wbs_adr_i[11] wbs_adr_i[12] wbs_dat_o[3]
+ wbs_dat_o[4] wbs_dat_o[5] wbs_dat_o[6] wbs_dat_o[7] wbs_dat_o[8] wbs_dat_o[9] wbs_sel_i[0]
+ wbs_sel_i[1] wbs_sel_i[2] wbs_sel_i[3] wbs_stb_i wbs_we_i afe_wb_0/adc_data[1] afe_wb_0/adc_data[2]
+ afe_wb_0/adc_data[3] afe_wb_0/adc_data[4] afe_wb_0/adc_data[5] afe_wb_0/adc_data[6]
+ afe_wb_0/adc_data[0] afe_wb_0/adc_data[9] afe_wb_0/adc_eof afe_wb_0/adc_data[10]
+ afe_wb_0/adc_data[11] afe_wb_0/adc_data[7] afe_wb_0/adc_data[8] afe_wb_0/analog_ctrl[100]
+ afe_wb_0/analog_ctrl[101] afe_wb_0/analog_ctrl[102] afe_wb_0/analog_ctrl[103] CF_REFBUF_0/pd
+ afe_wb_0/analog_ctrl[105] CF_REFBUF_0/boost CF_REFBUF_0/ch_cont afe_wb_0/analog_ctrl[108]
+ afe_wb_0/analog_ctrl[109] afe_wb_0/analog_ctrl[110] afe_wb_0/analog_ctrl[111] afe_wb_0/analog_ctrl[112]
+ afe_wb_0/analog_ctrl[113] afe_wb_0/analog_ctrl[114] afe_wb_0/analog_ctrl[115] afe_wb_0/analog_ctrl[116]
+ afe_wb_0/analog_ctrl[117] afe_wb_0/analog_ctrl[118] afe_wb_0/analog_ctrl[119] afe_wb_0/analog_ctrl[120]
+ afe_wb_0/analog_ctrl[121] afe_wb_0/analog_ctrl[122] afe_wb_0/analog_ctrl[62] afe_wb_0/analog_ctrl[63]
+ CF_BGR_0/trimTC[0] CF_BGR_0/trimTC[1] CF_BGR_0/trimTC[2] CF_BGR_0/trimTC[3] CF_BGR_0/trimTC[4]
+ CF_BGR_0/trimTC[5] CF_BGR_0/trimTC[6] CF_BGR_0/trimCurr[0] CF_BGR_0/trimCurr[1]
+ CF_BGR_0/trimCurr[2] CF_BGR_0/trimCurr[3] CF_BGR_0/trimCurr[4] CF_BGR_0/trimCurr[5]
+ CF_BGR_0/CurrAbsTrim[0] CF_BGR_0/CurrAbsTrim[1] CF_BGR_0/CurrAbsTrim[2] CF_BGR_0/CurrAbsTrim[3]
+ CF_BGR_0/CurrAbsTrim[4] CF_BGR_0/CurrAbsTrim[5] CF_BGR_0/inl_ctrl[0] CF_BGR_0/inl_ctrl[1]
+ CF_BGR_0/inl_ctrl[2] CF_BGR_0/inl_ctrl[3] CF_BGR_0/inl_ctrl[4] CF_BGR_0/inl_ctrl[5]
+ CF_BGR_0/inl_ctrl[6] CF_BGR_0/mux1sel[0] CF_BGR_0/mux1sel[1] CF_BGR_0/mux2sel CF_BGR_0/dft_sel
+ CF_BGR_0/pd CF_BGR_0/pd_ibg CF_BGR_0/finetune CF_BGR_0/en_startb afe_wb_0/analog_ctrl[98]
+ afe_wb_0/analog_ctrl[99] afe_wb_0/analog_ctrl[44] afe_wb_0/analog_ctrl[45] afe_wb_0/analog_ctrl[46]
+ afe_wb_0/analog_ctrl[47] afe_wb_0/analog_ctrl[48] afe_wb_0/analog_ctrl[49] vccd1
+ afe_wb_0/analog_ctrl[50] afe_wb_0/analog_ctrl[51] afe_wb_0/analog_ctrl[52] afe_wb_0/analog_ctrl[53]
+ afe_wb_0/analog_ctrl[54] afe_wb_0/analog_ctrl[55] afe_wb_0/analog_ctrl[56] afe_wb_0/analog_ctrl[57]
+ afe_wb_0/analog_ctrl[58] afe_wb_0/analog_ctrl[59] vccd1 afe_wb_0/analog_ctrl[60]
+ afe_wb_0/analog_ctrl[61] vccd1 afe_wb_0/analog_ctrl[10] afe_wb_0/analog_ctrl[11]
+ afe_wb_0/analog_ctrl[12] afe_wb_0/analog_ctrl[13] afe_wb_0/analog_ctrl[14] afe_wb_0/analog_ctrl[15]
+ CF_ADC_SAR12_0/trimunit vccd1 afe_wb_0/analog_ctrl[17] afe_wb_0/analog_ctrl[18]
+ afe_wb_0/analog_ctrl[19] vccd1 afe_wb_0/analog_ctrl[20] afe_wb_0/analog_ctrl[21]
+ afe_wb_0/analog_ctrl[22] afe_wb_0/analog_ctrl[23] afe_wb_0/analog_ctrl[24] afe_wb_0/analog_ctrl[25]
+ afe_wb_0/analog_ctrl[7] afe_wb_0/analog_ctrl[26] afe_wb_0/analog_ctrl[27] afe_wb_0/analog_ctrl[28]
+ afe_wb_0/analog_ctrl[29] vccd1 afe_wb_0/analog_ctrl[30] afe_wb_0/analog_ctrl[31]
+ afe_wb_0/analog_ctrl[32] afe_wb_0/analog_ctrl[33] afe_wb_0/analog_ctrl[34] CF_ADC_SAR12_0/pd
+ afe_wb_0/analog_ctrl[35] afe_wb_0/analog_ctrl[36] afe_wb_0/analog_ctrl[37] afe_wb_0/analog_ctrl[38]
+ afe_wb_0/analog_ctrl[39] vccd1 afe_wb_0/analog_ctrl[40] afe_wb_0/analog_ctrl[41]
+ afe_wb_0/analog_ctrl[42] afe_wb_0/analog_ctrl[43] CF_ADC_SAR12_0/pd_ana vccd1 vccd1
+ afe_wb
XCF_BUF_HIZ_0 CF_BUF_HIZ_0/iop analog_io[16] analog_io[17] CF_BUF_HIZ_0/ibias analog_io[15]
+ w_20364_130400# vccd1 analog_io[16] vccd1 analog_io[13] analog_io[12] vccd1 vccd1
+ vccd1 vccd1 CF_BUF_HIZ
.ends
